// DIV8K: chia co dau 8 bit, mang khong phuc hoi, moi hang mot KSA8 + khoi xu ly dau
simulator lang=spectre
subckt DIV8K A_0 A_1 A_2 A_3 A_4 A_5 A_6 A_7 B_0 B_1 B_2 B_3 B_4 B_5 B_6 B_7 Q_0 Q_1 Q_2 \
    Q_3 Q_4 Q_5 Q_6 Q_7 R_0 R_1 R_2 R_3 R_4 R_5 R_6 R_7 V DZ VDD VSS
I0 (A_7 A_0 nakn1 VDD VSS) NAND2_X1
I1 (A_1 nakn1 aa1 VDD VSS) XNOR2_X1
I2 (nakn1 nak1 VDD VSS) INV_X1
I3 (A_7 A_1 nak1 nakn2 VDD VSS) AOI21_X1
I4 (A_2 nakn2 aa2 VDD VSS) XNOR2_X1
I5 (nakn2 nak2 VDD VSS) INV_X1
I6 (A_7 A_2 nak2 nakn3 VDD VSS) AOI21_X1
I7 (A_3 nakn3 aa3 VDD VSS) XNOR2_X1
I8 (nakn3 nak3 VDD VSS) INV_X1
I9 (A_7 A_3 nak3 nakn4 VDD VSS) AOI21_X1
I10 (A_4 nakn4 aa4 VDD VSS) XNOR2_X1
I11 (nakn4 nak4 VDD VSS) INV_X1
I12 (A_7 A_4 nak4 nakn5 VDD VSS) AOI21_X1
I13 (A_5 nakn5 aa5 VDD VSS) XNOR2_X1
I14 (nakn5 nak5 VDD VSS) INV_X1
I15 (A_7 A_5 nak5 nakn6 VDD VSS) AOI21_X1
I16 (A_6 nakn6 aa6 VDD VSS) XNOR2_X1
I17 (nakn6 nak6 VDD VSS) INV_X1
I18 (A_7 A_6 nak6 nakn7 VDD VSS) AOI21_X1
I19 (A_7 nakn7 aa7 VDD VSS) XNOR2_X1
I20 (B_7 B_0 nbkn1 VDD VSS) NAND2_X1
I21 (B_1 nbkn1 dd1 VDD VSS) XNOR2_X1
I22 (nbkn1 nbk1 VDD VSS) INV_X1
I23 (B_7 B_1 nbk1 nbkn2 VDD VSS) AOI21_X1
I24 (B_2 nbkn2 dd2 VDD VSS) XNOR2_X1
I25 (nbkn2 nbk2 VDD VSS) INV_X1
I26 (B_7 B_2 nbk2 nbkn3 VDD VSS) AOI21_X1
I27 (B_3 nbkn3 dd3 VDD VSS) XNOR2_X1
I28 (nbkn3 nbk3 VDD VSS) INV_X1
I29 (B_7 B_3 nbk3 nbkn4 VDD VSS) AOI21_X1
I30 (B_4 nbkn4 dd4 VDD VSS) XNOR2_X1
I31 (nbkn4 nbk4 VDD VSS) INV_X1
I32 (B_7 B_4 nbk4 nbkn5 VDD VSS) AOI21_X1
I33 (B_5 nbkn5 dd5 VDD VSS) XNOR2_X1
I34 (nbkn5 nbk5 VDD VSS) INV_X1
I35 (B_7 B_5 nbk5 nbkn6 VDD VSS) AOI21_X1
I36 (B_6 nbkn6 dd6 VDD VSS) XNOR2_X1
I37 (nbkn6 nbk6 VDD VSS) INV_X1
I38 (B_7 B_6 nbk6 nbkn7 VDD VSS) AOI21_X1
I39 (B_7 nbkn7 dd7 VDD VSS) XNOR2_X1
I40 (B_0 VDD b0_0 VDD VSS) XOR2_X1
I41 (dd1 VDD b0_1 VDD VSS) XOR2_X1
I42 (dd2 VDD b0_2 VDD VSS) XOR2_X1
I43 (dd3 VDD b0_3 VDD VSS) XOR2_X1
I44 (dd4 VDD b0_4 VDD VSS) XOR2_X1
I45 (dd5 VDD b0_5 VDD VSS) XOR2_X1
I46 (dd6 VDD b0_6 VDD VSS) XOR2_X1
I47 (dd7 VDD b0_7 VDD VSS) XOR2_X1
I48 (aa7 VSS VSS VSS VSS VSS VSS VSS b0_0 b0_1 b0_2 b0_3 b0_4 b0_5 b0_6 b0_7 VDD p0_0 p0_1 \
    p0_2 p0_3 p0_4 p0_5 p0_6 p0_7 c0_7 c0_8 VDD VSS) KSA8
I49 (VSS VDD h0 VDD VSS) XOR2_X1
I50 (h0 c0_8 p0_8 VDD VSS) XOR2_X1
I51 (p0_8 qu7 VDD VSS) INV_X4
I52 (B_0 qu7 b1_0 VDD VSS) XOR2_X1
I53 (dd1 qu7 b1_1 VDD VSS) XOR2_X1
I54 (dd2 qu7 b1_2 VDD VSS) XOR2_X1
I55 (dd3 qu7 b1_3 VDD VSS) XOR2_X1
I56 (dd4 qu7 b1_4 VDD VSS) XOR2_X1
I57 (dd5 qu7 b1_5 VDD VSS) XOR2_X1
I58 (dd6 qu7 b1_6 VDD VSS) XOR2_X1
I59 (dd7 qu7 b1_7 VDD VSS) XOR2_X1
I60 (aa6 p0_0 p0_1 p0_2 p0_3 p0_4 p0_5 p0_6 b1_0 b1_1 b1_2 b1_3 b1_4 b1_5 b1_6 b1_7 qu7 \
    p1_0 p1_1 p1_2 p1_3 p1_4 p1_5 p1_6 p1_7 c1_7 c1_8 VDD VSS) KSA8
I61 (p0_7 qu7 h1 VDD VSS) XOR2_X1
I62 (h1 c1_8 p1_8 VDD VSS) XOR2_X1
I63 (p1_8 qu6 VDD VSS) INV_X4
I64 (B_0 qu6 b2_0 VDD VSS) XOR2_X1
I65 (dd1 qu6 b2_1 VDD VSS) XOR2_X1
I66 (dd2 qu6 b2_2 VDD VSS) XOR2_X1
I67 (dd3 qu6 b2_3 VDD VSS) XOR2_X1
I68 (dd4 qu6 b2_4 VDD VSS) XOR2_X1
I69 (dd5 qu6 b2_5 VDD VSS) XOR2_X1
I70 (dd6 qu6 b2_6 VDD VSS) XOR2_X1
I71 (dd7 qu6 b2_7 VDD VSS) XOR2_X1
I72 (aa5 p1_0 p1_1 p1_2 p1_3 p1_4 p1_5 p1_6 b2_0 b2_1 b2_2 b2_3 b2_4 b2_5 b2_6 b2_7 qu6 \
    p2_0 p2_1 p2_2 p2_3 p2_4 p2_5 p2_6 p2_7 c2_7 c2_8 VDD VSS) KSA8
I73 (p1_7 qu6 h2 VDD VSS) XOR2_X1
I74 (h2 c2_8 p2_8 VDD VSS) XOR2_X1
I75 (p2_8 qu5 VDD VSS) INV_X4
I76 (B_0 qu5 b3_0 VDD VSS) XOR2_X1
I77 (dd1 qu5 b3_1 VDD VSS) XOR2_X1
I78 (dd2 qu5 b3_2 VDD VSS) XOR2_X1
I79 (dd3 qu5 b3_3 VDD VSS) XOR2_X1
I80 (dd4 qu5 b3_4 VDD VSS) XOR2_X1
I81 (dd5 qu5 b3_5 VDD VSS) XOR2_X1
I82 (dd6 qu5 b3_6 VDD VSS) XOR2_X1
I83 (dd7 qu5 b3_7 VDD VSS) XOR2_X1
I84 (aa4 p2_0 p2_1 p2_2 p2_3 p2_4 p2_5 p2_6 b3_0 b3_1 b3_2 b3_3 b3_4 b3_5 b3_6 b3_7 qu5 \
    p3_0 p3_1 p3_2 p3_3 p3_4 p3_5 p3_6 p3_7 c3_7 c3_8 VDD VSS) KSA8
I85 (p2_7 qu5 h3 VDD VSS) XOR2_X1
I86 (h3 c3_8 p3_8 VDD VSS) XOR2_X1
I87 (p3_8 qu4 VDD VSS) INV_X4
I88 (B_0 qu4 b4_0 VDD VSS) XOR2_X1
I89 (dd1 qu4 b4_1 VDD VSS) XOR2_X1
I90 (dd2 qu4 b4_2 VDD VSS) XOR2_X1
I91 (dd3 qu4 b4_3 VDD VSS) XOR2_X1
I92 (dd4 qu4 b4_4 VDD VSS) XOR2_X1
I93 (dd5 qu4 b4_5 VDD VSS) XOR2_X1
I94 (dd6 qu4 b4_6 VDD VSS) XOR2_X1
I95 (dd7 qu4 b4_7 VDD VSS) XOR2_X1
I96 (aa3 p3_0 p3_1 p3_2 p3_3 p3_4 p3_5 p3_6 b4_0 b4_1 b4_2 b4_3 b4_4 b4_5 b4_6 b4_7 qu4 \
    p4_0 p4_1 p4_2 p4_3 p4_4 p4_5 p4_6 p4_7 c4_7 c4_8 VDD VSS) KSA8
I97 (p3_7 qu4 h4 VDD VSS) XOR2_X1
I98 (h4 c4_8 p4_8 VDD VSS) XOR2_X1
I99 (p4_8 qu3 VDD VSS) INV_X4
I100 (B_0 qu3 b5_0 VDD VSS) XOR2_X1
I101 (dd1 qu3 b5_1 VDD VSS) XOR2_X1
I102 (dd2 qu3 b5_2 VDD VSS) XOR2_X1
I103 (dd3 qu3 b5_3 VDD VSS) XOR2_X1
I104 (dd4 qu3 b5_4 VDD VSS) XOR2_X1
I105 (dd5 qu3 b5_5 VDD VSS) XOR2_X1
I106 (dd6 qu3 b5_6 VDD VSS) XOR2_X1
I107 (dd7 qu3 b5_7 VDD VSS) XOR2_X1
I108 (aa2 p4_0 p4_1 p4_2 p4_3 p4_4 p4_5 p4_6 b5_0 b5_1 b5_2 b5_3 b5_4 b5_5 b5_6 b5_7 qu3 \
    p5_0 p5_1 p5_2 p5_3 p5_4 p5_5 p5_6 p5_7 c5_7 c5_8 VDD VSS) KSA8
I109 (p4_7 qu3 h5 VDD VSS) XOR2_X1
I110 (h5 c5_8 p5_8 VDD VSS) XOR2_X1
I111 (p5_8 qu2 VDD VSS) INV_X4
I112 (B_0 qu2 b6_0 VDD VSS) XOR2_X1
I113 (dd1 qu2 b6_1 VDD VSS) XOR2_X1
I114 (dd2 qu2 b6_2 VDD VSS) XOR2_X1
I115 (dd3 qu2 b6_3 VDD VSS) XOR2_X1
I116 (dd4 qu2 b6_4 VDD VSS) XOR2_X1
I117 (dd5 qu2 b6_5 VDD VSS) XOR2_X1
I118 (dd6 qu2 b6_6 VDD VSS) XOR2_X1
I119 (dd7 qu2 b6_7 VDD VSS) XOR2_X1
I120 (aa1 p5_0 p5_1 p5_2 p5_3 p5_4 p5_5 p5_6 b6_0 b6_1 b6_2 b6_3 b6_4 b6_5 b6_6 b6_7 qu2 \
    p6_0 p6_1 p6_2 p6_3 p6_4 p6_5 p6_6 p6_7 c6_7 c6_8 VDD VSS) KSA8
I121 (p5_7 qu2 h6 VDD VSS) XOR2_X1
I122 (h6 c6_8 p6_8 VDD VSS) XOR2_X1
I123 (p6_8 qu1 VDD VSS) INV_X4
I124 (B_0 qu1 b7_0 VDD VSS) XOR2_X1
I125 (dd1 qu1 b7_1 VDD VSS) XOR2_X1
I126 (dd2 qu1 b7_2 VDD VSS) XOR2_X1
I127 (dd3 qu1 b7_3 VDD VSS) XOR2_X1
I128 (dd4 qu1 b7_4 VDD VSS) XOR2_X1
I129 (dd5 qu1 b7_5 VDD VSS) XOR2_X1
I130 (dd6 qu1 b7_6 VDD VSS) XOR2_X1
I131 (dd7 qu1 b7_7 VDD VSS) XOR2_X1
I132 (A_0 p6_0 p6_1 p6_2 p6_3 p6_4 p6_5 p6_6 b7_0 b7_1 b7_2 b7_3 b7_4 b7_5 b7_6 b7_7 qu1 \
    p7_0 p7_1 p7_2 p7_3 p7_4 p7_5 p7_6 p7_7 c7_7 c7_8 VDD VSS) KSA8
I133 (p6_7 qu1 h7 VDD VSS) XOR2_X1
I134 (h7 c7_8 p7_8 VDD VSS) XOR2_X1
I135 (p7_8 Q_0 VDD VSS) INV_X1
I136 (B_0 p7_8 dmn0 VDD VSS) NAND2_X1
I137 (dmn0 dm0 VDD VSS) INV_X1
I138 (dd1 p7_8 dmn1 VDD VSS) NAND2_X1
I139 (dmn1 dm1 VDD VSS) INV_X1
I140 (dd2 p7_8 dmn2 VDD VSS) NAND2_X1
I141 (dmn2 dm2 VDD VSS) INV_X1
I142 (dd3 p7_8 dmn3 VDD VSS) NAND2_X1
I143 (dmn3 dm3 VDD VSS) INV_X1
I144 (dd4 p7_8 dmn4 VDD VSS) NAND2_X1
I145 (dmn4 dm4 VDD VSS) INV_X1
I146 (dd5 p7_8 dmn5 VDD VSS) NAND2_X1
I147 (dmn5 dm5 VDD VSS) INV_X1
I148 (dd6 p7_8 dmn6 VDD VSS) NAND2_X1
I149 (dmn6 dm6 VDD VSS) INV_X1
I150 (dd7 p7_8 dmn7 VDD VSS) NAND2_X1
I151 (dmn7 dm7 VDD VSS) INV_X1
I152 (p7_0 p7_1 p7_2 p7_3 p7_4 p7_5 p7_6 p7_7 dm0 dm1 dm2 dm3 dm4 dm5 dm6 dm7 VSS R_0 ru1 \
    ru2 ru3 ru4 ru5 ru6 ru7 rc6 rc7 VDD VSS) KSA8
I153 (A_7 B_7 sq VDD VSS) XOR2_X1
I154 (sq Q_0 nqkn1 VDD VSS) NAND2_X1
I155 (qu1 nqkn1 Q_1 VDD VSS) XNOR2_X1
I156 (nqkn1 nqk1 VDD VSS) INV_X1
I157 (sq qu1 nqk1 nqkn2 VDD VSS) AOI21_X1
I158 (qu2 nqkn2 Q_2 VDD VSS) XNOR2_X1
I159 (nqkn2 nqk2 VDD VSS) INV_X1
I160 (sq qu2 nqk2 nqkn3 VDD VSS) AOI21_X1
I161 (qu3 nqkn3 Q_3 VDD VSS) XNOR2_X1
I162 (nqkn3 nqk3 VDD VSS) INV_X1
I163 (sq qu3 nqk3 nqkn4 VDD VSS) AOI21_X1
I164 (qu4 nqkn4 Q_4 VDD VSS) XNOR2_X1
I165 (nqkn4 nqk4 VDD VSS) INV_X1
I166 (sq qu4 nqk4 nqkn5 VDD VSS) AOI21_X1
I167 (qu5 nqkn5 Q_5 VDD VSS) XNOR2_X1
I168 (nqkn5 nqk5 VDD VSS) INV_X1
I169 (sq qu5 nqk5 nqkn6 VDD VSS) AOI21_X1
I170 (qu6 nqkn6 Q_6 VDD VSS) XNOR2_X1
I171 (nqkn6 nqk6 VDD VSS) INV_X1
I172 (sq qu6 nqk6 nqkn7 VDD VSS) AOI21_X1
I173 (qu7 nqkn7 Q_7 VDD VSS) XNOR2_X1
I174 (A_7 R_0 nrkn1 VDD VSS) NAND2_X1
I175 (ru1 nrkn1 R_1 VDD VSS) XNOR2_X1
I176 (nrkn1 nrk1 VDD VSS) INV_X1
I177 (A_7 ru1 nrk1 nrkn2 VDD VSS) AOI21_X1
I178 (ru2 nrkn2 R_2 VDD VSS) XNOR2_X1
I179 (nrkn2 nrk2 VDD VSS) INV_X1
I180 (A_7 ru2 nrk2 nrkn3 VDD VSS) AOI21_X1
I181 (ru3 nrkn3 R_3 VDD VSS) XNOR2_X1
I182 (nrkn3 nrk3 VDD VSS) INV_X1
I183 (A_7 ru3 nrk3 nrkn4 VDD VSS) AOI21_X1
I184 (ru4 nrkn4 R_4 VDD VSS) XNOR2_X1
I185 (nrkn4 nrk4 VDD VSS) INV_X1
I186 (A_7 ru4 nrk4 nrkn5 VDD VSS) AOI21_X1
I187 (ru5 nrkn5 R_5 VDD VSS) XNOR2_X1
I188 (nrkn5 nrk5 VDD VSS) INV_X1
I189 (A_7 ru5 nrk5 nrkn6 VDD VSS) AOI21_X1
I190 (ru6 nrkn6 R_6 VDD VSS) XNOR2_X1
I191 (nrkn6 nrk6 VDD VSS) INV_X1
I192 (A_7 ru6 nrk6 nrkn7 VDD VSS) AOI21_X1
I193 (ru7 nrkn7 R_7 VDD VSS) XNOR2_X1
I194 (B_0 B_1 z1_0 VDD VSS) NOR2_X1
I195 (B_2 B_3 z1_1 VDD VSS) NOR2_X1
I196 (B_4 B_5 z1_2 VDD VSS) NOR2_X1
I197 (B_6 B_7 z1_3 VDD VSS) NOR2_X1
I198 (z1_0 z1_1 z2_0 VDD VSS) NAND2_X1
I199 (z1_2 z1_3 z2_1 VDD VSS) NAND2_X1
I200 (z2_0 z2_1 DZ VDD VSS) NOR2_X1
I201 (sq sqn VDD VSS) INV_X1
I202 (Q_7 sqn vn VDD VSS) NAND2_X1
I203 (vn DZ V VDD VSS) NOR2_X1
ends DIV8K
