* DIV8K phang xuong cell la

.SUBCKT AOI21_X1 A1 A2 B Y VDD VSS
MN0 Y A1 n1 VSS nmos1v w=0.24u l=0.1u
MN1 n1 A2 VSS VSS nmos1v w=0.24u l=0.1u
MN2 Y B VSS VSS nmos1v w=0.12u l=0.1u
MP0 p1 A1 VDD VDD pmos1v w=0.48u l=0.1u
MP1 p1 A2 VDD VDD pmos1v w=0.48u l=0.1u
MP2 Y B p1 VDD pmos1v w=0.48u l=0.1u
.ENDS AOI21_X1

.SUBCKT INV_X1 A Y VDD VSS
MN0 Y A VSS VSS nmos1v w=0.12u l=0.1u
MP0 Y A VDD VDD pmos1v w=0.24u l=0.1u
.ENDS INV_X1

.SUBCKT INV_X4 A Y VDD VSS
MN1 Y A VSS VSS nmos1v w=0.48u l=0.1u
MP2 Y A VDD VDD pmos1v w=0.96u l=0.1u
.ENDS INV_X4

.SUBCKT NAND2_X1 A B Y VDD VSS
MN0 Y A n1 VSS nmos1v w=0.24u l=0.1u
MN1 n1 B VSS VSS nmos1v w=0.24u l=0.1u
MP0 Y A VDD VDD pmos1v w=0.24u l=0.1u
MP1 Y B VDD VDD pmos1v w=0.24u l=0.1u
.ENDS NAND2_X1

.SUBCKT NOR2_X1 A B Y VDD VSS
MN0 Y A VSS VSS nmos1v w=0.12u l=0.1u
MN1 Y B VSS VSS nmos1v w=0.12u l=0.1u
MP0 p1 A VDD VDD pmos1v w=0.48u l=0.1u
MP1 Y B p1 VDD pmos1v w=0.48u l=0.1u
.ENDS NOR2_X1

.SUBCKT OAI21_X1 A1 A2 B Y VDD VSS
MN0 Y A1 n1 VSS nmos1v w=0.24u l=0.1u
MN1 Y A2 n1 VSS nmos1v w=0.24u l=0.1u
MN2 n1 B VSS VSS nmos1v w=0.24u l=0.1u
MP0 p1 A1 VDD VDD pmos1v w=0.48u l=0.1u
MP1 Y A2 p1 VDD pmos1v w=0.48u l=0.1u
MP2 Y B VDD VDD pmos1v w=0.24u l=0.1u
.ENDS OAI21_X1

.SUBCKT XNOR2_X1 A B Y VDD VSS
MN0 An A VSS VSS nmos1v w=0.12u l=0.1u
MP0 An A VDD VDD pmos1v w=0.24u l=0.1u
MN1 Bn B VSS VSS nmos1v w=0.12u l=0.1u
MP1 Bn B VDD VDD pmos1v w=0.24u l=0.1u
MN2 Y A n1 VSS nmos1v w=0.24u l=0.1u
MN3 n1 Bn VSS VSS nmos1v w=0.24u l=0.1u
MN4 Y An n2 VSS nmos1v w=0.24u l=0.1u
MN5 n2 B VSS VSS nmos1v w=0.24u l=0.1u
MP2 p1 A VDD VDD pmos1v w=0.48u l=0.1u
MP3 p1 Bn VDD VDD pmos1v w=0.48u l=0.1u
MP4 Y An p1 VDD pmos1v w=0.48u l=0.1u
MP5 Y B p1 VDD pmos1v w=0.48u l=0.1u
.ENDS XNOR2_X1

.SUBCKT XOR2_X1 A B Y VDD VSS
MN0 An A VSS VSS nmos1v w=0.12u l=0.1u
MP0 An A VDD VDD pmos1v w=0.24u l=0.1u
MN1 Bn B VSS VSS nmos1v w=0.12u l=0.1u
MP1 Bn B VDD VDD pmos1v w=0.24u l=0.1u
MN2 Y A n1 VSS nmos1v w=0.24u l=0.1u
MN3 n1 B VSS VSS nmos1v w=0.24u l=0.1u
MN4 Y An n2 VSS nmos1v w=0.24u l=0.1u
MN5 n2 Bn VSS VSS nmos1v w=0.24u l=0.1u
MP2 p1 A VDD VDD pmos1v w=0.48u l=0.1u
MP3 p1 B VDD VDD pmos1v w=0.48u l=0.1u
MP4 Y An p1 VDD pmos1v w=0.48u l=0.1u
MP5 Y Bn p1 VDD pmos1v w=0.48u l=0.1u
.ENDS XOR2_X1

.SUBCKT DIV8K A_0 A_1 A_2 A_3 A_4 A_5 A_6 A_7 B_0 B_1 B_2 B_3 B_4 B_5 B_6 B_7 Q_0 Q_1 Q_2 Q_3 Q_4 Q_5 Q_6 Q_7 R_0 R_1 R_2 R_3 R_4 R_5 R_6 R_7 V DZ VDD VSS
XI0 A_7 A_0 nakn1 VDD VSS NAND2_X1
XI1 A_1 nakn1 aa1 VDD VSS XNOR2_X1
XI2 nakn1 nak1 VDD VSS INV_X1
XI3 A_7 A_1 nak1 nakn2 VDD VSS AOI21_X1
XI4 A_2 nakn2 aa2 VDD VSS XNOR2_X1
XI5 nakn2 nak2 VDD VSS INV_X1
XI6 A_7 A_2 nak2 nakn3 VDD VSS AOI21_X1
XI7 A_3 nakn3 aa3 VDD VSS XNOR2_X1
XI8 nakn3 nak3 VDD VSS INV_X1
XI9 A_7 A_3 nak3 nakn4 VDD VSS AOI21_X1
XI10 A_4 nakn4 aa4 VDD VSS XNOR2_X1
XI11 nakn4 nak4 VDD VSS INV_X1
XI12 A_7 A_4 nak4 nakn5 VDD VSS AOI21_X1
XI13 A_5 nakn5 aa5 VDD VSS XNOR2_X1
XI14 nakn5 nak5 VDD VSS INV_X1
XI15 A_7 A_5 nak5 nakn6 VDD VSS AOI21_X1
XI16 A_6 nakn6 aa6 VDD VSS XNOR2_X1
XI17 nakn6 nak6 VDD VSS INV_X1
XI18 A_7 A_6 nak6 nakn7 VDD VSS AOI21_X1
XI19 A_7 nakn7 aa7 VDD VSS XNOR2_X1
XI20 B_7 B_0 nbkn1 VDD VSS NAND2_X1
XI21 B_1 nbkn1 dd1 VDD VSS XNOR2_X1
XI22 nbkn1 nbk1 VDD VSS INV_X1
XI23 B_7 B_1 nbk1 nbkn2 VDD VSS AOI21_X1
XI24 B_2 nbkn2 dd2 VDD VSS XNOR2_X1
XI25 nbkn2 nbk2 VDD VSS INV_X1
XI26 B_7 B_2 nbk2 nbkn3 VDD VSS AOI21_X1
XI27 B_3 nbkn3 dd3 VDD VSS XNOR2_X1
XI28 nbkn3 nbk3 VDD VSS INV_X1
XI29 B_7 B_3 nbk3 nbkn4 VDD VSS AOI21_X1
XI30 B_4 nbkn4 dd4 VDD VSS XNOR2_X1
XI31 nbkn4 nbk4 VDD VSS INV_X1
XI32 B_7 B_4 nbk4 nbkn5 VDD VSS AOI21_X1
XI33 B_5 nbkn5 dd5 VDD VSS XNOR2_X1
XI34 nbkn5 nbk5 VDD VSS INV_X1
XI35 B_7 B_5 nbk5 nbkn6 VDD VSS AOI21_X1
XI36 B_6 nbkn6 dd6 VDD VSS XNOR2_X1
XI37 nbkn6 nbk6 VDD VSS INV_X1
XI38 B_7 B_6 nbk6 nbkn7 VDD VSS AOI21_X1
XI39 B_7 nbkn7 dd7 VDD VSS XNOR2_X1
XI40 B_0 VDD b0_0 VDD VSS XOR2_X1
XI41 dd1 VDD b0_1 VDD VSS XOR2_X1
XI42 dd2 VDD b0_2 VDD VSS XOR2_X1
XI43 dd3 VDD b0_3 VDD VSS XOR2_X1
XI44 dd4 VDD b0_4 VDD VSS XOR2_X1
XI45 dd5 VDD b0_5 VDD VSS XOR2_X1
XI46 dd6 VDD b0_6 VDD VSS XOR2_X1
XI47 dd7 VDD b0_7 VDD VSS XOR2_X1
XI48_I0 aa7 b0_0 I48_gn0 VDD VSS NAND2_X1
XI48_I1 VSS b0_1 I48_gn1 VDD VSS NAND2_X1
XI48_I2 VSS b0_2 I48_gn2 VDD VSS NAND2_X1
XI48_I3 VSS b0_3 I48_gn3 VDD VSS NAND2_X1
XI48_I4 VSS b0_4 I48_gn4 VDD VSS NAND2_X1
XI48_I5 VSS b0_5 I48_gn5 VDD VSS NAND2_X1
XI48_I6 VSS b0_6 I48_gn6 VDD VSS NAND2_X1
XI48_I7 VSS b0_7 I48_gn7 VDD VSS NAND2_X1
XI48_I8 aa7 b0_0 I48_pn0 VDD VSS XNOR2_X1
XI48_I9 VSS b0_1 I48_pn1 VDD VSS XNOR2_X1
XI48_I10 VSS b0_2 I48_pn2 VDD VSS XNOR2_X1
XI48_I11 VSS b0_3 I48_pn3 VDD VSS XNOR2_X1
XI48_I12 VSS b0_4 I48_pn4 VDD VSS XNOR2_X1
XI48_I13 VSS b0_5 I48_pn5 VDD VSS XNOR2_X1
XI48_I14 VSS b0_6 I48_pn6 VDD VSS XNOR2_X1
XI48_I15 VSS b0_7 I48_pn7 VDD VSS XNOR2_X1
XI48_I16 VDD I48_cinn VDD VSS INV_X1
XI48_I17_XG I48_pn0 I48_cinn I48_gn0 I48_G0_0 VDD VSS OAI21_X1
XI48_I18 I48_G0_0 I48_G0_0n VDD VSS INV_X1
XI48_I19_XG I48_pn1 I48_G0_0n I48_gn1 I48_G1_0 VDD VSS OAI21_X1
XI48_I20_XG I48_pn2 I48_gn1 I48_gn2 I48_G2_1 VDD VSS OAI21_X1
XI48_I20_XP I48_pn2 I48_pn1 I48_P2_1 VDD VSS NOR2_X1
XI48_I21_XG I48_pn3 I48_gn2 I48_gn3 I48_G3_2 VDD VSS OAI21_X1
XI48_I21_XP I48_pn3 I48_pn2 I48_P3_2 VDD VSS NOR2_X1
XI48_I22_XG I48_pn4 I48_gn3 I48_gn4 I48_G4_3 VDD VSS OAI21_X1
XI48_I22_XP I48_pn4 I48_pn3 I48_P4_3 VDD VSS NOR2_X1
XI48_I23_XG I48_pn5 I48_gn4 I48_gn5 I48_G5_4 VDD VSS OAI21_X1
XI48_I23_XP I48_pn5 I48_pn4 I48_P5_4 VDD VSS NOR2_X1
XI48_I24_XG I48_pn6 I48_gn5 I48_gn6 I48_G6_5 VDD VSS OAI21_X1
XI48_I24_XP I48_pn6 I48_pn5 I48_P6_5 VDD VSS NOR2_X1
XI48_I25_XG I48_pn7 I48_gn6 I48_gn7 I48_G7_6 VDD VSS OAI21_X1
XI48_I25_XP I48_pn7 I48_pn6 I48_P7_6 VDD VSS NOR2_X1
XI48_I26_XG I48_P2_1 I48_G0_0 I48_G2_1 I48_G2_0n VDD VSS AOI21_X1
XI48_I27_XG I48_P3_2 I48_G1_0 I48_G3_2 I48_G3_0n VDD VSS AOI21_X1
XI48_I28_XG I48_P4_3 I48_G2_1 I48_G4_3 I48_G4_1n VDD VSS AOI21_X1
XI48_I28_XP I48_P4_3 I48_P2_1 I48_P4_1n VDD VSS NAND2_X1
XI48_I29_XG I48_P5_4 I48_G3_2 I48_G5_4 I48_G5_2n VDD VSS AOI21_X1
XI48_I29_XP I48_P5_4 I48_P3_2 I48_P5_2n VDD VSS NAND2_X1
XI48_I30_XG I48_P6_5 I48_G4_3 I48_G6_5 I48_G6_3n VDD VSS AOI21_X1
XI48_I30_XP I48_P6_5 I48_P4_3 I48_P6_3n VDD VSS NAND2_X1
XI48_I31_XG I48_P7_6 I48_G5_4 I48_G7_6 I48_G7_4n VDD VSS AOI21_X1
XI48_I31_XP I48_P7_6 I48_P5_4 I48_P7_4n VDD VSS NAND2_X1
XI48_I32_XG I48_P4_1n I48_G0_0n I48_G4_1n I48_G4_0 VDD VSS OAI21_X1
XI48_I33 I48_G1_0 I48_G1_0n VDD VSS INV_X1
XI48_I34_XG I48_P5_2n I48_G1_0n I48_G5_2n I48_G5_0 VDD VSS OAI21_X1
XI48_I35_XG I48_P6_3n I48_G2_0n I48_G6_3n c0_7 VDD VSS OAI21_X1
XI48_I36_XG I48_P7_4n I48_G3_0n I48_G7_4n c0_8 VDD VSS OAI21_X1
XI48_I37 I48_pn0 VDD p0_0 VDD VSS XNOR2_X1
XI48_I38 I48_pn1 I48_G0_0 p0_1 VDD VSS XNOR2_X1
XI48_I39 I48_pn2 I48_G1_0 p0_2 VDD VSS XNOR2_X1
XI48_I40 I48_pn3 I48_G2_0n p0_3 VDD VSS XOR2_X1
XI48_I41 I48_pn4 I48_G3_0n p0_4 VDD VSS XOR2_X1
XI48_I42 I48_pn5 I48_G4_0 p0_5 VDD VSS XNOR2_X1
XI48_I43 I48_pn6 I48_G5_0 p0_6 VDD VSS XNOR2_X1
XI48_I44 I48_pn7 c0_7 p0_7 VDD VSS XNOR2_X1
XI49 VSS VDD h0 VDD VSS XOR2_X1
XI50 h0 c0_8 p0_8 VDD VSS XOR2_X1
XI51 p0_8 qu7 VDD VSS INV_X4
XI52 B_0 qu7 b1_0 VDD VSS XOR2_X1
XI53 dd1 qu7 b1_1 VDD VSS XOR2_X1
XI54 dd2 qu7 b1_2 VDD VSS XOR2_X1
XI55 dd3 qu7 b1_3 VDD VSS XOR2_X1
XI56 dd4 qu7 b1_4 VDD VSS XOR2_X1
XI57 dd5 qu7 b1_5 VDD VSS XOR2_X1
XI58 dd6 qu7 b1_6 VDD VSS XOR2_X1
XI59 dd7 qu7 b1_7 VDD VSS XOR2_X1
XI60_I0 aa6 b1_0 I60_gn0 VDD VSS NAND2_X1
XI60_I1 p0_0 b1_1 I60_gn1 VDD VSS NAND2_X1
XI60_I2 p0_1 b1_2 I60_gn2 VDD VSS NAND2_X1
XI60_I3 p0_2 b1_3 I60_gn3 VDD VSS NAND2_X1
XI60_I4 p0_3 b1_4 I60_gn4 VDD VSS NAND2_X1
XI60_I5 p0_4 b1_5 I60_gn5 VDD VSS NAND2_X1
XI60_I6 p0_5 b1_6 I60_gn6 VDD VSS NAND2_X1
XI60_I7 p0_6 b1_7 I60_gn7 VDD VSS NAND2_X1
XI60_I8 aa6 b1_0 I60_pn0 VDD VSS XNOR2_X1
XI60_I9 p0_0 b1_1 I60_pn1 VDD VSS XNOR2_X1
XI60_I10 p0_1 b1_2 I60_pn2 VDD VSS XNOR2_X1
XI60_I11 p0_2 b1_3 I60_pn3 VDD VSS XNOR2_X1
XI60_I12 p0_3 b1_4 I60_pn4 VDD VSS XNOR2_X1
XI60_I13 p0_4 b1_5 I60_pn5 VDD VSS XNOR2_X1
XI60_I14 p0_5 b1_6 I60_pn6 VDD VSS XNOR2_X1
XI60_I15 p0_6 b1_7 I60_pn7 VDD VSS XNOR2_X1
XI60_I16 qu7 I60_cinn VDD VSS INV_X1
XI60_I17_XG I60_pn0 I60_cinn I60_gn0 I60_G0_0 VDD VSS OAI21_X1
XI60_I18 I60_G0_0 I60_G0_0n VDD VSS INV_X1
XI60_I19_XG I60_pn1 I60_G0_0n I60_gn1 I60_G1_0 VDD VSS OAI21_X1
XI60_I20_XG I60_pn2 I60_gn1 I60_gn2 I60_G2_1 VDD VSS OAI21_X1
XI60_I20_XP I60_pn2 I60_pn1 I60_P2_1 VDD VSS NOR2_X1
XI60_I21_XG I60_pn3 I60_gn2 I60_gn3 I60_G3_2 VDD VSS OAI21_X1
XI60_I21_XP I60_pn3 I60_pn2 I60_P3_2 VDD VSS NOR2_X1
XI60_I22_XG I60_pn4 I60_gn3 I60_gn4 I60_G4_3 VDD VSS OAI21_X1
XI60_I22_XP I60_pn4 I60_pn3 I60_P4_3 VDD VSS NOR2_X1
XI60_I23_XG I60_pn5 I60_gn4 I60_gn5 I60_G5_4 VDD VSS OAI21_X1
XI60_I23_XP I60_pn5 I60_pn4 I60_P5_4 VDD VSS NOR2_X1
XI60_I24_XG I60_pn6 I60_gn5 I60_gn6 I60_G6_5 VDD VSS OAI21_X1
XI60_I24_XP I60_pn6 I60_pn5 I60_P6_5 VDD VSS NOR2_X1
XI60_I25_XG I60_pn7 I60_gn6 I60_gn7 I60_G7_6 VDD VSS OAI21_X1
XI60_I25_XP I60_pn7 I60_pn6 I60_P7_6 VDD VSS NOR2_X1
XI60_I26_XG I60_P2_1 I60_G0_0 I60_G2_1 I60_G2_0n VDD VSS AOI21_X1
XI60_I27_XG I60_P3_2 I60_G1_0 I60_G3_2 I60_G3_0n VDD VSS AOI21_X1
XI60_I28_XG I60_P4_3 I60_G2_1 I60_G4_3 I60_G4_1n VDD VSS AOI21_X1
XI60_I28_XP I60_P4_3 I60_P2_1 I60_P4_1n VDD VSS NAND2_X1
XI60_I29_XG I60_P5_4 I60_G3_2 I60_G5_4 I60_G5_2n VDD VSS AOI21_X1
XI60_I29_XP I60_P5_4 I60_P3_2 I60_P5_2n VDD VSS NAND2_X1
XI60_I30_XG I60_P6_5 I60_G4_3 I60_G6_5 I60_G6_3n VDD VSS AOI21_X1
XI60_I30_XP I60_P6_5 I60_P4_3 I60_P6_3n VDD VSS NAND2_X1
XI60_I31_XG I60_P7_6 I60_G5_4 I60_G7_6 I60_G7_4n VDD VSS AOI21_X1
XI60_I31_XP I60_P7_6 I60_P5_4 I60_P7_4n VDD VSS NAND2_X1
XI60_I32_XG I60_P4_1n I60_G0_0n I60_G4_1n I60_G4_0 VDD VSS OAI21_X1
XI60_I33 I60_G1_0 I60_G1_0n VDD VSS INV_X1
XI60_I34_XG I60_P5_2n I60_G1_0n I60_G5_2n I60_G5_0 VDD VSS OAI21_X1
XI60_I35_XG I60_P6_3n I60_G2_0n I60_G6_3n c1_7 VDD VSS OAI21_X1
XI60_I36_XG I60_P7_4n I60_G3_0n I60_G7_4n c1_8 VDD VSS OAI21_X1
XI60_I37 I60_pn0 qu7 p1_0 VDD VSS XNOR2_X1
XI60_I38 I60_pn1 I60_G0_0 p1_1 VDD VSS XNOR2_X1
XI60_I39 I60_pn2 I60_G1_0 p1_2 VDD VSS XNOR2_X1
XI60_I40 I60_pn3 I60_G2_0n p1_3 VDD VSS XOR2_X1
XI60_I41 I60_pn4 I60_G3_0n p1_4 VDD VSS XOR2_X1
XI60_I42 I60_pn5 I60_G4_0 p1_5 VDD VSS XNOR2_X1
XI60_I43 I60_pn6 I60_G5_0 p1_6 VDD VSS XNOR2_X1
XI60_I44 I60_pn7 c1_7 p1_7 VDD VSS XNOR2_X1
XI61 p0_7 qu7 h1 VDD VSS XOR2_X1
XI62 h1 c1_8 p1_8 VDD VSS XOR2_X1
XI63 p1_8 qu6 VDD VSS INV_X4
XI64 B_0 qu6 b2_0 VDD VSS XOR2_X1
XI65 dd1 qu6 b2_1 VDD VSS XOR2_X1
XI66 dd2 qu6 b2_2 VDD VSS XOR2_X1
XI67 dd3 qu6 b2_3 VDD VSS XOR2_X1
XI68 dd4 qu6 b2_4 VDD VSS XOR2_X1
XI69 dd5 qu6 b2_5 VDD VSS XOR2_X1
XI70 dd6 qu6 b2_6 VDD VSS XOR2_X1
XI71 dd7 qu6 b2_7 VDD VSS XOR2_X1
XI72_I0 aa5 b2_0 I72_gn0 VDD VSS NAND2_X1
XI72_I1 p1_0 b2_1 I72_gn1 VDD VSS NAND2_X1
XI72_I2 p1_1 b2_2 I72_gn2 VDD VSS NAND2_X1
XI72_I3 p1_2 b2_3 I72_gn3 VDD VSS NAND2_X1
XI72_I4 p1_3 b2_4 I72_gn4 VDD VSS NAND2_X1
XI72_I5 p1_4 b2_5 I72_gn5 VDD VSS NAND2_X1
XI72_I6 p1_5 b2_6 I72_gn6 VDD VSS NAND2_X1
XI72_I7 p1_6 b2_7 I72_gn7 VDD VSS NAND2_X1
XI72_I8 aa5 b2_0 I72_pn0 VDD VSS XNOR2_X1
XI72_I9 p1_0 b2_1 I72_pn1 VDD VSS XNOR2_X1
XI72_I10 p1_1 b2_2 I72_pn2 VDD VSS XNOR2_X1
XI72_I11 p1_2 b2_3 I72_pn3 VDD VSS XNOR2_X1
XI72_I12 p1_3 b2_4 I72_pn4 VDD VSS XNOR2_X1
XI72_I13 p1_4 b2_5 I72_pn5 VDD VSS XNOR2_X1
XI72_I14 p1_5 b2_6 I72_pn6 VDD VSS XNOR2_X1
XI72_I15 p1_6 b2_7 I72_pn7 VDD VSS XNOR2_X1
XI72_I16 qu6 I72_cinn VDD VSS INV_X1
XI72_I17_XG I72_pn0 I72_cinn I72_gn0 I72_G0_0 VDD VSS OAI21_X1
XI72_I18 I72_G0_0 I72_G0_0n VDD VSS INV_X1
XI72_I19_XG I72_pn1 I72_G0_0n I72_gn1 I72_G1_0 VDD VSS OAI21_X1
XI72_I20_XG I72_pn2 I72_gn1 I72_gn2 I72_G2_1 VDD VSS OAI21_X1
XI72_I20_XP I72_pn2 I72_pn1 I72_P2_1 VDD VSS NOR2_X1
XI72_I21_XG I72_pn3 I72_gn2 I72_gn3 I72_G3_2 VDD VSS OAI21_X1
XI72_I21_XP I72_pn3 I72_pn2 I72_P3_2 VDD VSS NOR2_X1
XI72_I22_XG I72_pn4 I72_gn3 I72_gn4 I72_G4_3 VDD VSS OAI21_X1
XI72_I22_XP I72_pn4 I72_pn3 I72_P4_3 VDD VSS NOR2_X1
XI72_I23_XG I72_pn5 I72_gn4 I72_gn5 I72_G5_4 VDD VSS OAI21_X1
XI72_I23_XP I72_pn5 I72_pn4 I72_P5_4 VDD VSS NOR2_X1
XI72_I24_XG I72_pn6 I72_gn5 I72_gn6 I72_G6_5 VDD VSS OAI21_X1
XI72_I24_XP I72_pn6 I72_pn5 I72_P6_5 VDD VSS NOR2_X1
XI72_I25_XG I72_pn7 I72_gn6 I72_gn7 I72_G7_6 VDD VSS OAI21_X1
XI72_I25_XP I72_pn7 I72_pn6 I72_P7_6 VDD VSS NOR2_X1
XI72_I26_XG I72_P2_1 I72_G0_0 I72_G2_1 I72_G2_0n VDD VSS AOI21_X1
XI72_I27_XG I72_P3_2 I72_G1_0 I72_G3_2 I72_G3_0n VDD VSS AOI21_X1
XI72_I28_XG I72_P4_3 I72_G2_1 I72_G4_3 I72_G4_1n VDD VSS AOI21_X1
XI72_I28_XP I72_P4_3 I72_P2_1 I72_P4_1n VDD VSS NAND2_X1
XI72_I29_XG I72_P5_4 I72_G3_2 I72_G5_4 I72_G5_2n VDD VSS AOI21_X1
XI72_I29_XP I72_P5_4 I72_P3_2 I72_P5_2n VDD VSS NAND2_X1
XI72_I30_XG I72_P6_5 I72_G4_3 I72_G6_5 I72_G6_3n VDD VSS AOI21_X1
XI72_I30_XP I72_P6_5 I72_P4_3 I72_P6_3n VDD VSS NAND2_X1
XI72_I31_XG I72_P7_6 I72_G5_4 I72_G7_6 I72_G7_4n VDD VSS AOI21_X1
XI72_I31_XP I72_P7_6 I72_P5_4 I72_P7_4n VDD VSS NAND2_X1
XI72_I32_XG I72_P4_1n I72_G0_0n I72_G4_1n I72_G4_0 VDD VSS OAI21_X1
XI72_I33 I72_G1_0 I72_G1_0n VDD VSS INV_X1
XI72_I34_XG I72_P5_2n I72_G1_0n I72_G5_2n I72_G5_0 VDD VSS OAI21_X1
XI72_I35_XG I72_P6_3n I72_G2_0n I72_G6_3n c2_7 VDD VSS OAI21_X1
XI72_I36_XG I72_P7_4n I72_G3_0n I72_G7_4n c2_8 VDD VSS OAI21_X1
XI72_I37 I72_pn0 qu6 p2_0 VDD VSS XNOR2_X1
XI72_I38 I72_pn1 I72_G0_0 p2_1 VDD VSS XNOR2_X1
XI72_I39 I72_pn2 I72_G1_0 p2_2 VDD VSS XNOR2_X1
XI72_I40 I72_pn3 I72_G2_0n p2_3 VDD VSS XOR2_X1
XI72_I41 I72_pn4 I72_G3_0n p2_4 VDD VSS XOR2_X1
XI72_I42 I72_pn5 I72_G4_0 p2_5 VDD VSS XNOR2_X1
XI72_I43 I72_pn6 I72_G5_0 p2_6 VDD VSS XNOR2_X1
XI72_I44 I72_pn7 c2_7 p2_7 VDD VSS XNOR2_X1
XI73 p1_7 qu6 h2 VDD VSS XOR2_X1
XI74 h2 c2_8 p2_8 VDD VSS XOR2_X1
XI75 p2_8 qu5 VDD VSS INV_X4
XI76 B_0 qu5 b3_0 VDD VSS XOR2_X1
XI77 dd1 qu5 b3_1 VDD VSS XOR2_X1
XI78 dd2 qu5 b3_2 VDD VSS XOR2_X1
XI79 dd3 qu5 b3_3 VDD VSS XOR2_X1
XI80 dd4 qu5 b3_4 VDD VSS XOR2_X1
XI81 dd5 qu5 b3_5 VDD VSS XOR2_X1
XI82 dd6 qu5 b3_6 VDD VSS XOR2_X1
XI83 dd7 qu5 b3_7 VDD VSS XOR2_X1
XI84_I0 aa4 b3_0 I84_gn0 VDD VSS NAND2_X1
XI84_I1 p2_0 b3_1 I84_gn1 VDD VSS NAND2_X1
XI84_I2 p2_1 b3_2 I84_gn2 VDD VSS NAND2_X1
XI84_I3 p2_2 b3_3 I84_gn3 VDD VSS NAND2_X1
XI84_I4 p2_3 b3_4 I84_gn4 VDD VSS NAND2_X1
XI84_I5 p2_4 b3_5 I84_gn5 VDD VSS NAND2_X1
XI84_I6 p2_5 b3_6 I84_gn6 VDD VSS NAND2_X1
XI84_I7 p2_6 b3_7 I84_gn7 VDD VSS NAND2_X1
XI84_I8 aa4 b3_0 I84_pn0 VDD VSS XNOR2_X1
XI84_I9 p2_0 b3_1 I84_pn1 VDD VSS XNOR2_X1
XI84_I10 p2_1 b3_2 I84_pn2 VDD VSS XNOR2_X1
XI84_I11 p2_2 b3_3 I84_pn3 VDD VSS XNOR2_X1
XI84_I12 p2_3 b3_4 I84_pn4 VDD VSS XNOR2_X1
XI84_I13 p2_4 b3_5 I84_pn5 VDD VSS XNOR2_X1
XI84_I14 p2_5 b3_6 I84_pn6 VDD VSS XNOR2_X1
XI84_I15 p2_6 b3_7 I84_pn7 VDD VSS XNOR2_X1
XI84_I16 qu5 I84_cinn VDD VSS INV_X1
XI84_I17_XG I84_pn0 I84_cinn I84_gn0 I84_G0_0 VDD VSS OAI21_X1
XI84_I18 I84_G0_0 I84_G0_0n VDD VSS INV_X1
XI84_I19_XG I84_pn1 I84_G0_0n I84_gn1 I84_G1_0 VDD VSS OAI21_X1
XI84_I20_XG I84_pn2 I84_gn1 I84_gn2 I84_G2_1 VDD VSS OAI21_X1
XI84_I20_XP I84_pn2 I84_pn1 I84_P2_1 VDD VSS NOR2_X1
XI84_I21_XG I84_pn3 I84_gn2 I84_gn3 I84_G3_2 VDD VSS OAI21_X1
XI84_I21_XP I84_pn3 I84_pn2 I84_P3_2 VDD VSS NOR2_X1
XI84_I22_XG I84_pn4 I84_gn3 I84_gn4 I84_G4_3 VDD VSS OAI21_X1
XI84_I22_XP I84_pn4 I84_pn3 I84_P4_3 VDD VSS NOR2_X1
XI84_I23_XG I84_pn5 I84_gn4 I84_gn5 I84_G5_4 VDD VSS OAI21_X1
XI84_I23_XP I84_pn5 I84_pn4 I84_P5_4 VDD VSS NOR2_X1
XI84_I24_XG I84_pn6 I84_gn5 I84_gn6 I84_G6_5 VDD VSS OAI21_X1
XI84_I24_XP I84_pn6 I84_pn5 I84_P6_5 VDD VSS NOR2_X1
XI84_I25_XG I84_pn7 I84_gn6 I84_gn7 I84_G7_6 VDD VSS OAI21_X1
XI84_I25_XP I84_pn7 I84_pn6 I84_P7_6 VDD VSS NOR2_X1
XI84_I26_XG I84_P2_1 I84_G0_0 I84_G2_1 I84_G2_0n VDD VSS AOI21_X1
XI84_I27_XG I84_P3_2 I84_G1_0 I84_G3_2 I84_G3_0n VDD VSS AOI21_X1
XI84_I28_XG I84_P4_3 I84_G2_1 I84_G4_3 I84_G4_1n VDD VSS AOI21_X1
XI84_I28_XP I84_P4_3 I84_P2_1 I84_P4_1n VDD VSS NAND2_X1
XI84_I29_XG I84_P5_4 I84_G3_2 I84_G5_4 I84_G5_2n VDD VSS AOI21_X1
XI84_I29_XP I84_P5_4 I84_P3_2 I84_P5_2n VDD VSS NAND2_X1
XI84_I30_XG I84_P6_5 I84_G4_3 I84_G6_5 I84_G6_3n VDD VSS AOI21_X1
XI84_I30_XP I84_P6_5 I84_P4_3 I84_P6_3n VDD VSS NAND2_X1
XI84_I31_XG I84_P7_6 I84_G5_4 I84_G7_6 I84_G7_4n VDD VSS AOI21_X1
XI84_I31_XP I84_P7_6 I84_P5_4 I84_P7_4n VDD VSS NAND2_X1
XI84_I32_XG I84_P4_1n I84_G0_0n I84_G4_1n I84_G4_0 VDD VSS OAI21_X1
XI84_I33 I84_G1_0 I84_G1_0n VDD VSS INV_X1
XI84_I34_XG I84_P5_2n I84_G1_0n I84_G5_2n I84_G5_0 VDD VSS OAI21_X1
XI84_I35_XG I84_P6_3n I84_G2_0n I84_G6_3n c3_7 VDD VSS OAI21_X1
XI84_I36_XG I84_P7_4n I84_G3_0n I84_G7_4n c3_8 VDD VSS OAI21_X1
XI84_I37 I84_pn0 qu5 p3_0 VDD VSS XNOR2_X1
XI84_I38 I84_pn1 I84_G0_0 p3_1 VDD VSS XNOR2_X1
XI84_I39 I84_pn2 I84_G1_0 p3_2 VDD VSS XNOR2_X1
XI84_I40 I84_pn3 I84_G2_0n p3_3 VDD VSS XOR2_X1
XI84_I41 I84_pn4 I84_G3_0n p3_4 VDD VSS XOR2_X1
XI84_I42 I84_pn5 I84_G4_0 p3_5 VDD VSS XNOR2_X1
XI84_I43 I84_pn6 I84_G5_0 p3_6 VDD VSS XNOR2_X1
XI84_I44 I84_pn7 c3_7 p3_7 VDD VSS XNOR2_X1
XI85 p2_7 qu5 h3 VDD VSS XOR2_X1
XI86 h3 c3_8 p3_8 VDD VSS XOR2_X1
XI87 p3_8 qu4 VDD VSS INV_X4
XI88 B_0 qu4 b4_0 VDD VSS XOR2_X1
XI89 dd1 qu4 b4_1 VDD VSS XOR2_X1
XI90 dd2 qu4 b4_2 VDD VSS XOR2_X1
XI91 dd3 qu4 b4_3 VDD VSS XOR2_X1
XI92 dd4 qu4 b4_4 VDD VSS XOR2_X1
XI93 dd5 qu4 b4_5 VDD VSS XOR2_X1
XI94 dd6 qu4 b4_6 VDD VSS XOR2_X1
XI95 dd7 qu4 b4_7 VDD VSS XOR2_X1
XI96_I0 aa3 b4_0 I96_gn0 VDD VSS NAND2_X1
XI96_I1 p3_0 b4_1 I96_gn1 VDD VSS NAND2_X1
XI96_I2 p3_1 b4_2 I96_gn2 VDD VSS NAND2_X1
XI96_I3 p3_2 b4_3 I96_gn3 VDD VSS NAND2_X1
XI96_I4 p3_3 b4_4 I96_gn4 VDD VSS NAND2_X1
XI96_I5 p3_4 b4_5 I96_gn5 VDD VSS NAND2_X1
XI96_I6 p3_5 b4_6 I96_gn6 VDD VSS NAND2_X1
XI96_I7 p3_6 b4_7 I96_gn7 VDD VSS NAND2_X1
XI96_I8 aa3 b4_0 I96_pn0 VDD VSS XNOR2_X1
XI96_I9 p3_0 b4_1 I96_pn1 VDD VSS XNOR2_X1
XI96_I10 p3_1 b4_2 I96_pn2 VDD VSS XNOR2_X1
XI96_I11 p3_2 b4_3 I96_pn3 VDD VSS XNOR2_X1
XI96_I12 p3_3 b4_4 I96_pn4 VDD VSS XNOR2_X1
XI96_I13 p3_4 b4_5 I96_pn5 VDD VSS XNOR2_X1
XI96_I14 p3_5 b4_6 I96_pn6 VDD VSS XNOR2_X1
XI96_I15 p3_6 b4_7 I96_pn7 VDD VSS XNOR2_X1
XI96_I16 qu4 I96_cinn VDD VSS INV_X1
XI96_I17_XG I96_pn0 I96_cinn I96_gn0 I96_G0_0 VDD VSS OAI21_X1
XI96_I18 I96_G0_0 I96_G0_0n VDD VSS INV_X1
XI96_I19_XG I96_pn1 I96_G0_0n I96_gn1 I96_G1_0 VDD VSS OAI21_X1
XI96_I20_XG I96_pn2 I96_gn1 I96_gn2 I96_G2_1 VDD VSS OAI21_X1
XI96_I20_XP I96_pn2 I96_pn1 I96_P2_1 VDD VSS NOR2_X1
XI96_I21_XG I96_pn3 I96_gn2 I96_gn3 I96_G3_2 VDD VSS OAI21_X1
XI96_I21_XP I96_pn3 I96_pn2 I96_P3_2 VDD VSS NOR2_X1
XI96_I22_XG I96_pn4 I96_gn3 I96_gn4 I96_G4_3 VDD VSS OAI21_X1
XI96_I22_XP I96_pn4 I96_pn3 I96_P4_3 VDD VSS NOR2_X1
XI96_I23_XG I96_pn5 I96_gn4 I96_gn5 I96_G5_4 VDD VSS OAI21_X1
XI96_I23_XP I96_pn5 I96_pn4 I96_P5_4 VDD VSS NOR2_X1
XI96_I24_XG I96_pn6 I96_gn5 I96_gn6 I96_G6_5 VDD VSS OAI21_X1
XI96_I24_XP I96_pn6 I96_pn5 I96_P6_5 VDD VSS NOR2_X1
XI96_I25_XG I96_pn7 I96_gn6 I96_gn7 I96_G7_6 VDD VSS OAI21_X1
XI96_I25_XP I96_pn7 I96_pn6 I96_P7_6 VDD VSS NOR2_X1
XI96_I26_XG I96_P2_1 I96_G0_0 I96_G2_1 I96_G2_0n VDD VSS AOI21_X1
XI96_I27_XG I96_P3_2 I96_G1_0 I96_G3_2 I96_G3_0n VDD VSS AOI21_X1
XI96_I28_XG I96_P4_3 I96_G2_1 I96_G4_3 I96_G4_1n VDD VSS AOI21_X1
XI96_I28_XP I96_P4_3 I96_P2_1 I96_P4_1n VDD VSS NAND2_X1
XI96_I29_XG I96_P5_4 I96_G3_2 I96_G5_4 I96_G5_2n VDD VSS AOI21_X1
XI96_I29_XP I96_P5_4 I96_P3_2 I96_P5_2n VDD VSS NAND2_X1
XI96_I30_XG I96_P6_5 I96_G4_3 I96_G6_5 I96_G6_3n VDD VSS AOI21_X1
XI96_I30_XP I96_P6_5 I96_P4_3 I96_P6_3n VDD VSS NAND2_X1
XI96_I31_XG I96_P7_6 I96_G5_4 I96_G7_6 I96_G7_4n VDD VSS AOI21_X1
XI96_I31_XP I96_P7_6 I96_P5_4 I96_P7_4n VDD VSS NAND2_X1
XI96_I32_XG I96_P4_1n I96_G0_0n I96_G4_1n I96_G4_0 VDD VSS OAI21_X1
XI96_I33 I96_G1_0 I96_G1_0n VDD VSS INV_X1
XI96_I34_XG I96_P5_2n I96_G1_0n I96_G5_2n I96_G5_0 VDD VSS OAI21_X1
XI96_I35_XG I96_P6_3n I96_G2_0n I96_G6_3n c4_7 VDD VSS OAI21_X1
XI96_I36_XG I96_P7_4n I96_G3_0n I96_G7_4n c4_8 VDD VSS OAI21_X1
XI96_I37 I96_pn0 qu4 p4_0 VDD VSS XNOR2_X1
XI96_I38 I96_pn1 I96_G0_0 p4_1 VDD VSS XNOR2_X1
XI96_I39 I96_pn2 I96_G1_0 p4_2 VDD VSS XNOR2_X1
XI96_I40 I96_pn3 I96_G2_0n p4_3 VDD VSS XOR2_X1
XI96_I41 I96_pn4 I96_G3_0n p4_4 VDD VSS XOR2_X1
XI96_I42 I96_pn5 I96_G4_0 p4_5 VDD VSS XNOR2_X1
XI96_I43 I96_pn6 I96_G5_0 p4_6 VDD VSS XNOR2_X1
XI96_I44 I96_pn7 c4_7 p4_7 VDD VSS XNOR2_X1
XI97 p3_7 qu4 h4 VDD VSS XOR2_X1
XI98 h4 c4_8 p4_8 VDD VSS XOR2_X1
XI99 p4_8 qu3 VDD VSS INV_X4
XI100 B_0 qu3 b5_0 VDD VSS XOR2_X1
XI101 dd1 qu3 b5_1 VDD VSS XOR2_X1
XI102 dd2 qu3 b5_2 VDD VSS XOR2_X1
XI103 dd3 qu3 b5_3 VDD VSS XOR2_X1
XI104 dd4 qu3 b5_4 VDD VSS XOR2_X1
XI105 dd5 qu3 b5_5 VDD VSS XOR2_X1
XI106 dd6 qu3 b5_6 VDD VSS XOR2_X1
XI107 dd7 qu3 b5_7 VDD VSS XOR2_X1
XI108_I0 aa2 b5_0 I108_gn0 VDD VSS NAND2_X1
XI108_I1 p4_0 b5_1 I108_gn1 VDD VSS NAND2_X1
XI108_I2 p4_1 b5_2 I108_gn2 VDD VSS NAND2_X1
XI108_I3 p4_2 b5_3 I108_gn3 VDD VSS NAND2_X1
XI108_I4 p4_3 b5_4 I108_gn4 VDD VSS NAND2_X1
XI108_I5 p4_4 b5_5 I108_gn5 VDD VSS NAND2_X1
XI108_I6 p4_5 b5_6 I108_gn6 VDD VSS NAND2_X1
XI108_I7 p4_6 b5_7 I108_gn7 VDD VSS NAND2_X1
XI108_I8 aa2 b5_0 I108_pn0 VDD VSS XNOR2_X1
XI108_I9 p4_0 b5_1 I108_pn1 VDD VSS XNOR2_X1
XI108_I10 p4_1 b5_2 I108_pn2 VDD VSS XNOR2_X1
XI108_I11 p4_2 b5_3 I108_pn3 VDD VSS XNOR2_X1
XI108_I12 p4_3 b5_4 I108_pn4 VDD VSS XNOR2_X1
XI108_I13 p4_4 b5_5 I108_pn5 VDD VSS XNOR2_X1
XI108_I14 p4_5 b5_6 I108_pn6 VDD VSS XNOR2_X1
XI108_I15 p4_6 b5_7 I108_pn7 VDD VSS XNOR2_X1
XI108_I16 qu3 I108_cinn VDD VSS INV_X1
XI108_I17_XG I108_pn0 I108_cinn I108_gn0 I108_G0_0 VDD VSS OAI21_X1
XI108_I18 I108_G0_0 I108_G0_0n VDD VSS INV_X1
XI108_I19_XG I108_pn1 I108_G0_0n I108_gn1 I108_G1_0 VDD VSS OAI21_X1
XI108_I20_XG I108_pn2 I108_gn1 I108_gn2 I108_G2_1 VDD VSS OAI21_X1
XI108_I20_XP I108_pn2 I108_pn1 I108_P2_1 VDD VSS NOR2_X1
XI108_I21_XG I108_pn3 I108_gn2 I108_gn3 I108_G3_2 VDD VSS OAI21_X1
XI108_I21_XP I108_pn3 I108_pn2 I108_P3_2 VDD VSS NOR2_X1
XI108_I22_XG I108_pn4 I108_gn3 I108_gn4 I108_G4_3 VDD VSS OAI21_X1
XI108_I22_XP I108_pn4 I108_pn3 I108_P4_3 VDD VSS NOR2_X1
XI108_I23_XG I108_pn5 I108_gn4 I108_gn5 I108_G5_4 VDD VSS OAI21_X1
XI108_I23_XP I108_pn5 I108_pn4 I108_P5_4 VDD VSS NOR2_X1
XI108_I24_XG I108_pn6 I108_gn5 I108_gn6 I108_G6_5 VDD VSS OAI21_X1
XI108_I24_XP I108_pn6 I108_pn5 I108_P6_5 VDD VSS NOR2_X1
XI108_I25_XG I108_pn7 I108_gn6 I108_gn7 I108_G7_6 VDD VSS OAI21_X1
XI108_I25_XP I108_pn7 I108_pn6 I108_P7_6 VDD VSS NOR2_X1
XI108_I26_XG I108_P2_1 I108_G0_0 I108_G2_1 I108_G2_0n VDD VSS AOI21_X1
XI108_I27_XG I108_P3_2 I108_G1_0 I108_G3_2 I108_G3_0n VDD VSS AOI21_X1
XI108_I28_XG I108_P4_3 I108_G2_1 I108_G4_3 I108_G4_1n VDD VSS AOI21_X1
XI108_I28_XP I108_P4_3 I108_P2_1 I108_P4_1n VDD VSS NAND2_X1
XI108_I29_XG I108_P5_4 I108_G3_2 I108_G5_4 I108_G5_2n VDD VSS AOI21_X1
XI108_I29_XP I108_P5_4 I108_P3_2 I108_P5_2n VDD VSS NAND2_X1
XI108_I30_XG I108_P6_5 I108_G4_3 I108_G6_5 I108_G6_3n VDD VSS AOI21_X1
XI108_I30_XP I108_P6_5 I108_P4_3 I108_P6_3n VDD VSS NAND2_X1
XI108_I31_XG I108_P7_6 I108_G5_4 I108_G7_6 I108_G7_4n VDD VSS AOI21_X1
XI108_I31_XP I108_P7_6 I108_P5_4 I108_P7_4n VDD VSS NAND2_X1
XI108_I32_XG I108_P4_1n I108_G0_0n I108_G4_1n I108_G4_0 VDD VSS OAI21_X1
XI108_I33 I108_G1_0 I108_G1_0n VDD VSS INV_X1
XI108_I34_XG I108_P5_2n I108_G1_0n I108_G5_2n I108_G5_0 VDD VSS OAI21_X1
XI108_I35_XG I108_P6_3n I108_G2_0n I108_G6_3n c5_7 VDD VSS OAI21_X1
XI108_I36_XG I108_P7_4n I108_G3_0n I108_G7_4n c5_8 VDD VSS OAI21_X1
XI108_I37 I108_pn0 qu3 p5_0 VDD VSS XNOR2_X1
XI108_I38 I108_pn1 I108_G0_0 p5_1 VDD VSS XNOR2_X1
XI108_I39 I108_pn2 I108_G1_0 p5_2 VDD VSS XNOR2_X1
XI108_I40 I108_pn3 I108_G2_0n p5_3 VDD VSS XOR2_X1
XI108_I41 I108_pn4 I108_G3_0n p5_4 VDD VSS XOR2_X1
XI108_I42 I108_pn5 I108_G4_0 p5_5 VDD VSS XNOR2_X1
XI108_I43 I108_pn6 I108_G5_0 p5_6 VDD VSS XNOR2_X1
XI108_I44 I108_pn7 c5_7 p5_7 VDD VSS XNOR2_X1
XI109 p4_7 qu3 h5 VDD VSS XOR2_X1
XI110 h5 c5_8 p5_8 VDD VSS XOR2_X1
XI111 p5_8 qu2 VDD VSS INV_X4
XI112 B_0 qu2 b6_0 VDD VSS XOR2_X1
XI113 dd1 qu2 b6_1 VDD VSS XOR2_X1
XI114 dd2 qu2 b6_2 VDD VSS XOR2_X1
XI115 dd3 qu2 b6_3 VDD VSS XOR2_X1
XI116 dd4 qu2 b6_4 VDD VSS XOR2_X1
XI117 dd5 qu2 b6_5 VDD VSS XOR2_X1
XI118 dd6 qu2 b6_6 VDD VSS XOR2_X1
XI119 dd7 qu2 b6_7 VDD VSS XOR2_X1
XI120_I0 aa1 b6_0 I120_gn0 VDD VSS NAND2_X1
XI120_I1 p5_0 b6_1 I120_gn1 VDD VSS NAND2_X1
XI120_I2 p5_1 b6_2 I120_gn2 VDD VSS NAND2_X1
XI120_I3 p5_2 b6_3 I120_gn3 VDD VSS NAND2_X1
XI120_I4 p5_3 b6_4 I120_gn4 VDD VSS NAND2_X1
XI120_I5 p5_4 b6_5 I120_gn5 VDD VSS NAND2_X1
XI120_I6 p5_5 b6_6 I120_gn6 VDD VSS NAND2_X1
XI120_I7 p5_6 b6_7 I120_gn7 VDD VSS NAND2_X1
XI120_I8 aa1 b6_0 I120_pn0 VDD VSS XNOR2_X1
XI120_I9 p5_0 b6_1 I120_pn1 VDD VSS XNOR2_X1
XI120_I10 p5_1 b6_2 I120_pn2 VDD VSS XNOR2_X1
XI120_I11 p5_2 b6_3 I120_pn3 VDD VSS XNOR2_X1
XI120_I12 p5_3 b6_4 I120_pn4 VDD VSS XNOR2_X1
XI120_I13 p5_4 b6_5 I120_pn5 VDD VSS XNOR2_X1
XI120_I14 p5_5 b6_6 I120_pn6 VDD VSS XNOR2_X1
XI120_I15 p5_6 b6_7 I120_pn7 VDD VSS XNOR2_X1
XI120_I16 qu2 I120_cinn VDD VSS INV_X1
XI120_I17_XG I120_pn0 I120_cinn I120_gn0 I120_G0_0 VDD VSS OAI21_X1
XI120_I18 I120_G0_0 I120_G0_0n VDD VSS INV_X1
XI120_I19_XG I120_pn1 I120_G0_0n I120_gn1 I120_G1_0 VDD VSS OAI21_X1
XI120_I20_XG I120_pn2 I120_gn1 I120_gn2 I120_G2_1 VDD VSS OAI21_X1
XI120_I20_XP I120_pn2 I120_pn1 I120_P2_1 VDD VSS NOR2_X1
XI120_I21_XG I120_pn3 I120_gn2 I120_gn3 I120_G3_2 VDD VSS OAI21_X1
XI120_I21_XP I120_pn3 I120_pn2 I120_P3_2 VDD VSS NOR2_X1
XI120_I22_XG I120_pn4 I120_gn3 I120_gn4 I120_G4_3 VDD VSS OAI21_X1
XI120_I22_XP I120_pn4 I120_pn3 I120_P4_3 VDD VSS NOR2_X1
XI120_I23_XG I120_pn5 I120_gn4 I120_gn5 I120_G5_4 VDD VSS OAI21_X1
XI120_I23_XP I120_pn5 I120_pn4 I120_P5_4 VDD VSS NOR2_X1
XI120_I24_XG I120_pn6 I120_gn5 I120_gn6 I120_G6_5 VDD VSS OAI21_X1
XI120_I24_XP I120_pn6 I120_pn5 I120_P6_5 VDD VSS NOR2_X1
XI120_I25_XG I120_pn7 I120_gn6 I120_gn7 I120_G7_6 VDD VSS OAI21_X1
XI120_I25_XP I120_pn7 I120_pn6 I120_P7_6 VDD VSS NOR2_X1
XI120_I26_XG I120_P2_1 I120_G0_0 I120_G2_1 I120_G2_0n VDD VSS AOI21_X1
XI120_I27_XG I120_P3_2 I120_G1_0 I120_G3_2 I120_G3_0n VDD VSS AOI21_X1
XI120_I28_XG I120_P4_3 I120_G2_1 I120_G4_3 I120_G4_1n VDD VSS AOI21_X1
XI120_I28_XP I120_P4_3 I120_P2_1 I120_P4_1n VDD VSS NAND2_X1
XI120_I29_XG I120_P5_4 I120_G3_2 I120_G5_4 I120_G5_2n VDD VSS AOI21_X1
XI120_I29_XP I120_P5_4 I120_P3_2 I120_P5_2n VDD VSS NAND2_X1
XI120_I30_XG I120_P6_5 I120_G4_3 I120_G6_5 I120_G6_3n VDD VSS AOI21_X1
XI120_I30_XP I120_P6_5 I120_P4_3 I120_P6_3n VDD VSS NAND2_X1
XI120_I31_XG I120_P7_6 I120_G5_4 I120_G7_6 I120_G7_4n VDD VSS AOI21_X1
XI120_I31_XP I120_P7_6 I120_P5_4 I120_P7_4n VDD VSS NAND2_X1
XI120_I32_XG I120_P4_1n I120_G0_0n I120_G4_1n I120_G4_0 VDD VSS OAI21_X1
XI120_I33 I120_G1_0 I120_G1_0n VDD VSS INV_X1
XI120_I34_XG I120_P5_2n I120_G1_0n I120_G5_2n I120_G5_0 VDD VSS OAI21_X1
XI120_I35_XG I120_P6_3n I120_G2_0n I120_G6_3n c6_7 VDD VSS OAI21_X1
XI120_I36_XG I120_P7_4n I120_G3_0n I120_G7_4n c6_8 VDD VSS OAI21_X1
XI120_I37 I120_pn0 qu2 p6_0 VDD VSS XNOR2_X1
XI120_I38 I120_pn1 I120_G0_0 p6_1 VDD VSS XNOR2_X1
XI120_I39 I120_pn2 I120_G1_0 p6_2 VDD VSS XNOR2_X1
XI120_I40 I120_pn3 I120_G2_0n p6_3 VDD VSS XOR2_X1
XI120_I41 I120_pn4 I120_G3_0n p6_4 VDD VSS XOR2_X1
XI120_I42 I120_pn5 I120_G4_0 p6_5 VDD VSS XNOR2_X1
XI120_I43 I120_pn6 I120_G5_0 p6_6 VDD VSS XNOR2_X1
XI120_I44 I120_pn7 c6_7 p6_7 VDD VSS XNOR2_X1
XI121 p5_7 qu2 h6 VDD VSS XOR2_X1
XI122 h6 c6_8 p6_8 VDD VSS XOR2_X1
XI123 p6_8 qu1 VDD VSS INV_X4
XI124 B_0 qu1 b7_0 VDD VSS XOR2_X1
XI125 dd1 qu1 b7_1 VDD VSS XOR2_X1
XI126 dd2 qu1 b7_2 VDD VSS XOR2_X1
XI127 dd3 qu1 b7_3 VDD VSS XOR2_X1
XI128 dd4 qu1 b7_4 VDD VSS XOR2_X1
XI129 dd5 qu1 b7_5 VDD VSS XOR2_X1
XI130 dd6 qu1 b7_6 VDD VSS XOR2_X1
XI131 dd7 qu1 b7_7 VDD VSS XOR2_X1
XI132_I0 A_0 b7_0 I132_gn0 VDD VSS NAND2_X1
XI132_I1 p6_0 b7_1 I132_gn1 VDD VSS NAND2_X1
XI132_I2 p6_1 b7_2 I132_gn2 VDD VSS NAND2_X1
XI132_I3 p6_2 b7_3 I132_gn3 VDD VSS NAND2_X1
XI132_I4 p6_3 b7_4 I132_gn4 VDD VSS NAND2_X1
XI132_I5 p6_4 b7_5 I132_gn5 VDD VSS NAND2_X1
XI132_I6 p6_5 b7_6 I132_gn6 VDD VSS NAND2_X1
XI132_I7 p6_6 b7_7 I132_gn7 VDD VSS NAND2_X1
XI132_I8 A_0 b7_0 I132_pn0 VDD VSS XNOR2_X1
XI132_I9 p6_0 b7_1 I132_pn1 VDD VSS XNOR2_X1
XI132_I10 p6_1 b7_2 I132_pn2 VDD VSS XNOR2_X1
XI132_I11 p6_2 b7_3 I132_pn3 VDD VSS XNOR2_X1
XI132_I12 p6_3 b7_4 I132_pn4 VDD VSS XNOR2_X1
XI132_I13 p6_4 b7_5 I132_pn5 VDD VSS XNOR2_X1
XI132_I14 p6_5 b7_6 I132_pn6 VDD VSS XNOR2_X1
XI132_I15 p6_6 b7_7 I132_pn7 VDD VSS XNOR2_X1
XI132_I16 qu1 I132_cinn VDD VSS INV_X1
XI132_I17_XG I132_pn0 I132_cinn I132_gn0 I132_G0_0 VDD VSS OAI21_X1
XI132_I18 I132_G0_0 I132_G0_0n VDD VSS INV_X1
XI132_I19_XG I132_pn1 I132_G0_0n I132_gn1 I132_G1_0 VDD VSS OAI21_X1
XI132_I20_XG I132_pn2 I132_gn1 I132_gn2 I132_G2_1 VDD VSS OAI21_X1
XI132_I20_XP I132_pn2 I132_pn1 I132_P2_1 VDD VSS NOR2_X1
XI132_I21_XG I132_pn3 I132_gn2 I132_gn3 I132_G3_2 VDD VSS OAI21_X1
XI132_I21_XP I132_pn3 I132_pn2 I132_P3_2 VDD VSS NOR2_X1
XI132_I22_XG I132_pn4 I132_gn3 I132_gn4 I132_G4_3 VDD VSS OAI21_X1
XI132_I22_XP I132_pn4 I132_pn3 I132_P4_3 VDD VSS NOR2_X1
XI132_I23_XG I132_pn5 I132_gn4 I132_gn5 I132_G5_4 VDD VSS OAI21_X1
XI132_I23_XP I132_pn5 I132_pn4 I132_P5_4 VDD VSS NOR2_X1
XI132_I24_XG I132_pn6 I132_gn5 I132_gn6 I132_G6_5 VDD VSS OAI21_X1
XI132_I24_XP I132_pn6 I132_pn5 I132_P6_5 VDD VSS NOR2_X1
XI132_I25_XG I132_pn7 I132_gn6 I132_gn7 I132_G7_6 VDD VSS OAI21_X1
XI132_I25_XP I132_pn7 I132_pn6 I132_P7_6 VDD VSS NOR2_X1
XI132_I26_XG I132_P2_1 I132_G0_0 I132_G2_1 I132_G2_0n VDD VSS AOI21_X1
XI132_I27_XG I132_P3_2 I132_G1_0 I132_G3_2 I132_G3_0n VDD VSS AOI21_X1
XI132_I28_XG I132_P4_3 I132_G2_1 I132_G4_3 I132_G4_1n VDD VSS AOI21_X1
XI132_I28_XP I132_P4_3 I132_P2_1 I132_P4_1n VDD VSS NAND2_X1
XI132_I29_XG I132_P5_4 I132_G3_2 I132_G5_4 I132_G5_2n VDD VSS AOI21_X1
XI132_I29_XP I132_P5_4 I132_P3_2 I132_P5_2n VDD VSS NAND2_X1
XI132_I30_XG I132_P6_5 I132_G4_3 I132_G6_5 I132_G6_3n VDD VSS AOI21_X1
XI132_I30_XP I132_P6_5 I132_P4_3 I132_P6_3n VDD VSS NAND2_X1
XI132_I31_XG I132_P7_6 I132_G5_4 I132_G7_6 I132_G7_4n VDD VSS AOI21_X1
XI132_I31_XP I132_P7_6 I132_P5_4 I132_P7_4n VDD VSS NAND2_X1
XI132_I32_XG I132_P4_1n I132_G0_0n I132_G4_1n I132_G4_0 VDD VSS OAI21_X1
XI132_I33 I132_G1_0 I132_G1_0n VDD VSS INV_X1
XI132_I34_XG I132_P5_2n I132_G1_0n I132_G5_2n I132_G5_0 VDD VSS OAI21_X1
XI132_I35_XG I132_P6_3n I132_G2_0n I132_G6_3n c7_7 VDD VSS OAI21_X1
XI132_I36_XG I132_P7_4n I132_G3_0n I132_G7_4n c7_8 VDD VSS OAI21_X1
XI132_I37 I132_pn0 qu1 p7_0 VDD VSS XNOR2_X1
XI132_I38 I132_pn1 I132_G0_0 p7_1 VDD VSS XNOR2_X1
XI132_I39 I132_pn2 I132_G1_0 p7_2 VDD VSS XNOR2_X1
XI132_I40 I132_pn3 I132_G2_0n p7_3 VDD VSS XOR2_X1
XI132_I41 I132_pn4 I132_G3_0n p7_4 VDD VSS XOR2_X1
XI132_I42 I132_pn5 I132_G4_0 p7_5 VDD VSS XNOR2_X1
XI132_I43 I132_pn6 I132_G5_0 p7_6 VDD VSS XNOR2_X1
XI132_I44 I132_pn7 c7_7 p7_7 VDD VSS XNOR2_X1
XI133 p6_7 qu1 h7 VDD VSS XOR2_X1
XI134 h7 c7_8 p7_8 VDD VSS XOR2_X1
XI135 p7_8 Q_0 VDD VSS INV_X1
XI136 B_0 p7_8 dmn0 VDD VSS NAND2_X1
XI137 dmn0 dm0 VDD VSS INV_X1
XI138 dd1 p7_8 dmn1 VDD VSS NAND2_X1
XI139 dmn1 dm1 VDD VSS INV_X1
XI140 dd2 p7_8 dmn2 VDD VSS NAND2_X1
XI141 dmn2 dm2 VDD VSS INV_X1
XI142 dd3 p7_8 dmn3 VDD VSS NAND2_X1
XI143 dmn3 dm3 VDD VSS INV_X1
XI144 dd4 p7_8 dmn4 VDD VSS NAND2_X1
XI145 dmn4 dm4 VDD VSS INV_X1
XI146 dd5 p7_8 dmn5 VDD VSS NAND2_X1
XI147 dmn5 dm5 VDD VSS INV_X1
XI148 dd6 p7_8 dmn6 VDD VSS NAND2_X1
XI149 dmn6 dm6 VDD VSS INV_X1
XI150 dd7 p7_8 dmn7 VDD VSS NAND2_X1
XI151 dmn7 dm7 VDD VSS INV_X1
XI152_I0 p7_0 dm0 I152_gn0 VDD VSS NAND2_X1
XI152_I1 p7_1 dm1 I152_gn1 VDD VSS NAND2_X1
XI152_I2 p7_2 dm2 I152_gn2 VDD VSS NAND2_X1
XI152_I3 p7_3 dm3 I152_gn3 VDD VSS NAND2_X1
XI152_I4 p7_4 dm4 I152_gn4 VDD VSS NAND2_X1
XI152_I5 p7_5 dm5 I152_gn5 VDD VSS NAND2_X1
XI152_I6 p7_6 dm6 I152_gn6 VDD VSS NAND2_X1
XI152_I7 p7_7 dm7 I152_gn7 VDD VSS NAND2_X1
XI152_I8 p7_0 dm0 I152_pn0 VDD VSS XNOR2_X1
XI152_I9 p7_1 dm1 I152_pn1 VDD VSS XNOR2_X1
XI152_I10 p7_2 dm2 I152_pn2 VDD VSS XNOR2_X1
XI152_I11 p7_3 dm3 I152_pn3 VDD VSS XNOR2_X1
XI152_I12 p7_4 dm4 I152_pn4 VDD VSS XNOR2_X1
XI152_I13 p7_5 dm5 I152_pn5 VDD VSS XNOR2_X1
XI152_I14 p7_6 dm6 I152_pn6 VDD VSS XNOR2_X1
XI152_I15 p7_7 dm7 I152_pn7 VDD VSS XNOR2_X1
XI152_I16 VSS I152_cinn VDD VSS INV_X1
XI152_I17_XG I152_pn0 I152_cinn I152_gn0 I152_G0_0 VDD VSS OAI21_X1
XI152_I18 I152_G0_0 I152_G0_0n VDD VSS INV_X1
XI152_I19_XG I152_pn1 I152_G0_0n I152_gn1 I152_G1_0 VDD VSS OAI21_X1
XI152_I20_XG I152_pn2 I152_gn1 I152_gn2 I152_G2_1 VDD VSS OAI21_X1
XI152_I20_XP I152_pn2 I152_pn1 I152_P2_1 VDD VSS NOR2_X1
XI152_I21_XG I152_pn3 I152_gn2 I152_gn3 I152_G3_2 VDD VSS OAI21_X1
XI152_I21_XP I152_pn3 I152_pn2 I152_P3_2 VDD VSS NOR2_X1
XI152_I22_XG I152_pn4 I152_gn3 I152_gn4 I152_G4_3 VDD VSS OAI21_X1
XI152_I22_XP I152_pn4 I152_pn3 I152_P4_3 VDD VSS NOR2_X1
XI152_I23_XG I152_pn5 I152_gn4 I152_gn5 I152_G5_4 VDD VSS OAI21_X1
XI152_I23_XP I152_pn5 I152_pn4 I152_P5_4 VDD VSS NOR2_X1
XI152_I24_XG I152_pn6 I152_gn5 I152_gn6 I152_G6_5 VDD VSS OAI21_X1
XI152_I24_XP I152_pn6 I152_pn5 I152_P6_5 VDD VSS NOR2_X1
XI152_I25_XG I152_pn7 I152_gn6 I152_gn7 I152_G7_6 VDD VSS OAI21_X1
XI152_I25_XP I152_pn7 I152_pn6 I152_P7_6 VDD VSS NOR2_X1
XI152_I26_XG I152_P2_1 I152_G0_0 I152_G2_1 I152_G2_0n VDD VSS AOI21_X1
XI152_I27_XG I152_P3_2 I152_G1_0 I152_G3_2 I152_G3_0n VDD VSS AOI21_X1
XI152_I28_XG I152_P4_3 I152_G2_1 I152_G4_3 I152_G4_1n VDD VSS AOI21_X1
XI152_I28_XP I152_P4_3 I152_P2_1 I152_P4_1n VDD VSS NAND2_X1
XI152_I29_XG I152_P5_4 I152_G3_2 I152_G5_4 I152_G5_2n VDD VSS AOI21_X1
XI152_I29_XP I152_P5_4 I152_P3_2 I152_P5_2n VDD VSS NAND2_X1
XI152_I30_XG I152_P6_5 I152_G4_3 I152_G6_5 I152_G6_3n VDD VSS AOI21_X1
XI152_I30_XP I152_P6_5 I152_P4_3 I152_P6_3n VDD VSS NAND2_X1
XI152_I31_XG I152_P7_6 I152_G5_4 I152_G7_6 I152_G7_4n VDD VSS AOI21_X1
XI152_I31_XP I152_P7_6 I152_P5_4 I152_P7_4n VDD VSS NAND2_X1
XI152_I32_XG I152_P4_1n I152_G0_0n I152_G4_1n I152_G4_0 VDD VSS OAI21_X1
XI152_I33 I152_G1_0 I152_G1_0n VDD VSS INV_X1
XI152_I34_XG I152_P5_2n I152_G1_0n I152_G5_2n I152_G5_0 VDD VSS OAI21_X1
XI152_I35_XG I152_P6_3n I152_G2_0n I152_G6_3n rc6 VDD VSS OAI21_X1
XI152_I36_XG I152_P7_4n I152_G3_0n I152_G7_4n rc7 VDD VSS OAI21_X1
XI152_I37 I152_pn0 VSS R_0 VDD VSS XNOR2_X1
XI152_I38 I152_pn1 I152_G0_0 ru1 VDD VSS XNOR2_X1
XI152_I39 I152_pn2 I152_G1_0 ru2 VDD VSS XNOR2_X1
XI152_I40 I152_pn3 I152_G2_0n ru3 VDD VSS XOR2_X1
XI152_I41 I152_pn4 I152_G3_0n ru4 VDD VSS XOR2_X1
XI152_I42 I152_pn5 I152_G4_0 ru5 VDD VSS XNOR2_X1
XI152_I43 I152_pn6 I152_G5_0 ru6 VDD VSS XNOR2_X1
XI152_I44 I152_pn7 rc6 ru7 VDD VSS XNOR2_X1
XI153 A_7 B_7 sq VDD VSS XOR2_X1
XI154 sq Q_0 nqkn1 VDD VSS NAND2_X1
XI155 qu1 nqkn1 Q_1 VDD VSS XNOR2_X1
XI156 nqkn1 nqk1 VDD VSS INV_X1
XI157 sq qu1 nqk1 nqkn2 VDD VSS AOI21_X1
XI158 qu2 nqkn2 Q_2 VDD VSS XNOR2_X1
XI159 nqkn2 nqk2 VDD VSS INV_X1
XI160 sq qu2 nqk2 nqkn3 VDD VSS AOI21_X1
XI161 qu3 nqkn3 Q_3 VDD VSS XNOR2_X1
XI162 nqkn3 nqk3 VDD VSS INV_X1
XI163 sq qu3 nqk3 nqkn4 VDD VSS AOI21_X1
XI164 qu4 nqkn4 Q_4 VDD VSS XNOR2_X1
XI165 nqkn4 nqk4 VDD VSS INV_X1
XI166 sq qu4 nqk4 nqkn5 VDD VSS AOI21_X1
XI167 qu5 nqkn5 Q_5 VDD VSS XNOR2_X1
XI168 nqkn5 nqk5 VDD VSS INV_X1
XI169 sq qu5 nqk5 nqkn6 VDD VSS AOI21_X1
XI170 qu6 nqkn6 Q_6 VDD VSS XNOR2_X1
XI171 nqkn6 nqk6 VDD VSS INV_X1
XI172 sq qu6 nqk6 nqkn7 VDD VSS AOI21_X1
XI173 qu7 nqkn7 Q_7 VDD VSS XNOR2_X1
XI174 A_7 R_0 nrkn1 VDD VSS NAND2_X1
XI175 ru1 nrkn1 R_1 VDD VSS XNOR2_X1
XI176 nrkn1 nrk1 VDD VSS INV_X1
XI177 A_7 ru1 nrk1 nrkn2 VDD VSS AOI21_X1
XI178 ru2 nrkn2 R_2 VDD VSS XNOR2_X1
XI179 nrkn2 nrk2 VDD VSS INV_X1
XI180 A_7 ru2 nrk2 nrkn3 VDD VSS AOI21_X1
XI181 ru3 nrkn3 R_3 VDD VSS XNOR2_X1
XI182 nrkn3 nrk3 VDD VSS INV_X1
XI183 A_7 ru3 nrk3 nrkn4 VDD VSS AOI21_X1
XI184 ru4 nrkn4 R_4 VDD VSS XNOR2_X1
XI185 nrkn4 nrk4 VDD VSS INV_X1
XI186 A_7 ru4 nrk4 nrkn5 VDD VSS AOI21_X1
XI187 ru5 nrkn5 R_5 VDD VSS XNOR2_X1
XI188 nrkn5 nrk5 VDD VSS INV_X1
XI189 A_7 ru5 nrk5 nrkn6 VDD VSS AOI21_X1
XI190 ru6 nrkn6 R_6 VDD VSS XNOR2_X1
XI191 nrkn6 nrk6 VDD VSS INV_X1
XI192 A_7 ru6 nrk6 nrkn7 VDD VSS AOI21_X1
XI193 ru7 nrkn7 R_7 VDD VSS XNOR2_X1
XI194 B_0 B_1 z1_0 VDD VSS NOR2_X1
XI195 B_2 B_3 z1_1 VDD VSS NOR2_X1
XI196 B_4 B_5 z1_2 VDD VSS NOR2_X1
XI197 B_6 B_7 z1_3 VDD VSS NOR2_X1
XI198 z1_0 z1_1 z2_0 VDD VSS NAND2_X1
XI199 z1_2 z1_3 z2_1 VDD VSS NAND2_X1
XI200 z2_0 z2_1 DZ VDD VSS NOR2_X1
XI201 sq sqn VDD VSS INV_X1
XI202 Q_7 sqn vn VDD VSS NAND2_X1
XI203 vn DZ V VDD VSS NOR2_X1
.ENDS DIV8K
