* ALU_CORE phang xuong cell la

.SUBCKT AOI21_X1 A1 A2 B Y VDD VSS
MN0 Y A1 n1 VSS nmos1v w=0.24u l=0.1u
MN1 n1 A2 VSS VSS nmos1v w=0.24u l=0.1u
MN2 Y B VSS VSS nmos1v w=0.12u l=0.1u
MP0 p1 A1 VDD VDD pmos1v w=0.48u l=0.1u
MP1 p1 A2 VDD VDD pmos1v w=0.48u l=0.1u
MP2 Y B p1 VDD pmos1v w=0.48u l=0.1u
.ENDS AOI21_X1

.SUBCKT INV_X1 A Y VDD VSS
MN0 Y A VSS VSS nmos1v w=0.12u l=0.1u
MP0 Y A VDD VDD pmos1v w=0.24u l=0.1u
.ENDS INV_X1

.SUBCKT NAND2_X1 A B Y VDD VSS
MN0 Y A n1 VSS nmos1v w=0.24u l=0.1u
MN1 n1 B VSS VSS nmos1v w=0.24u l=0.1u
MP0 Y A VDD VDD pmos1v w=0.24u l=0.1u
MP1 Y B VDD VDD pmos1v w=0.24u l=0.1u
.ENDS NAND2_X1

.SUBCKT NOR2_X1 A B Y VDD VSS
MN0 Y A VSS VSS nmos1v w=0.12u l=0.1u
MN1 Y B VSS VSS nmos1v w=0.12u l=0.1u
MP0 p1 A VDD VDD pmos1v w=0.48u l=0.1u
MP1 Y B p1 VDD pmos1v w=0.48u l=0.1u
.ENDS NOR2_X1

.SUBCKT OAI21_X1 A1 A2 B Y VDD VSS
MN0 Y A1 n1 VSS nmos1v w=0.24u l=0.1u
MN1 Y A2 n1 VSS nmos1v w=0.24u l=0.1u
MN2 n1 B VSS VSS nmos1v w=0.24u l=0.1u
MP0 p1 A1 VDD VDD pmos1v w=0.48u l=0.1u
MP1 Y A2 p1 VDD pmos1v w=0.48u l=0.1u
MP2 Y B VDD VDD pmos1v w=0.24u l=0.1u
.ENDS OAI21_X1

.SUBCKT XNOR2_X1 A B Y VDD VSS
MN0 An A VSS VSS nmos1v w=0.12u l=0.1u
MP0 An A VDD VDD pmos1v w=0.24u l=0.1u
MN1 Bn B VSS VSS nmos1v w=0.12u l=0.1u
MP1 Bn B VDD VDD pmos1v w=0.24u l=0.1u
MN2 Y A n1 VSS nmos1v w=0.24u l=0.1u
MN3 n1 Bn VSS VSS nmos1v w=0.24u l=0.1u
MN4 Y An n2 VSS nmos1v w=0.24u l=0.1u
MN5 n2 B VSS VSS nmos1v w=0.24u l=0.1u
MP2 p1 A VDD VDD pmos1v w=0.48u l=0.1u
MP3 p1 Bn VDD VDD pmos1v w=0.48u l=0.1u
MP4 Y An p1 VDD pmos1v w=0.48u l=0.1u
MP5 Y B p1 VDD pmos1v w=0.48u l=0.1u
.ENDS XNOR2_X1

.SUBCKT XOR2_X1 A B Y VDD VSS
MN0 An A VSS VSS nmos1v w=0.12u l=0.1u
MP0 An A VDD VDD pmos1v w=0.24u l=0.1u
MN1 Bn B VSS VSS nmos1v w=0.12u l=0.1u
MP1 Bn B VDD VDD pmos1v w=0.24u l=0.1u
MN2 Y A n1 VSS nmos1v w=0.24u l=0.1u
MN3 n1 B VSS VSS nmos1v w=0.24u l=0.1u
MN4 Y An n2 VSS nmos1v w=0.24u l=0.1u
MN5 n2 Bn VSS VSS nmos1v w=0.24u l=0.1u
MP2 p1 A VDD VDD pmos1v w=0.48u l=0.1u
MP3 p1 B VDD VDD pmos1v w=0.48u l=0.1u
MP4 Y An p1 VDD pmos1v w=0.48u l=0.1u
MP5 Y Bn p1 VDD pmos1v w=0.48u l=0.1u
.ENDS XOR2_X1

.SUBCKT ALU_CORE A_0 A_1 A_2 A_3 A_4 A_5 A_6 A_7 B_0 B_1 B_2 B_3 B_4 B_5 B_6 B_7 OP_0 OP_1 OP_2 OP_3 MULP_0 MULP_1 MULP_2 MULP_3 MULP_4 MULP_5 MULP_6 MULP_7 MULP_8 MULP_9 MULP_10 MULP_11 MULP_12 MULP_13 MULP_14 MULP_15 DIVQ_0 DIVQ_1 DIVQ_2 DIVQ_3 DIVQ_4 DIVQ_5 DIVQ_6 DIVQ_7 DIVR_0 DIVR_1 DIVR_2 DIVR_3 DIVR_4 DIVR_5 DIVR_6 DIVR_7 DIVV DIVDZ Y_0 Y_1 Y_2 Y_3 Y_4 Y_5 Y_6 Y_7 Y_8 Y_9 Y_10 Y_11 Y_12 Y_13 Y_14 Y_15 Z C V DZ VDD VSS
XI0_I0 OP_0 I0_opn0 VDD VSS INV_X1
XI0_I1 OP_1 I0_opn1 VDD VSS INV_X1
XI0_I2 OP_2 I0_opn2 VDD VSS INV_X1
XI0_I3 OP_3 I0_opn3 VDD VSS INV_X1
XI0_I4 I0_opn3 I0_opn2 I0_h00 VDD VSS NAND2_X1
XI0_I5 I0_opn3 OP_2 I0_h01 VDD VSS NAND2_X1
XI0_I6 OP_3 I0_opn2 I0_h10 VDD VSS NAND2_X1
XI0_I7 I0_opn1 I0_opn0 I0_l00 VDD VSS NAND2_X1
XI0_I8 I0_opn1 OP_0 I0_l01 VDD VSS NAND2_X1
XI0_I9 OP_1 I0_opn0 I0_l10 VDD VSS NAND2_X1
XI0_I10 OP_1 OP_0 I0_l11 VDD VSS NAND2_X1
XI0_I11 I0_h00 OP_1 SEL_AS VDD VSS NOR2_X1
XI0_I12 I0_h00 I0_l10 SEL_AND VDD VSS NOR2_X1
XI0_I13 I0_h00 I0_l11 SEL_OR VDD VSS NOR2_X1
XI0_I14 I0_h01 I0_l00 SEL_XOR VDD VSS NOR2_X1
XI0_I15 I0_h01 I0_l01 SEL_NOT VDD VSS NOR2_X1
XI0_I16 I0_h10 I0_l01 SEL_MUL VDD VSS NOR2_X1
XI0_I17 I0_h10 I0_l11 SEL_DIV VDD VSS NOR2_X1
XI1_I0 B_0 OP_0 I1_bx0 VDD VSS XOR2_X1
XI1_I1 B_1 OP_0 I1_bx1 VDD VSS XOR2_X1
XI1_I2 B_2 OP_0 I1_bx2 VDD VSS XOR2_X1
XI1_I3 B_3 OP_0 I1_bx3 VDD VSS XOR2_X1
XI1_I4 B_4 OP_0 I1_bx4 VDD VSS XOR2_X1
XI1_I5 B_5 OP_0 I1_bx5 VDD VSS XOR2_X1
XI1_I6 B_6 OP_0 I1_bx6 VDD VSS XOR2_X1
XI1_I7 B_7 OP_0 I1_bx7 VDD VSS XOR2_X1
XI1_I8_I0 A_0 I1_bx0 I1_I8_gn0 VDD VSS NAND2_X1
XI1_I8_I1 A_1 I1_bx1 I1_I8_gn1 VDD VSS NAND2_X1
XI1_I8_I2 A_2 I1_bx2 I1_I8_gn2 VDD VSS NAND2_X1
XI1_I8_I3 A_3 I1_bx3 I1_I8_gn3 VDD VSS NAND2_X1
XI1_I8_I4 A_4 I1_bx4 I1_I8_gn4 VDD VSS NAND2_X1
XI1_I8_I5 A_5 I1_bx5 I1_I8_gn5 VDD VSS NAND2_X1
XI1_I8_I6 A_6 I1_bx6 I1_I8_gn6 VDD VSS NAND2_X1
XI1_I8_I7 A_7 I1_bx7 I1_I8_gn7 VDD VSS NAND2_X1
XI1_I8_I8 A_0 I1_bx0 I1_I8_pn0 VDD VSS XNOR2_X1
XI1_I8_I9 A_1 I1_bx1 I1_I8_pn1 VDD VSS XNOR2_X1
XI1_I8_I10 A_2 I1_bx2 I1_I8_pn2 VDD VSS XNOR2_X1
XI1_I8_I11 A_3 I1_bx3 I1_I8_pn3 VDD VSS XNOR2_X1
XI1_I8_I12 A_4 I1_bx4 I1_I8_pn4 VDD VSS XNOR2_X1
XI1_I8_I13 A_5 I1_bx5 I1_I8_pn5 VDD VSS XNOR2_X1
XI1_I8_I14 A_6 I1_bx6 I1_I8_pn6 VDD VSS XNOR2_X1
XI1_I8_I15 A_7 I1_bx7 I1_I8_pn7 VDD VSS XNOR2_X1
XI1_I8_I16 OP_0 I1_I8_cinn VDD VSS INV_X1
XI1_I8_I17_XG I1_I8_pn0 I1_I8_cinn I1_I8_gn0 I1_I8_G0_0 VDD VSS OAI21_X1
XI1_I8_I18 I1_I8_G0_0 I1_I8_G0_0n VDD VSS INV_X1
XI1_I8_I19_XG I1_I8_pn1 I1_I8_G0_0n I1_I8_gn1 I1_I8_G1_0 VDD VSS OAI21_X1
XI1_I8_I20_XG I1_I8_pn2 I1_I8_gn1 I1_I8_gn2 I1_I8_G2_1 VDD VSS OAI21_X1
XI1_I8_I20_XP I1_I8_pn2 I1_I8_pn1 I1_I8_P2_1 VDD VSS NOR2_X1
XI1_I8_I21_XG I1_I8_pn3 I1_I8_gn2 I1_I8_gn3 I1_I8_G3_2 VDD VSS OAI21_X1
XI1_I8_I21_XP I1_I8_pn3 I1_I8_pn2 I1_I8_P3_2 VDD VSS NOR2_X1
XI1_I8_I22_XG I1_I8_pn4 I1_I8_gn3 I1_I8_gn4 I1_I8_G4_3 VDD VSS OAI21_X1
XI1_I8_I22_XP I1_I8_pn4 I1_I8_pn3 I1_I8_P4_3 VDD VSS NOR2_X1
XI1_I8_I23_XG I1_I8_pn5 I1_I8_gn4 I1_I8_gn5 I1_I8_G5_4 VDD VSS OAI21_X1
XI1_I8_I23_XP I1_I8_pn5 I1_I8_pn4 I1_I8_P5_4 VDD VSS NOR2_X1
XI1_I8_I24_XG I1_I8_pn6 I1_I8_gn5 I1_I8_gn6 I1_I8_G6_5 VDD VSS OAI21_X1
XI1_I8_I24_XP I1_I8_pn6 I1_I8_pn5 I1_I8_P6_5 VDD VSS NOR2_X1
XI1_I8_I25_XG I1_I8_pn7 I1_I8_gn6 I1_I8_gn7 I1_I8_G7_6 VDD VSS OAI21_X1
XI1_I8_I25_XP I1_I8_pn7 I1_I8_pn6 I1_I8_P7_6 VDD VSS NOR2_X1
XI1_I8_I26_XG I1_I8_P2_1 I1_I8_G0_0 I1_I8_G2_1 I1_I8_G2_0n VDD VSS AOI21_X1
XI1_I8_I27_XG I1_I8_P3_2 I1_I8_G1_0 I1_I8_G3_2 I1_I8_G3_0n VDD VSS AOI21_X1
XI1_I8_I28_XG I1_I8_P4_3 I1_I8_G2_1 I1_I8_G4_3 I1_I8_G4_1n VDD VSS AOI21_X1
XI1_I8_I28_XP I1_I8_P4_3 I1_I8_P2_1 I1_I8_P4_1n VDD VSS NAND2_X1
XI1_I8_I29_XG I1_I8_P5_4 I1_I8_G3_2 I1_I8_G5_4 I1_I8_G5_2n VDD VSS AOI21_X1
XI1_I8_I29_XP I1_I8_P5_4 I1_I8_P3_2 I1_I8_P5_2n VDD VSS NAND2_X1
XI1_I8_I30_XG I1_I8_P6_5 I1_I8_G4_3 I1_I8_G6_5 I1_I8_G6_3n VDD VSS AOI21_X1
XI1_I8_I30_XP I1_I8_P6_5 I1_I8_P4_3 I1_I8_P6_3n VDD VSS NAND2_X1
XI1_I8_I31_XG I1_I8_P7_6 I1_I8_G5_4 I1_I8_G7_6 I1_I8_G7_4n VDD VSS AOI21_X1
XI1_I8_I31_XP I1_I8_P7_6 I1_I8_P5_4 I1_I8_P7_4n VDD VSS NAND2_X1
XI1_I8_I32_XG I1_I8_P4_1n I1_I8_G0_0n I1_I8_G4_1n I1_I8_G4_0 VDD VSS OAI21_X1
XI1_I8_I33 I1_I8_G1_0 I1_I8_G1_0n VDD VSS INV_X1
XI1_I8_I34_XG I1_I8_P5_2n I1_I8_G1_0n I1_I8_G5_2n I1_I8_G5_0 VDD VSS OAI21_X1
XI1_I8_I35_XG I1_I8_P6_3n I1_I8_G2_0n I1_I8_G6_3n C7 VDD VSS OAI21_X1
XI1_I8_I36_XG I1_I8_P7_4n I1_I8_G3_0n I1_I8_G7_4n C8 VDD VSS OAI21_X1
XI1_I8_I37 I1_I8_pn0 OP_0 S_0 VDD VSS XNOR2_X1
XI1_I8_I38 I1_I8_pn1 I1_I8_G0_0 S_1 VDD VSS XNOR2_X1
XI1_I8_I39 I1_I8_pn2 I1_I8_G1_0 S_2 VDD VSS XNOR2_X1
XI1_I8_I40 I1_I8_pn3 I1_I8_G2_0n S_3 VDD VSS XOR2_X1
XI1_I8_I41 I1_I8_pn4 I1_I8_G3_0n S_4 VDD VSS XOR2_X1
XI1_I8_I42 I1_I8_pn5 I1_I8_G4_0 S_5 VDD VSS XNOR2_X1
XI1_I8_I43 I1_I8_pn6 I1_I8_G5_0 S_6 VDD VSS XNOR2_X1
XI1_I8_I44 I1_I8_pn7 C7 S_7 VDD VSS XNOR2_X1
XI2_I0 A_0 B_0 I2_nand0 VDD VSS NAND2_X1
XI2_I1 I2_nand0 AND_0 VDD VSS INV_X1
XI2_I2 A_0 B_0 I2_nor0 VDD VSS NOR2_X1
XI2_I3 I2_nor0 OR_0 VDD VSS INV_X1
XI2_I4 A_0 B_0 XOR_0 VDD VSS XOR2_X1
XI2_I5 A_0 NOT_0 VDD VSS INV_X1
XI2_I6 A_1 B_1 I2_nand1 VDD VSS NAND2_X1
XI2_I7 I2_nand1 AND_1 VDD VSS INV_X1
XI2_I8 A_1 B_1 I2_nor1 VDD VSS NOR2_X1
XI2_I9 I2_nor1 OR_1 VDD VSS INV_X1
XI2_I10 A_1 B_1 XOR_1 VDD VSS XOR2_X1
XI2_I11 A_1 NOT_1 VDD VSS INV_X1
XI2_I12 A_2 B_2 I2_nand2 VDD VSS NAND2_X1
XI2_I13 I2_nand2 AND_2 VDD VSS INV_X1
XI2_I14 A_2 B_2 I2_nor2 VDD VSS NOR2_X1
XI2_I15 I2_nor2 OR_2 VDD VSS INV_X1
XI2_I16 A_2 B_2 XOR_2 VDD VSS XOR2_X1
XI2_I17 A_2 NOT_2 VDD VSS INV_X1
XI2_I18 A_3 B_3 I2_nand3 VDD VSS NAND2_X1
XI2_I19 I2_nand3 AND_3 VDD VSS INV_X1
XI2_I20 A_3 B_3 I2_nor3 VDD VSS NOR2_X1
XI2_I21 I2_nor3 OR_3 VDD VSS INV_X1
XI2_I22 A_3 B_3 XOR_3 VDD VSS XOR2_X1
XI2_I23 A_3 NOT_3 VDD VSS INV_X1
XI2_I24 A_4 B_4 I2_nand4 VDD VSS NAND2_X1
XI2_I25 I2_nand4 AND_4 VDD VSS INV_X1
XI2_I26 A_4 B_4 I2_nor4 VDD VSS NOR2_X1
XI2_I27 I2_nor4 OR_4 VDD VSS INV_X1
XI2_I28 A_4 B_4 XOR_4 VDD VSS XOR2_X1
XI2_I29 A_4 NOT_4 VDD VSS INV_X1
XI2_I30 A_5 B_5 I2_nand5 VDD VSS NAND2_X1
XI2_I31 I2_nand5 AND_5 VDD VSS INV_X1
XI2_I32 A_5 B_5 I2_nor5 VDD VSS NOR2_X1
XI2_I33 I2_nor5 OR_5 VDD VSS INV_X1
XI2_I34 A_5 B_5 XOR_5 VDD VSS XOR2_X1
XI2_I35 A_5 NOT_5 VDD VSS INV_X1
XI2_I36 A_6 B_6 I2_nand6 VDD VSS NAND2_X1
XI2_I37 I2_nand6 AND_6 VDD VSS INV_X1
XI2_I38 A_6 B_6 I2_nor6 VDD VSS NOR2_X1
XI2_I39 I2_nor6 OR_6 VDD VSS INV_X1
XI2_I40 A_6 B_6 XOR_6 VDD VSS XOR2_X1
XI2_I41 A_6 NOT_6 VDD VSS INV_X1
XI2_I42 A_7 B_7 I2_nand7 VDD VSS NAND2_X1
XI2_I43 I2_nand7 AND_7 VDD VSS INV_X1
XI2_I44 A_7 B_7 I2_nor7 VDD VSS NOR2_X1
XI2_I45 I2_nor7 OR_7 VDD VSS INV_X1
XI2_I46 A_7 B_7 XOR_7 VDD VSS XOR2_X1
XI2_I47 A_7 NOT_7 VDD VSS INV_X1
XI3_I0 SEL_AND AND_0 I3_n0_0 VDD VSS NAND2_X1
XI3_I1 SEL_OR OR_0 I3_n0_1 VDD VSS NAND2_X1
XI3_I2 SEL_XOR XOR_0 I3_n0_2 VDD VSS NAND2_X1
XI3_I3 SEL_NOT NOT_0 I3_n0_3 VDD VSS NAND2_X1
XI3_I4 SEL_MUL MULP_0 I3_n0_4 VDD VSS NAND2_X1
XI3_I5 SEL_DIV DIVQ_0 I3_n0_5 VDD VSS NAND2_X1
XI3_I6 I3_n0_0 I3_n0_1 I3_o0_0 VDD VSS NAND2_X1
XI3_I7 I3_n0_2 I3_n0_3 I3_o0_1 VDD VSS NAND2_X1
XI3_I8 I3_n0_4 I3_n0_5 I3_o0_2 VDD VSS NAND2_X1
XI3_I9 I3_o0_0 I3_o0_1 I3_q0_1 VDD VSS NOR2_X1
XI3_I10 SEL_AS S_0 I3_o0_2 I3_q0_2 VDD VSS AOI21_X1
XI3_I11 I3_q0_1 I3_q0_2 Y_0 VDD VSS NAND2_X1
XI3_I12 SEL_AND AND_1 I3_n1_0 VDD VSS NAND2_X1
XI3_I13 SEL_OR OR_1 I3_n1_1 VDD VSS NAND2_X1
XI3_I14 SEL_XOR XOR_1 I3_n1_2 VDD VSS NAND2_X1
XI3_I15 SEL_NOT NOT_1 I3_n1_3 VDD VSS NAND2_X1
XI3_I16 SEL_MUL MULP_1 I3_n1_4 VDD VSS NAND2_X1
XI3_I17 SEL_DIV DIVQ_1 I3_n1_5 VDD VSS NAND2_X1
XI3_I18 I3_n1_0 I3_n1_1 I3_o1_0 VDD VSS NAND2_X1
XI3_I19 I3_n1_2 I3_n1_3 I3_o1_1 VDD VSS NAND2_X1
XI3_I20 I3_n1_4 I3_n1_5 I3_o1_2 VDD VSS NAND2_X1
XI3_I21 I3_o1_0 I3_o1_1 I3_q1_1 VDD VSS NOR2_X1
XI3_I22 SEL_AS S_1 I3_o1_2 I3_q1_2 VDD VSS AOI21_X1
XI3_I23 I3_q1_1 I3_q1_2 Y_1 VDD VSS NAND2_X1
XI3_I24 SEL_AND AND_2 I3_n2_0 VDD VSS NAND2_X1
XI3_I25 SEL_OR OR_2 I3_n2_1 VDD VSS NAND2_X1
XI3_I26 SEL_XOR XOR_2 I3_n2_2 VDD VSS NAND2_X1
XI3_I27 SEL_NOT NOT_2 I3_n2_3 VDD VSS NAND2_X1
XI3_I28 SEL_MUL MULP_2 I3_n2_4 VDD VSS NAND2_X1
XI3_I29 SEL_DIV DIVQ_2 I3_n2_5 VDD VSS NAND2_X1
XI3_I30 I3_n2_0 I3_n2_1 I3_o2_0 VDD VSS NAND2_X1
XI3_I31 I3_n2_2 I3_n2_3 I3_o2_1 VDD VSS NAND2_X1
XI3_I32 I3_n2_4 I3_n2_5 I3_o2_2 VDD VSS NAND2_X1
XI3_I33 I3_o2_0 I3_o2_1 I3_q2_1 VDD VSS NOR2_X1
XI3_I34 SEL_AS S_2 I3_o2_2 I3_q2_2 VDD VSS AOI21_X1
XI3_I35 I3_q2_1 I3_q2_2 Y_2 VDD VSS NAND2_X1
XI3_I36 SEL_AND AND_3 I3_n3_0 VDD VSS NAND2_X1
XI3_I37 SEL_OR OR_3 I3_n3_1 VDD VSS NAND2_X1
XI3_I38 SEL_XOR XOR_3 I3_n3_2 VDD VSS NAND2_X1
XI3_I39 SEL_NOT NOT_3 I3_n3_3 VDD VSS NAND2_X1
XI3_I40 SEL_MUL MULP_3 I3_n3_4 VDD VSS NAND2_X1
XI3_I41 SEL_DIV DIVQ_3 I3_n3_5 VDD VSS NAND2_X1
XI3_I42 I3_n3_0 I3_n3_1 I3_o3_0 VDD VSS NAND2_X1
XI3_I43 I3_n3_2 I3_n3_3 I3_o3_1 VDD VSS NAND2_X1
XI3_I44 I3_n3_4 I3_n3_5 I3_o3_2 VDD VSS NAND2_X1
XI3_I45 I3_o3_0 I3_o3_1 I3_q3_1 VDD VSS NOR2_X1
XI3_I46 SEL_AS S_3 I3_o3_2 I3_q3_2 VDD VSS AOI21_X1
XI3_I47 I3_q3_1 I3_q3_2 Y_3 VDD VSS NAND2_X1
XI3_I48 SEL_AND AND_4 I3_n4_0 VDD VSS NAND2_X1
XI3_I49 SEL_OR OR_4 I3_n4_1 VDD VSS NAND2_X1
XI3_I50 SEL_XOR XOR_4 I3_n4_2 VDD VSS NAND2_X1
XI3_I51 SEL_NOT NOT_4 I3_n4_3 VDD VSS NAND2_X1
XI3_I52 SEL_MUL MULP_4 I3_n4_4 VDD VSS NAND2_X1
XI3_I53 SEL_DIV DIVQ_4 I3_n4_5 VDD VSS NAND2_X1
XI3_I54 I3_n4_0 I3_n4_1 I3_o4_0 VDD VSS NAND2_X1
XI3_I55 I3_n4_2 I3_n4_3 I3_o4_1 VDD VSS NAND2_X1
XI3_I56 I3_n4_4 I3_n4_5 I3_o4_2 VDD VSS NAND2_X1
XI3_I57 I3_o4_0 I3_o4_1 I3_q4_1 VDD VSS NOR2_X1
XI3_I58 SEL_AS S_4 I3_o4_2 I3_q4_2 VDD VSS AOI21_X1
XI3_I59 I3_q4_1 I3_q4_2 Y_4 VDD VSS NAND2_X1
XI3_I60 SEL_AND AND_5 I3_n5_0 VDD VSS NAND2_X1
XI3_I61 SEL_OR OR_5 I3_n5_1 VDD VSS NAND2_X1
XI3_I62 SEL_XOR XOR_5 I3_n5_2 VDD VSS NAND2_X1
XI3_I63 SEL_NOT NOT_5 I3_n5_3 VDD VSS NAND2_X1
XI3_I64 SEL_MUL MULP_5 I3_n5_4 VDD VSS NAND2_X1
XI3_I65 SEL_DIV DIVQ_5 I3_n5_5 VDD VSS NAND2_X1
XI3_I66 I3_n5_0 I3_n5_1 I3_o5_0 VDD VSS NAND2_X1
XI3_I67 I3_n5_2 I3_n5_3 I3_o5_1 VDD VSS NAND2_X1
XI3_I68 I3_n5_4 I3_n5_5 I3_o5_2 VDD VSS NAND2_X1
XI3_I69 I3_o5_0 I3_o5_1 I3_q5_1 VDD VSS NOR2_X1
XI3_I70 SEL_AS S_5 I3_o5_2 I3_q5_2 VDD VSS AOI21_X1
XI3_I71 I3_q5_1 I3_q5_2 Y_5 VDD VSS NAND2_X1
XI3_I72 SEL_AND AND_6 I3_n6_0 VDD VSS NAND2_X1
XI3_I73 SEL_OR OR_6 I3_n6_1 VDD VSS NAND2_X1
XI3_I74 SEL_XOR XOR_6 I3_n6_2 VDD VSS NAND2_X1
XI3_I75 SEL_NOT NOT_6 I3_n6_3 VDD VSS NAND2_X1
XI3_I76 SEL_MUL MULP_6 I3_n6_4 VDD VSS NAND2_X1
XI3_I77 SEL_DIV DIVQ_6 I3_n6_5 VDD VSS NAND2_X1
XI3_I78 I3_n6_0 I3_n6_1 I3_o6_0 VDD VSS NAND2_X1
XI3_I79 I3_n6_2 I3_n6_3 I3_o6_1 VDD VSS NAND2_X1
XI3_I80 I3_n6_4 I3_n6_5 I3_o6_2 VDD VSS NAND2_X1
XI3_I81 I3_o6_0 I3_o6_1 I3_q6_1 VDD VSS NOR2_X1
XI3_I82 SEL_AS S_6 I3_o6_2 I3_q6_2 VDD VSS AOI21_X1
XI3_I83 I3_q6_1 I3_q6_2 Y_6 VDD VSS NAND2_X1
XI3_I84 SEL_AND AND_7 I3_n7_0 VDD VSS NAND2_X1
XI3_I85 SEL_OR OR_7 I3_n7_1 VDD VSS NAND2_X1
XI3_I86 SEL_XOR XOR_7 I3_n7_2 VDD VSS NAND2_X1
XI3_I87 SEL_NOT NOT_7 I3_n7_3 VDD VSS NAND2_X1
XI3_I88 SEL_MUL MULP_7 I3_n7_4 VDD VSS NAND2_X1
XI3_I89 SEL_DIV DIVQ_7 I3_n7_5 VDD VSS NAND2_X1
XI3_I90 I3_n7_0 I3_n7_1 I3_o7_0 VDD VSS NAND2_X1
XI3_I91 I3_n7_2 I3_n7_3 I3_o7_1 VDD VSS NAND2_X1
XI3_I92 I3_n7_4 I3_n7_5 I3_o7_2 VDD VSS NAND2_X1
XI3_I93 I3_o7_0 I3_o7_1 I3_q7_1 VDD VSS NOR2_X1
XI3_I94 SEL_AS S_7 I3_o7_2 I3_q7_2 VDD VSS AOI21_X1
XI3_I95 I3_q7_1 I3_q7_2 Y_7 VDD VSS NAND2_X1
XI3_I96 SEL_MUL MULP_8 I3_hm8 VDD VSS NAND2_X1
XI3_I97 SEL_DIV DIVR_0 I3_hd8 VDD VSS NAND2_X1
XI3_I98 I3_hm8 I3_hd8 Y_8 VDD VSS NAND2_X1
XI3_I99 SEL_MUL MULP_9 I3_hm9 VDD VSS NAND2_X1
XI3_I100 SEL_DIV DIVR_1 I3_hd9 VDD VSS NAND2_X1
XI3_I101 I3_hm9 I3_hd9 Y_9 VDD VSS NAND2_X1
XI3_I102 SEL_MUL MULP_10 I3_hm10 VDD VSS NAND2_X1
XI3_I103 SEL_DIV DIVR_2 I3_hd10 VDD VSS NAND2_X1
XI3_I104 I3_hm10 I3_hd10 Y_10 VDD VSS NAND2_X1
XI3_I105 SEL_MUL MULP_11 I3_hm11 VDD VSS NAND2_X1
XI3_I106 SEL_DIV DIVR_3 I3_hd11 VDD VSS NAND2_X1
XI3_I107 I3_hm11 I3_hd11 Y_11 VDD VSS NAND2_X1
XI3_I108 SEL_MUL MULP_12 I3_hm12 VDD VSS NAND2_X1
XI3_I109 SEL_DIV DIVR_4 I3_hd12 VDD VSS NAND2_X1
XI3_I110 I3_hm12 I3_hd12 Y_12 VDD VSS NAND2_X1
XI3_I111 SEL_MUL MULP_13 I3_hm13 VDD VSS NAND2_X1
XI3_I112 SEL_DIV DIVR_5 I3_hd13 VDD VSS NAND2_X1
XI3_I113 I3_hm13 I3_hd13 Y_13 VDD VSS NAND2_X1
XI3_I114 SEL_MUL MULP_14 I3_hm14 VDD VSS NAND2_X1
XI3_I115 SEL_DIV DIVR_6 I3_hd14 VDD VSS NAND2_X1
XI3_I116 I3_hm14 I3_hd14 Y_14 VDD VSS NAND2_X1
XI3_I117 SEL_MUL MULP_15 I3_hm15 VDD VSS NAND2_X1
XI3_I118 SEL_DIV DIVR_7 I3_hd15 VDD VSS NAND2_X1
XI3_I119 I3_hm15 I3_hd15 Y_15 VDD VSS NAND2_X1
XI4_I0 Y_0 Y_1 I4_za0 VDD VSS NOR2_X1
XI4_I1 Y_2 Y_3 I4_za1 VDD VSS NOR2_X1
XI4_I2 Y_4 Y_5 I4_za2 VDD VSS NOR2_X1
XI4_I3 Y_6 Y_7 I4_za3 VDD VSS NOR2_X1
XI4_I4 Y_8 Y_9 I4_za4 VDD VSS NOR2_X1
XI4_I5 Y_10 Y_11 I4_za5 VDD VSS NOR2_X1
XI4_I6 Y_12 Y_13 I4_za6 VDD VSS NOR2_X1
XI4_I7 Y_14 Y_15 I4_za7 VDD VSS NOR2_X1
XI4_I8 I4_za0 I4_za1 I4_zb0 VDD VSS NAND2_X1
XI4_I9 I4_za2 I4_za3 I4_zb1 VDD VSS NAND2_X1
XI4_I10 I4_za4 I4_za5 I4_zb2 VDD VSS NAND2_X1
XI4_I11 I4_za6 I4_za7 I4_zb3 VDD VSS NAND2_X1
XI4_I12 I4_zb0 I4_zb1 I4_zc0 VDD VSS NOR2_X1
XI4_I13 I4_zb2 I4_zb3 I4_zc1 VDD VSS NOR2_X1
XI4_I14 I4_zc0 I4_zc1 I4_zd VDD VSS NAND2_X1
XI4_I15 I4_zd Z VDD VSS INV_X1
XI4_I16 C8 SEL_AS I4_cn VDD VSS NAND2_X1
XI4_I17 I4_cn C VDD VSS INV_X1
XI4_I18 C7 C8 I4_ovf VDD VSS XOR2_X1
XI4_I19 SEL_AS I4_ovf I4_v1 VDD VSS NAND2_X1
XI4_I20 SEL_DIV DIVV I4_v2 VDD VSS NAND2_X1
XI4_I21 I4_v1 I4_v2 V VDD VSS NAND2_X1
XI4_I22 SEL_DIV DIVDZ I4_dzn VDD VSS NAND2_X1
XI4_I23 I4_dzn DZ VDD VSS INV_X1
.ENDS ALU_CORE
