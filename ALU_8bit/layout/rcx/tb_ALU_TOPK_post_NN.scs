// ALU_TOPK sau layout (Assura RCX), corner NN
simulator lang=spectre
include "/home/buet/cadence/gpdk090_v4.6/models/spectre/gpdk090.scs" section=NN
include "../../../tang1_cell/cells.scs"
include "ALU_TOPK_rcx.scs"
include "../../tb/tb_ALU_TOPK.scs"
