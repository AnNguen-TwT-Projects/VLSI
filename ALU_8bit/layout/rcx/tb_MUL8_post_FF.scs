// MUL8 sau layout (Assura RCX), corner FF
simulator lang=spectre
include "/home/buet/cadence/gpdk090_v4.6/models/spectre/gpdk090.scs" section=FF
include "../../../tang1_cell/cells.scs"
include "MUL8_rcx.scs"
include "../../tb/tb_MUL8.scs"
