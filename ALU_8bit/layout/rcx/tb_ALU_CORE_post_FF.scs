// ALU_CORE sau layout (Assura RCX), corner FF
simulator lang=spectre
include "/home/buet/cadence/gpdk090_v4.6/models/spectre/gpdk090.scs" section=FF
include "../../../tang1_cell/cells.scs"
include "ALU_CORE_rcx.scs"
include "../../tb/tb_ALU_CORE.scs"
