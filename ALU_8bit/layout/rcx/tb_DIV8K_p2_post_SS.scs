// DIV8K_p2 sau layout (Assura RCX), corner SS
simulator lang=spectre
include "/home/buet/cadence/gpdk090_v4.6/models/spectre/gpdk090.scs" section=SS
include "../../../tang1_cell/cells.scs"
include "DIV8K_rcx.scs"
include "../../tb/tb_DIV8K_p2_slow.scs"
