// ALU_CORE, corner NN
simulator lang=spectre
include "/home/buet/cadence/gpdk090_v4.6/models/spectre/gpdk090.scs" section=NN
include "../../tang1_cell/cells.scs"
include "../ALU_8bit.scs"
include "tb_ALU_CORE.scs"
