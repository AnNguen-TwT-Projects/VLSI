;; run in the VM:  bash virtuoso/run_schematic.sh sch_ALU_8bit.il
;; run with < /dev/null; any SKILL error -> message + exit, never a hanging CIW prompt
unless(errset(progn(
sbDir = or(getShellEnvVar("SB_DIR") ".")
load(strcat(sbDir "/sch_build.il"))
sbBegin()
sbLib("ALU_ADD" "gpdk090")
sbLib("ALU_CORE" "gpdk090")
sbLib("ALU_MUL" "gpdk090")
sbLib("ALU_DIV" "gpdk090")
sbLib("ALU_TOP" "gpdk090")
unless(errset(sbCell("ALU_ADD" "KSA8" '(("A_0" "input") ("A_1" "input") ("A_2" "input") ("A_3" "input") ("A_4" "input") ("A_5" "input") ("A_6" "input") ("A_7" "input") ("B_0" "input") ("B_1" "input") ("B_2" "input") ("B_3" "input") ("B_4" "input") ("B_5" "input") ("B_6" "input") ("B_7" "input") ("CIN" "input") ("S_0" "output") ("S_1" "output") ("S_2" "output") ("S_3" "output") ("S_4" "output") ("S_5" "output") ("S_6" "output") ("S_7" "output") ("C7" "output") ("C8" "output") ("VDD" "inputOutput") ("VSS" "inputOutput"))
 '(
  ("I0" "ALU_CELLS_A" "NAND2_X1" (("A" "A_0") ("B" "B_0") ("Y" "gn0") ("VDD" "VDD") ("VSS" "VSS")) ())
  ("I1" "ALU_CELLS_A" "NAND2_X1" (("A" "A_1") ("B" "B_1") ("Y" "gn1") ("VDD" "VDD") ("VSS" "VSS")) ())
  ("I2" "ALU_CELLS_A" "NAND2_X1" (("A" "A_2") ("B" "B_2") ("Y" "gn2") ("VDD" "VDD") ("VSS" "VSS")) ())
  ("I3" "ALU_CELLS_A" "NAND2_X1" (("A" "A_3") ("B" "B_3") ("Y" "gn3") ("VDD" "VDD") ("VSS" "VSS")) ())
  ("I4" "ALU_CELLS_A" "NAND2_X1" (("A" "A_4") ("B" "B_4") ("Y" "gn4") ("VDD" "VDD") ("VSS" "VSS")) ())
  ("I5" "ALU_CELLS_A" "NAND2_X1" (("A" "A_5") ("B" "B_5") ("Y" "gn5") ("VDD" "VDD") ("VSS" "VSS")) ())
  ("I6" "ALU_CELLS_A" "NAND2_X1" (("A" "A_6") ("B" "B_6") ("Y" "gn6") ("VDD" "VDD") ("VSS" "VSS")) ())
  ("I7" "ALU_CELLS_A" "NAND2_X1" (("A" "A_7") ("B" "B_7") ("Y" "gn7") ("VDD" "VDD") ("VSS" "VSS")) ())
  ("I8" "ALU_CELLS_X" "XNOR2_X1" (("A" "A_0") ("B" "B_0") ("Y" "pn0") ("VDD" "VDD") ("VSS" "VSS")) ())
  ("I9" "ALU_CELLS_X" "XNOR2_X1" (("A" "A_1") ("B" "B_1") ("Y" "pn1") ("VDD" "VDD") ("VSS" "VSS")) ())
  ("I10" "ALU_CELLS_X" "XNOR2_X1" (("A" "A_2") ("B" "B_2") ("Y" "pn2") ("VDD" "VDD") ("VSS" "VSS")) ())
  ("I11" "ALU_CELLS_X" "XNOR2_X1" (("A" "A_3") ("B" "B_3") ("Y" "pn3") ("VDD" "VDD") ("VSS" "VSS")) ())
  ("I12" "ALU_CELLS_X" "XNOR2_X1" (("A" "A_4") ("B" "B_4") ("Y" "pn4") ("VDD" "VDD") ("VSS" "VSS")) ())
  ("I13" "ALU_CELLS_X" "XNOR2_X1" (("A" "A_5") ("B" "B_5") ("Y" "pn5") ("VDD" "VDD") ("VSS" "VSS")) ())
  ("I14" "ALU_CELLS_X" "XNOR2_X1" (("A" "A_6") ("B" "B_6") ("Y" "pn6") ("VDD" "VDD") ("VSS" "VSS")) ())
  ("I15" "ALU_CELLS_X" "XNOR2_X1" (("A" "A_7") ("B" "B_7") ("Y" "pn7") ("VDD" "VDD") ("VSS" "VSS")) ())
  ("I16" "ALU_CELLS_A" "INV_X1" (("A" "CIN") ("Y" "cinn") ("VDD" "VDD") ("VSS" "VSS")) ())
  ("I17" "ALU_CELLS_A" "GRY_N" (("GIN" "gn0") ("PIN" "pn0") ("GKN" "cinn") ("GO" "G0_0") ("VDD" "VDD") ("VSS" "VSS")) ())
  ("I18" "ALU_CELLS_A" "INV_X1" (("A" "G0_0") ("Y" "G0_0n") ("VDD" "VDD") ("VSS" "VSS")) ())
  ("I19" "ALU_CELLS_A" "GRY_N" (("GIN" "gn1") ("PIN" "pn1") ("GKN" "G0_0n") ("GO" "G1_0") ("VDD" "VDD") ("VSS" "VSS")) ())
  ("I20" "ALU_CELLS_A" "BLK_N" (("GIN" "gn2") ("PIN" "pn2") ("GKN" "gn1") ("PKN" "pn1") ("GO" "G2_1") ("PO" "P2_1") ("VDD" "VDD") ("VSS" "VSS")) ())
  ("I21" "ALU_CELLS_A" "BLK_N" (("GIN" "gn3") ("PIN" "pn3") ("GKN" "gn2") ("PKN" "pn2") ("GO" "G3_2") ("PO" "P3_2") ("VDD" "VDD") ("VSS" "VSS")) ())
  ("I22" "ALU_CELLS_A" "BLK_N" (("GIN" "gn4") ("PIN" "pn4") ("GKN" "gn3") ("PKN" "pn3") ("GO" "G4_3") ("PO" "P4_3") ("VDD" "VDD") ("VSS" "VSS")) ())
  ("I23" "ALU_CELLS_A" "BLK_N" (("GIN" "gn5") ("PIN" "pn5") ("GKN" "gn4") ("PKN" "pn4") ("GO" "G5_4") ("PO" "P5_4") ("VDD" "VDD") ("VSS" "VSS")) ())
  ("I24" "ALU_CELLS_A" "BLK_N" (("GIN" "gn6") ("PIN" "pn6") ("GKN" "gn5") ("PKN" "pn5") ("GO" "G6_5") ("PO" "P6_5") ("VDD" "VDD") ("VSS" "VSS")) ())
  ("I25" "ALU_CELLS_A" "BLK_N" (("GIN" "gn7") ("PIN" "pn7") ("GKN" "gn6") ("PKN" "pn6") ("GO" "G7_6") ("PO" "P7_6") ("VDD" "VDD") ("VSS" "VSS")) ())
  ("I26" "ALU_CELLS_A" "GRY_P" (("GI" "G2_1") ("PI" "P2_1") ("GK" "G0_0") ("GON" "G2_0n") ("VDD" "VDD") ("VSS" "VSS")) ())
  ("I27" "ALU_CELLS_A" "GRY_P" (("GI" "G3_2") ("PI" "P3_2") ("GK" "G1_0") ("GON" "G3_0n") ("VDD" "VDD") ("VSS" "VSS")) ())
  ("I28" "ALU_CELLS_A" "BLK_P" (("GI" "G4_3") ("PI" "P4_3") ("GK" "G2_1") ("PK" "P2_1") ("GON" "G4_1n") ("PON" "P4_1n") ("VDD" "VDD") ("VSS" "VSS")) ())
  ("I29" "ALU_CELLS_A" "BLK_P" (("GI" "G5_4") ("PI" "P5_4") ("GK" "G3_2") ("PK" "P3_2") ("GON" "G5_2n") ("PON" "P5_2n") ("VDD" "VDD") ("VSS" "VSS")) ())
  ("I30" "ALU_CELLS_A" "BLK_P" (("GI" "G6_5") ("PI" "P6_5") ("GK" "G4_3") ("PK" "P4_3") ("GON" "G6_3n") ("PON" "P6_3n") ("VDD" "VDD") ("VSS" "VSS")) ())
  ("I31" "ALU_CELLS_A" "BLK_P" (("GI" "G7_6") ("PI" "P7_6") ("GK" "G5_4") ("PK" "P5_4") ("GON" "G7_4n") ("PON" "P7_4n") ("VDD" "VDD") ("VSS" "VSS")) ())
  ("I32" "ALU_CELLS_A" "GRY_N" (("GIN" "G4_1n") ("PIN" "P4_1n") ("GKN" "G0_0n") ("GO" "G4_0") ("VDD" "VDD") ("VSS" "VSS")) ())
  ("I33" "ALU_CELLS_A" "INV_X1" (("A" "G1_0") ("Y" "G1_0n") ("VDD" "VDD") ("VSS" "VSS")) ())
  ("I34" "ALU_CELLS_A" "GRY_N" (("GIN" "G5_2n") ("PIN" "P5_2n") ("GKN" "G1_0n") ("GO" "G5_0") ("VDD" "VDD") ("VSS" "VSS")) ())
  ("I35" "ALU_CELLS_A" "GRY_N" (("GIN" "G6_3n") ("PIN" "P6_3n") ("GKN" "G2_0n") ("GO" "C7") ("VDD" "VDD") ("VSS" "VSS")) ())
  ("I36" "ALU_CELLS_A" "GRY_N" (("GIN" "G7_4n") ("PIN" "P7_4n") ("GKN" "G3_0n") ("GO" "C8") ("VDD" "VDD") ("VSS" "VSS")) ())
  ("I37" "ALU_CELLS_X" "XNOR2_X1" (("A" "pn0") ("B" "CIN") ("Y" "S_0") ("VDD" "VDD") ("VSS" "VSS")) ())
  ("I38" "ALU_CELLS_X" "XNOR2_X1" (("A" "pn1") ("B" "G0_0") ("Y" "S_1") ("VDD" "VDD") ("VSS" "VSS")) ())
  ("I39" "ALU_CELLS_X" "XNOR2_X1" (("A" "pn2") ("B" "G1_0") ("Y" "S_2") ("VDD" "VDD") ("VSS" "VSS")) ())
  ("I40" "ALU_CELLS_X" "XOR2_X1" (("A" "pn3") ("B" "G2_0n") ("Y" "S_3") ("VDD" "VDD") ("VSS" "VSS")) ())
  ("I41" "ALU_CELLS_X" "XOR2_X1" (("A" "pn4") ("B" "G3_0n") ("Y" "S_4") ("VDD" "VDD") ("VSS" "VSS")) ())
  ("I42" "ALU_CELLS_X" "XNOR2_X1" (("A" "pn5") ("B" "G4_0") ("Y" "S_5") ("VDD" "VDD") ("VSS" "VSS")) ())
  ("I43" "ALU_CELLS_X" "XNOR2_X1" (("A" "pn6") ("B" "G5_0") ("Y" "S_6") ("VDD" "VDD") ("VSS" "VSS")) ())
  ("I44" "ALU_CELLS_X" "XNOR2_X1" (("A" "pn7") ("B" "C7") ("Y" "S_7") ("VDD" "VDD") ("VSS" "VSS")) ()))) t)
  sbErrors++ printf("SB_ERROR KSA8: %L\n" errset.errset))
unless(errset(sbCell("ALU_ADD" "ADDSUB8" '(("A_0" "input") ("A_1" "input") ("A_2" "input") ("A_3" "input") ("A_4" "input") ("A_5" "input") ("A_6" "input") ("A_7" "input") ("B_0" "input") ("B_1" "input") ("B_2" "input") ("B_3" "input") ("B_4" "input") ("B_5" "input") ("B_6" "input") ("B_7" "input") ("SUB" "input") ("S_0" "output") ("S_1" "output") ("S_2" "output") ("S_3" "output") ("S_4" "output") ("S_5" "output") ("S_6" "output") ("S_7" "output") ("C7" "output") ("C8" "output") ("VDD" "inputOutput") ("VSS" "inputOutput"))
 '(
  ("I0" "ALU_CELLS_X" "XOR2_X1" (("A" "B_0") ("B" "SUB") ("Y" "bx0") ("VDD" "VDD") ("VSS" "VSS")) ())
  ("I1" "ALU_CELLS_X" "XOR2_X1" (("A" "B_1") ("B" "SUB") ("Y" "bx1") ("VDD" "VDD") ("VSS" "VSS")) ())
  ("I2" "ALU_CELLS_X" "XOR2_X1" (("A" "B_2") ("B" "SUB") ("Y" "bx2") ("VDD" "VDD") ("VSS" "VSS")) ())
  ("I3" "ALU_CELLS_X" "XOR2_X1" (("A" "B_3") ("B" "SUB") ("Y" "bx3") ("VDD" "VDD") ("VSS" "VSS")) ())
  ("I4" "ALU_CELLS_X" "XOR2_X1" (("A" "B_4") ("B" "SUB") ("Y" "bx4") ("VDD" "VDD") ("VSS" "VSS")) ())
  ("I5" "ALU_CELLS_X" "XOR2_X1" (("A" "B_5") ("B" "SUB") ("Y" "bx5") ("VDD" "VDD") ("VSS" "VSS")) ())
  ("I6" "ALU_CELLS_X" "XOR2_X1" (("A" "B_6") ("B" "SUB") ("Y" "bx6") ("VDD" "VDD") ("VSS" "VSS")) ())
  ("I7" "ALU_CELLS_X" "XOR2_X1" (("A" "B_7") ("B" "SUB") ("Y" "bx7") ("VDD" "VDD") ("VSS" "VSS")) ())
  ("I8" "ALU_ADD" "KSA8" (("A_0" "A_0") ("A_1" "A_1") ("A_2" "A_2") ("A_3" "A_3") ("A_4" "A_4") ("A_5" "A_5") ("A_6" "A_6") ("A_7" "A_7") ("B_0" "bx0") ("B_1" "bx1") ("B_2" "bx2") ("B_3" "bx3") ("B_4" "bx4") ("B_5" "bx5") ("B_6" "bx6") ("B_7" "bx7") ("CIN" "SUB") ("S_0" "S_0") ("S_1" "S_1") ("S_2" "S_2") ("S_3" "S_3") ("S_4" "S_4") ("S_5" "S_5") ("S_6" "S_6") ("S_7" "S_7") ("C7" "C7") ("C8" "C8") ("VDD" "VDD") ("VSS" "VSS")) ()))) t)
  sbErrors++ printf("SB_ERROR ADDSUB8: %L\n" errset.errset))
unless(errset(sbCell("ALU_CORE" "LOGIC8" '(("A_0" "input") ("A_1" "input") ("A_2" "input") ("A_3" "input") ("A_4" "input") ("A_5" "input") ("A_6" "input") ("A_7" "input") ("B_0" "input") ("B_1" "input") ("B_2" "input") ("B_3" "input") ("B_4" "input") ("B_5" "input") ("B_6" "input") ("B_7" "input") ("AND_0" "output") ("AND_1" "output") ("AND_2" "output") ("AND_3" "output") ("AND_4" "output") ("AND_5" "output") ("AND_6" "output") ("AND_7" "output") ("OR_0" "output") ("OR_1" "output") ("OR_2" "output") ("OR_3" "output") ("OR_4" "output") ("OR_5" "output") ("OR_6" "output") ("OR_7" "output") ("XOR_0" "output") ("XOR_1" "output") ("XOR_2" "output") ("XOR_3" "output") ("XOR_4" "output") ("XOR_5" "output") ("XOR_6" "output") ("XOR_7" "output") ("NOT_0" "output") ("NOT_1" "output") ("NOT_2" "output") ("NOT_3" "output") ("NOT_4" "output") ("NOT_5" "output") ("NOT_6" "output") ("NOT_7" "output") ("VDD" "inputOutput") ("VSS" "inputOutput"))
 '(
  ("I0" "ALU_CELLS_A" "NAND2_X1" (("A" "A_0") ("B" "B_0") ("Y" "nand0") ("VDD" "VDD") ("VSS" "VSS")) ())
  ("I1" "ALU_CELLS_A" "INV_X1" (("A" "nand0") ("Y" "AND_0") ("VDD" "VDD") ("VSS" "VSS")) ())
  ("I2" "ALU_CELLS_A" "NOR2_X1" (("A" "A_0") ("B" "B_0") ("Y" "nor0") ("VDD" "VDD") ("VSS" "VSS")) ())
  ("I3" "ALU_CELLS_A" "INV_X1" (("A" "nor0") ("Y" "OR_0") ("VDD" "VDD") ("VSS" "VSS")) ())
  ("I4" "ALU_CELLS_X" "XOR2_X1" (("A" "A_0") ("B" "B_0") ("Y" "XOR_0") ("VDD" "VDD") ("VSS" "VSS")) ())
  ("I5" "ALU_CELLS_A" "INV_X1" (("A" "A_0") ("Y" "NOT_0") ("VDD" "VDD") ("VSS" "VSS")) ())
  ("I6" "ALU_CELLS_A" "NAND2_X1" (("A" "A_1") ("B" "B_1") ("Y" "nand1") ("VDD" "VDD") ("VSS" "VSS")) ())
  ("I7" "ALU_CELLS_A" "INV_X1" (("A" "nand1") ("Y" "AND_1") ("VDD" "VDD") ("VSS" "VSS")) ())
  ("I8" "ALU_CELLS_A" "NOR2_X1" (("A" "A_1") ("B" "B_1") ("Y" "nor1") ("VDD" "VDD") ("VSS" "VSS")) ())
  ("I9" "ALU_CELLS_A" "INV_X1" (("A" "nor1") ("Y" "OR_1") ("VDD" "VDD") ("VSS" "VSS")) ())
  ("I10" "ALU_CELLS_X" "XOR2_X1" (("A" "A_1") ("B" "B_1") ("Y" "XOR_1") ("VDD" "VDD") ("VSS" "VSS")) ())
  ("I11" "ALU_CELLS_A" "INV_X1" (("A" "A_1") ("Y" "NOT_1") ("VDD" "VDD") ("VSS" "VSS")) ())
  ("I12" "ALU_CELLS_A" "NAND2_X1" (("A" "A_2") ("B" "B_2") ("Y" "nand2") ("VDD" "VDD") ("VSS" "VSS")) ())
  ("I13" "ALU_CELLS_A" "INV_X1" (("A" "nand2") ("Y" "AND_2") ("VDD" "VDD") ("VSS" "VSS")) ())
  ("I14" "ALU_CELLS_A" "NOR2_X1" (("A" "A_2") ("B" "B_2") ("Y" "nor2") ("VDD" "VDD") ("VSS" "VSS")) ())
  ("I15" "ALU_CELLS_A" "INV_X1" (("A" "nor2") ("Y" "OR_2") ("VDD" "VDD") ("VSS" "VSS")) ())
  ("I16" "ALU_CELLS_X" "XOR2_X1" (("A" "A_2") ("B" "B_2") ("Y" "XOR_2") ("VDD" "VDD") ("VSS" "VSS")) ())
  ("I17" "ALU_CELLS_A" "INV_X1" (("A" "A_2") ("Y" "NOT_2") ("VDD" "VDD") ("VSS" "VSS")) ())
  ("I18" "ALU_CELLS_A" "NAND2_X1" (("A" "A_3") ("B" "B_3") ("Y" "nand3") ("VDD" "VDD") ("VSS" "VSS")) ())
  ("I19" "ALU_CELLS_A" "INV_X1" (("A" "nand3") ("Y" "AND_3") ("VDD" "VDD") ("VSS" "VSS")) ())
  ("I20" "ALU_CELLS_A" "NOR2_X1" (("A" "A_3") ("B" "B_3") ("Y" "nor3") ("VDD" "VDD") ("VSS" "VSS")) ())
  ("I21" "ALU_CELLS_A" "INV_X1" (("A" "nor3") ("Y" "OR_3") ("VDD" "VDD") ("VSS" "VSS")) ())
  ("I22" "ALU_CELLS_X" "XOR2_X1" (("A" "A_3") ("B" "B_3") ("Y" "XOR_3") ("VDD" "VDD") ("VSS" "VSS")) ())
  ("I23" "ALU_CELLS_A" "INV_X1" (("A" "A_3") ("Y" "NOT_3") ("VDD" "VDD") ("VSS" "VSS")) ())
  ("I24" "ALU_CELLS_A" "NAND2_X1" (("A" "A_4") ("B" "B_4") ("Y" "nand4") ("VDD" "VDD") ("VSS" "VSS")) ())
  ("I25" "ALU_CELLS_A" "INV_X1" (("A" "nand4") ("Y" "AND_4") ("VDD" "VDD") ("VSS" "VSS")) ())
  ("I26" "ALU_CELLS_A" "NOR2_X1" (("A" "A_4") ("B" "B_4") ("Y" "nor4") ("VDD" "VDD") ("VSS" "VSS")) ())
  ("I27" "ALU_CELLS_A" "INV_X1" (("A" "nor4") ("Y" "OR_4") ("VDD" "VDD") ("VSS" "VSS")) ())
  ("I28" "ALU_CELLS_X" "XOR2_X1" (("A" "A_4") ("B" "B_4") ("Y" "XOR_4") ("VDD" "VDD") ("VSS" "VSS")) ())
  ("I29" "ALU_CELLS_A" "INV_X1" (("A" "A_4") ("Y" "NOT_4") ("VDD" "VDD") ("VSS" "VSS")) ())
  ("I30" "ALU_CELLS_A" "NAND2_X1" (("A" "A_5") ("B" "B_5") ("Y" "nand5") ("VDD" "VDD") ("VSS" "VSS")) ())
  ("I31" "ALU_CELLS_A" "INV_X1" (("A" "nand5") ("Y" "AND_5") ("VDD" "VDD") ("VSS" "VSS")) ())
  ("I32" "ALU_CELLS_A" "NOR2_X1" (("A" "A_5") ("B" "B_5") ("Y" "nor5") ("VDD" "VDD") ("VSS" "VSS")) ())
  ("I33" "ALU_CELLS_A" "INV_X1" (("A" "nor5") ("Y" "OR_5") ("VDD" "VDD") ("VSS" "VSS")) ())
  ("I34" "ALU_CELLS_X" "XOR2_X1" (("A" "A_5") ("B" "B_5") ("Y" "XOR_5") ("VDD" "VDD") ("VSS" "VSS")) ())
  ("I35" "ALU_CELLS_A" "INV_X1" (("A" "A_5") ("Y" "NOT_5") ("VDD" "VDD") ("VSS" "VSS")) ())
  ("I36" "ALU_CELLS_A" "NAND2_X1" (("A" "A_6") ("B" "B_6") ("Y" "nand6") ("VDD" "VDD") ("VSS" "VSS")) ())
  ("I37" "ALU_CELLS_A" "INV_X1" (("A" "nand6") ("Y" "AND_6") ("VDD" "VDD") ("VSS" "VSS")) ())
  ("I38" "ALU_CELLS_A" "NOR2_X1" (("A" "A_6") ("B" "B_6") ("Y" "nor6") ("VDD" "VDD") ("VSS" "VSS")) ())
  ("I39" "ALU_CELLS_A" "INV_X1" (("A" "nor6") ("Y" "OR_6") ("VDD" "VDD") ("VSS" "VSS")) ())
  ("I40" "ALU_CELLS_X" "XOR2_X1" (("A" "A_6") ("B" "B_6") ("Y" "XOR_6") ("VDD" "VDD") ("VSS" "VSS")) ())
  ("I41" "ALU_CELLS_A" "INV_X1" (("A" "A_6") ("Y" "NOT_6") ("VDD" "VDD") ("VSS" "VSS")) ())
  ("I42" "ALU_CELLS_A" "NAND2_X1" (("A" "A_7") ("B" "B_7") ("Y" "nand7") ("VDD" "VDD") ("VSS" "VSS")) ())
  ("I43" "ALU_CELLS_A" "INV_X1" (("A" "nand7") ("Y" "AND_7") ("VDD" "VDD") ("VSS" "VSS")) ())
  ("I44" "ALU_CELLS_A" "NOR2_X1" (("A" "A_7") ("B" "B_7") ("Y" "nor7") ("VDD" "VDD") ("VSS" "VSS")) ())
  ("I45" "ALU_CELLS_A" "INV_X1" (("A" "nor7") ("Y" "OR_7") ("VDD" "VDD") ("VSS" "VSS")) ())
  ("I46" "ALU_CELLS_X" "XOR2_X1" (("A" "A_7") ("B" "B_7") ("Y" "XOR_7") ("VDD" "VDD") ("VSS" "VSS")) ())
  ("I47" "ALU_CELLS_A" "INV_X1" (("A" "A_7") ("Y" "NOT_7") ("VDD" "VDD") ("VSS" "VSS")) ()))) t)
  sbErrors++ printf("SB_ERROR LOGIC8: %L\n" errset.errset))
unless(errset(sbCell("ALU_CORE" "DEC_OP" '(("OP_0" "input") ("OP_1" "input") ("OP_2" "input") ("OP_3" "input") ("SEL_AS" "output") ("SEL_AND" "output") ("SEL_OR" "output") ("SEL_XOR" "output") ("SEL_NOT" "output") ("SEL_MUL" "output") ("SEL_DIV" "output") ("VDD" "inputOutput") ("VSS" "inputOutput"))
 '(
  ("I0" "ALU_CELLS_A" "INV_X1" (("A" "OP_0") ("Y" "opn0") ("VDD" "VDD") ("VSS" "VSS")) ())
  ("I1" "ALU_CELLS_A" "INV_X1" (("A" "OP_1") ("Y" "opn1") ("VDD" "VDD") ("VSS" "VSS")) ())
  ("I2" "ALU_CELLS_A" "INV_X1" (("A" "OP_2") ("Y" "opn2") ("VDD" "VDD") ("VSS" "VSS")) ())
  ("I3" "ALU_CELLS_A" "INV_X1" (("A" "OP_3") ("Y" "opn3") ("VDD" "VDD") ("VSS" "VSS")) ())
  ("I4" "ALU_CELLS_A" "NAND2_X1" (("A" "opn3") ("B" "opn2") ("Y" "h00") ("VDD" "VDD") ("VSS" "VSS")) ())
  ("I5" "ALU_CELLS_A" "NAND2_X1" (("A" "opn3") ("B" "OP_2") ("Y" "h01") ("VDD" "VDD") ("VSS" "VSS")) ())
  ("I6" "ALU_CELLS_A" "NAND2_X1" (("A" "OP_3") ("B" "opn2") ("Y" "h10") ("VDD" "VDD") ("VSS" "VSS")) ())
  ("I7" "ALU_CELLS_A" "NAND2_X1" (("A" "opn1") ("B" "opn0") ("Y" "l00") ("VDD" "VDD") ("VSS" "VSS")) ())
  ("I8" "ALU_CELLS_A" "NAND2_X1" (("A" "opn1") ("B" "OP_0") ("Y" "l01") ("VDD" "VDD") ("VSS" "VSS")) ())
  ("I9" "ALU_CELLS_A" "NAND2_X1" (("A" "OP_1") ("B" "opn0") ("Y" "l10") ("VDD" "VDD") ("VSS" "VSS")) ())
  ("I10" "ALU_CELLS_A" "NAND2_X1" (("A" "OP_1") ("B" "OP_0") ("Y" "l11") ("VDD" "VDD") ("VSS" "VSS")) ())
  ("I11" "ALU_CELLS_A" "NOR2_X1" (("A" "h00") ("B" "OP_1") ("Y" "SEL_AS") ("VDD" "VDD") ("VSS" "VSS")) ())
  ("I12" "ALU_CELLS_A" "NOR2_X1" (("A" "h00") ("B" "l10") ("Y" "SEL_AND") ("VDD" "VDD") ("VSS" "VSS")) ())
  ("I13" "ALU_CELLS_A" "NOR2_X1" (("A" "h00") ("B" "l11") ("Y" "SEL_OR") ("VDD" "VDD") ("VSS" "VSS")) ())
  ("I14" "ALU_CELLS_A" "NOR2_X1" (("A" "h01") ("B" "l00") ("Y" "SEL_XOR") ("VDD" "VDD") ("VSS" "VSS")) ())
  ("I15" "ALU_CELLS_A" "NOR2_X1" (("A" "h01") ("B" "l01") ("Y" "SEL_NOT") ("VDD" "VDD") ("VSS" "VSS")) ())
  ("I16" "ALU_CELLS_A" "NOR2_X1" (("A" "h10") ("B" "l01") ("Y" "SEL_MUL") ("VDD" "VDD") ("VSS" "VSS")) ())
  ("I17" "ALU_CELLS_A" "NOR2_X1" (("A" "h10") ("B" "l11") ("Y" "SEL_DIV") ("VDD" "VDD") ("VSS" "VSS")) ()))) t)
  sbErrors++ printf("SB_ERROR DEC_OP: %L\n" errset.errset))
unless(errset(sbCell("ALU_CORE" "OUTMUX" '(("S_0" "input") ("S_1" "input") ("S_2" "input") ("S_3" "input") ("S_4" "input") ("S_5" "input") ("S_6" "input") ("S_7" "input") ("AND_0" "input") ("AND_1" "input") ("AND_2" "input") ("AND_3" "input") ("AND_4" "input") ("AND_5" "input") ("AND_6" "input") ("AND_7" "input") ("OR_0" "input") ("OR_1" "input") ("OR_2" "input") ("OR_3" "input") ("OR_4" "input") ("OR_5" "input") ("OR_6" "input") ("OR_7" "input") ("XOR_0" "input") ("XOR_1" "input") ("XOR_2" "input") ("XOR_3" "input") ("XOR_4" "input") ("XOR_5" "input") ("XOR_6" "input") ("XOR_7" "input") ("NOT_0" "input") ("NOT_1" "input") ("NOT_2" "input") ("NOT_3" "input") ("NOT_4" "input") ("NOT_5" "input") ("NOT_6" "input") ("NOT_7" "input") ("MULP_0" "input") ("MULP_1" "input") ("MULP_2" "input") ("MULP_3" "input") ("MULP_4" "input") ("MULP_5" "input") ("MULP_6" "input") ("MULP_7" "input") ("MULP_8" "input") ("MULP_9" "input") ("MULP_10" "input") ("MULP_11" "input") ("MULP_12" "input") ("MULP_13" "input") ("MULP_14" "input") ("MULP_15" "input") ("DIVQ_0" "input") ("DIVQ_1" "input") ("DIVQ_2" "input") ("DIVQ_3" "input") ("DIVQ_4" "input") ("DIVQ_5" "input") ("DIVQ_6" "input") ("DIVQ_7" "input") ("DIVR_0" "input") ("DIVR_1" "input") ("DIVR_2" "input") ("DIVR_3" "input") ("DIVR_4" "input") ("DIVR_5" "input") ("DIVR_6" "input") ("DIVR_7" "input") ("SEL_AS" "input") ("SEL_AND" "input") ("SEL_OR" "input") ("SEL_XOR" "input") ("SEL_NOT" "input") ("SEL_MUL" "input") ("SEL_DIV" "input") ("Y_0" "output") ("Y_1" "output") ("Y_2" "output") ("Y_3" "output") ("Y_4" "output") ("Y_5" "output") ("Y_6" "output") ("Y_7" "output") ("Y_8" "output") ("Y_9" "output") ("Y_10" "output") ("Y_11" "output") ("Y_12" "output") ("Y_13" "output") ("Y_14" "output") ("Y_15" "output") ("VDD" "inputOutput") ("VSS" "inputOutput"))
 '(
  ("I0" "ALU_CELLS_A" "NAND2_X1" (("A" "SEL_AND") ("B" "AND_0") ("Y" "n0_0") ("VDD" "VDD") ("VSS" "VSS")) ())
  ("I1" "ALU_CELLS_A" "NAND2_X1" (("A" "SEL_OR") ("B" "OR_0") ("Y" "n0_1") ("VDD" "VDD") ("VSS" "VSS")) ())
  ("I2" "ALU_CELLS_A" "NAND2_X1" (("A" "SEL_XOR") ("B" "XOR_0") ("Y" "n0_2") ("VDD" "VDD") ("VSS" "VSS")) ())
  ("I3" "ALU_CELLS_A" "NAND2_X1" (("A" "SEL_NOT") ("B" "NOT_0") ("Y" "n0_3") ("VDD" "VDD") ("VSS" "VSS")) ())
  ("I4" "ALU_CELLS_A" "NAND2_X1" (("A" "SEL_MUL") ("B" "MULP_0") ("Y" "n0_4") ("VDD" "VDD") ("VSS" "VSS")) ())
  ("I5" "ALU_CELLS_A" "NAND2_X1" (("A" "SEL_DIV") ("B" "DIVQ_0") ("Y" "n0_5") ("VDD" "VDD") ("VSS" "VSS")) ())
  ("I6" "ALU_CELLS_A" "NAND2_X1" (("A" "n0_0") ("B" "n0_1") ("Y" "o0_0") ("VDD" "VDD") ("VSS" "VSS")) ())
  ("I7" "ALU_CELLS_A" "NAND2_X1" (("A" "n0_2") ("B" "n0_3") ("Y" "o0_1") ("VDD" "VDD") ("VSS" "VSS")) ())
  ("I8" "ALU_CELLS_A" "NAND2_X1" (("A" "n0_4") ("B" "n0_5") ("Y" "o0_2") ("VDD" "VDD") ("VSS" "VSS")) ())
  ("I9" "ALU_CELLS_A" "NOR2_X1" (("A" "o0_0") ("B" "o0_1") ("Y" "q0_1") ("VDD" "VDD") ("VSS" "VSS")) ())
  ("I10" "ALU_CELLS_A" "AOI21_X1" (("A1" "SEL_AS") ("A2" "S_0") ("B" "o0_2") ("Y" "q0_2") ("VDD" "VDD") ("VSS" "VSS")) ())
  ("I11" "ALU_CELLS_A" "NAND2_X1" (("A" "q0_1") ("B" "q0_2") ("Y" "Y_0") ("VDD" "VDD") ("VSS" "VSS")) ())
  ("I12" "ALU_CELLS_A" "NAND2_X1" (("A" "SEL_AND") ("B" "AND_1") ("Y" "n1_0") ("VDD" "VDD") ("VSS" "VSS")) ())
  ("I13" "ALU_CELLS_A" "NAND2_X1" (("A" "SEL_OR") ("B" "OR_1") ("Y" "n1_1") ("VDD" "VDD") ("VSS" "VSS")) ())
  ("I14" "ALU_CELLS_A" "NAND2_X1" (("A" "SEL_XOR") ("B" "XOR_1") ("Y" "n1_2") ("VDD" "VDD") ("VSS" "VSS")) ())
  ("I15" "ALU_CELLS_A" "NAND2_X1" (("A" "SEL_NOT") ("B" "NOT_1") ("Y" "n1_3") ("VDD" "VDD") ("VSS" "VSS")) ())
  ("I16" "ALU_CELLS_A" "NAND2_X1" (("A" "SEL_MUL") ("B" "MULP_1") ("Y" "n1_4") ("VDD" "VDD") ("VSS" "VSS")) ())
  ("I17" "ALU_CELLS_A" "NAND2_X1" (("A" "SEL_DIV") ("B" "DIVQ_1") ("Y" "n1_5") ("VDD" "VDD") ("VSS" "VSS")) ())
  ("I18" "ALU_CELLS_A" "NAND2_X1" (("A" "n1_0") ("B" "n1_1") ("Y" "o1_0") ("VDD" "VDD") ("VSS" "VSS")) ())
  ("I19" "ALU_CELLS_A" "NAND2_X1" (("A" "n1_2") ("B" "n1_3") ("Y" "o1_1") ("VDD" "VDD") ("VSS" "VSS")) ())
  ("I20" "ALU_CELLS_A" "NAND2_X1" (("A" "n1_4") ("B" "n1_5") ("Y" "o1_2") ("VDD" "VDD") ("VSS" "VSS")) ())
  ("I21" "ALU_CELLS_A" "NOR2_X1" (("A" "o1_0") ("B" "o1_1") ("Y" "q1_1") ("VDD" "VDD") ("VSS" "VSS")) ())
  ("I22" "ALU_CELLS_A" "AOI21_X1" (("A1" "SEL_AS") ("A2" "S_1") ("B" "o1_2") ("Y" "q1_2") ("VDD" "VDD") ("VSS" "VSS")) ())
  ("I23" "ALU_CELLS_A" "NAND2_X1" (("A" "q1_1") ("B" "q1_2") ("Y" "Y_1") ("VDD" "VDD") ("VSS" "VSS")) ())
  ("I24" "ALU_CELLS_A" "NAND2_X1" (("A" "SEL_AND") ("B" "AND_2") ("Y" "n2_0") ("VDD" "VDD") ("VSS" "VSS")) ())
  ("I25" "ALU_CELLS_A" "NAND2_X1" (("A" "SEL_OR") ("B" "OR_2") ("Y" "n2_1") ("VDD" "VDD") ("VSS" "VSS")) ())
  ("I26" "ALU_CELLS_A" "NAND2_X1" (("A" "SEL_XOR") ("B" "XOR_2") ("Y" "n2_2") ("VDD" "VDD") ("VSS" "VSS")) ())
  ("I27" "ALU_CELLS_A" "NAND2_X1" (("A" "SEL_NOT") ("B" "NOT_2") ("Y" "n2_3") ("VDD" "VDD") ("VSS" "VSS")) ())
  ("I28" "ALU_CELLS_A" "NAND2_X1" (("A" "SEL_MUL") ("B" "MULP_2") ("Y" "n2_4") ("VDD" "VDD") ("VSS" "VSS")) ())
  ("I29" "ALU_CELLS_A" "NAND2_X1" (("A" "SEL_DIV") ("B" "DIVQ_2") ("Y" "n2_5") ("VDD" "VDD") ("VSS" "VSS")) ())
  ("I30" "ALU_CELLS_A" "NAND2_X1" (("A" "n2_0") ("B" "n2_1") ("Y" "o2_0") ("VDD" "VDD") ("VSS" "VSS")) ())
  ("I31" "ALU_CELLS_A" "NAND2_X1" (("A" "n2_2") ("B" "n2_3") ("Y" "o2_1") ("VDD" "VDD") ("VSS" "VSS")) ())
  ("I32" "ALU_CELLS_A" "NAND2_X1" (("A" "n2_4") ("B" "n2_5") ("Y" "o2_2") ("VDD" "VDD") ("VSS" "VSS")) ())
  ("I33" "ALU_CELLS_A" "NOR2_X1" (("A" "o2_0") ("B" "o2_1") ("Y" "q2_1") ("VDD" "VDD") ("VSS" "VSS")) ())
  ("I34" "ALU_CELLS_A" "AOI21_X1" (("A1" "SEL_AS") ("A2" "S_2") ("B" "o2_2") ("Y" "q2_2") ("VDD" "VDD") ("VSS" "VSS")) ())
  ("I35" "ALU_CELLS_A" "NAND2_X1" (("A" "q2_1") ("B" "q2_2") ("Y" "Y_2") ("VDD" "VDD") ("VSS" "VSS")) ())
  ("I36" "ALU_CELLS_A" "NAND2_X1" (("A" "SEL_AND") ("B" "AND_3") ("Y" "n3_0") ("VDD" "VDD") ("VSS" "VSS")) ())
  ("I37" "ALU_CELLS_A" "NAND2_X1" (("A" "SEL_OR") ("B" "OR_3") ("Y" "n3_1") ("VDD" "VDD") ("VSS" "VSS")) ())
  ("I38" "ALU_CELLS_A" "NAND2_X1" (("A" "SEL_XOR") ("B" "XOR_3") ("Y" "n3_2") ("VDD" "VDD") ("VSS" "VSS")) ())
  ("I39" "ALU_CELLS_A" "NAND2_X1" (("A" "SEL_NOT") ("B" "NOT_3") ("Y" "n3_3") ("VDD" "VDD") ("VSS" "VSS")) ())
  ("I40" "ALU_CELLS_A" "NAND2_X1" (("A" "SEL_MUL") ("B" "MULP_3") ("Y" "n3_4") ("VDD" "VDD") ("VSS" "VSS")) ())
  ("I41" "ALU_CELLS_A" "NAND2_X1" (("A" "SEL_DIV") ("B" "DIVQ_3") ("Y" "n3_5") ("VDD" "VDD") ("VSS" "VSS")) ())
  ("I42" "ALU_CELLS_A" "NAND2_X1" (("A" "n3_0") ("B" "n3_1") ("Y" "o3_0") ("VDD" "VDD") ("VSS" "VSS")) ())
  ("I43" "ALU_CELLS_A" "NAND2_X1" (("A" "n3_2") ("B" "n3_3") ("Y" "o3_1") ("VDD" "VDD") ("VSS" "VSS")) ())
  ("I44" "ALU_CELLS_A" "NAND2_X1" (("A" "n3_4") ("B" "n3_5") ("Y" "o3_2") ("VDD" "VDD") ("VSS" "VSS")) ())
  ("I45" "ALU_CELLS_A" "NOR2_X1" (("A" "o3_0") ("B" "o3_1") ("Y" "q3_1") ("VDD" "VDD") ("VSS" "VSS")) ())
  ("I46" "ALU_CELLS_A" "AOI21_X1" (("A1" "SEL_AS") ("A2" "S_3") ("B" "o3_2") ("Y" "q3_2") ("VDD" "VDD") ("VSS" "VSS")) ())
  ("I47" "ALU_CELLS_A" "NAND2_X1" (("A" "q3_1") ("B" "q3_2") ("Y" "Y_3") ("VDD" "VDD") ("VSS" "VSS")) ())
  ("I48" "ALU_CELLS_A" "NAND2_X1" (("A" "SEL_AND") ("B" "AND_4") ("Y" "n4_0") ("VDD" "VDD") ("VSS" "VSS")) ())
  ("I49" "ALU_CELLS_A" "NAND2_X1" (("A" "SEL_OR") ("B" "OR_4") ("Y" "n4_1") ("VDD" "VDD") ("VSS" "VSS")) ())
  ("I50" "ALU_CELLS_A" "NAND2_X1" (("A" "SEL_XOR") ("B" "XOR_4") ("Y" "n4_2") ("VDD" "VDD") ("VSS" "VSS")) ())
  ("I51" "ALU_CELLS_A" "NAND2_X1" (("A" "SEL_NOT") ("B" "NOT_4") ("Y" "n4_3") ("VDD" "VDD") ("VSS" "VSS")) ())
  ("I52" "ALU_CELLS_A" "NAND2_X1" (("A" "SEL_MUL") ("B" "MULP_4") ("Y" "n4_4") ("VDD" "VDD") ("VSS" "VSS")) ())
  ("I53" "ALU_CELLS_A" "NAND2_X1" (("A" "SEL_DIV") ("B" "DIVQ_4") ("Y" "n4_5") ("VDD" "VDD") ("VSS" "VSS")) ())
  ("I54" "ALU_CELLS_A" "NAND2_X1" (("A" "n4_0") ("B" "n4_1") ("Y" "o4_0") ("VDD" "VDD") ("VSS" "VSS")) ())
  ("I55" "ALU_CELLS_A" "NAND2_X1" (("A" "n4_2") ("B" "n4_3") ("Y" "o4_1") ("VDD" "VDD") ("VSS" "VSS")) ())
  ("I56" "ALU_CELLS_A" "NAND2_X1" (("A" "n4_4") ("B" "n4_5") ("Y" "o4_2") ("VDD" "VDD") ("VSS" "VSS")) ())
  ("I57" "ALU_CELLS_A" "NOR2_X1" (("A" "o4_0") ("B" "o4_1") ("Y" "q4_1") ("VDD" "VDD") ("VSS" "VSS")) ())
  ("I58" "ALU_CELLS_A" "AOI21_X1" (("A1" "SEL_AS") ("A2" "S_4") ("B" "o4_2") ("Y" "q4_2") ("VDD" "VDD") ("VSS" "VSS")) ())
  ("I59" "ALU_CELLS_A" "NAND2_X1" (("A" "q4_1") ("B" "q4_2") ("Y" "Y_4") ("VDD" "VDD") ("VSS" "VSS")) ())
  ("I60" "ALU_CELLS_A" "NAND2_X1" (("A" "SEL_AND") ("B" "AND_5") ("Y" "n5_0") ("VDD" "VDD") ("VSS" "VSS")) ())
  ("I61" "ALU_CELLS_A" "NAND2_X1" (("A" "SEL_OR") ("B" "OR_5") ("Y" "n5_1") ("VDD" "VDD") ("VSS" "VSS")) ())
  ("I62" "ALU_CELLS_A" "NAND2_X1" (("A" "SEL_XOR") ("B" "XOR_5") ("Y" "n5_2") ("VDD" "VDD") ("VSS" "VSS")) ())
  ("I63" "ALU_CELLS_A" "NAND2_X1" (("A" "SEL_NOT") ("B" "NOT_5") ("Y" "n5_3") ("VDD" "VDD") ("VSS" "VSS")) ())
  ("I64" "ALU_CELLS_A" "NAND2_X1" (("A" "SEL_MUL") ("B" "MULP_5") ("Y" "n5_4") ("VDD" "VDD") ("VSS" "VSS")) ())
  ("I65" "ALU_CELLS_A" "NAND2_X1" (("A" "SEL_DIV") ("B" "DIVQ_5") ("Y" "n5_5") ("VDD" "VDD") ("VSS" "VSS")) ())
  ("I66" "ALU_CELLS_A" "NAND2_X1" (("A" "n5_0") ("B" "n5_1") ("Y" "o5_0") ("VDD" "VDD") ("VSS" "VSS")) ())
  ("I67" "ALU_CELLS_A" "NAND2_X1" (("A" "n5_2") ("B" "n5_3") ("Y" "o5_1") ("VDD" "VDD") ("VSS" "VSS")) ())
  ("I68" "ALU_CELLS_A" "NAND2_X1" (("A" "n5_4") ("B" "n5_5") ("Y" "o5_2") ("VDD" "VDD") ("VSS" "VSS")) ())
  ("I69" "ALU_CELLS_A" "NOR2_X1" (("A" "o5_0") ("B" "o5_1") ("Y" "q5_1") ("VDD" "VDD") ("VSS" "VSS")) ())
  ("I70" "ALU_CELLS_A" "AOI21_X1" (("A1" "SEL_AS") ("A2" "S_5") ("B" "o5_2") ("Y" "q5_2") ("VDD" "VDD") ("VSS" "VSS")) ())
  ("I71" "ALU_CELLS_A" "NAND2_X1" (("A" "q5_1") ("B" "q5_2") ("Y" "Y_5") ("VDD" "VDD") ("VSS" "VSS")) ())
  ("I72" "ALU_CELLS_A" "NAND2_X1" (("A" "SEL_AND") ("B" "AND_6") ("Y" "n6_0") ("VDD" "VDD") ("VSS" "VSS")) ())
  ("I73" "ALU_CELLS_A" "NAND2_X1" (("A" "SEL_OR") ("B" "OR_6") ("Y" "n6_1") ("VDD" "VDD") ("VSS" "VSS")) ())
  ("I74" "ALU_CELLS_A" "NAND2_X1" (("A" "SEL_XOR") ("B" "XOR_6") ("Y" "n6_2") ("VDD" "VDD") ("VSS" "VSS")) ())
  ("I75" "ALU_CELLS_A" "NAND2_X1" (("A" "SEL_NOT") ("B" "NOT_6") ("Y" "n6_3") ("VDD" "VDD") ("VSS" "VSS")) ())
  ("I76" "ALU_CELLS_A" "NAND2_X1" (("A" "SEL_MUL") ("B" "MULP_6") ("Y" "n6_4") ("VDD" "VDD") ("VSS" "VSS")) ())
  ("I77" "ALU_CELLS_A" "NAND2_X1" (("A" "SEL_DIV") ("B" "DIVQ_6") ("Y" "n6_5") ("VDD" "VDD") ("VSS" "VSS")) ())
  ("I78" "ALU_CELLS_A" "NAND2_X1" (("A" "n6_0") ("B" "n6_1") ("Y" "o6_0") ("VDD" "VDD") ("VSS" "VSS")) ())
  ("I79" "ALU_CELLS_A" "NAND2_X1" (("A" "n6_2") ("B" "n6_3") ("Y" "o6_1") ("VDD" "VDD") ("VSS" "VSS")) ())
  ("I80" "ALU_CELLS_A" "NAND2_X1" (("A" "n6_4") ("B" "n6_5") ("Y" "o6_2") ("VDD" "VDD") ("VSS" "VSS")) ())
  ("I81" "ALU_CELLS_A" "NOR2_X1" (("A" "o6_0") ("B" "o6_1") ("Y" "q6_1") ("VDD" "VDD") ("VSS" "VSS")) ())
  ("I82" "ALU_CELLS_A" "AOI21_X1" (("A1" "SEL_AS") ("A2" "S_6") ("B" "o6_2") ("Y" "q6_2") ("VDD" "VDD") ("VSS" "VSS")) ())
  ("I83" "ALU_CELLS_A" "NAND2_X1" (("A" "q6_1") ("B" "q6_2") ("Y" "Y_6") ("VDD" "VDD") ("VSS" "VSS")) ())
  ("I84" "ALU_CELLS_A" "NAND2_X1" (("A" "SEL_AND") ("B" "AND_7") ("Y" "n7_0") ("VDD" "VDD") ("VSS" "VSS")) ())
  ("I85" "ALU_CELLS_A" "NAND2_X1" (("A" "SEL_OR") ("B" "OR_7") ("Y" "n7_1") ("VDD" "VDD") ("VSS" "VSS")) ())
  ("I86" "ALU_CELLS_A" "NAND2_X1" (("A" "SEL_XOR") ("B" "XOR_7") ("Y" "n7_2") ("VDD" "VDD") ("VSS" "VSS")) ())
  ("I87" "ALU_CELLS_A" "NAND2_X1" (("A" "SEL_NOT") ("B" "NOT_7") ("Y" "n7_3") ("VDD" "VDD") ("VSS" "VSS")) ())
  ("I88" "ALU_CELLS_A" "NAND2_X1" (("A" "SEL_MUL") ("B" "MULP_7") ("Y" "n7_4") ("VDD" "VDD") ("VSS" "VSS")) ())
  ("I89" "ALU_CELLS_A" "NAND2_X1" (("A" "SEL_DIV") ("B" "DIVQ_7") ("Y" "n7_5") ("VDD" "VDD") ("VSS" "VSS")) ())
  ("I90" "ALU_CELLS_A" "NAND2_X1" (("A" "n7_0") ("B" "n7_1") ("Y" "o7_0") ("VDD" "VDD") ("VSS" "VSS")) ())
  ("I91" "ALU_CELLS_A" "NAND2_X1" (("A" "n7_2") ("B" "n7_3") ("Y" "o7_1") ("VDD" "VDD") ("VSS" "VSS")) ())
  ("I92" "ALU_CELLS_A" "NAND2_X1" (("A" "n7_4") ("B" "n7_5") ("Y" "o7_2") ("VDD" "VDD") ("VSS" "VSS")) ())
  ("I93" "ALU_CELLS_A" "NOR2_X1" (("A" "o7_0") ("B" "o7_1") ("Y" "q7_1") ("VDD" "VDD") ("VSS" "VSS")) ())
  ("I94" "ALU_CELLS_A" "AOI21_X1" (("A1" "SEL_AS") ("A2" "S_7") ("B" "o7_2") ("Y" "q7_2") ("VDD" "VDD") ("VSS" "VSS")) ())
  ("I95" "ALU_CELLS_A" "NAND2_X1" (("A" "q7_1") ("B" "q7_2") ("Y" "Y_7") ("VDD" "VDD") ("VSS" "VSS")) ())
  ("I96" "ALU_CELLS_A" "NAND2_X1" (("A" "SEL_MUL") ("B" "MULP_8") ("Y" "hm8") ("VDD" "VDD") ("VSS" "VSS")) ())
  ("I97" "ALU_CELLS_A" "NAND2_X1" (("A" "SEL_DIV") ("B" "DIVR_0") ("Y" "hd8") ("VDD" "VDD") ("VSS" "VSS")) ())
  ("I98" "ALU_CELLS_A" "NAND2_X1" (("A" "hm8") ("B" "hd8") ("Y" "Y_8") ("VDD" "VDD") ("VSS" "VSS")) ())
  ("I99" "ALU_CELLS_A" "NAND2_X1" (("A" "SEL_MUL") ("B" "MULP_9") ("Y" "hm9") ("VDD" "VDD") ("VSS" "VSS")) ())
  ("I100" "ALU_CELLS_A" "NAND2_X1" (("A" "SEL_DIV") ("B" "DIVR_1") ("Y" "hd9") ("VDD" "VDD") ("VSS" "VSS")) ())
  ("I101" "ALU_CELLS_A" "NAND2_X1" (("A" "hm9") ("B" "hd9") ("Y" "Y_9") ("VDD" "VDD") ("VSS" "VSS")) ())
  ("I102" "ALU_CELLS_A" "NAND2_X1" (("A" "SEL_MUL") ("B" "MULP_10") ("Y" "hm10") ("VDD" "VDD") ("VSS" "VSS")) ())
  ("I103" "ALU_CELLS_A" "NAND2_X1" (("A" "SEL_DIV") ("B" "DIVR_2") ("Y" "hd10") ("VDD" "VDD") ("VSS" "VSS")) ())
  ("I104" "ALU_CELLS_A" "NAND2_X1" (("A" "hm10") ("B" "hd10") ("Y" "Y_10") ("VDD" "VDD") ("VSS" "VSS")) ())
  ("I105" "ALU_CELLS_A" "NAND2_X1" (("A" "SEL_MUL") ("B" "MULP_11") ("Y" "hm11") ("VDD" "VDD") ("VSS" "VSS")) ())
  ("I106" "ALU_CELLS_A" "NAND2_X1" (("A" "SEL_DIV") ("B" "DIVR_3") ("Y" "hd11") ("VDD" "VDD") ("VSS" "VSS")) ())
  ("I107" "ALU_CELLS_A" "NAND2_X1" (("A" "hm11") ("B" "hd11") ("Y" "Y_11") ("VDD" "VDD") ("VSS" "VSS")) ())
  ("I108" "ALU_CELLS_A" "NAND2_X1" (("A" "SEL_MUL") ("B" "MULP_12") ("Y" "hm12") ("VDD" "VDD") ("VSS" "VSS")) ())
  ("I109" "ALU_CELLS_A" "NAND2_X1" (("A" "SEL_DIV") ("B" "DIVR_4") ("Y" "hd12") ("VDD" "VDD") ("VSS" "VSS")) ())
  ("I110" "ALU_CELLS_A" "NAND2_X1" (("A" "hm12") ("B" "hd12") ("Y" "Y_12") ("VDD" "VDD") ("VSS" "VSS")) ())
  ("I111" "ALU_CELLS_A" "NAND2_X1" (("A" "SEL_MUL") ("B" "MULP_13") ("Y" "hm13") ("VDD" "VDD") ("VSS" "VSS")) ())
  ("I112" "ALU_CELLS_A" "NAND2_X1" (("A" "SEL_DIV") ("B" "DIVR_5") ("Y" "hd13") ("VDD" "VDD") ("VSS" "VSS")) ())
  ("I113" "ALU_CELLS_A" "NAND2_X1" (("A" "hm13") ("B" "hd13") ("Y" "Y_13") ("VDD" "VDD") ("VSS" "VSS")) ())
  ("I114" "ALU_CELLS_A" "NAND2_X1" (("A" "SEL_MUL") ("B" "MULP_14") ("Y" "hm14") ("VDD" "VDD") ("VSS" "VSS")) ())
  ("I115" "ALU_CELLS_A" "NAND2_X1" (("A" "SEL_DIV") ("B" "DIVR_6") ("Y" "hd14") ("VDD" "VDD") ("VSS" "VSS")) ())
  ("I116" "ALU_CELLS_A" "NAND2_X1" (("A" "hm14") ("B" "hd14") ("Y" "Y_14") ("VDD" "VDD") ("VSS" "VSS")) ())
  ("I117" "ALU_CELLS_A" "NAND2_X1" (("A" "SEL_MUL") ("B" "MULP_15") ("Y" "hm15") ("VDD" "VDD") ("VSS" "VSS")) ())
  ("I118" "ALU_CELLS_A" "NAND2_X1" (("A" "SEL_DIV") ("B" "DIVR_7") ("Y" "hd15") ("VDD" "VDD") ("VSS" "VSS")) ())
  ("I119" "ALU_CELLS_A" "NAND2_X1" (("A" "hm15") ("B" "hd15") ("Y" "Y_15") ("VDD" "VDD") ("VSS" "VSS")) ()))) t)
  sbErrors++ printf("SB_ERROR OUTMUX: %L\n" errset.errset))
unless(errset(sbCell("ALU_CORE" "FLAGS" '(("Y_0" "input") ("Y_1" "input") ("Y_2" "input") ("Y_3" "input") ("Y_4" "input") ("Y_5" "input") ("Y_6" "input") ("Y_7" "input") ("Y_8" "input") ("Y_9" "input") ("Y_10" "input") ("Y_11" "input") ("Y_12" "input") ("Y_13" "input") ("Y_14" "input") ("Y_15" "input") ("C7" "input") ("C8" "input") ("DIVV" "input") ("DIVDZ" "input") ("SEL_AS" "input") ("SEL_DIV" "input") ("Z" "output") ("C" "output") ("V" "output") ("DZ" "output") ("VDD" "inputOutput") ("VSS" "inputOutput"))
 '(
  ("I0" "ALU_CELLS_A" "NOR2_X1" (("A" "Y_0") ("B" "Y_1") ("Y" "za0") ("VDD" "VDD") ("VSS" "VSS")) ())
  ("I1" "ALU_CELLS_A" "NOR2_X1" (("A" "Y_2") ("B" "Y_3") ("Y" "za1") ("VDD" "VDD") ("VSS" "VSS")) ())
  ("I2" "ALU_CELLS_A" "NOR2_X1" (("A" "Y_4") ("B" "Y_5") ("Y" "za2") ("VDD" "VDD") ("VSS" "VSS")) ())
  ("I3" "ALU_CELLS_A" "NOR2_X1" (("A" "Y_6") ("B" "Y_7") ("Y" "za3") ("VDD" "VDD") ("VSS" "VSS")) ())
  ("I4" "ALU_CELLS_A" "NOR2_X1" (("A" "Y_8") ("B" "Y_9") ("Y" "za4") ("VDD" "VDD") ("VSS" "VSS")) ())
  ("I5" "ALU_CELLS_A" "NOR2_X1" (("A" "Y_10") ("B" "Y_11") ("Y" "za5") ("VDD" "VDD") ("VSS" "VSS")) ())
  ("I6" "ALU_CELLS_A" "NOR2_X1" (("A" "Y_12") ("B" "Y_13") ("Y" "za6") ("VDD" "VDD") ("VSS" "VSS")) ())
  ("I7" "ALU_CELLS_A" "NOR2_X1" (("A" "Y_14") ("B" "Y_15") ("Y" "za7") ("VDD" "VDD") ("VSS" "VSS")) ())
  ("I8" "ALU_CELLS_A" "NAND2_X1" (("A" "za0") ("B" "za1") ("Y" "zb0") ("VDD" "VDD") ("VSS" "VSS")) ())
  ("I9" "ALU_CELLS_A" "NAND2_X1" (("A" "za2") ("B" "za3") ("Y" "zb1") ("VDD" "VDD") ("VSS" "VSS")) ())
  ("I10" "ALU_CELLS_A" "NAND2_X1" (("A" "za4") ("B" "za5") ("Y" "zb2") ("VDD" "VDD") ("VSS" "VSS")) ())
  ("I11" "ALU_CELLS_A" "NAND2_X1" (("A" "za6") ("B" "za7") ("Y" "zb3") ("VDD" "VDD") ("VSS" "VSS")) ())
  ("I12" "ALU_CELLS_A" "NOR2_X1" (("A" "zb0") ("B" "zb1") ("Y" "zc0") ("VDD" "VDD") ("VSS" "VSS")) ())
  ("I13" "ALU_CELLS_A" "NOR2_X1" (("A" "zb2") ("B" "zb3") ("Y" "zc1") ("VDD" "VDD") ("VSS" "VSS")) ())
  ("I14" "ALU_CELLS_A" "NAND2_X1" (("A" "zc0") ("B" "zc1") ("Y" "zd") ("VDD" "VDD") ("VSS" "VSS")) ())
  ("I15" "ALU_CELLS_A" "INV_X1" (("A" "zd") ("Y" "Z") ("VDD" "VDD") ("VSS" "VSS")) ())
  ("I16" "ALU_CELLS_A" "NAND2_X1" (("A" "C8") ("B" "SEL_AS") ("Y" "cn") ("VDD" "VDD") ("VSS" "VSS")) ())
  ("I17" "ALU_CELLS_A" "INV_X1" (("A" "cn") ("Y" "C") ("VDD" "VDD") ("VSS" "VSS")) ())
  ("I18" "ALU_CELLS_X" "XOR2_X1" (("A" "C7") ("B" "C8") ("Y" "ovf") ("VDD" "VDD") ("VSS" "VSS")) ())
  ("I19" "ALU_CELLS_A" "NAND2_X1" (("A" "SEL_AS") ("B" "ovf") ("Y" "v1") ("VDD" "VDD") ("VSS" "VSS")) ())
  ("I20" "ALU_CELLS_A" "NAND2_X1" (("A" "SEL_DIV") ("B" "DIVV") ("Y" "v2") ("VDD" "VDD") ("VSS" "VSS")) ())
  ("I21" "ALU_CELLS_A" "NAND2_X1" (("A" "v1") ("B" "v2") ("Y" "V") ("VDD" "VDD") ("VSS" "VSS")) ())
  ("I22" "ALU_CELLS_A" "NAND2_X1" (("A" "SEL_DIV") ("B" "DIVDZ") ("Y" "dzn") ("VDD" "VDD") ("VSS" "VSS")) ())
  ("I23" "ALU_CELLS_A" "INV_X1" (("A" "dzn") ("Y" "DZ") ("VDD" "VDD") ("VSS" "VSS")) ()))) t)
  sbErrors++ printf("SB_ERROR FLAGS: %L\n" errset.errset))
unless(errset(sbCell("ALU_CORE" "ALU_CORE" '(("A_0" "input") ("A_1" "input") ("A_2" "input") ("A_3" "input") ("A_4" "input") ("A_5" "input") ("A_6" "input") ("A_7" "input") ("B_0" "input") ("B_1" "input") ("B_2" "input") ("B_3" "input") ("B_4" "input") ("B_5" "input") ("B_6" "input") ("B_7" "input") ("OP_0" "input") ("OP_1" "input") ("OP_2" "input") ("OP_3" "input") ("MULP_0" "input") ("MULP_1" "input") ("MULP_2" "input") ("MULP_3" "input") ("MULP_4" "input") ("MULP_5" "input") ("MULP_6" "input") ("MULP_7" "input") ("MULP_8" "input") ("MULP_9" "input") ("MULP_10" "input") ("MULP_11" "input") ("MULP_12" "input") ("MULP_13" "input") ("MULP_14" "input") ("MULP_15" "input") ("DIVQ_0" "input") ("DIVQ_1" "input") ("DIVQ_2" "input") ("DIVQ_3" "input") ("DIVQ_4" "input") ("DIVQ_5" "input") ("DIVQ_6" "input") ("DIVQ_7" "input") ("DIVR_0" "input") ("DIVR_1" "input") ("DIVR_2" "input") ("DIVR_3" "input") ("DIVR_4" "input") ("DIVR_5" "input") ("DIVR_6" "input") ("DIVR_7" "input") ("DIVV" "input") ("DIVDZ" "input") ("Y_0" "output") ("Y_1" "output") ("Y_2" "output") ("Y_3" "output") ("Y_4" "output") ("Y_5" "output") ("Y_6" "output") ("Y_7" "output") ("Y_8" "output") ("Y_9" "output") ("Y_10" "output") ("Y_11" "output") ("Y_12" "output") ("Y_13" "output") ("Y_14" "output") ("Y_15" "output") ("Z" "output") ("C" "output") ("V" "output") ("DZ" "output") ("VDD" "inputOutput") ("VSS" "inputOutput"))
 '(
  ("I0" "ALU_CORE" "DEC_OP" (("OP_0" "OP_0") ("OP_1" "OP_1") ("OP_2" "OP_2") ("OP_3" "OP_3") ("SEL_AS" "SEL_AS") ("SEL_AND" "SEL_AND") ("SEL_OR" "SEL_OR") ("SEL_XOR" "SEL_XOR") ("SEL_NOT" "SEL_NOT") ("SEL_MUL" "SEL_MUL") ("SEL_DIV" "SEL_DIV") ("VDD" "VDD") ("VSS" "VSS")) ())
  ("I1" "ALU_ADD" "ADDSUB8" (("A_0" "A_0") ("A_1" "A_1") ("A_2" "A_2") ("A_3" "A_3") ("A_4" "A_4") ("A_5" "A_5") ("A_6" "A_6") ("A_7" "A_7") ("B_0" "B_0") ("B_1" "B_1") ("B_2" "B_2") ("B_3" "B_3") ("B_4" "B_4") ("B_5" "B_5") ("B_6" "B_6") ("B_7" "B_7") ("SUB" "OP_0") ("S_0" "S_0") ("S_1" "S_1") ("S_2" "S_2") ("S_3" "S_3") ("S_4" "S_4") ("S_5" "S_5") ("S_6" "S_6") ("S_7" "S_7") ("C7" "C7") ("C8" "C8") ("VDD" "VDD") ("VSS" "VSS")) ())
  ("I2" "ALU_CORE" "LOGIC8" (("A_0" "A_0") ("A_1" "A_1") ("A_2" "A_2") ("A_3" "A_3") ("A_4" "A_4") ("A_5" "A_5") ("A_6" "A_6") ("A_7" "A_7") ("B_0" "B_0") ("B_1" "B_1") ("B_2" "B_2") ("B_3" "B_3") ("B_4" "B_4") ("B_5" "B_5") ("B_6" "B_6") ("B_7" "B_7") ("AND_0" "AND_0") ("AND_1" "AND_1") ("AND_2" "AND_2") ("AND_3" "AND_3") ("AND_4" "AND_4") ("AND_5" "AND_5") ("AND_6" "AND_6") ("AND_7" "AND_7") ("OR_0" "OR_0") ("OR_1" "OR_1") ("OR_2" "OR_2") ("OR_3" "OR_3") ("OR_4" "OR_4") ("OR_5" "OR_5") ("OR_6" "OR_6") ("OR_7" "OR_7") ("XOR_0" "XOR_0") ("XOR_1" "XOR_1") ("XOR_2" "XOR_2") ("XOR_3" "XOR_3") ("XOR_4" "XOR_4") ("XOR_5" "XOR_5") ("XOR_6" "XOR_6") ("XOR_7" "XOR_7") ("NOT_0" "NOT_0") ("NOT_1" "NOT_1") ("NOT_2" "NOT_2") ("NOT_3" "NOT_3") ("NOT_4" "NOT_4") ("NOT_5" "NOT_5") ("NOT_6" "NOT_6") ("NOT_7" "NOT_7") ("VDD" "VDD") ("VSS" "VSS")) ())
  ("I3" "ALU_CORE" "OUTMUX" (("S_0" "S_0") ("S_1" "S_1") ("S_2" "S_2") ("S_3" "S_3") ("S_4" "S_4") ("S_5" "S_5") ("S_6" "S_6") ("S_7" "S_7") ("AND_0" "AND_0") ("AND_1" "AND_1") ("AND_2" "AND_2") ("AND_3" "AND_3") ("AND_4" "AND_4") ("AND_5" "AND_5") ("AND_6" "AND_6") ("AND_7" "AND_7") ("OR_0" "OR_0") ("OR_1" "OR_1") ("OR_2" "OR_2") ("OR_3" "OR_3") ("OR_4" "OR_4") ("OR_5" "OR_5") ("OR_6" "OR_6") ("OR_7" "OR_7") ("XOR_0" "XOR_0") ("XOR_1" "XOR_1") ("XOR_2" "XOR_2") ("XOR_3" "XOR_3") ("XOR_4" "XOR_4") ("XOR_5" "XOR_5") ("XOR_6" "XOR_6") ("XOR_7" "XOR_7") ("NOT_0" "NOT_0") ("NOT_1" "NOT_1") ("NOT_2" "NOT_2") ("NOT_3" "NOT_3") ("NOT_4" "NOT_4") ("NOT_5" "NOT_5") ("NOT_6" "NOT_6") ("NOT_7" "NOT_7") ("MULP_0" "MULP_0") ("MULP_1" "MULP_1") ("MULP_2" "MULP_2") ("MULP_3" "MULP_3") ("MULP_4" "MULP_4") ("MULP_5" "MULP_5") ("MULP_6" "MULP_6") ("MULP_7" "MULP_7") ("MULP_8" "MULP_8") ("MULP_9" "MULP_9") ("MULP_10" "MULP_10") ("MULP_11" "MULP_11") ("MULP_12" "MULP_12") ("MULP_13" "MULP_13") ("MULP_14" "MULP_14") ("MULP_15" "MULP_15") ("DIVQ_0" "DIVQ_0") ("DIVQ_1" "DIVQ_1") ("DIVQ_2" "DIVQ_2") ("DIVQ_3" "DIVQ_3") ("DIVQ_4" "DIVQ_4") ("DIVQ_5" "DIVQ_5") ("DIVQ_6" "DIVQ_6") ("DIVQ_7" "DIVQ_7") ("DIVR_0" "DIVR_0") ("DIVR_1" "DIVR_1") ("DIVR_2" "DIVR_2") ("DIVR_3" "DIVR_3") ("DIVR_4" "DIVR_4") ("DIVR_5" "DIVR_5") ("DIVR_6" "DIVR_6") ("DIVR_7" "DIVR_7") ("SEL_AS" "SEL_AS") ("SEL_AND" "SEL_AND") ("SEL_OR" "SEL_OR") ("SEL_XOR" "SEL_XOR") ("SEL_NOT" "SEL_NOT") ("SEL_MUL" "SEL_MUL") ("SEL_DIV" "SEL_DIV") ("Y_0" "Y_0") ("Y_1" "Y_1") ("Y_2" "Y_2") ("Y_3" "Y_3") ("Y_4" "Y_4") ("Y_5" "Y_5") ("Y_6" "Y_6") ("Y_7" "Y_7") ("Y_8" "Y_8") ("Y_9" "Y_9") ("Y_10" "Y_10") ("Y_11" "Y_11") ("Y_12" "Y_12") ("Y_13" "Y_13") ("Y_14" "Y_14") ("Y_15" "Y_15") ("VDD" "VDD") ("VSS" "VSS")) ())
  ("I4" "ALU_CORE" "FLAGS" (("Y_0" "Y_0") ("Y_1" "Y_1") ("Y_2" "Y_2") ("Y_3" "Y_3") ("Y_4" "Y_4") ("Y_5" "Y_5") ("Y_6" "Y_6") ("Y_7" "Y_7") ("Y_8" "Y_8") ("Y_9" "Y_9") ("Y_10" "Y_10") ("Y_11" "Y_11") ("Y_12" "Y_12") ("Y_13" "Y_13") ("Y_14" "Y_14") ("Y_15" "Y_15") ("C7" "C7") ("C8" "C8") ("DIVV" "DIVV") ("DIVDZ" "DIVDZ") ("SEL_AS" "SEL_AS") ("SEL_DIV" "SEL_DIV") ("Z" "Z") ("C" "C") ("V" "V") ("DZ" "DZ") ("VDD" "VDD") ("VSS" "VSS")) ()))) t)
  sbErrors++ printf("SB_ERROR ALU_CORE: %L\n" errset.errset))
unless(errset(sbCell("ALU_MUL" "MUL8" '(("A_0" "input") ("A_1" "input") ("A_2" "input") ("A_3" "input") ("A_4" "input") ("A_5" "input") ("A_6" "input") ("A_7" "input") ("B_0" "input") ("B_1" "input") ("B_2" "input") ("B_3" "input") ("B_4" "input") ("B_5" "input") ("B_6" "input") ("B_7" "input") ("P_0" "output") ("P_1" "output") ("P_2" "output") ("P_3" "output") ("P_4" "output") ("P_5" "output") ("P_6" "output") ("P_7" "output") ("P_8" "output") ("P_9" "output") ("P_10" "output") ("P_11" "output") ("P_12" "output") ("P_13" "output") ("P_14" "output") ("P_15" "output") ("VDD" "inputOutput") ("VSS" "inputOutput"))
 '(
  ("I0" "ALU_CELLS_B" "BOOTH_ENC" (("X2" "B_1") ("X1" "B_0") ("X0" "VSS") ("ONE" "one0") ("TWO" "two0") ("VDD" "VDD") ("VSS" "VSS")) ())
  ("I1" "ALU_CELLS_B" "BOOTH_SEL" (("AJ" "A_0") ("AJM" "VSS") ("ONE" "one0") ("TWO" "two0") ("NEG" "B_1") ("PP" "pp0_0") ("VDD" "VDD") ("VSS" "VSS")) ())
  ("I2" "ALU_CELLS_B" "BOOTH_SEL" (("AJ" "A_1") ("AJM" "A_0") ("ONE" "one0") ("TWO" "two0") ("NEG" "B_1") ("PP" "pp0_1") ("VDD" "VDD") ("VSS" "VSS")) ())
  ("I3" "ALU_CELLS_B" "BOOTH_SEL" (("AJ" "A_2") ("AJM" "A_1") ("ONE" "one0") ("TWO" "two0") ("NEG" "B_1") ("PP" "pp0_2") ("VDD" "VDD") ("VSS" "VSS")) ())
  ("I4" "ALU_CELLS_B" "BOOTH_SEL" (("AJ" "A_3") ("AJM" "A_2") ("ONE" "one0") ("TWO" "two0") ("NEG" "B_1") ("PP" "pp0_3") ("VDD" "VDD") ("VSS" "VSS")) ())
  ("I5" "ALU_CELLS_B" "BOOTH_SEL" (("AJ" "A_4") ("AJM" "A_3") ("ONE" "one0") ("TWO" "two0") ("NEG" "B_1") ("PP" "pp0_4") ("VDD" "VDD") ("VSS" "VSS")) ())
  ("I6" "ALU_CELLS_B" "BOOTH_SEL" (("AJ" "A_5") ("AJM" "A_4") ("ONE" "one0") ("TWO" "two0") ("NEG" "B_1") ("PP" "pp0_5") ("VDD" "VDD") ("VSS" "VSS")) ())
  ("I7" "ALU_CELLS_B" "BOOTH_SEL" (("AJ" "A_6") ("AJM" "A_5") ("ONE" "one0") ("TWO" "two0") ("NEG" "B_1") ("PP" "pp0_6") ("VDD" "VDD") ("VSS" "VSS")) ())
  ("I8" "ALU_CELLS_B" "BOOTH_SEL" (("AJ" "A_7") ("AJM" "A_6") ("ONE" "one0") ("TWO" "two0") ("NEG" "B_1") ("PP" "pp0_7") ("VDD" "VDD") ("VSS" "VSS")) ())
  ("I9" "ALU_CELLS_B" "BOOTH_SEL" (("AJ" "A_7") ("AJM" "A_7") ("ONE" "one0") ("TWO" "two0") ("NEG" "B_1") ("PP" "pp0_8") ("VDD" "VDD") ("VSS" "VSS")) ())
  ("I10" "ALU_CELLS_A" "INV_X1" (("A" "pp0_8") ("Y" "sn0") ("VDD" "VDD") ("VSS" "VSS")) ())
  ("I11" "ALU_CELLS_B" "BOOTH_ENC" (("X2" "B_3") ("X1" "B_2") ("X0" "B_1") ("ONE" "one1") ("TWO" "two1") ("VDD" "VDD") ("VSS" "VSS")) ())
  ("I12" "ALU_CELLS_B" "BOOTH_SEL" (("AJ" "A_0") ("AJM" "VSS") ("ONE" "one1") ("TWO" "two1") ("NEG" "B_3") ("PP" "pp1_0") ("VDD" "VDD") ("VSS" "VSS")) ())
  ("I13" "ALU_CELLS_B" "BOOTH_SEL" (("AJ" "A_1") ("AJM" "A_0") ("ONE" "one1") ("TWO" "two1") ("NEG" "B_3") ("PP" "pp1_1") ("VDD" "VDD") ("VSS" "VSS")) ())
  ("I14" "ALU_CELLS_B" "BOOTH_SEL" (("AJ" "A_2") ("AJM" "A_1") ("ONE" "one1") ("TWO" "two1") ("NEG" "B_3") ("PP" "pp1_2") ("VDD" "VDD") ("VSS" "VSS")) ())
  ("I15" "ALU_CELLS_B" "BOOTH_SEL" (("AJ" "A_3") ("AJM" "A_2") ("ONE" "one1") ("TWO" "two1") ("NEG" "B_3") ("PP" "pp1_3") ("VDD" "VDD") ("VSS" "VSS")) ())
  ("I16" "ALU_CELLS_B" "BOOTH_SEL" (("AJ" "A_4") ("AJM" "A_3") ("ONE" "one1") ("TWO" "two1") ("NEG" "B_3") ("PP" "pp1_4") ("VDD" "VDD") ("VSS" "VSS")) ())
  ("I17" "ALU_CELLS_B" "BOOTH_SEL" (("AJ" "A_5") ("AJM" "A_4") ("ONE" "one1") ("TWO" "two1") ("NEG" "B_3") ("PP" "pp1_5") ("VDD" "VDD") ("VSS" "VSS")) ())
  ("I18" "ALU_CELLS_B" "BOOTH_SEL" (("AJ" "A_6") ("AJM" "A_5") ("ONE" "one1") ("TWO" "two1") ("NEG" "B_3") ("PP" "pp1_6") ("VDD" "VDD") ("VSS" "VSS")) ())
  ("I19" "ALU_CELLS_B" "BOOTH_SEL" (("AJ" "A_7") ("AJM" "A_6") ("ONE" "one1") ("TWO" "two1") ("NEG" "B_3") ("PP" "pp1_7") ("VDD" "VDD") ("VSS" "VSS")) ())
  ("I20" "ALU_CELLS_B" "BOOTH_SEL" (("AJ" "A_7") ("AJM" "A_7") ("ONE" "one1") ("TWO" "two1") ("NEG" "B_3") ("PP" "pp1_8") ("VDD" "VDD") ("VSS" "VSS")) ())
  ("I21" "ALU_CELLS_A" "INV_X1" (("A" "pp1_8") ("Y" "sn1") ("VDD" "VDD") ("VSS" "VSS")) ())
  ("I22" "ALU_CELLS_B" "BOOTH_ENC" (("X2" "B_5") ("X1" "B_4") ("X0" "B_3") ("ONE" "one2") ("TWO" "two2") ("VDD" "VDD") ("VSS" "VSS")) ())
  ("I23" "ALU_CELLS_B" "BOOTH_SEL" (("AJ" "A_0") ("AJM" "VSS") ("ONE" "one2") ("TWO" "two2") ("NEG" "B_5") ("PP" "pp2_0") ("VDD" "VDD") ("VSS" "VSS")) ())
  ("I24" "ALU_CELLS_B" "BOOTH_SEL" (("AJ" "A_1") ("AJM" "A_0") ("ONE" "one2") ("TWO" "two2") ("NEG" "B_5") ("PP" "pp2_1") ("VDD" "VDD") ("VSS" "VSS")) ())
  ("I25" "ALU_CELLS_B" "BOOTH_SEL" (("AJ" "A_2") ("AJM" "A_1") ("ONE" "one2") ("TWO" "two2") ("NEG" "B_5") ("PP" "pp2_2") ("VDD" "VDD") ("VSS" "VSS")) ())
  ("I26" "ALU_CELLS_B" "BOOTH_SEL" (("AJ" "A_3") ("AJM" "A_2") ("ONE" "one2") ("TWO" "two2") ("NEG" "B_5") ("PP" "pp2_3") ("VDD" "VDD") ("VSS" "VSS")) ())
  ("I27" "ALU_CELLS_B" "BOOTH_SEL" (("AJ" "A_4") ("AJM" "A_3") ("ONE" "one2") ("TWO" "two2") ("NEG" "B_5") ("PP" "pp2_4") ("VDD" "VDD") ("VSS" "VSS")) ())
  ("I28" "ALU_CELLS_B" "BOOTH_SEL" (("AJ" "A_5") ("AJM" "A_4") ("ONE" "one2") ("TWO" "two2") ("NEG" "B_5") ("PP" "pp2_5") ("VDD" "VDD") ("VSS" "VSS")) ())
  ("I29" "ALU_CELLS_B" "BOOTH_SEL" (("AJ" "A_6") ("AJM" "A_5") ("ONE" "one2") ("TWO" "two2") ("NEG" "B_5") ("PP" "pp2_6") ("VDD" "VDD") ("VSS" "VSS")) ())
  ("I30" "ALU_CELLS_B" "BOOTH_SEL" (("AJ" "A_7") ("AJM" "A_6") ("ONE" "one2") ("TWO" "two2") ("NEG" "B_5") ("PP" "pp2_7") ("VDD" "VDD") ("VSS" "VSS")) ())
  ("I31" "ALU_CELLS_B" "BOOTH_SEL" (("AJ" "A_7") ("AJM" "A_7") ("ONE" "one2") ("TWO" "two2") ("NEG" "B_5") ("PP" "pp2_8") ("VDD" "VDD") ("VSS" "VSS")) ())
  ("I32" "ALU_CELLS_A" "INV_X1" (("A" "pp2_8") ("Y" "sn2") ("VDD" "VDD") ("VSS" "VSS")) ())
  ("I33" "ALU_CELLS_B" "BOOTH_ENC" (("X2" "B_7") ("X1" "B_6") ("X0" "B_5") ("ONE" "one3") ("TWO" "two3") ("VDD" "VDD") ("VSS" "VSS")) ())
  ("I34" "ALU_CELLS_B" "BOOTH_SEL" (("AJ" "A_0") ("AJM" "VSS") ("ONE" "one3") ("TWO" "two3") ("NEG" "B_7") ("PP" "pp3_0") ("VDD" "VDD") ("VSS" "VSS")) ())
  ("I35" "ALU_CELLS_B" "BOOTH_SEL" (("AJ" "A_1") ("AJM" "A_0") ("ONE" "one3") ("TWO" "two3") ("NEG" "B_7") ("PP" "pp3_1") ("VDD" "VDD") ("VSS" "VSS")) ())
  ("I36" "ALU_CELLS_B" "BOOTH_SEL" (("AJ" "A_2") ("AJM" "A_1") ("ONE" "one3") ("TWO" "two3") ("NEG" "B_7") ("PP" "pp3_2") ("VDD" "VDD") ("VSS" "VSS")) ())
  ("I37" "ALU_CELLS_B" "BOOTH_SEL" (("AJ" "A_3") ("AJM" "A_2") ("ONE" "one3") ("TWO" "two3") ("NEG" "B_7") ("PP" "pp3_3") ("VDD" "VDD") ("VSS" "VSS")) ())
  ("I38" "ALU_CELLS_B" "BOOTH_SEL" (("AJ" "A_4") ("AJM" "A_3") ("ONE" "one3") ("TWO" "two3") ("NEG" "B_7") ("PP" "pp3_4") ("VDD" "VDD") ("VSS" "VSS")) ())
  ("I39" "ALU_CELLS_B" "BOOTH_SEL" (("AJ" "A_5") ("AJM" "A_4") ("ONE" "one3") ("TWO" "two3") ("NEG" "B_7") ("PP" "pp3_5") ("VDD" "VDD") ("VSS" "VSS")) ())
  ("I40" "ALU_CELLS_B" "BOOTH_SEL" (("AJ" "A_6") ("AJM" "A_5") ("ONE" "one3") ("TWO" "two3") ("NEG" "B_7") ("PP" "pp3_6") ("VDD" "VDD") ("VSS" "VSS")) ())
  ("I41" "ALU_CELLS_B" "BOOTH_SEL" (("AJ" "A_7") ("AJM" "A_6") ("ONE" "one3") ("TWO" "two3") ("NEG" "B_7") ("PP" "pp3_7") ("VDD" "VDD") ("VSS" "VSS")) ())
  ("I42" "ALU_CELLS_B" "BOOTH_SEL" (("AJ" "A_7") ("AJM" "A_7") ("ONE" "one3") ("TWO" "two3") ("NEG" "B_7") ("PP" "pp3_8") ("VDD" "VDD") ("VSS" "VSS")) ())
  ("I43" "ALU_CELLS_A" "INV_X1" (("A" "pp3_8") ("Y" "sn3") ("VDD" "VDD") ("VSS" "VSS")) ())
  ("I44" "ALU_CELLS_C" "FA_X1" (("A" "pp0_2") ("B" "pp1_0") ("CI" "B_3") ("S" "fa1_0") ("CO" "fa1_1") ("VDD" "VDD") ("VSS" "VSS")) ())
  ("I45" "ALU_CELLS_C" "HA_X1" (("A" "pp0_3") ("B" "pp1_1") ("S" "ha2_0") ("CO" "ha2_1") ("VDD" "VDD") ("VSS" "VSS")) ())
  ("I46" "ALU_CELLS_C" "FA_X1" (("A" "pp0_4") ("B" "pp1_2") ("CI" "pp2_0") ("S" "fa3_0") ("CO" "fa3_1") ("VDD" "VDD") ("VSS" "VSS")) ())
  ("I47" "ALU_CELLS_C" "FA_X1" (("A" "pp0_5") ("B" "pp1_3") ("CI" "pp2_1") ("S" "fa4_0") ("CO" "fa4_1") ("VDD" "VDD") ("VSS" "VSS")) ())
  ("I48" "ALU_CELLS_B" "CMP42" (("X1" "pp0_6") ("X2" "pp1_4") ("X3" "pp2_2") ("X4" "pp3_0") ("CI" "B_7") ("S" "cm5_0") ("C" "cm5_1") ("CO" "cm5_2") ("VDD" "VDD") ("VSS" "VSS")) ())
  ("I49" "ALU_CELLS_B" "CMP42" (("X1" "pp0_7") ("X2" "pp1_5") ("X3" "pp2_3") ("X4" "pp3_1") ("CI" "cm5_2") ("S" "cm6_0") ("C" "cm6_1") ("CO" "cm6_2") ("VDD" "VDD") ("VSS" "VSS")) ())
  ("I50" "ALU_CELLS_B" "CMP42" (("X1" "pp0_8") ("X2" "pp1_6") ("X3" "pp2_4") ("X4" "pp3_2") ("CI" "cm6_2") ("S" "cm7_0") ("C" "cm7_1") ("CO" "cm7_2") ("VDD" "VDD") ("VSS" "VSS")) ())
  ("I51" "ALU_CELLS_B" "CMP42" (("X1" "pp0_8") ("X2" "pp1_7") ("X3" "pp2_5") ("X4" "pp3_3") ("CI" "cm7_2") ("S" "cm8_0") ("C" "cm8_1") ("CO" "cm8_2") ("VDD" "VDD") ("VSS" "VSS")) ())
  ("I52" "ALU_CELLS_B" "CMP42" (("X1" "pp0_8") ("X2" "pp1_8") ("X3" "pp2_6") ("X4" "pp3_4") ("CI" "cm8_2") ("S" "cm9_0") ("C" "cm9_1") ("CO" "cm9_2") ("VDD" "VDD") ("VSS" "VSS")) ())
  ("I53" "ALU_CELLS_B" "CMP42" (("X1" "sn0") ("X2" "sn1") ("X3" "pp2_7") ("X4" "pp3_5") ("CI" "cm9_2") ("S" "cm10_0") ("C" "cm10_1") ("CO" "cm10_2") ("VDD" "VDD") ("VSS" "VSS")) ())
  ("I54" "ALU_CELLS_B" "CMP42" (("X1" "VDD") ("X2" "pp2_8") ("X3" "pp3_6") ("X4" "VSS") ("CI" "cm10_2") ("S" "cm11_0") ("C" "cm11_1") ("CO" "cm11_2") ("VDD" "VDD") ("VSS" "VSS")) ())
  ("I55" "ALU_CELLS_C" "FA_X1" (("A" "sn2") ("B" "pp3_7") ("CI" "cm11_2") ("S" "fa12_0") ("CO" "fa12_1") ("VDD" "VDD") ("VSS" "VSS")) ())
  ("I56" "ALU_CELLS_C" "HA_X1" (("A" "VDD") ("B" "pp3_8") ("S" "ha13_0") ("CO" "ha13_1") ("VDD" "VDD") ("VSS" "VSS")) ())
  ("I57" "ALU_CELLS_C" "FA_X1" (("A" "ha2_1") ("B" "fa3_0") ("CI" "B_5") ("S" "fa14_0") ("CO" "fa14_1") ("VDD" "VDD") ("VSS" "VSS")) ())
  ("I58" "ALU_CELLS_C" "HA_X1" (("A" "fa3_1") ("B" "fa4_0") ("S" "ha15_0") ("CO" "ha15_1") ("VDD" "VDD") ("VSS" "VSS")) ())
  ("I59" "ALU_CELLS_C" "HA_X1" (("A" "fa4_1") ("B" "cm5_0") ("S" "ha16_0") ("CO" "ha16_1") ("VDD" "VDD") ("VSS" "VSS")) ())
  ("I60" "ALU_CELLS_C" "HA_X1" (("A" "cm5_1") ("B" "cm6_0") ("S" "ha17_0") ("CO" "ha17_1") ("VDD" "VDD") ("VSS" "VSS")) ())
  ("I61" "ALU_CELLS_C" "HA_X1" (("A" "cm6_1") ("B" "cm7_0") ("S" "ha18_0") ("CO" "ha18_1") ("VDD" "VDD") ("VSS" "VSS")) ())
  ("I62" "ALU_CELLS_C" "HA_X1" (("A" "cm7_1") ("B" "cm8_0") ("S" "ha19_0") ("CO" "ha19_1") ("VDD" "VDD") ("VSS" "VSS")) ())
  ("I63" "ALU_CELLS_C" "HA_X1" (("A" "cm8_1") ("B" "cm9_0") ("S" "ha20_0") ("CO" "ha20_1") ("VDD" "VDD") ("VSS" "VSS")) ())
  ("I64" "ALU_CELLS_C" "HA_X1" (("A" "cm9_1") ("B" "cm10_0") ("S" "ha21_0") ("CO" "ha21_1") ("VDD" "VDD") ("VSS" "VSS")) ())
  ("I65" "ALU_CELLS_C" "HA_X1" (("A" "cm10_1") ("B" "cm11_0") ("S" "ha22_0") ("CO" "ha22_1") ("VDD" "VDD") ("VSS" "VSS")) ())
  ("I66" "ALU_CELLS_C" "HA_X1" (("A" "cm11_1") ("B" "fa12_0") ("S" "ha23_0") ("CO" "ha23_1") ("VDD" "VDD") ("VSS" "VSS")) ())
  ("I67" "ALU_CELLS_C" "HA_X1" (("A" "fa12_1") ("B" "ha13_0") ("S" "ha24_0") ("CO" "ha24_1") ("VDD" "VDD") ("VSS" "VSS")) ())
  ("I68" "ALU_CELLS_C" "HA_X1" (("A" "ha13_1") ("B" "sn3") ("S" "ha25_0") ("CO" "ha25_1") ("VDD" "VDD") ("VSS" "VSS")) ())
  ("I69" "ALU_CELLS_C" "HA_X1" (("A" "pp0_0") ("B" "B_1") ("S" "P_0") ("CO" "rc1") ("VDD" "VDD") ("VSS" "VSS")) ())
  ("I70" "ALU_CELLS_C" "HA_X1" (("A" "pp0_1") ("B" "rc1") ("S" "P_1") ("CO" "rc2") ("VDD" "VDD") ("VSS" "VSS")) ())
  ("I71" "ALU_CELLS_C" "HA_X1" (("A" "fa1_0") ("B" "rc2") ("S" "P_2") ("CO" "rc3") ("VDD" "VDD") ("VSS" "VSS")) ())
  ("I72" "ALU_CELLS_C" "FA_X1" (("A" "fa1_1") ("B" "ha2_0") ("CI" "rc3") ("S" "P_3") ("CO" "rc4") ("VDD" "VDD") ("VSS" "VSS")) ())
  ("I73" "ALU_CELLS_C" "HA_X1" (("A" "fa14_0") ("B" "rc4") ("S" "P_4") ("CO" "rc5") ("VDD" "VDD") ("VSS" "VSS")) ())
  ("I74" "ALU_CELLS_C" "FA_X1" (("A" "fa14_1") ("B" "ha15_0") ("CI" "rc5") ("S" "P_5") ("CO" "rc6") ("VDD" "VDD") ("VSS" "VSS")) ())
  ("I75" "ALU_CELLS_C" "FA_X1" (("A" "ha15_1") ("B" "ha16_0") ("CI" "rc6") ("S" "P_6") ("CO" "rc7") ("VDD" "VDD") ("VSS" "VSS")) ())
  ("I76" "ALU_CELLS_C" "FA_X1" (("A" "ha16_1") ("B" "ha17_0") ("CI" "rc7") ("S" "P_7") ("CO" "rc8") ("VDD" "VDD") ("VSS" "VSS")) ())
  ("I77" "ALU_ADD" "KSA8" (("A_0" "ha17_1") ("A_1" "ha18_1") ("A_2" "ha19_1") ("A_3" "ha20_1") ("A_4" "ha21_1") ("A_5" "ha22_1") ("A_6" "ha23_1") ("A_7" "ha24_1") ("B_0" "ha18_0") ("B_1" "ha19_0") ("B_2" "ha20_0") ("B_3" "ha21_0") ("B_4" "ha22_0") ("B_5" "ha23_0") ("B_6" "ha24_0") ("B_7" "ha25_0") ("CIN" "rc8") ("S_0" "P_8") ("S_1" "P_9") ("S_2" "P_10") ("S_3" "P_11") ("S_4" "P_12") ("S_5" "P_13") ("S_6" "P_14") ("S_7" "P_15") ("C7" "kc7") ("C8" "kc8") ("VDD" "VDD") ("VSS" "VSS")) ()))) t)
  sbErrors++ printf("SB_ERROR MUL8: %L\n" errset.errset))
unless(errset(sbCell("ALU_DIV" "DIV8K" '(("A_0" "input") ("A_1" "input") ("A_2" "input") ("A_3" "input") ("A_4" "input") ("A_5" "input") ("A_6" "input") ("A_7" "input") ("B_0" "input") ("B_1" "input") ("B_2" "input") ("B_3" "input") ("B_4" "input") ("B_5" "input") ("B_6" "input") ("B_7" "input") ("Q_0" "output") ("Q_1" "output") ("Q_2" "output") ("Q_3" "output") ("Q_4" "output") ("Q_5" "output") ("Q_6" "output") ("Q_7" "output") ("R_0" "output") ("R_1" "output") ("R_2" "output") ("R_3" "output") ("R_4" "output") ("R_5" "output") ("R_6" "output") ("R_7" "output") ("V" "output") ("DZ" "output") ("VDD" "inputOutput") ("VSS" "inputOutput"))
 '(
  ("I0" "ALU_CELLS_A" "NAND2_X1" (("A" "A_7") ("B" "A_0") ("Y" "nakn1") ("VDD" "VDD") ("VSS" "VSS")) ())
  ("I1" "ALU_CELLS_X" "XNOR2_X1" (("A" "A_1") ("B" "nakn1") ("Y" "aa1") ("VDD" "VDD") ("VSS" "VSS")) ())
  ("I2" "ALU_CELLS_A" "INV_X1" (("A" "nakn1") ("Y" "nak1") ("VDD" "VDD") ("VSS" "VSS")) ())
  ("I3" "ALU_CELLS_A" "AOI21_X1" (("A1" "A_7") ("A2" "A_1") ("B" "nak1") ("Y" "nakn2") ("VDD" "VDD") ("VSS" "VSS")) ())
  ("I4" "ALU_CELLS_X" "XNOR2_X1" (("A" "A_2") ("B" "nakn2") ("Y" "aa2") ("VDD" "VDD") ("VSS" "VSS")) ())
  ("I5" "ALU_CELLS_A" "INV_X1" (("A" "nakn2") ("Y" "nak2") ("VDD" "VDD") ("VSS" "VSS")) ())
  ("I6" "ALU_CELLS_A" "AOI21_X1" (("A1" "A_7") ("A2" "A_2") ("B" "nak2") ("Y" "nakn3") ("VDD" "VDD") ("VSS" "VSS")) ())
  ("I7" "ALU_CELLS_X" "XNOR2_X1" (("A" "A_3") ("B" "nakn3") ("Y" "aa3") ("VDD" "VDD") ("VSS" "VSS")) ())
  ("I8" "ALU_CELLS_A" "INV_X1" (("A" "nakn3") ("Y" "nak3") ("VDD" "VDD") ("VSS" "VSS")) ())
  ("I9" "ALU_CELLS_A" "AOI21_X1" (("A1" "A_7") ("A2" "A_3") ("B" "nak3") ("Y" "nakn4") ("VDD" "VDD") ("VSS" "VSS")) ())
  ("I10" "ALU_CELLS_X" "XNOR2_X1" (("A" "A_4") ("B" "nakn4") ("Y" "aa4") ("VDD" "VDD") ("VSS" "VSS")) ())
  ("I11" "ALU_CELLS_A" "INV_X1" (("A" "nakn4") ("Y" "nak4") ("VDD" "VDD") ("VSS" "VSS")) ())
  ("I12" "ALU_CELLS_A" "AOI21_X1" (("A1" "A_7") ("A2" "A_4") ("B" "nak4") ("Y" "nakn5") ("VDD" "VDD") ("VSS" "VSS")) ())
  ("I13" "ALU_CELLS_X" "XNOR2_X1" (("A" "A_5") ("B" "nakn5") ("Y" "aa5") ("VDD" "VDD") ("VSS" "VSS")) ())
  ("I14" "ALU_CELLS_A" "INV_X1" (("A" "nakn5") ("Y" "nak5") ("VDD" "VDD") ("VSS" "VSS")) ())
  ("I15" "ALU_CELLS_A" "AOI21_X1" (("A1" "A_7") ("A2" "A_5") ("B" "nak5") ("Y" "nakn6") ("VDD" "VDD") ("VSS" "VSS")) ())
  ("I16" "ALU_CELLS_X" "XNOR2_X1" (("A" "A_6") ("B" "nakn6") ("Y" "aa6") ("VDD" "VDD") ("VSS" "VSS")) ())
  ("I17" "ALU_CELLS_A" "INV_X1" (("A" "nakn6") ("Y" "nak6") ("VDD" "VDD") ("VSS" "VSS")) ())
  ("I18" "ALU_CELLS_A" "AOI21_X1" (("A1" "A_7") ("A2" "A_6") ("B" "nak6") ("Y" "nakn7") ("VDD" "VDD") ("VSS" "VSS")) ())
  ("I19" "ALU_CELLS_X" "XNOR2_X1" (("A" "A_7") ("B" "nakn7") ("Y" "aa7") ("VDD" "VDD") ("VSS" "VSS")) ())
  ("I20" "ALU_CELLS_A" "NAND2_X1" (("A" "B_7") ("B" "B_0") ("Y" "nbkn1") ("VDD" "VDD") ("VSS" "VSS")) ())
  ("I21" "ALU_CELLS_X" "XNOR2_X1" (("A" "B_1") ("B" "nbkn1") ("Y" "dd1") ("VDD" "VDD") ("VSS" "VSS")) ())
  ("I22" "ALU_CELLS_A" "INV_X1" (("A" "nbkn1") ("Y" "nbk1") ("VDD" "VDD") ("VSS" "VSS")) ())
  ("I23" "ALU_CELLS_A" "AOI21_X1" (("A1" "B_7") ("A2" "B_1") ("B" "nbk1") ("Y" "nbkn2") ("VDD" "VDD") ("VSS" "VSS")) ())
  ("I24" "ALU_CELLS_X" "XNOR2_X1" (("A" "B_2") ("B" "nbkn2") ("Y" "dd2") ("VDD" "VDD") ("VSS" "VSS")) ())
  ("I25" "ALU_CELLS_A" "INV_X1" (("A" "nbkn2") ("Y" "nbk2") ("VDD" "VDD") ("VSS" "VSS")) ())
  ("I26" "ALU_CELLS_A" "AOI21_X1" (("A1" "B_7") ("A2" "B_2") ("B" "nbk2") ("Y" "nbkn3") ("VDD" "VDD") ("VSS" "VSS")) ())
  ("I27" "ALU_CELLS_X" "XNOR2_X1" (("A" "B_3") ("B" "nbkn3") ("Y" "dd3") ("VDD" "VDD") ("VSS" "VSS")) ())
  ("I28" "ALU_CELLS_A" "INV_X1" (("A" "nbkn3") ("Y" "nbk3") ("VDD" "VDD") ("VSS" "VSS")) ())
  ("I29" "ALU_CELLS_A" "AOI21_X1" (("A1" "B_7") ("A2" "B_3") ("B" "nbk3") ("Y" "nbkn4") ("VDD" "VDD") ("VSS" "VSS")) ())
  ("I30" "ALU_CELLS_X" "XNOR2_X1" (("A" "B_4") ("B" "nbkn4") ("Y" "dd4") ("VDD" "VDD") ("VSS" "VSS")) ())
  ("I31" "ALU_CELLS_A" "INV_X1" (("A" "nbkn4") ("Y" "nbk4") ("VDD" "VDD") ("VSS" "VSS")) ())
  ("I32" "ALU_CELLS_A" "AOI21_X1" (("A1" "B_7") ("A2" "B_4") ("B" "nbk4") ("Y" "nbkn5") ("VDD" "VDD") ("VSS" "VSS")) ())
  ("I33" "ALU_CELLS_X" "XNOR2_X1" (("A" "B_5") ("B" "nbkn5") ("Y" "dd5") ("VDD" "VDD") ("VSS" "VSS")) ())
  ("I34" "ALU_CELLS_A" "INV_X1" (("A" "nbkn5") ("Y" "nbk5") ("VDD" "VDD") ("VSS" "VSS")) ())
  ("I35" "ALU_CELLS_A" "AOI21_X1" (("A1" "B_7") ("A2" "B_5") ("B" "nbk5") ("Y" "nbkn6") ("VDD" "VDD") ("VSS" "VSS")) ())
  ("I36" "ALU_CELLS_X" "XNOR2_X1" (("A" "B_6") ("B" "nbkn6") ("Y" "dd6") ("VDD" "VDD") ("VSS" "VSS")) ())
  ("I37" "ALU_CELLS_A" "INV_X1" (("A" "nbkn6") ("Y" "nbk6") ("VDD" "VDD") ("VSS" "VSS")) ())
  ("I38" "ALU_CELLS_A" "AOI21_X1" (("A1" "B_7") ("A2" "B_6") ("B" "nbk6") ("Y" "nbkn7") ("VDD" "VDD") ("VSS" "VSS")) ())
  ("I39" "ALU_CELLS_X" "XNOR2_X1" (("A" "B_7") ("B" "nbkn7") ("Y" "dd7") ("VDD" "VDD") ("VSS" "VSS")) ())
  ("I40" "ALU_CELLS_X" "XOR2_X1" (("A" "B_0") ("B" "VDD") ("Y" "b0_0") ("VDD" "VDD") ("VSS" "VSS")) ())
  ("I41" "ALU_CELLS_X" "XOR2_X1" (("A" "dd1") ("B" "VDD") ("Y" "b0_1") ("VDD" "VDD") ("VSS" "VSS")) ())
  ("I42" "ALU_CELLS_X" "XOR2_X1" (("A" "dd2") ("B" "VDD") ("Y" "b0_2") ("VDD" "VDD") ("VSS" "VSS")) ())
  ("I43" "ALU_CELLS_X" "XOR2_X1" (("A" "dd3") ("B" "VDD") ("Y" "b0_3") ("VDD" "VDD") ("VSS" "VSS")) ())
  ("I44" "ALU_CELLS_X" "XOR2_X1" (("A" "dd4") ("B" "VDD") ("Y" "b0_4") ("VDD" "VDD") ("VSS" "VSS")) ())
  ("I45" "ALU_CELLS_X" "XOR2_X1" (("A" "dd5") ("B" "VDD") ("Y" "b0_5") ("VDD" "VDD") ("VSS" "VSS")) ())
  ("I46" "ALU_CELLS_X" "XOR2_X1" (("A" "dd6") ("B" "VDD") ("Y" "b0_6") ("VDD" "VDD") ("VSS" "VSS")) ())
  ("I47" "ALU_CELLS_X" "XOR2_X1" (("A" "dd7") ("B" "VDD") ("Y" "b0_7") ("VDD" "VDD") ("VSS" "VSS")) ())
  ("I48" "ALU_ADD" "KSA8" (("A_0" "aa7") ("A_1" "VSS") ("A_2" "VSS") ("A_3" "VSS") ("A_4" "VSS") ("A_5" "VSS") ("A_6" "VSS") ("A_7" "VSS") ("B_0" "b0_0") ("B_1" "b0_1") ("B_2" "b0_2") ("B_3" "b0_3") ("B_4" "b0_4") ("B_5" "b0_5") ("B_6" "b0_6") ("B_7" "b0_7") ("CIN" "VDD") ("S_0" "p0_0") ("S_1" "p0_1") ("S_2" "p0_2") ("S_3" "p0_3") ("S_4" "p0_4") ("S_5" "p0_5") ("S_6" "p0_6") ("S_7" "p0_7") ("C7" "c0_7") ("C8" "c0_8") ("VDD" "VDD") ("VSS" "VSS")) ())
  ("I49" "ALU_CELLS_X" "XOR2_X1" (("A" "VSS") ("B" "VDD") ("Y" "h0") ("VDD" "VDD") ("VSS" "VSS")) ())
  ("I50" "ALU_CELLS_X" "XOR2_X1" (("A" "h0") ("B" "c0_8") ("Y" "p0_8") ("VDD" "VDD") ("VSS" "VSS")) ())
  ("I51" "ALU_CELLS_C" "INV_X4" (("A" "p0_8") ("Y" "qu7") ("VDD" "VDD") ("VSS" "VSS")) ())
  ("I52" "ALU_CELLS_X" "XOR2_X1" (("A" "B_0") ("B" "qu7") ("Y" "b1_0") ("VDD" "VDD") ("VSS" "VSS")) ())
  ("I53" "ALU_CELLS_X" "XOR2_X1" (("A" "dd1") ("B" "qu7") ("Y" "b1_1") ("VDD" "VDD") ("VSS" "VSS")) ())
  ("I54" "ALU_CELLS_X" "XOR2_X1" (("A" "dd2") ("B" "qu7") ("Y" "b1_2") ("VDD" "VDD") ("VSS" "VSS")) ())
  ("I55" "ALU_CELLS_X" "XOR2_X1" (("A" "dd3") ("B" "qu7") ("Y" "b1_3") ("VDD" "VDD") ("VSS" "VSS")) ())
  ("I56" "ALU_CELLS_X" "XOR2_X1" (("A" "dd4") ("B" "qu7") ("Y" "b1_4") ("VDD" "VDD") ("VSS" "VSS")) ())
  ("I57" "ALU_CELLS_X" "XOR2_X1" (("A" "dd5") ("B" "qu7") ("Y" "b1_5") ("VDD" "VDD") ("VSS" "VSS")) ())
  ("I58" "ALU_CELLS_X" "XOR2_X1" (("A" "dd6") ("B" "qu7") ("Y" "b1_6") ("VDD" "VDD") ("VSS" "VSS")) ())
  ("I59" "ALU_CELLS_X" "XOR2_X1" (("A" "dd7") ("B" "qu7") ("Y" "b1_7") ("VDD" "VDD") ("VSS" "VSS")) ())
  ("I60" "ALU_ADD" "KSA8" (("A_0" "aa6") ("A_1" "p0_0") ("A_2" "p0_1") ("A_3" "p0_2") ("A_4" "p0_3") ("A_5" "p0_4") ("A_6" "p0_5") ("A_7" "p0_6") ("B_0" "b1_0") ("B_1" "b1_1") ("B_2" "b1_2") ("B_3" "b1_3") ("B_4" "b1_4") ("B_5" "b1_5") ("B_6" "b1_6") ("B_7" "b1_7") ("CIN" "qu7") ("S_0" "p1_0") ("S_1" "p1_1") ("S_2" "p1_2") ("S_3" "p1_3") ("S_4" "p1_4") ("S_5" "p1_5") ("S_6" "p1_6") ("S_7" "p1_7") ("C7" "c1_7") ("C8" "c1_8") ("VDD" "VDD") ("VSS" "VSS")) ())
  ("I61" "ALU_CELLS_X" "XOR2_X1" (("A" "p0_7") ("B" "qu7") ("Y" "h1") ("VDD" "VDD") ("VSS" "VSS")) ())
  ("I62" "ALU_CELLS_X" "XOR2_X1" (("A" "h1") ("B" "c1_8") ("Y" "p1_8") ("VDD" "VDD") ("VSS" "VSS")) ())
  ("I63" "ALU_CELLS_C" "INV_X4" (("A" "p1_8") ("Y" "qu6") ("VDD" "VDD") ("VSS" "VSS")) ())
  ("I64" "ALU_CELLS_X" "XOR2_X1" (("A" "B_0") ("B" "qu6") ("Y" "b2_0") ("VDD" "VDD") ("VSS" "VSS")) ())
  ("I65" "ALU_CELLS_X" "XOR2_X1" (("A" "dd1") ("B" "qu6") ("Y" "b2_1") ("VDD" "VDD") ("VSS" "VSS")) ())
  ("I66" "ALU_CELLS_X" "XOR2_X1" (("A" "dd2") ("B" "qu6") ("Y" "b2_2") ("VDD" "VDD") ("VSS" "VSS")) ())
  ("I67" "ALU_CELLS_X" "XOR2_X1" (("A" "dd3") ("B" "qu6") ("Y" "b2_3") ("VDD" "VDD") ("VSS" "VSS")) ())
  ("I68" "ALU_CELLS_X" "XOR2_X1" (("A" "dd4") ("B" "qu6") ("Y" "b2_4") ("VDD" "VDD") ("VSS" "VSS")) ())
  ("I69" "ALU_CELLS_X" "XOR2_X1" (("A" "dd5") ("B" "qu6") ("Y" "b2_5") ("VDD" "VDD") ("VSS" "VSS")) ())
  ("I70" "ALU_CELLS_X" "XOR2_X1" (("A" "dd6") ("B" "qu6") ("Y" "b2_6") ("VDD" "VDD") ("VSS" "VSS")) ())
  ("I71" "ALU_CELLS_X" "XOR2_X1" (("A" "dd7") ("B" "qu6") ("Y" "b2_7") ("VDD" "VDD") ("VSS" "VSS")) ())
  ("I72" "ALU_ADD" "KSA8" (("A_0" "aa5") ("A_1" "p1_0") ("A_2" "p1_1") ("A_3" "p1_2") ("A_4" "p1_3") ("A_5" "p1_4") ("A_6" "p1_5") ("A_7" "p1_6") ("B_0" "b2_0") ("B_1" "b2_1") ("B_2" "b2_2") ("B_3" "b2_3") ("B_4" "b2_4") ("B_5" "b2_5") ("B_6" "b2_6") ("B_7" "b2_7") ("CIN" "qu6") ("S_0" "p2_0") ("S_1" "p2_1") ("S_2" "p2_2") ("S_3" "p2_3") ("S_4" "p2_4") ("S_5" "p2_5") ("S_6" "p2_6") ("S_7" "p2_7") ("C7" "c2_7") ("C8" "c2_8") ("VDD" "VDD") ("VSS" "VSS")) ())
  ("I73" "ALU_CELLS_X" "XOR2_X1" (("A" "p1_7") ("B" "qu6") ("Y" "h2") ("VDD" "VDD") ("VSS" "VSS")) ())
  ("I74" "ALU_CELLS_X" "XOR2_X1" (("A" "h2") ("B" "c2_8") ("Y" "p2_8") ("VDD" "VDD") ("VSS" "VSS")) ())
  ("I75" "ALU_CELLS_C" "INV_X4" (("A" "p2_8") ("Y" "qu5") ("VDD" "VDD") ("VSS" "VSS")) ())
  ("I76" "ALU_CELLS_X" "XOR2_X1" (("A" "B_0") ("B" "qu5") ("Y" "b3_0") ("VDD" "VDD") ("VSS" "VSS")) ())
  ("I77" "ALU_CELLS_X" "XOR2_X1" (("A" "dd1") ("B" "qu5") ("Y" "b3_1") ("VDD" "VDD") ("VSS" "VSS")) ())
  ("I78" "ALU_CELLS_X" "XOR2_X1" (("A" "dd2") ("B" "qu5") ("Y" "b3_2") ("VDD" "VDD") ("VSS" "VSS")) ())
  ("I79" "ALU_CELLS_X" "XOR2_X1" (("A" "dd3") ("B" "qu5") ("Y" "b3_3") ("VDD" "VDD") ("VSS" "VSS")) ())
  ("I80" "ALU_CELLS_X" "XOR2_X1" (("A" "dd4") ("B" "qu5") ("Y" "b3_4") ("VDD" "VDD") ("VSS" "VSS")) ())
  ("I81" "ALU_CELLS_X" "XOR2_X1" (("A" "dd5") ("B" "qu5") ("Y" "b3_5") ("VDD" "VDD") ("VSS" "VSS")) ())
  ("I82" "ALU_CELLS_X" "XOR2_X1" (("A" "dd6") ("B" "qu5") ("Y" "b3_6") ("VDD" "VDD") ("VSS" "VSS")) ())
  ("I83" "ALU_CELLS_X" "XOR2_X1" (("A" "dd7") ("B" "qu5") ("Y" "b3_7") ("VDD" "VDD") ("VSS" "VSS")) ())
  ("I84" "ALU_ADD" "KSA8" (("A_0" "aa4") ("A_1" "p2_0") ("A_2" "p2_1") ("A_3" "p2_2") ("A_4" "p2_3") ("A_5" "p2_4") ("A_6" "p2_5") ("A_7" "p2_6") ("B_0" "b3_0") ("B_1" "b3_1") ("B_2" "b3_2") ("B_3" "b3_3") ("B_4" "b3_4") ("B_5" "b3_5") ("B_6" "b3_6") ("B_7" "b3_7") ("CIN" "qu5") ("S_0" "p3_0") ("S_1" "p3_1") ("S_2" "p3_2") ("S_3" "p3_3") ("S_4" "p3_4") ("S_5" "p3_5") ("S_6" "p3_6") ("S_7" "p3_7") ("C7" "c3_7") ("C8" "c3_8") ("VDD" "VDD") ("VSS" "VSS")) ())
  ("I85" "ALU_CELLS_X" "XOR2_X1" (("A" "p2_7") ("B" "qu5") ("Y" "h3") ("VDD" "VDD") ("VSS" "VSS")) ())
  ("I86" "ALU_CELLS_X" "XOR2_X1" (("A" "h3") ("B" "c3_8") ("Y" "p3_8") ("VDD" "VDD") ("VSS" "VSS")) ())
  ("I87" "ALU_CELLS_C" "INV_X4" (("A" "p3_8") ("Y" "qu4") ("VDD" "VDD") ("VSS" "VSS")) ())
  ("I88" "ALU_CELLS_X" "XOR2_X1" (("A" "B_0") ("B" "qu4") ("Y" "b4_0") ("VDD" "VDD") ("VSS" "VSS")) ())
  ("I89" "ALU_CELLS_X" "XOR2_X1" (("A" "dd1") ("B" "qu4") ("Y" "b4_1") ("VDD" "VDD") ("VSS" "VSS")) ())
  ("I90" "ALU_CELLS_X" "XOR2_X1" (("A" "dd2") ("B" "qu4") ("Y" "b4_2") ("VDD" "VDD") ("VSS" "VSS")) ())
  ("I91" "ALU_CELLS_X" "XOR2_X1" (("A" "dd3") ("B" "qu4") ("Y" "b4_3") ("VDD" "VDD") ("VSS" "VSS")) ())
  ("I92" "ALU_CELLS_X" "XOR2_X1" (("A" "dd4") ("B" "qu4") ("Y" "b4_4") ("VDD" "VDD") ("VSS" "VSS")) ())
  ("I93" "ALU_CELLS_X" "XOR2_X1" (("A" "dd5") ("B" "qu4") ("Y" "b4_5") ("VDD" "VDD") ("VSS" "VSS")) ())
  ("I94" "ALU_CELLS_X" "XOR2_X1" (("A" "dd6") ("B" "qu4") ("Y" "b4_6") ("VDD" "VDD") ("VSS" "VSS")) ())
  ("I95" "ALU_CELLS_X" "XOR2_X1" (("A" "dd7") ("B" "qu4") ("Y" "b4_7") ("VDD" "VDD") ("VSS" "VSS")) ())
  ("I96" "ALU_ADD" "KSA8" (("A_0" "aa3") ("A_1" "p3_0") ("A_2" "p3_1") ("A_3" "p3_2") ("A_4" "p3_3") ("A_5" "p3_4") ("A_6" "p3_5") ("A_7" "p3_6") ("B_0" "b4_0") ("B_1" "b4_1") ("B_2" "b4_2") ("B_3" "b4_3") ("B_4" "b4_4") ("B_5" "b4_5") ("B_6" "b4_6") ("B_7" "b4_7") ("CIN" "qu4") ("S_0" "p4_0") ("S_1" "p4_1") ("S_2" "p4_2") ("S_3" "p4_3") ("S_4" "p4_4") ("S_5" "p4_5") ("S_6" "p4_6") ("S_7" "p4_7") ("C7" "c4_7") ("C8" "c4_8") ("VDD" "VDD") ("VSS" "VSS")) ())
  ("I97" "ALU_CELLS_X" "XOR2_X1" (("A" "p3_7") ("B" "qu4") ("Y" "h4") ("VDD" "VDD") ("VSS" "VSS")) ())
  ("I98" "ALU_CELLS_X" "XOR2_X1" (("A" "h4") ("B" "c4_8") ("Y" "p4_8") ("VDD" "VDD") ("VSS" "VSS")) ())
  ("I99" "ALU_CELLS_C" "INV_X4" (("A" "p4_8") ("Y" "qu3") ("VDD" "VDD") ("VSS" "VSS")) ())
  ("I100" "ALU_CELLS_X" "XOR2_X1" (("A" "B_0") ("B" "qu3") ("Y" "b5_0") ("VDD" "VDD") ("VSS" "VSS")) ())
  ("I101" "ALU_CELLS_X" "XOR2_X1" (("A" "dd1") ("B" "qu3") ("Y" "b5_1") ("VDD" "VDD") ("VSS" "VSS")) ())
  ("I102" "ALU_CELLS_X" "XOR2_X1" (("A" "dd2") ("B" "qu3") ("Y" "b5_2") ("VDD" "VDD") ("VSS" "VSS")) ())
  ("I103" "ALU_CELLS_X" "XOR2_X1" (("A" "dd3") ("B" "qu3") ("Y" "b5_3") ("VDD" "VDD") ("VSS" "VSS")) ())
  ("I104" "ALU_CELLS_X" "XOR2_X1" (("A" "dd4") ("B" "qu3") ("Y" "b5_4") ("VDD" "VDD") ("VSS" "VSS")) ())
  ("I105" "ALU_CELLS_X" "XOR2_X1" (("A" "dd5") ("B" "qu3") ("Y" "b5_5") ("VDD" "VDD") ("VSS" "VSS")) ())
  ("I106" "ALU_CELLS_X" "XOR2_X1" (("A" "dd6") ("B" "qu3") ("Y" "b5_6") ("VDD" "VDD") ("VSS" "VSS")) ())
  ("I107" "ALU_CELLS_X" "XOR2_X1" (("A" "dd7") ("B" "qu3") ("Y" "b5_7") ("VDD" "VDD") ("VSS" "VSS")) ())
  ("I108" "ALU_ADD" "KSA8" (("A_0" "aa2") ("A_1" "p4_0") ("A_2" "p4_1") ("A_3" "p4_2") ("A_4" "p4_3") ("A_5" "p4_4") ("A_6" "p4_5") ("A_7" "p4_6") ("B_0" "b5_0") ("B_1" "b5_1") ("B_2" "b5_2") ("B_3" "b5_3") ("B_4" "b5_4") ("B_5" "b5_5") ("B_6" "b5_6") ("B_7" "b5_7") ("CIN" "qu3") ("S_0" "p5_0") ("S_1" "p5_1") ("S_2" "p5_2") ("S_3" "p5_3") ("S_4" "p5_4") ("S_5" "p5_5") ("S_6" "p5_6") ("S_7" "p5_7") ("C7" "c5_7") ("C8" "c5_8") ("VDD" "VDD") ("VSS" "VSS")) ())
  ("I109" "ALU_CELLS_X" "XOR2_X1" (("A" "p4_7") ("B" "qu3") ("Y" "h5") ("VDD" "VDD") ("VSS" "VSS")) ())
  ("I110" "ALU_CELLS_X" "XOR2_X1" (("A" "h5") ("B" "c5_8") ("Y" "p5_8") ("VDD" "VDD") ("VSS" "VSS")) ())
  ("I111" "ALU_CELLS_C" "INV_X4" (("A" "p5_8") ("Y" "qu2") ("VDD" "VDD") ("VSS" "VSS")) ())
  ("I112" "ALU_CELLS_X" "XOR2_X1" (("A" "B_0") ("B" "qu2") ("Y" "b6_0") ("VDD" "VDD") ("VSS" "VSS")) ())
  ("I113" "ALU_CELLS_X" "XOR2_X1" (("A" "dd1") ("B" "qu2") ("Y" "b6_1") ("VDD" "VDD") ("VSS" "VSS")) ())
  ("I114" "ALU_CELLS_X" "XOR2_X1" (("A" "dd2") ("B" "qu2") ("Y" "b6_2") ("VDD" "VDD") ("VSS" "VSS")) ())
  ("I115" "ALU_CELLS_X" "XOR2_X1" (("A" "dd3") ("B" "qu2") ("Y" "b6_3") ("VDD" "VDD") ("VSS" "VSS")) ())
  ("I116" "ALU_CELLS_X" "XOR2_X1" (("A" "dd4") ("B" "qu2") ("Y" "b6_4") ("VDD" "VDD") ("VSS" "VSS")) ())
  ("I117" "ALU_CELLS_X" "XOR2_X1" (("A" "dd5") ("B" "qu2") ("Y" "b6_5") ("VDD" "VDD") ("VSS" "VSS")) ())
  ("I118" "ALU_CELLS_X" "XOR2_X1" (("A" "dd6") ("B" "qu2") ("Y" "b6_6") ("VDD" "VDD") ("VSS" "VSS")) ())
  ("I119" "ALU_CELLS_X" "XOR2_X1" (("A" "dd7") ("B" "qu2") ("Y" "b6_7") ("VDD" "VDD") ("VSS" "VSS")) ())
  ("I120" "ALU_ADD" "KSA8" (("A_0" "aa1") ("A_1" "p5_0") ("A_2" "p5_1") ("A_3" "p5_2") ("A_4" "p5_3") ("A_5" "p5_4") ("A_6" "p5_5") ("A_7" "p5_6") ("B_0" "b6_0") ("B_1" "b6_1") ("B_2" "b6_2") ("B_3" "b6_3") ("B_4" "b6_4") ("B_5" "b6_5") ("B_6" "b6_6") ("B_7" "b6_7") ("CIN" "qu2") ("S_0" "p6_0") ("S_1" "p6_1") ("S_2" "p6_2") ("S_3" "p6_3") ("S_4" "p6_4") ("S_5" "p6_5") ("S_6" "p6_6") ("S_7" "p6_7") ("C7" "c6_7") ("C8" "c6_8") ("VDD" "VDD") ("VSS" "VSS")) ())
  ("I121" "ALU_CELLS_X" "XOR2_X1" (("A" "p5_7") ("B" "qu2") ("Y" "h6") ("VDD" "VDD") ("VSS" "VSS")) ())
  ("I122" "ALU_CELLS_X" "XOR2_X1" (("A" "h6") ("B" "c6_8") ("Y" "p6_8") ("VDD" "VDD") ("VSS" "VSS")) ())
  ("I123" "ALU_CELLS_C" "INV_X4" (("A" "p6_8") ("Y" "qu1") ("VDD" "VDD") ("VSS" "VSS")) ())
  ("I124" "ALU_CELLS_X" "XOR2_X1" (("A" "B_0") ("B" "qu1") ("Y" "b7_0") ("VDD" "VDD") ("VSS" "VSS")) ())
  ("I125" "ALU_CELLS_X" "XOR2_X1" (("A" "dd1") ("B" "qu1") ("Y" "b7_1") ("VDD" "VDD") ("VSS" "VSS")) ())
  ("I126" "ALU_CELLS_X" "XOR2_X1" (("A" "dd2") ("B" "qu1") ("Y" "b7_2") ("VDD" "VDD") ("VSS" "VSS")) ())
  ("I127" "ALU_CELLS_X" "XOR2_X1" (("A" "dd3") ("B" "qu1") ("Y" "b7_3") ("VDD" "VDD") ("VSS" "VSS")) ())
  ("I128" "ALU_CELLS_X" "XOR2_X1" (("A" "dd4") ("B" "qu1") ("Y" "b7_4") ("VDD" "VDD") ("VSS" "VSS")) ())
  ("I129" "ALU_CELLS_X" "XOR2_X1" (("A" "dd5") ("B" "qu1") ("Y" "b7_5") ("VDD" "VDD") ("VSS" "VSS")) ())
  ("I130" "ALU_CELLS_X" "XOR2_X1" (("A" "dd6") ("B" "qu1") ("Y" "b7_6") ("VDD" "VDD") ("VSS" "VSS")) ())
  ("I131" "ALU_CELLS_X" "XOR2_X1" (("A" "dd7") ("B" "qu1") ("Y" "b7_7") ("VDD" "VDD") ("VSS" "VSS")) ())
  ("I132" "ALU_ADD" "KSA8" (("A_0" "A_0") ("A_1" "p6_0") ("A_2" "p6_1") ("A_3" "p6_2") ("A_4" "p6_3") ("A_5" "p6_4") ("A_6" "p6_5") ("A_7" "p6_6") ("B_0" "b7_0") ("B_1" "b7_1") ("B_2" "b7_2") ("B_3" "b7_3") ("B_4" "b7_4") ("B_5" "b7_5") ("B_6" "b7_6") ("B_7" "b7_7") ("CIN" "qu1") ("S_0" "p7_0") ("S_1" "p7_1") ("S_2" "p7_2") ("S_3" "p7_3") ("S_4" "p7_4") ("S_5" "p7_5") ("S_6" "p7_6") ("S_7" "p7_7") ("C7" "c7_7") ("C8" "c7_8") ("VDD" "VDD") ("VSS" "VSS")) ())
  ("I133" "ALU_CELLS_X" "XOR2_X1" (("A" "p6_7") ("B" "qu1") ("Y" "h7") ("VDD" "VDD") ("VSS" "VSS")) ())
  ("I134" "ALU_CELLS_X" "XOR2_X1" (("A" "h7") ("B" "c7_8") ("Y" "p7_8") ("VDD" "VDD") ("VSS" "VSS")) ())
  ("I135" "ALU_CELLS_A" "INV_X1" (("A" "p7_8") ("Y" "Q_0") ("VDD" "VDD") ("VSS" "VSS")) ())
  ("I136" "ALU_CELLS_A" "NAND2_X1" (("A" "B_0") ("B" "p7_8") ("Y" "dmn0") ("VDD" "VDD") ("VSS" "VSS")) ())
  ("I137" "ALU_CELLS_A" "INV_X1" (("A" "dmn0") ("Y" "dm0") ("VDD" "VDD") ("VSS" "VSS")) ())
  ("I138" "ALU_CELLS_A" "NAND2_X1" (("A" "dd1") ("B" "p7_8") ("Y" "dmn1") ("VDD" "VDD") ("VSS" "VSS")) ())
  ("I139" "ALU_CELLS_A" "INV_X1" (("A" "dmn1") ("Y" "dm1") ("VDD" "VDD") ("VSS" "VSS")) ())
  ("I140" "ALU_CELLS_A" "NAND2_X1" (("A" "dd2") ("B" "p7_8") ("Y" "dmn2") ("VDD" "VDD") ("VSS" "VSS")) ())
  ("I141" "ALU_CELLS_A" "INV_X1" (("A" "dmn2") ("Y" "dm2") ("VDD" "VDD") ("VSS" "VSS")) ())
  ("I142" "ALU_CELLS_A" "NAND2_X1" (("A" "dd3") ("B" "p7_8") ("Y" "dmn3") ("VDD" "VDD") ("VSS" "VSS")) ())
  ("I143" "ALU_CELLS_A" "INV_X1" (("A" "dmn3") ("Y" "dm3") ("VDD" "VDD") ("VSS" "VSS")) ())
  ("I144" "ALU_CELLS_A" "NAND2_X1" (("A" "dd4") ("B" "p7_8") ("Y" "dmn4") ("VDD" "VDD") ("VSS" "VSS")) ())
  ("I145" "ALU_CELLS_A" "INV_X1" (("A" "dmn4") ("Y" "dm4") ("VDD" "VDD") ("VSS" "VSS")) ())
  ("I146" "ALU_CELLS_A" "NAND2_X1" (("A" "dd5") ("B" "p7_8") ("Y" "dmn5") ("VDD" "VDD") ("VSS" "VSS")) ())
  ("I147" "ALU_CELLS_A" "INV_X1" (("A" "dmn5") ("Y" "dm5") ("VDD" "VDD") ("VSS" "VSS")) ())
  ("I148" "ALU_CELLS_A" "NAND2_X1" (("A" "dd6") ("B" "p7_8") ("Y" "dmn6") ("VDD" "VDD") ("VSS" "VSS")) ())
  ("I149" "ALU_CELLS_A" "INV_X1" (("A" "dmn6") ("Y" "dm6") ("VDD" "VDD") ("VSS" "VSS")) ())
  ("I150" "ALU_CELLS_A" "NAND2_X1" (("A" "dd7") ("B" "p7_8") ("Y" "dmn7") ("VDD" "VDD") ("VSS" "VSS")) ())
  ("I151" "ALU_CELLS_A" "INV_X1" (("A" "dmn7") ("Y" "dm7") ("VDD" "VDD") ("VSS" "VSS")) ())
  ("I152" "ALU_ADD" "KSA8" (("A_0" "p7_0") ("A_1" "p7_1") ("A_2" "p7_2") ("A_3" "p7_3") ("A_4" "p7_4") ("A_5" "p7_5") ("A_6" "p7_6") ("A_7" "p7_7") ("B_0" "dm0") ("B_1" "dm1") ("B_2" "dm2") ("B_3" "dm3") ("B_4" "dm4") ("B_5" "dm5") ("B_6" "dm6") ("B_7" "dm7") ("CIN" "VSS") ("S_0" "R_0") ("S_1" "ru1") ("S_2" "ru2") ("S_3" "ru3") ("S_4" "ru4") ("S_5" "ru5") ("S_6" "ru6") ("S_7" "ru7") ("C7" "rc6") ("C8" "rc7") ("VDD" "VDD") ("VSS" "VSS")) ())
  ("I153" "ALU_CELLS_X" "XOR2_X1" (("A" "A_7") ("B" "B_7") ("Y" "sq") ("VDD" "VDD") ("VSS" "VSS")) ())
  ("I154" "ALU_CELLS_A" "NAND2_X1" (("A" "sq") ("B" "Q_0") ("Y" "nqkn1") ("VDD" "VDD") ("VSS" "VSS")) ())
  ("I155" "ALU_CELLS_X" "XNOR2_X1" (("A" "qu1") ("B" "nqkn1") ("Y" "Q_1") ("VDD" "VDD") ("VSS" "VSS")) ())
  ("I156" "ALU_CELLS_A" "INV_X1" (("A" "nqkn1") ("Y" "nqk1") ("VDD" "VDD") ("VSS" "VSS")) ())
  ("I157" "ALU_CELLS_A" "AOI21_X1" (("A1" "sq") ("A2" "qu1") ("B" "nqk1") ("Y" "nqkn2") ("VDD" "VDD") ("VSS" "VSS")) ())
  ("I158" "ALU_CELLS_X" "XNOR2_X1" (("A" "qu2") ("B" "nqkn2") ("Y" "Q_2") ("VDD" "VDD") ("VSS" "VSS")) ())
  ("I159" "ALU_CELLS_A" "INV_X1" (("A" "nqkn2") ("Y" "nqk2") ("VDD" "VDD") ("VSS" "VSS")) ())
  ("I160" "ALU_CELLS_A" "AOI21_X1" (("A1" "sq") ("A2" "qu2") ("B" "nqk2") ("Y" "nqkn3") ("VDD" "VDD") ("VSS" "VSS")) ())
  ("I161" "ALU_CELLS_X" "XNOR2_X1" (("A" "qu3") ("B" "nqkn3") ("Y" "Q_3") ("VDD" "VDD") ("VSS" "VSS")) ())
  ("I162" "ALU_CELLS_A" "INV_X1" (("A" "nqkn3") ("Y" "nqk3") ("VDD" "VDD") ("VSS" "VSS")) ())
  ("I163" "ALU_CELLS_A" "AOI21_X1" (("A1" "sq") ("A2" "qu3") ("B" "nqk3") ("Y" "nqkn4") ("VDD" "VDD") ("VSS" "VSS")) ())
  ("I164" "ALU_CELLS_X" "XNOR2_X1" (("A" "qu4") ("B" "nqkn4") ("Y" "Q_4") ("VDD" "VDD") ("VSS" "VSS")) ())
  ("I165" "ALU_CELLS_A" "INV_X1" (("A" "nqkn4") ("Y" "nqk4") ("VDD" "VDD") ("VSS" "VSS")) ())
  ("I166" "ALU_CELLS_A" "AOI21_X1" (("A1" "sq") ("A2" "qu4") ("B" "nqk4") ("Y" "nqkn5") ("VDD" "VDD") ("VSS" "VSS")) ())
  ("I167" "ALU_CELLS_X" "XNOR2_X1" (("A" "qu5") ("B" "nqkn5") ("Y" "Q_5") ("VDD" "VDD") ("VSS" "VSS")) ())
  ("I168" "ALU_CELLS_A" "INV_X1" (("A" "nqkn5") ("Y" "nqk5") ("VDD" "VDD") ("VSS" "VSS")) ())
  ("I169" "ALU_CELLS_A" "AOI21_X1" (("A1" "sq") ("A2" "qu5") ("B" "nqk5") ("Y" "nqkn6") ("VDD" "VDD") ("VSS" "VSS")) ())
  ("I170" "ALU_CELLS_X" "XNOR2_X1" (("A" "qu6") ("B" "nqkn6") ("Y" "Q_6") ("VDD" "VDD") ("VSS" "VSS")) ())
  ("I171" "ALU_CELLS_A" "INV_X1" (("A" "nqkn6") ("Y" "nqk6") ("VDD" "VDD") ("VSS" "VSS")) ())
  ("I172" "ALU_CELLS_A" "AOI21_X1" (("A1" "sq") ("A2" "qu6") ("B" "nqk6") ("Y" "nqkn7") ("VDD" "VDD") ("VSS" "VSS")) ())
  ("I173" "ALU_CELLS_X" "XNOR2_X1" (("A" "qu7") ("B" "nqkn7") ("Y" "Q_7") ("VDD" "VDD") ("VSS" "VSS")) ())
  ("I174" "ALU_CELLS_A" "NAND2_X1" (("A" "A_7") ("B" "R_0") ("Y" "nrkn1") ("VDD" "VDD") ("VSS" "VSS")) ())
  ("I175" "ALU_CELLS_X" "XNOR2_X1" (("A" "ru1") ("B" "nrkn1") ("Y" "R_1") ("VDD" "VDD") ("VSS" "VSS")) ())
  ("I176" "ALU_CELLS_A" "INV_X1" (("A" "nrkn1") ("Y" "nrk1") ("VDD" "VDD") ("VSS" "VSS")) ())
  ("I177" "ALU_CELLS_A" "AOI21_X1" (("A1" "A_7") ("A2" "ru1") ("B" "nrk1") ("Y" "nrkn2") ("VDD" "VDD") ("VSS" "VSS")) ())
  ("I178" "ALU_CELLS_X" "XNOR2_X1" (("A" "ru2") ("B" "nrkn2") ("Y" "R_2") ("VDD" "VDD") ("VSS" "VSS")) ())
  ("I179" "ALU_CELLS_A" "INV_X1" (("A" "nrkn2") ("Y" "nrk2") ("VDD" "VDD") ("VSS" "VSS")) ())
  ("I180" "ALU_CELLS_A" "AOI21_X1" (("A1" "A_7") ("A2" "ru2") ("B" "nrk2") ("Y" "nrkn3") ("VDD" "VDD") ("VSS" "VSS")) ())
  ("I181" "ALU_CELLS_X" "XNOR2_X1" (("A" "ru3") ("B" "nrkn3") ("Y" "R_3") ("VDD" "VDD") ("VSS" "VSS")) ())
  ("I182" "ALU_CELLS_A" "INV_X1" (("A" "nrkn3") ("Y" "nrk3") ("VDD" "VDD") ("VSS" "VSS")) ())
  ("I183" "ALU_CELLS_A" "AOI21_X1" (("A1" "A_7") ("A2" "ru3") ("B" "nrk3") ("Y" "nrkn4") ("VDD" "VDD") ("VSS" "VSS")) ())
  ("I184" "ALU_CELLS_X" "XNOR2_X1" (("A" "ru4") ("B" "nrkn4") ("Y" "R_4") ("VDD" "VDD") ("VSS" "VSS")) ())
  ("I185" "ALU_CELLS_A" "INV_X1" (("A" "nrkn4") ("Y" "nrk4") ("VDD" "VDD") ("VSS" "VSS")) ())
  ("I186" "ALU_CELLS_A" "AOI21_X1" (("A1" "A_7") ("A2" "ru4") ("B" "nrk4") ("Y" "nrkn5") ("VDD" "VDD") ("VSS" "VSS")) ())
  ("I187" "ALU_CELLS_X" "XNOR2_X1" (("A" "ru5") ("B" "nrkn5") ("Y" "R_5") ("VDD" "VDD") ("VSS" "VSS")) ())
  ("I188" "ALU_CELLS_A" "INV_X1" (("A" "nrkn5") ("Y" "nrk5") ("VDD" "VDD") ("VSS" "VSS")) ())
  ("I189" "ALU_CELLS_A" "AOI21_X1" (("A1" "A_7") ("A2" "ru5") ("B" "nrk5") ("Y" "nrkn6") ("VDD" "VDD") ("VSS" "VSS")) ())
  ("I190" "ALU_CELLS_X" "XNOR2_X1" (("A" "ru6") ("B" "nrkn6") ("Y" "R_6") ("VDD" "VDD") ("VSS" "VSS")) ())
  ("I191" "ALU_CELLS_A" "INV_X1" (("A" "nrkn6") ("Y" "nrk6") ("VDD" "VDD") ("VSS" "VSS")) ())
  ("I192" "ALU_CELLS_A" "AOI21_X1" (("A1" "A_7") ("A2" "ru6") ("B" "nrk6") ("Y" "nrkn7") ("VDD" "VDD") ("VSS" "VSS")) ())
  ("I193" "ALU_CELLS_X" "XNOR2_X1" (("A" "ru7") ("B" "nrkn7") ("Y" "R_7") ("VDD" "VDD") ("VSS" "VSS")) ())
  ("I194" "ALU_CELLS_A" "NOR2_X1" (("A" "B_0") ("B" "B_1") ("Y" "z1_0") ("VDD" "VDD") ("VSS" "VSS")) ())
  ("I195" "ALU_CELLS_A" "NOR2_X1" (("A" "B_2") ("B" "B_3") ("Y" "z1_1") ("VDD" "VDD") ("VSS" "VSS")) ())
  ("I196" "ALU_CELLS_A" "NOR2_X1" (("A" "B_4") ("B" "B_5") ("Y" "z1_2") ("VDD" "VDD") ("VSS" "VSS")) ())
  ("I197" "ALU_CELLS_A" "NOR2_X1" (("A" "B_6") ("B" "B_7") ("Y" "z1_3") ("VDD" "VDD") ("VSS" "VSS")) ())
  ("I198" "ALU_CELLS_A" "NAND2_X1" (("A" "z1_0") ("B" "z1_1") ("Y" "z2_0") ("VDD" "VDD") ("VSS" "VSS")) ())
  ("I199" "ALU_CELLS_A" "NAND2_X1" (("A" "z1_2") ("B" "z1_3") ("Y" "z2_1") ("VDD" "VDD") ("VSS" "VSS")) ())
  ("I200" "ALU_CELLS_A" "NOR2_X1" (("A" "z2_0") ("B" "z2_1") ("Y" "DZ") ("VDD" "VDD") ("VSS" "VSS")) ())
  ("I201" "ALU_CELLS_A" "INV_X1" (("A" "sq") ("Y" "sqn") ("VDD" "VDD") ("VSS" "VSS")) ())
  ("I202" "ALU_CELLS_A" "NAND2_X1" (("A" "Q_7") ("B" "sqn") ("Y" "vn") ("VDD" "VDD") ("VSS" "VSS")) ())
  ("I203" "ALU_CELLS_A" "NOR2_X1" (("A" "vn") ("B" "DZ") ("Y" "V") ("VDD" "VDD") ("VSS" "VSS")) ()))) t)
  sbErrors++ printf("SB_ERROR DIV8K: %L\n" errset.errset))
unless(errset(sbCell("ALU_TOP" "ALU_TOPK" '(("A_0" "input") ("A_1" "input") ("A_2" "input") ("A_3" "input") ("A_4" "input") ("A_5" "input") ("A_6" "input") ("A_7" "input") ("B_0" "input") ("B_1" "input") ("B_2" "input") ("B_3" "input") ("B_4" "input") ("B_5" "input") ("B_6" "input") ("B_7" "input") ("OP_0" "input") ("OP_1" "input") ("OP_2" "input") ("OP_3" "input") ("Y_0" "output") ("Y_1" "output") ("Y_2" "output") ("Y_3" "output") ("Y_4" "output") ("Y_5" "output") ("Y_6" "output") ("Y_7" "output") ("Y_8" "output") ("Y_9" "output") ("Y_10" "output") ("Y_11" "output") ("Y_12" "output") ("Y_13" "output") ("Y_14" "output") ("Y_15" "output") ("Z" "output") ("C" "output") ("V" "output") ("DZ" "output") ("VDD" "inputOutput") ("VSS" "inputOutput"))
 '(
  ("I0" "ALU_MUL" "MUL8" (("A_0" "A_0") ("A_1" "A_1") ("A_2" "A_2") ("A_3" "A_3") ("A_4" "A_4") ("A_5" "A_5") ("A_6" "A_6") ("A_7" "A_7") ("B_0" "B_0") ("B_1" "B_1") ("B_2" "B_2") ("B_3" "B_3") ("B_4" "B_4") ("B_5" "B_5") ("B_6" "B_6") ("B_7" "B_7") ("P_0" "MULP_0") ("P_1" "MULP_1") ("P_2" "MULP_2") ("P_3" "MULP_3") ("P_4" "MULP_4") ("P_5" "MULP_5") ("P_6" "MULP_6") ("P_7" "MULP_7") ("P_8" "MULP_8") ("P_9" "MULP_9") ("P_10" "MULP_10") ("P_11" "MULP_11") ("P_12" "MULP_12") ("P_13" "MULP_13") ("P_14" "MULP_14") ("P_15" "MULP_15") ("VDD" "VDD") ("VSS" "VSS")) ())
  ("I1" "ALU_DIV" "DIV8K" (("A_0" "A_0") ("A_1" "A_1") ("A_2" "A_2") ("A_3" "A_3") ("A_4" "A_4") ("A_5" "A_5") ("A_6" "A_6") ("A_7" "A_7") ("B_0" "B_0") ("B_1" "B_1") ("B_2" "B_2") ("B_3" "B_3") ("B_4" "B_4") ("B_5" "B_5") ("B_6" "B_6") ("B_7" "B_7") ("Q_0" "DIVQ_0") ("Q_1" "DIVQ_1") ("Q_2" "DIVQ_2") ("Q_3" "DIVQ_3") ("Q_4" "DIVQ_4") ("Q_5" "DIVQ_5") ("Q_6" "DIVQ_6") ("Q_7" "DIVQ_7") ("R_0" "DIVR_0") ("R_1" "DIVR_1") ("R_2" "DIVR_2") ("R_3" "DIVR_3") ("R_4" "DIVR_4") ("R_5" "DIVR_5") ("R_6" "DIVR_6") ("R_7" "DIVR_7") ("V" "DIVV") ("DZ" "DIVDZ") ("VDD" "VDD") ("VSS" "VSS")) ())
  ("I2" "ALU_CORE" "ALU_CORE" (("A_0" "A_0") ("A_1" "A_1") ("A_2" "A_2") ("A_3" "A_3") ("A_4" "A_4") ("A_5" "A_5") ("A_6" "A_6") ("A_7" "A_7") ("B_0" "B_0") ("B_1" "B_1") ("B_2" "B_2") ("B_3" "B_3") ("B_4" "B_4") ("B_5" "B_5") ("B_6" "B_6") ("B_7" "B_7") ("OP_0" "OP_0") ("OP_1" "OP_1") ("OP_2" "OP_2") ("OP_3" "OP_3") ("MULP_0" "MULP_0") ("MULP_1" "MULP_1") ("MULP_2" "MULP_2") ("MULP_3" "MULP_3") ("MULP_4" "MULP_4") ("MULP_5" "MULP_5") ("MULP_6" "MULP_6") ("MULP_7" "MULP_7") ("MULP_8" "MULP_8") ("MULP_9" "MULP_9") ("MULP_10" "MULP_10") ("MULP_11" "MULP_11") ("MULP_12" "MULP_12") ("MULP_13" "MULP_13") ("MULP_14" "MULP_14") ("MULP_15" "MULP_15") ("DIVQ_0" "DIVQ_0") ("DIVQ_1" "DIVQ_1") ("DIVQ_2" "DIVQ_2") ("DIVQ_3" "DIVQ_3") ("DIVQ_4" "DIVQ_4") ("DIVQ_5" "DIVQ_5") ("DIVQ_6" "DIVQ_6") ("DIVQ_7" "DIVQ_7") ("DIVR_0" "DIVR_0") ("DIVR_1" "DIVR_1") ("DIVR_2" "DIVR_2") ("DIVR_3" "DIVR_3") ("DIVR_4" "DIVR_4") ("DIVR_5" "DIVR_5") ("DIVR_6" "DIVR_6") ("DIVR_7" "DIVR_7") ("DIVV" "DIVV") ("DIVDZ" "DIVDZ") ("Y_0" "Y_0") ("Y_1" "Y_1") ("Y_2" "Y_2") ("Y_3" "Y_3") ("Y_4" "Y_4") ("Y_5" "Y_5") ("Y_6" "Y_6") ("Y_7" "Y_7") ("Y_8" "Y_8") ("Y_9" "Y_9") ("Y_10" "Y_10") ("Y_11" "Y_11") ("Y_12" "Y_12") ("Y_13" "Y_13") ("Y_14" "Y_14") ("Y_15" "Y_15") ("Z" "Z") ("C" "C") ("V" "V") ("DZ" "DZ") ("VDD" "VDD") ("VSS" "VSS")) ()))) t)
  sbErrors++ printf("SB_ERROR ALU_TOPK: %L\n" errset.errset))
sbEnd()) t)
  printf("SB_ERROR uncaught: %L\n" errset.errset)
  exit(2))
exit(3)   ; unconditional: -nograph never exits on stdin EOF
