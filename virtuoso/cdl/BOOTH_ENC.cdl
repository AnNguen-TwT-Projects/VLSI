.SUBCKT BOOTH_ENC X2 X1 X0 ONE TWO VDD VSS
MN1 aan X1 VSS VSS nmos1v w=0.12u l=0.1u
MP2 aan X1 VDD VDD pmos1v w=0.24u l=0.1u
MN3 abn X0 VSS VSS nmos1v w=0.12u l=0.1u
MP4 abn X0 VDD VDD pmos1v w=0.24u l=0.1u
MN5 ONE X1 an1 VSS nmos1v w=0.24u l=0.1u
MN6 an1 X0 VSS VSS nmos1v w=0.24u l=0.1u
MN7 ONE aan an2 VSS nmos1v w=0.24u l=0.1u
MN8 an2 abn VSS VSS nmos1v w=0.24u l=0.1u
MP9 ap1 X1 VDD VDD pmos1v w=0.48u l=0.1u
MP10 ap1 X0 VDD VDD pmos1v w=0.48u l=0.1u
MP11 ONE aan ap1 VDD pmos1v w=0.48u l=0.1u
MP12 ONE abn ap1 VDD pmos1v w=0.48u l=0.1u
MN13 ban X2 VSS VSS nmos1v w=0.12u l=0.1u
MP14 ban X2 VDD VDD pmos1v w=0.24u l=0.1u
MN15 bbn X1 VSS VSS nmos1v w=0.12u l=0.1u
MP16 bbn X1 VDD VDD pmos1v w=0.24u l=0.1u
MN17 e X2 bn1 VSS nmos1v w=0.24u l=0.1u
MN18 bn1 bbn VSS VSS nmos1v w=0.24u l=0.1u
MN19 e ban bn2 VSS nmos1v w=0.24u l=0.1u
MN20 bn2 X1 VSS VSS nmos1v w=0.24u l=0.1u
MP21 bp1 X2 VDD VDD pmos1v w=0.48u l=0.1u
MP22 bp1 bbn VDD VDD pmos1v w=0.48u l=0.1u
MP23 e ban bp1 VDD pmos1v w=0.48u l=0.1u
MP24 e X1 bp1 VDD pmos1v w=0.48u l=0.1u
MN25 TWO e VSS VSS nmos1v w=0.12u l=0.1u
MN26 TWO ONE VSS VSS nmos1v w=0.12u l=0.1u
MP27 cp e VDD VDD pmos1v w=0.48u l=0.1u
MP28 TWO ONE cp VDD pmos1v w=0.48u l=0.1u
.ENDS BOOTH_ENC
