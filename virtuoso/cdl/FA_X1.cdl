.SUBCKT FA_X1 A B CI S CO VDD VSS
MN1 n1 A VSS VSS nmos1v w=0.24u l=0.1u
MN2 con B n1 VSS nmos1v w=0.24u l=0.1u
MN3 n2 A VSS VSS nmos1v w=0.24u l=0.1u
MN4 n2 B VSS VSS nmos1v w=0.24u l=0.1u
MN5 con CI n2 VSS nmos1v w=0.24u l=0.1u
MN6 n3 A VSS VSS nmos1v w=0.24u l=0.1u
MN7 n3 B VSS VSS nmos1v w=0.24u l=0.1u
MN8 n3 CI VSS VSS nmos1v w=0.24u l=0.1u
MN9 sn con n3 VSS nmos1v w=0.24u l=0.1u
MN10 n4 A VSS VSS nmos1v w=0.36u l=0.1u
MN11 n5 B n4 VSS nmos1v w=0.36u l=0.1u
MN12 sn CI n5 VSS nmos1v w=0.36u l=0.1u
MP13 p1 A VDD VDD pmos1v w=0.48u l=0.1u
MP14 con B p1 VDD pmos1v w=0.48u l=0.1u
MP15 p2 A VDD VDD pmos1v w=0.48u l=0.1u
MP16 p2 B VDD VDD pmos1v w=0.48u l=0.1u
MP17 con CI p2 VDD pmos1v w=0.48u l=0.1u
MP18 p3 A VDD VDD pmos1v w=0.48u l=0.1u
MP19 p3 B VDD VDD pmos1v w=0.48u l=0.1u
MP20 p3 CI VDD VDD pmos1v w=0.48u l=0.1u
MP21 sn con p3 VDD pmos1v w=0.48u l=0.1u
MP22 p4 A VDD VDD pmos1v w=0.72u l=0.1u
MP23 p5 B p4 VDD pmos1v w=0.72u l=0.1u
MP24 sn CI p5 VDD pmos1v w=0.72u l=0.1u
MN25 S sn VSS VSS nmos1v w=0.12u l=0.1u
MP26 S sn VDD VDD pmos1v w=0.24u l=0.1u
MN27 CO con VSS VSS nmos1v w=0.12u l=0.1u
MP28 CO con VDD VDD pmos1v w=0.24u l=0.1u
.ENDS FA_X1
