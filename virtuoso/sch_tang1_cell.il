;; run in the VM:  bash virtuoso/run_schematic.sh sch_tang1_cell.il
;; run with < /dev/null; any SKILL error -> message + exit, never a hanging CIW prompt
unless(errset(progn(
sbDir = or(getShellEnvVar("SB_DIR") ".")
load(strcat(sbDir "/sch_build.il"))
sbBegin()
sbLib("ALU_CELLS_A" "gpdk090")
sbLib("ALU_CELLS_C" "gpdk090")
sbLib("ALU_CELLS_X" "gpdk090")
sbLib("ALU_CELLS_B" "gpdk090")
sbLib("ALU_CELLS_D" "gpdk090")
unless(errset(sbCell("ALU_CELLS_A" "INV_X1" '(("A" "input") ("Y" "output") ("VDD" "inputOutput") ("VSS" "inputOutput"))
 '(
  ("MN0" "gpdk090" "nmos1v" (("D" "Y") ("G" "A") ("S" "VSS") ("B" "VSS")) (("fingers" "1") ("w" "120n") ("fw" "120n") ("l" "100n")))
  ("MP0" "gpdk090" "pmos1v" (("D" "Y") ("G" "A") ("S" "VDD") ("B" "VDD")) (("fingers" "1") ("w" "240n") ("fw" "240n") ("l" "100n"))))) t)
  sbErrors++ printf("SB_ERROR INV_X1: %L\n" errset.errset))
unless(errset(sbCell("ALU_CELLS_C" "INV_X4" '(("A" "input") ("Y" "output") ("VDD" "inputOutput") ("VSS" "inputOutput"))
 '(
  ("MN1" "gpdk090" "nmos1v" (("D" "Y") ("G" "A") ("S" "VSS") ("B" "VSS")) (("fingers" "1") ("w" "480n") ("fw" "480n") ("l" "100n")))
  ("MP2" "gpdk090" "pmos1v" (("D" "Y") ("G" "A") ("S" "VDD") ("B" "VDD")) (("fingers" "1") ("w" "960n") ("fw" "960n") ("l" "100n"))))) t)
  sbErrors++ printf("SB_ERROR INV_X4: %L\n" errset.errset))
unless(errset(sbCell("ALU_CELLS_A" "NAND2_X1" '(("A" "input") ("B" "input") ("Y" "output") ("VDD" "inputOutput") ("VSS" "inputOutput"))
 '(
  ("MN0" "gpdk090" "nmos1v" (("D" "Y") ("G" "A") ("S" "n1") ("B" "VSS")) (("fingers" "1") ("w" "240n") ("fw" "240n") ("l" "100n")))
  ("MN1" "gpdk090" "nmos1v" (("D" "n1") ("G" "B") ("S" "VSS") ("B" "VSS")) (("fingers" "1") ("w" "240n") ("fw" "240n") ("l" "100n")))
  ("MP0" "gpdk090" "pmos1v" (("D" "Y") ("G" "A") ("S" "VDD") ("B" "VDD")) (("fingers" "1") ("w" "240n") ("fw" "240n") ("l" "100n")))
  ("MP1" "gpdk090" "pmos1v" (("D" "Y") ("G" "B") ("S" "VDD") ("B" "VDD")) (("fingers" "1") ("w" "240n") ("fw" "240n") ("l" "100n"))))) t)
  sbErrors++ printf("SB_ERROR NAND2_X1: %L\n" errset.errset))
unless(errset(sbCell("ALU_CELLS_A" "NOR2_X1" '(("A" "input") ("B" "input") ("Y" "output") ("VDD" "inputOutput") ("VSS" "inputOutput"))
 '(
  ("MN0" "gpdk090" "nmos1v" (("D" "Y") ("G" "A") ("S" "VSS") ("B" "VSS")) (("fingers" "1") ("w" "120n") ("fw" "120n") ("l" "100n")))
  ("MN1" "gpdk090" "nmos1v" (("D" "Y") ("G" "B") ("S" "VSS") ("B" "VSS")) (("fingers" "1") ("w" "120n") ("fw" "120n") ("l" "100n")))
  ("MP0" "gpdk090" "pmos1v" (("D" "p1") ("G" "A") ("S" "VDD") ("B" "VDD")) (("fingers" "1") ("w" "480n") ("fw" "480n") ("l" "100n")))
  ("MP1" "gpdk090" "pmos1v" (("D" "Y") ("G" "B") ("S" "p1") ("B" "VDD")) (("fingers" "1") ("w" "480n") ("fw" "480n") ("l" "100n"))))) t)
  sbErrors++ printf("SB_ERROR NOR2_X1: %L\n" errset.errset))
unless(errset(sbCell("ALU_CELLS_A" "AOI21_X1" '(("A1" "input") ("A2" "input") ("B" "input") ("Y" "output") ("VDD" "inputOutput") ("VSS" "inputOutput"))
 '(
  ("MN0" "gpdk090" "nmos1v" (("D" "Y") ("G" "A1") ("S" "n1") ("B" "VSS")) (("fingers" "1") ("w" "240n") ("fw" "240n") ("l" "100n")))
  ("MN1" "gpdk090" "nmos1v" (("D" "n1") ("G" "A2") ("S" "VSS") ("B" "VSS")) (("fingers" "1") ("w" "240n") ("fw" "240n") ("l" "100n")))
  ("MN2" "gpdk090" "nmos1v" (("D" "Y") ("G" "B") ("S" "VSS") ("B" "VSS")) (("fingers" "1") ("w" "120n") ("fw" "120n") ("l" "100n")))
  ("MP0" "gpdk090" "pmos1v" (("D" "p1") ("G" "A1") ("S" "VDD") ("B" "VDD")) (("fingers" "1") ("w" "480n") ("fw" "480n") ("l" "100n")))
  ("MP1" "gpdk090" "pmos1v" (("D" "p1") ("G" "A2") ("S" "VDD") ("B" "VDD")) (("fingers" "1") ("w" "480n") ("fw" "480n") ("l" "100n")))
  ("MP2" "gpdk090" "pmos1v" (("D" "Y") ("G" "B") ("S" "p1") ("B" "VDD")) (("fingers" "1") ("w" "480n") ("fw" "480n") ("l" "100n"))))) t)
  sbErrors++ printf("SB_ERROR AOI21_X1: %L\n" errset.errset))
unless(errset(sbCell("ALU_CELLS_A" "OAI21_X1" '(("A1" "input") ("A2" "input") ("B" "input") ("Y" "output") ("VDD" "inputOutput") ("VSS" "inputOutput"))
 '(
  ("MN0" "gpdk090" "nmos1v" (("D" "Y") ("G" "A1") ("S" "n1") ("B" "VSS")) (("fingers" "1") ("w" "240n") ("fw" "240n") ("l" "100n")))
  ("MN1" "gpdk090" "nmos1v" (("D" "Y") ("G" "A2") ("S" "n1") ("B" "VSS")) (("fingers" "1") ("w" "240n") ("fw" "240n") ("l" "100n")))
  ("MN2" "gpdk090" "nmos1v" (("D" "n1") ("G" "B") ("S" "VSS") ("B" "VSS")) (("fingers" "1") ("w" "240n") ("fw" "240n") ("l" "100n")))
  ("MP0" "gpdk090" "pmos1v" (("D" "p1") ("G" "A1") ("S" "VDD") ("B" "VDD")) (("fingers" "1") ("w" "480n") ("fw" "480n") ("l" "100n")))
  ("MP1" "gpdk090" "pmos1v" (("D" "Y") ("G" "A2") ("S" "p1") ("B" "VDD")) (("fingers" "1") ("w" "480n") ("fw" "480n") ("l" "100n")))
  ("MP2" "gpdk090" "pmos1v" (("D" "Y") ("G" "B") ("S" "VDD") ("B" "VDD")) (("fingers" "1") ("w" "240n") ("fw" "240n") ("l" "100n"))))) t)
  sbErrors++ printf("SB_ERROR OAI21_X1: %L\n" errset.errset))
unless(errset(sbCell("ALU_CELLS_X" "XOR2_X1" '(("A" "input") ("B" "input") ("Y" "output") ("VDD" "inputOutput") ("VSS" "inputOutput"))
 '(
  ("MN0" "gpdk090" "nmos1v" (("D" "An") ("G" "A") ("S" "VSS") ("B" "VSS")) (("fingers" "1") ("w" "120n") ("fw" "120n") ("l" "100n")))
  ("MP0" "gpdk090" "pmos1v" (("D" "An") ("G" "A") ("S" "VDD") ("B" "VDD")) (("fingers" "1") ("w" "240n") ("fw" "240n") ("l" "100n")))
  ("MN1" "gpdk090" "nmos1v" (("D" "Bn") ("G" "B") ("S" "VSS") ("B" "VSS")) (("fingers" "1") ("w" "120n") ("fw" "120n") ("l" "100n")))
  ("MP1" "gpdk090" "pmos1v" (("D" "Bn") ("G" "B") ("S" "VDD") ("B" "VDD")) (("fingers" "1") ("w" "240n") ("fw" "240n") ("l" "100n")))
  ("MN2" "gpdk090" "nmos1v" (("D" "Y") ("G" "A") ("S" "n1") ("B" "VSS")) (("fingers" "1") ("w" "240n") ("fw" "240n") ("l" "100n")))
  ("MN3" "gpdk090" "nmos1v" (("D" "n1") ("G" "B") ("S" "VSS") ("B" "VSS")) (("fingers" "1") ("w" "240n") ("fw" "240n") ("l" "100n")))
  ("MN4" "gpdk090" "nmos1v" (("D" "Y") ("G" "An") ("S" "n2") ("B" "VSS")) (("fingers" "1") ("w" "240n") ("fw" "240n") ("l" "100n")))
  ("MN5" "gpdk090" "nmos1v" (("D" "n2") ("G" "Bn") ("S" "VSS") ("B" "VSS")) (("fingers" "1") ("w" "240n") ("fw" "240n") ("l" "100n")))
  ("MP2" "gpdk090" "pmos1v" (("D" "p1") ("G" "A") ("S" "VDD") ("B" "VDD")) (("fingers" "1") ("w" "480n") ("fw" "480n") ("l" "100n")))
  ("MP3" "gpdk090" "pmos1v" (("D" "p1") ("G" "B") ("S" "VDD") ("B" "VDD")) (("fingers" "1") ("w" "480n") ("fw" "480n") ("l" "100n")))
  ("MP4" "gpdk090" "pmos1v" (("D" "Y") ("G" "An") ("S" "p1") ("B" "VDD")) (("fingers" "1") ("w" "480n") ("fw" "480n") ("l" "100n")))
  ("MP5" "gpdk090" "pmos1v" (("D" "Y") ("G" "Bn") ("S" "p1") ("B" "VDD")) (("fingers" "1") ("w" "480n") ("fw" "480n") ("l" "100n"))))) t)
  sbErrors++ printf("SB_ERROR XOR2_X1: %L\n" errset.errset))
unless(errset(sbCell("ALU_CELLS_X" "XNOR2_X1" '(("A" "input") ("B" "input") ("Y" "output") ("VDD" "inputOutput") ("VSS" "inputOutput"))
 '(
  ("MN0" "gpdk090" "nmos1v" (("D" "An") ("G" "A") ("S" "VSS") ("B" "VSS")) (("fingers" "1") ("w" "120n") ("fw" "120n") ("l" "100n")))
  ("MP0" "gpdk090" "pmos1v" (("D" "An") ("G" "A") ("S" "VDD") ("B" "VDD")) (("fingers" "1") ("w" "240n") ("fw" "240n") ("l" "100n")))
  ("MN1" "gpdk090" "nmos1v" (("D" "Bn") ("G" "B") ("S" "VSS") ("B" "VSS")) (("fingers" "1") ("w" "120n") ("fw" "120n") ("l" "100n")))
  ("MP1" "gpdk090" "pmos1v" (("D" "Bn") ("G" "B") ("S" "VDD") ("B" "VDD")) (("fingers" "1") ("w" "240n") ("fw" "240n") ("l" "100n")))
  ("MN2" "gpdk090" "nmos1v" (("D" "Y") ("G" "A") ("S" "n1") ("B" "VSS")) (("fingers" "1") ("w" "240n") ("fw" "240n") ("l" "100n")))
  ("MN3" "gpdk090" "nmos1v" (("D" "n1") ("G" "Bn") ("S" "VSS") ("B" "VSS")) (("fingers" "1") ("w" "240n") ("fw" "240n") ("l" "100n")))
  ("MN4" "gpdk090" "nmos1v" (("D" "Y") ("G" "An") ("S" "n2") ("B" "VSS")) (("fingers" "1") ("w" "240n") ("fw" "240n") ("l" "100n")))
  ("MN5" "gpdk090" "nmos1v" (("D" "n2") ("G" "B") ("S" "VSS") ("B" "VSS")) (("fingers" "1") ("w" "240n") ("fw" "240n") ("l" "100n")))
  ("MP2" "gpdk090" "pmos1v" (("D" "p1") ("G" "A") ("S" "VDD") ("B" "VDD")) (("fingers" "1") ("w" "480n") ("fw" "480n") ("l" "100n")))
  ("MP3" "gpdk090" "pmos1v" (("D" "p1") ("G" "Bn") ("S" "VDD") ("B" "VDD")) (("fingers" "1") ("w" "480n") ("fw" "480n") ("l" "100n")))
  ("MP4" "gpdk090" "pmos1v" (("D" "Y") ("G" "An") ("S" "p1") ("B" "VDD")) (("fingers" "1") ("w" "480n") ("fw" "480n") ("l" "100n")))
  ("MP5" "gpdk090" "pmos1v" (("D" "Y") ("G" "B") ("S" "p1") ("B" "VDD")) (("fingers" "1") ("w" "480n") ("fw" "480n") ("l" "100n"))))) t)
  sbErrors++ printf("SB_ERROR XNOR2_X1: %L\n" errset.errset))
unless(errset(sbCell("ALU_CELLS_A" "BLK_P" '(("GI" "input") ("PI" "input") ("GK" "input") ("PK" "input") ("GON" "output") ("PON" "output") ("VDD" "inputOutput") ("VSS" "inputOutput"))
 '(
  ("XG" "ALU_CELLS_A" "AOI21_X1" (("A1" "PI") ("A2" "GK") ("B" "GI") ("Y" "GON") ("VDD" "VDD") ("VSS" "VSS")) ())
  ("XP" "ALU_CELLS_A" "NAND2_X1" (("A" "PI") ("B" "PK") ("Y" "PON") ("VDD" "VDD") ("VSS" "VSS")) ()))) t)
  sbErrors++ printf("SB_ERROR BLK_P: %L\n" errset.errset))
unless(errset(sbCell("ALU_CELLS_A" "BLK_N" '(("GIN" "input") ("PIN" "input") ("GKN" "input") ("PKN" "input") ("GO" "output") ("PO" "output") ("VDD" "inputOutput") ("VSS" "inputOutput"))
 '(
  ("XG" "ALU_CELLS_A" "OAI21_X1" (("A1" "PIN") ("A2" "GKN") ("B" "GIN") ("Y" "GO") ("VDD" "VDD") ("VSS" "VSS")) ())
  ("XP" "ALU_CELLS_A" "NOR2_X1" (("A" "PIN") ("B" "PKN") ("Y" "PO") ("VDD" "VDD") ("VSS" "VSS")) ()))) t)
  sbErrors++ printf("SB_ERROR BLK_N: %L\n" errset.errset))
unless(errset(sbCell("ALU_CELLS_A" "GRY_P" '(("GI" "input") ("PI" "input") ("GK" "input") ("GON" "output") ("VDD" "inputOutput") ("VSS" "inputOutput"))
 '(
  ("XG" "ALU_CELLS_A" "AOI21_X1" (("A1" "PI") ("A2" "GK") ("B" "GI") ("Y" "GON") ("VDD" "VDD") ("VSS" "VSS")) ()))) t)
  sbErrors++ printf("SB_ERROR GRY_P: %L\n" errset.errset))
unless(errset(sbCell("ALU_CELLS_A" "GRY_N" '(("GIN" "input") ("PIN" "input") ("GKN" "input") ("GO" "output") ("VDD" "inputOutput") ("VSS" "inputOutput"))
 '(
  ("XG" "ALU_CELLS_A" "OAI21_X1" (("A1" "PIN") ("A2" "GKN") ("B" "GIN") ("Y" "GO") ("VDD" "VDD") ("VSS" "VSS")) ()))) t)
  sbErrors++ printf("SB_ERROR GRY_N: %L\n" errset.errset))
unless(errset(sbCell("ALU_CELLS_C" "HA_X1" '(("A" "input") ("B" "input") ("S" "output") ("CO" "output") ("VDD" "inputOutput") ("VSS" "inputOutput"))
 '(
  ("MN1" "gpdk090" "nmos1v" (("D" "xan") ("G" "A") ("S" "VSS") ("B" "VSS")) (("fingers" "1") ("w" "120n") ("fw" "120n") ("l" "100n")))
  ("MP2" "gpdk090" "pmos1v" (("D" "xan") ("G" "A") ("S" "VDD") ("B" "VDD")) (("fingers" "1") ("w" "240n") ("fw" "240n") ("l" "100n")))
  ("MN3" "gpdk090" "nmos1v" (("D" "xbn") ("G" "B") ("S" "VSS") ("B" "VSS")) (("fingers" "1") ("w" "120n") ("fw" "120n") ("l" "100n")))
  ("MP4" "gpdk090" "pmos1v" (("D" "xbn") ("G" "B") ("S" "VDD") ("B" "VDD")) (("fingers" "1") ("w" "240n") ("fw" "240n") ("l" "100n")))
  ("MN5" "gpdk090" "nmos1v" (("D" "S") ("G" "A") ("S" "xn1") ("B" "VSS")) (("fingers" "1") ("w" "240n") ("fw" "240n") ("l" "100n")))
  ("MN6" "gpdk090" "nmos1v" (("D" "xn1") ("G" "B") ("S" "VSS") ("B" "VSS")) (("fingers" "1") ("w" "240n") ("fw" "240n") ("l" "100n")))
  ("MN7" "gpdk090" "nmos1v" (("D" "S") ("G" "xan") ("S" "xn2") ("B" "VSS")) (("fingers" "1") ("w" "240n") ("fw" "240n") ("l" "100n")))
  ("MN8" "gpdk090" "nmos1v" (("D" "xn2") ("G" "xbn") ("S" "VSS") ("B" "VSS")) (("fingers" "1") ("w" "240n") ("fw" "240n") ("l" "100n")))
  ("MP9" "gpdk090" "pmos1v" (("D" "xp1") ("G" "A") ("S" "VDD") ("B" "VDD")) (("fingers" "1") ("w" "480n") ("fw" "480n") ("l" "100n")))
  ("MP10" "gpdk090" "pmos1v" (("D" "xp1") ("G" "B") ("S" "VDD") ("B" "VDD")) (("fingers" "1") ("w" "480n") ("fw" "480n") ("l" "100n")))
  ("MP11" "gpdk090" "pmos1v" (("D" "S") ("G" "xan") ("S" "xp1") ("B" "VDD")) (("fingers" "1") ("w" "480n") ("fw" "480n") ("l" "100n")))
  ("MP12" "gpdk090" "pmos1v" (("D" "S") ("G" "xbn") ("S" "xp1") ("B" "VDD")) (("fingers" "1") ("w" "480n") ("fw" "480n") ("l" "100n")))
  ("MN13" "gpdk090" "nmos1v" (("D" "con") ("G" "A") ("S" "an") ("B" "VSS")) (("fingers" "1") ("w" "240n") ("fw" "240n") ("l" "100n")))
  ("MN14" "gpdk090" "nmos1v" (("D" "an") ("G" "B") ("S" "VSS") ("B" "VSS")) (("fingers" "1") ("w" "240n") ("fw" "240n") ("l" "100n")))
  ("MP15" "gpdk090" "pmos1v" (("D" "con") ("G" "A") ("S" "VDD") ("B" "VDD")) (("fingers" "1") ("w" "240n") ("fw" "240n") ("l" "100n")))
  ("MP16" "gpdk090" "pmos1v" (("D" "con") ("G" "B") ("S" "VDD") ("B" "VDD")) (("fingers" "1") ("w" "240n") ("fw" "240n") ("l" "100n")))
  ("MN17" "gpdk090" "nmos1v" (("D" "CO") ("G" "con") ("S" "VSS") ("B" "VSS")) (("fingers" "1") ("w" "120n") ("fw" "120n") ("l" "100n")))
  ("MP18" "gpdk090" "pmos1v" (("D" "CO") ("G" "con") ("S" "VDD") ("B" "VDD")) (("fingers" "1") ("w" "240n") ("fw" "240n") ("l" "100n"))))) t)
  sbErrors++ printf("SB_ERROR HA_X1: %L\n" errset.errset))
unless(errset(sbCell("ALU_CELLS_C" "FA_X1" '(("A" "input") ("B" "input") ("CI" "input") ("S" "output") ("CO" "output") ("VDD" "inputOutput") ("VSS" "inputOutput"))
 '(
  ("MN1" "gpdk090" "nmos1v" (("D" "n1") ("G" "A") ("S" "VSS") ("B" "VSS")) (("fingers" "1") ("w" "240n") ("fw" "240n") ("l" "100n")))
  ("MN2" "gpdk090" "nmos1v" (("D" "con") ("G" "B") ("S" "n1") ("B" "VSS")) (("fingers" "1") ("w" "240n") ("fw" "240n") ("l" "100n")))
  ("MN3" "gpdk090" "nmos1v" (("D" "n2") ("G" "A") ("S" "VSS") ("B" "VSS")) (("fingers" "1") ("w" "240n") ("fw" "240n") ("l" "100n")))
  ("MN4" "gpdk090" "nmos1v" (("D" "n2") ("G" "B") ("S" "VSS") ("B" "VSS")) (("fingers" "1") ("w" "240n") ("fw" "240n") ("l" "100n")))
  ("MN5" "gpdk090" "nmos1v" (("D" "con") ("G" "CI") ("S" "n2") ("B" "VSS")) (("fingers" "1") ("w" "240n") ("fw" "240n") ("l" "100n")))
  ("MN6" "gpdk090" "nmos1v" (("D" "n3") ("G" "A") ("S" "VSS") ("B" "VSS")) (("fingers" "1") ("w" "240n") ("fw" "240n") ("l" "100n")))
  ("MN7" "gpdk090" "nmos1v" (("D" "n3") ("G" "B") ("S" "VSS") ("B" "VSS")) (("fingers" "1") ("w" "240n") ("fw" "240n") ("l" "100n")))
  ("MN8" "gpdk090" "nmos1v" (("D" "n3") ("G" "CI") ("S" "VSS") ("B" "VSS")) (("fingers" "1") ("w" "240n") ("fw" "240n") ("l" "100n")))
  ("MN9" "gpdk090" "nmos1v" (("D" "sn") ("G" "con") ("S" "n3") ("B" "VSS")) (("fingers" "1") ("w" "240n") ("fw" "240n") ("l" "100n")))
  ("MN10" "gpdk090" "nmos1v" (("D" "n4") ("G" "A") ("S" "VSS") ("B" "VSS")) (("fingers" "1") ("w" "360n") ("fw" "360n") ("l" "100n")))
  ("MN11" "gpdk090" "nmos1v" (("D" "n5") ("G" "B") ("S" "n4") ("B" "VSS")) (("fingers" "1") ("w" "360n") ("fw" "360n") ("l" "100n")))
  ("MN12" "gpdk090" "nmos1v" (("D" "sn") ("G" "CI") ("S" "n5") ("B" "VSS")) (("fingers" "1") ("w" "360n") ("fw" "360n") ("l" "100n")))
  ("MP13" "gpdk090" "pmos1v" (("D" "p1") ("G" "A") ("S" "VDD") ("B" "VDD")) (("fingers" "1") ("w" "480n") ("fw" "480n") ("l" "100n")))
  ("MP14" "gpdk090" "pmos1v" (("D" "con") ("G" "B") ("S" "p1") ("B" "VDD")) (("fingers" "1") ("w" "480n") ("fw" "480n") ("l" "100n")))
  ("MP15" "gpdk090" "pmos1v" (("D" "p2") ("G" "A") ("S" "VDD") ("B" "VDD")) (("fingers" "1") ("w" "480n") ("fw" "480n") ("l" "100n")))
  ("MP16" "gpdk090" "pmos1v" (("D" "p2") ("G" "B") ("S" "VDD") ("B" "VDD")) (("fingers" "1") ("w" "480n") ("fw" "480n") ("l" "100n")))
  ("MP17" "gpdk090" "pmos1v" (("D" "con") ("G" "CI") ("S" "p2") ("B" "VDD")) (("fingers" "1") ("w" "480n") ("fw" "480n") ("l" "100n")))
  ("MP18" "gpdk090" "pmos1v" (("D" "p3") ("G" "A") ("S" "VDD") ("B" "VDD")) (("fingers" "1") ("w" "480n") ("fw" "480n") ("l" "100n")))
  ("MP19" "gpdk090" "pmos1v" (("D" "p3") ("G" "B") ("S" "VDD") ("B" "VDD")) (("fingers" "1") ("w" "480n") ("fw" "480n") ("l" "100n")))
  ("MP20" "gpdk090" "pmos1v" (("D" "p3") ("G" "CI") ("S" "VDD") ("B" "VDD")) (("fingers" "1") ("w" "480n") ("fw" "480n") ("l" "100n")))
  ("MP21" "gpdk090" "pmos1v" (("D" "sn") ("G" "con") ("S" "p3") ("B" "VDD")) (("fingers" "1") ("w" "480n") ("fw" "480n") ("l" "100n")))
  ("MP22" "gpdk090" "pmos1v" (("D" "p4") ("G" "A") ("S" "VDD") ("B" "VDD")) (("fingers" "1") ("w" "720n") ("fw" "720n") ("l" "100n")))
  ("MP23" "gpdk090" "pmos1v" (("D" "p5") ("G" "B") ("S" "p4") ("B" "VDD")) (("fingers" "1") ("w" "720n") ("fw" "720n") ("l" "100n")))
  ("MP24" "gpdk090" "pmos1v" (("D" "sn") ("G" "CI") ("S" "p5") ("B" "VDD")) (("fingers" "1") ("w" "720n") ("fw" "720n") ("l" "100n")))
  ("MN25" "gpdk090" "nmos1v" (("D" "S") ("G" "sn") ("S" "VSS") ("B" "VSS")) (("fingers" "1") ("w" "120n") ("fw" "120n") ("l" "100n")))
  ("MP26" "gpdk090" "pmos1v" (("D" "S") ("G" "sn") ("S" "VDD") ("B" "VDD")) (("fingers" "1") ("w" "240n") ("fw" "240n") ("l" "100n")))
  ("MN27" "gpdk090" "nmos1v" (("D" "CO") ("G" "con") ("S" "VSS") ("B" "VSS")) (("fingers" "1") ("w" "120n") ("fw" "120n") ("l" "100n")))
  ("MP28" "gpdk090" "pmos1v" (("D" "CO") ("G" "con") ("S" "VDD") ("B" "VDD")) (("fingers" "1") ("w" "240n") ("fw" "240n") ("l" "100n"))))) t)
  sbErrors++ printf("SB_ERROR FA_X1: %L\n" errset.errset))
unless(errset(sbCell("ALU_CELLS_B" "CMP42" '(("X1" "input") ("X2" "input") ("X3" "input") ("X4" "input") ("CI" "input") ("S" "output") ("C" "output") ("CO" "output") ("VDD" "inputOutput") ("VSS" "inputOutput"))
 '(
  ("MN1" "gpdk090" "nmos1v" (("D" "an1") ("G" "X1") ("S" "VSS") ("B" "VSS")) (("fingers" "1") ("w" "240n") ("fw" "240n") ("l" "100n")))
  ("MN2" "gpdk090" "nmos1v" (("D" "acon") ("G" "X2") ("S" "an1") ("B" "VSS")) (("fingers" "1") ("w" "240n") ("fw" "240n") ("l" "100n")))
  ("MN3" "gpdk090" "nmos1v" (("D" "an2") ("G" "X1") ("S" "VSS") ("B" "VSS")) (("fingers" "1") ("w" "240n") ("fw" "240n") ("l" "100n")))
  ("MN4" "gpdk090" "nmos1v" (("D" "an2") ("G" "X2") ("S" "VSS") ("B" "VSS")) (("fingers" "1") ("w" "240n") ("fw" "240n") ("l" "100n")))
  ("MN5" "gpdk090" "nmos1v" (("D" "acon") ("G" "X3") ("S" "an2") ("B" "VSS")) (("fingers" "1") ("w" "240n") ("fw" "240n") ("l" "100n")))
  ("MN6" "gpdk090" "nmos1v" (("D" "an3") ("G" "X1") ("S" "VSS") ("B" "VSS")) (("fingers" "1") ("w" "240n") ("fw" "240n") ("l" "100n")))
  ("MN7" "gpdk090" "nmos1v" (("D" "an3") ("G" "X2") ("S" "VSS") ("B" "VSS")) (("fingers" "1") ("w" "240n") ("fw" "240n") ("l" "100n")))
  ("MN8" "gpdk090" "nmos1v" (("D" "an3") ("G" "X3") ("S" "VSS") ("B" "VSS")) (("fingers" "1") ("w" "240n") ("fw" "240n") ("l" "100n")))
  ("MN9" "gpdk090" "nmos1v" (("D" "asn") ("G" "acon") ("S" "an3") ("B" "VSS")) (("fingers" "1") ("w" "240n") ("fw" "240n") ("l" "100n")))
  ("MN10" "gpdk090" "nmos1v" (("D" "an4") ("G" "X1") ("S" "VSS") ("B" "VSS")) (("fingers" "1") ("w" "360n") ("fw" "360n") ("l" "100n")))
  ("MN11" "gpdk090" "nmos1v" (("D" "an5") ("G" "X2") ("S" "an4") ("B" "VSS")) (("fingers" "1") ("w" "360n") ("fw" "360n") ("l" "100n")))
  ("MN12" "gpdk090" "nmos1v" (("D" "asn") ("G" "X3") ("S" "an5") ("B" "VSS")) (("fingers" "1") ("w" "360n") ("fw" "360n") ("l" "100n")))
  ("MP13" "gpdk090" "pmos1v" (("D" "ap1") ("G" "X1") ("S" "VDD") ("B" "VDD")) (("fingers" "1") ("w" "480n") ("fw" "480n") ("l" "100n")))
  ("MP14" "gpdk090" "pmos1v" (("D" "acon") ("G" "X2") ("S" "ap1") ("B" "VDD")) (("fingers" "1") ("w" "480n") ("fw" "480n") ("l" "100n")))
  ("MP15" "gpdk090" "pmos1v" (("D" "ap2") ("G" "X1") ("S" "VDD") ("B" "VDD")) (("fingers" "1") ("w" "480n") ("fw" "480n") ("l" "100n")))
  ("MP16" "gpdk090" "pmos1v" (("D" "ap2") ("G" "X2") ("S" "VDD") ("B" "VDD")) (("fingers" "1") ("w" "480n") ("fw" "480n") ("l" "100n")))
  ("MP17" "gpdk090" "pmos1v" (("D" "acon") ("G" "X3") ("S" "ap2") ("B" "VDD")) (("fingers" "1") ("w" "480n") ("fw" "480n") ("l" "100n")))
  ("MP18" "gpdk090" "pmos1v" (("D" "ap3") ("G" "X1") ("S" "VDD") ("B" "VDD")) (("fingers" "1") ("w" "480n") ("fw" "480n") ("l" "100n")))
  ("MP19" "gpdk090" "pmos1v" (("D" "ap3") ("G" "X2") ("S" "VDD") ("B" "VDD")) (("fingers" "1") ("w" "480n") ("fw" "480n") ("l" "100n")))
  ("MP20" "gpdk090" "pmos1v" (("D" "ap3") ("G" "X3") ("S" "VDD") ("B" "VDD")) (("fingers" "1") ("w" "480n") ("fw" "480n") ("l" "100n")))
  ("MP21" "gpdk090" "pmos1v" (("D" "asn") ("G" "acon") ("S" "ap3") ("B" "VDD")) (("fingers" "1") ("w" "480n") ("fw" "480n") ("l" "100n")))
  ("MP22" "gpdk090" "pmos1v" (("D" "ap4") ("G" "X1") ("S" "VDD") ("B" "VDD")) (("fingers" "1") ("w" "720n") ("fw" "720n") ("l" "100n")))
  ("MP23" "gpdk090" "pmos1v" (("D" "ap5") ("G" "X2") ("S" "ap4") ("B" "VDD")) (("fingers" "1") ("w" "720n") ("fw" "720n") ("l" "100n")))
  ("MP24" "gpdk090" "pmos1v" (("D" "asn") ("G" "X3") ("S" "ap5") ("B" "VDD")) (("fingers" "1") ("w" "720n") ("fw" "720n") ("l" "100n")))
  ("MN25" "gpdk090" "nmos1v" (("D" "s1") ("G" "asn") ("S" "VSS") ("B" "VSS")) (("fingers" "1") ("w" "120n") ("fw" "120n") ("l" "100n")))
  ("MP26" "gpdk090" "pmos1v" (("D" "s1") ("G" "asn") ("S" "VDD") ("B" "VDD")) (("fingers" "1") ("w" "240n") ("fw" "240n") ("l" "100n")))
  ("MN27" "gpdk090" "nmos1v" (("D" "CO") ("G" "acon") ("S" "VSS") ("B" "VSS")) (("fingers" "1") ("w" "120n") ("fw" "120n") ("l" "100n")))
  ("MP28" "gpdk090" "pmos1v" (("D" "CO") ("G" "acon") ("S" "VDD") ("B" "VDD")) (("fingers" "1") ("w" "240n") ("fw" "240n") ("l" "100n")))
  ("MN29" "gpdk090" "nmos1v" (("D" "bn1") ("G" "s1") ("S" "VSS") ("B" "VSS")) (("fingers" "1") ("w" "240n") ("fw" "240n") ("l" "100n")))
  ("MN30" "gpdk090" "nmos1v" (("D" "bcon") ("G" "X4") ("S" "bn1") ("B" "VSS")) (("fingers" "1") ("w" "240n") ("fw" "240n") ("l" "100n")))
  ("MN31" "gpdk090" "nmos1v" (("D" "bn2") ("G" "s1") ("S" "VSS") ("B" "VSS")) (("fingers" "1") ("w" "240n") ("fw" "240n") ("l" "100n")))
  ("MN32" "gpdk090" "nmos1v" (("D" "bn2") ("G" "X4") ("S" "VSS") ("B" "VSS")) (("fingers" "1") ("w" "240n") ("fw" "240n") ("l" "100n")))
  ("MN33" "gpdk090" "nmos1v" (("D" "bcon") ("G" "CI") ("S" "bn2") ("B" "VSS")) (("fingers" "1") ("w" "240n") ("fw" "240n") ("l" "100n")))
  ("MN34" "gpdk090" "nmos1v" (("D" "bn3") ("G" "s1") ("S" "VSS") ("B" "VSS")) (("fingers" "1") ("w" "240n") ("fw" "240n") ("l" "100n")))
  ("MN35" "gpdk090" "nmos1v" (("D" "bn3") ("G" "X4") ("S" "VSS") ("B" "VSS")) (("fingers" "1") ("w" "240n") ("fw" "240n") ("l" "100n")))
  ("MN36" "gpdk090" "nmos1v" (("D" "bn3") ("G" "CI") ("S" "VSS") ("B" "VSS")) (("fingers" "1") ("w" "240n") ("fw" "240n") ("l" "100n")))
  ("MN37" "gpdk090" "nmos1v" (("D" "bsn") ("G" "bcon") ("S" "bn3") ("B" "VSS")) (("fingers" "1") ("w" "240n") ("fw" "240n") ("l" "100n")))
  ("MN38" "gpdk090" "nmos1v" (("D" "bn4") ("G" "s1") ("S" "VSS") ("B" "VSS")) (("fingers" "1") ("w" "360n") ("fw" "360n") ("l" "100n")))
  ("MN39" "gpdk090" "nmos1v" (("D" "bn5") ("G" "X4") ("S" "bn4") ("B" "VSS")) (("fingers" "1") ("w" "360n") ("fw" "360n") ("l" "100n")))
  ("MN40" "gpdk090" "nmos1v" (("D" "bsn") ("G" "CI") ("S" "bn5") ("B" "VSS")) (("fingers" "1") ("w" "360n") ("fw" "360n") ("l" "100n")))
  ("MP41" "gpdk090" "pmos1v" (("D" "bp1") ("G" "s1") ("S" "VDD") ("B" "VDD")) (("fingers" "1") ("w" "480n") ("fw" "480n") ("l" "100n")))
  ("MP42" "gpdk090" "pmos1v" (("D" "bcon") ("G" "X4") ("S" "bp1") ("B" "VDD")) (("fingers" "1") ("w" "480n") ("fw" "480n") ("l" "100n")))
  ("MP43" "gpdk090" "pmos1v" (("D" "bp2") ("G" "s1") ("S" "VDD") ("B" "VDD")) (("fingers" "1") ("w" "480n") ("fw" "480n") ("l" "100n")))
  ("MP44" "gpdk090" "pmos1v" (("D" "bp2") ("G" "X4") ("S" "VDD") ("B" "VDD")) (("fingers" "1") ("w" "480n") ("fw" "480n") ("l" "100n")))
  ("MP45" "gpdk090" "pmos1v" (("D" "bcon") ("G" "CI") ("S" "bp2") ("B" "VDD")) (("fingers" "1") ("w" "480n") ("fw" "480n") ("l" "100n")))
  ("MP46" "gpdk090" "pmos1v" (("D" "bp3") ("G" "s1") ("S" "VDD") ("B" "VDD")) (("fingers" "1") ("w" "480n") ("fw" "480n") ("l" "100n")))
  ("MP47" "gpdk090" "pmos1v" (("D" "bp3") ("G" "X4") ("S" "VDD") ("B" "VDD")) (("fingers" "1") ("w" "480n") ("fw" "480n") ("l" "100n")))
  ("MP48" "gpdk090" "pmos1v" (("D" "bp3") ("G" "CI") ("S" "VDD") ("B" "VDD")) (("fingers" "1") ("w" "480n") ("fw" "480n") ("l" "100n")))
  ("MP49" "gpdk090" "pmos1v" (("D" "bsn") ("G" "bcon") ("S" "bp3") ("B" "VDD")) (("fingers" "1") ("w" "480n") ("fw" "480n") ("l" "100n")))
  ("MP50" "gpdk090" "pmos1v" (("D" "bp4") ("G" "s1") ("S" "VDD") ("B" "VDD")) (("fingers" "1") ("w" "720n") ("fw" "720n") ("l" "100n")))
  ("MP51" "gpdk090" "pmos1v" (("D" "bp5") ("G" "X4") ("S" "bp4") ("B" "VDD")) (("fingers" "1") ("w" "720n") ("fw" "720n") ("l" "100n")))
  ("MP52" "gpdk090" "pmos1v" (("D" "bsn") ("G" "CI") ("S" "bp5") ("B" "VDD")) (("fingers" "1") ("w" "720n") ("fw" "720n") ("l" "100n")))
  ("MN53" "gpdk090" "nmos1v" (("D" "S") ("G" "bsn") ("S" "VSS") ("B" "VSS")) (("fingers" "1") ("w" "120n") ("fw" "120n") ("l" "100n")))
  ("MP54" "gpdk090" "pmos1v" (("D" "S") ("G" "bsn") ("S" "VDD") ("B" "VDD")) (("fingers" "1") ("w" "240n") ("fw" "240n") ("l" "100n")))
  ("MN55" "gpdk090" "nmos1v" (("D" "C") ("G" "bcon") ("S" "VSS") ("B" "VSS")) (("fingers" "1") ("w" "120n") ("fw" "120n") ("l" "100n")))
  ("MP56" "gpdk090" "pmos1v" (("D" "C") ("G" "bcon") ("S" "VDD") ("B" "VDD")) (("fingers" "1") ("w" "240n") ("fw" "240n") ("l" "100n"))))) t)
  sbErrors++ printf("SB_ERROR CMP42: %L\n" errset.errset))
unless(errset(sbCell("ALU_CELLS_B" "BOOTH_ENC" '(("X2" "input") ("X1" "input") ("X0" "input") ("ONE" "output") ("TWO" "output") ("VDD" "inputOutput") ("VSS" "inputOutput"))
 '(
  ("MN1" "gpdk090" "nmos1v" (("D" "aan") ("G" "X1") ("S" "VSS") ("B" "VSS")) (("fingers" "1") ("w" "120n") ("fw" "120n") ("l" "100n")))
  ("MP2" "gpdk090" "pmos1v" (("D" "aan") ("G" "X1") ("S" "VDD") ("B" "VDD")) (("fingers" "1") ("w" "240n") ("fw" "240n") ("l" "100n")))
  ("MN3" "gpdk090" "nmos1v" (("D" "abn") ("G" "X0") ("S" "VSS") ("B" "VSS")) (("fingers" "1") ("w" "120n") ("fw" "120n") ("l" "100n")))
  ("MP4" "gpdk090" "pmos1v" (("D" "abn") ("G" "X0") ("S" "VDD") ("B" "VDD")) (("fingers" "1") ("w" "240n") ("fw" "240n") ("l" "100n")))
  ("MN5" "gpdk090" "nmos1v" (("D" "ONE") ("G" "X1") ("S" "an1") ("B" "VSS")) (("fingers" "1") ("w" "240n") ("fw" "240n") ("l" "100n")))
  ("MN6" "gpdk090" "nmos1v" (("D" "an1") ("G" "X0") ("S" "VSS") ("B" "VSS")) (("fingers" "1") ("w" "240n") ("fw" "240n") ("l" "100n")))
  ("MN7" "gpdk090" "nmos1v" (("D" "ONE") ("G" "aan") ("S" "an2") ("B" "VSS")) (("fingers" "1") ("w" "240n") ("fw" "240n") ("l" "100n")))
  ("MN8" "gpdk090" "nmos1v" (("D" "an2") ("G" "abn") ("S" "VSS") ("B" "VSS")) (("fingers" "1") ("w" "240n") ("fw" "240n") ("l" "100n")))
  ("MP9" "gpdk090" "pmos1v" (("D" "ap1") ("G" "X1") ("S" "VDD") ("B" "VDD")) (("fingers" "1") ("w" "480n") ("fw" "480n") ("l" "100n")))
  ("MP10" "gpdk090" "pmos1v" (("D" "ap1") ("G" "X0") ("S" "VDD") ("B" "VDD")) (("fingers" "1") ("w" "480n") ("fw" "480n") ("l" "100n")))
  ("MP11" "gpdk090" "pmos1v" (("D" "ONE") ("G" "aan") ("S" "ap1") ("B" "VDD")) (("fingers" "1") ("w" "480n") ("fw" "480n") ("l" "100n")))
  ("MP12" "gpdk090" "pmos1v" (("D" "ONE") ("G" "abn") ("S" "ap1") ("B" "VDD")) (("fingers" "1") ("w" "480n") ("fw" "480n") ("l" "100n")))
  ("MN13" "gpdk090" "nmos1v" (("D" "ban") ("G" "X2") ("S" "VSS") ("B" "VSS")) (("fingers" "1") ("w" "120n") ("fw" "120n") ("l" "100n")))
  ("MP14" "gpdk090" "pmos1v" (("D" "ban") ("G" "X2") ("S" "VDD") ("B" "VDD")) (("fingers" "1") ("w" "240n") ("fw" "240n") ("l" "100n")))
  ("MN15" "gpdk090" "nmos1v" (("D" "bbn") ("G" "X1") ("S" "VSS") ("B" "VSS")) (("fingers" "1") ("w" "120n") ("fw" "120n") ("l" "100n")))
  ("MP16" "gpdk090" "pmos1v" (("D" "bbn") ("G" "X1") ("S" "VDD") ("B" "VDD")) (("fingers" "1") ("w" "240n") ("fw" "240n") ("l" "100n")))
  ("MN17" "gpdk090" "nmos1v" (("D" "e") ("G" "X2") ("S" "bn1") ("B" "VSS")) (("fingers" "1") ("w" "240n") ("fw" "240n") ("l" "100n")))
  ("MN18" "gpdk090" "nmos1v" (("D" "bn1") ("G" "bbn") ("S" "VSS") ("B" "VSS")) (("fingers" "1") ("w" "240n") ("fw" "240n") ("l" "100n")))
  ("MN19" "gpdk090" "nmos1v" (("D" "e") ("G" "ban") ("S" "bn2") ("B" "VSS")) (("fingers" "1") ("w" "240n") ("fw" "240n") ("l" "100n")))
  ("MN20" "gpdk090" "nmos1v" (("D" "bn2") ("G" "X1") ("S" "VSS") ("B" "VSS")) (("fingers" "1") ("w" "240n") ("fw" "240n") ("l" "100n")))
  ("MP21" "gpdk090" "pmos1v" (("D" "bp1") ("G" "X2") ("S" "VDD") ("B" "VDD")) (("fingers" "1") ("w" "480n") ("fw" "480n") ("l" "100n")))
  ("MP22" "gpdk090" "pmos1v" (("D" "bp1") ("G" "bbn") ("S" "VDD") ("B" "VDD")) (("fingers" "1") ("w" "480n") ("fw" "480n") ("l" "100n")))
  ("MP23" "gpdk090" "pmos1v" (("D" "e") ("G" "ban") ("S" "bp1") ("B" "VDD")) (("fingers" "1") ("w" "480n") ("fw" "480n") ("l" "100n")))
  ("MP24" "gpdk090" "pmos1v" (("D" "e") ("G" "X1") ("S" "bp1") ("B" "VDD")) (("fingers" "1") ("w" "480n") ("fw" "480n") ("l" "100n")))
  ("MN25" "gpdk090" "nmos1v" (("D" "TWO") ("G" "e") ("S" "VSS") ("B" "VSS")) (("fingers" "1") ("w" "120n") ("fw" "120n") ("l" "100n")))
  ("MN26" "gpdk090" "nmos1v" (("D" "TWO") ("G" "ONE") ("S" "VSS") ("B" "VSS")) (("fingers" "1") ("w" "120n") ("fw" "120n") ("l" "100n")))
  ("MP27" "gpdk090" "pmos1v" (("D" "cp") ("G" "e") ("S" "VDD") ("B" "VDD")) (("fingers" "1") ("w" "480n") ("fw" "480n") ("l" "100n")))
  ("MP28" "gpdk090" "pmos1v" (("D" "TWO") ("G" "ONE") ("S" "cp") ("B" "VDD")) (("fingers" "1") ("w" "480n") ("fw" "480n") ("l" "100n"))))) t)
  sbErrors++ printf("SB_ERROR BOOTH_ENC: %L\n" errset.errset))
unless(errset(sbCell("ALU_CELLS_B" "BOOTH_SEL" '(("AJ" "input") ("AJM" "input") ("ONE" "input") ("TWO" "input") ("NEG" "input") ("PP" "output") ("VDD" "inputOutput") ("VSS" "inputOutput"))
 '(
  ("MN1" "gpdk090" "nmos1v" (("D" "xn") ("G" "ONE") ("S" "n1") ("B" "VSS")) (("fingers" "1") ("w" "240n") ("fw" "240n") ("l" "100n")))
  ("MN2" "gpdk090" "nmos1v" (("D" "n1") ("G" "AJ") ("S" "VSS") ("B" "VSS")) (("fingers" "1") ("w" "240n") ("fw" "240n") ("l" "100n")))
  ("MN3" "gpdk090" "nmos1v" (("D" "xn") ("G" "TWO") ("S" "n2") ("B" "VSS")) (("fingers" "1") ("w" "240n") ("fw" "240n") ("l" "100n")))
  ("MN4" "gpdk090" "nmos1v" (("D" "n2") ("G" "AJM") ("S" "VSS") ("B" "VSS")) (("fingers" "1") ("w" "240n") ("fw" "240n") ("l" "100n")))
  ("MP5" "gpdk090" "pmos1v" (("D" "p1") ("G" "ONE") ("S" "VDD") ("B" "VDD")) (("fingers" "1") ("w" "480n") ("fw" "480n") ("l" "100n")))
  ("MP6" "gpdk090" "pmos1v" (("D" "p1") ("G" "AJ") ("S" "VDD") ("B" "VDD")) (("fingers" "1") ("w" "480n") ("fw" "480n") ("l" "100n")))
  ("MP7" "gpdk090" "pmos1v" (("D" "xn") ("G" "TWO") ("S" "p1") ("B" "VDD")) (("fingers" "1") ("w" "480n") ("fw" "480n") ("l" "100n")))
  ("MP8" "gpdk090" "pmos1v" (("D" "xn") ("G" "AJM") ("S" "p1") ("B" "VDD")) (("fingers" "1") ("w" "480n") ("fw" "480n") ("l" "100n")))
  ("MN9" "gpdk090" "nmos1v" (("D" "xan") ("G" "xn") ("S" "VSS") ("B" "VSS")) (("fingers" "1") ("w" "120n") ("fw" "120n") ("l" "100n")))
  ("MP10" "gpdk090" "pmos1v" (("D" "xan") ("G" "xn") ("S" "VDD") ("B" "VDD")) (("fingers" "1") ("w" "240n") ("fw" "240n") ("l" "100n")))
  ("MN11" "gpdk090" "nmos1v" (("D" "xbn") ("G" "NEG") ("S" "VSS") ("B" "VSS")) (("fingers" "1") ("w" "120n") ("fw" "120n") ("l" "100n")))
  ("MP12" "gpdk090" "pmos1v" (("D" "xbn") ("G" "NEG") ("S" "VDD") ("B" "VDD")) (("fingers" "1") ("w" "240n") ("fw" "240n") ("l" "100n")))
  ("MN13" "gpdk090" "nmos1v" (("D" "PP") ("G" "xn") ("S" "xn1") ("B" "VSS")) (("fingers" "1") ("w" "240n") ("fw" "240n") ("l" "100n")))
  ("MN14" "gpdk090" "nmos1v" (("D" "xn1") ("G" "xbn") ("S" "VSS") ("B" "VSS")) (("fingers" "1") ("w" "240n") ("fw" "240n") ("l" "100n")))
  ("MN15" "gpdk090" "nmos1v" (("D" "PP") ("G" "xan") ("S" "xn2") ("B" "VSS")) (("fingers" "1") ("w" "240n") ("fw" "240n") ("l" "100n")))
  ("MN16" "gpdk090" "nmos1v" (("D" "xn2") ("G" "NEG") ("S" "VSS") ("B" "VSS")) (("fingers" "1") ("w" "240n") ("fw" "240n") ("l" "100n")))
  ("MP17" "gpdk090" "pmos1v" (("D" "xp1") ("G" "xn") ("S" "VDD") ("B" "VDD")) (("fingers" "1") ("w" "480n") ("fw" "480n") ("l" "100n")))
  ("MP18" "gpdk090" "pmos1v" (("D" "xp1") ("G" "xbn") ("S" "VDD") ("B" "VDD")) (("fingers" "1") ("w" "480n") ("fw" "480n") ("l" "100n")))
  ("MP19" "gpdk090" "pmos1v" (("D" "PP") ("G" "xan") ("S" "xp1") ("B" "VDD")) (("fingers" "1") ("w" "480n") ("fw" "480n") ("l" "100n")))
  ("MP20" "gpdk090" "pmos1v" (("D" "PP") ("G" "NEG") ("S" "xp1") ("B" "VDD")) (("fingers" "1") ("w" "480n") ("fw" "480n") ("l" "100n"))))) t)
  sbErrors++ printf("SB_ERROR BOOTH_SEL: %L\n" errset.errset))
unless(errset(sbCell("ALU_CELLS_D" "CAS_X1" '(("X" "input") ("D" "input") ("T" "input") ("CI" "input") ("S" "output") ("CO" "output") ("VDD" "inputOutput") ("VSS" "inputOutput"))
 '(
  ("I0" "ALU_CELLS_X" "XOR2_X1" (("A" "D") ("B" "T") ("Y" "b") ("VDD" "VDD") ("VSS" "VSS")) ())
  ("I1" "ALU_CELLS_X" "XOR2_X1" (("A" "X") ("B" "b") ("Y" "p") ("VDD" "VDD") ("VSS" "VSS")) ())
  ("I2" "ALU_CELLS_X" "XOR2_X1" (("A" "p") ("B" "CI") ("Y" "S") ("VDD" "VDD") ("VSS" "VSS")) ())
  ("I3" "ALU_CELLS_A" "NAND2_X1" (("A" "X") ("B" "b") ("Y" "g_n") ("VDD" "VDD") ("VSS" "VSS")) ())
  ("I4" "ALU_CELLS_A" "NAND2_X1" (("A" "p") ("B" "CI") ("Y" "pc_n") ("VDD" "VDD") ("VSS" "VSS")) ())
  ("I5" "ALU_CELLS_A" "NAND2_X1" (("A" "g_n") ("B" "pc_n") ("Y" "CO") ("VDD" "VDD") ("VSS" "VSS")) ()))) t)
  sbErrors++ printf("SB_ERROR CAS_X1: %L\n" errset.errset))
sbEnd()) t)
  printf("SB_ERROR uncaught: %L\n" errset.errset)
  exit(2))
exit(3)   ; unconditional: -nograph never exits on stdin EOF
