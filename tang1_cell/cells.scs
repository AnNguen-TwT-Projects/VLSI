// Tang 1: 18 cell chuan cua ALU (gpdk090, 1.2 V). Include file nay mot lan sau file model.
simulator lang=spectre
include "INV_X1/INV_X1.scs"
include "INV_X4/INV_X4.scs"
include "NAND2_X1/NAND2_X1.scs"
include "NOR2_X1/NOR2_X1.scs"
include "AOI21_X1/AOI21_X1.scs"
include "OAI21_X1/OAI21_X1.scs"
include "XOR2_X1/XOR2_X1.scs"
include "XNOR2_X1/XNOR2_X1.scs"
include "BLK_P/BLK_P.scs"
include "BLK_N/BLK_N.scs"
include "GRY_P/GRY_P.scs"
include "GRY_N/GRY_N.scs"
include "HA_X1/HA_X1.scs"
include "FA_X1/FA_X1.scs"
include "CMP42/CMP42.scs"
include "BOOTH_ENC/BOOTH_ENC.scs"
include "BOOTH_SEL/BOOTH_SEL.scs"
include "CAS_X1/CAS_X1.scs"
