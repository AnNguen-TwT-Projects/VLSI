// Testbench KSA8: sinh tu dong boi blocks/gen_tb.py tu vectors/ksa8.csv (148 vector)
// 2 ns/vector, suon 20 ps, tai 4x INV_X1 moi ngo ra
simulator lang=spectre
global 0
VVDD (VDD 0) vsource dc=1.2
VVSS (VSS 0) vsource dc=0
VA_0 (A_0 0) vsource type=pwl wave=[ \
    0p 0 28000p 0 28020p 1.2 84000p 1.2 84020p 0 112000p 0 112020p 1.2 168000p 1.2 \
    168020p 0 196000p 0 196020p 1.2 212000p 1.2 212020p 0 220000p 0 220020p 1.2 224000p 1.2 \
    224020p 0 226000p 0 226020p 1.2 230000p 1.2 230020p 0 234000p 0 234020p 1.2 236000p 1.2 \
    236020p 0 242000p 0 242020p 1.2 248000p 1.2 248020p 0 250000p 0 250020p 1.2 252000p 1.2 \
    252020p 0 254000p 0 254020p 1.2 260000p 1.2 260020p 0 266000p 0 266020p 1.2 268000p 1.2 \
    268020p 0 274000p 0 274020p 1.2 282000p 1.2 282020p 0 286000p 0 286020p 1.2 288000p 1.2 \
    288020p 0 290000p 0 290020p 1.2 294000p 1.2 294020p 0 ]
VA_1 (A_1 0) vsource type=pwl wave=[ \
    0p 0 56000p 0 56020p 1.2 84000p 1.2 84020p 0 112000p 0 112020p 1.2 140000p 1.2 \
    140020p 0 168000p 0 168020p 1.2 200000p 1.2 200020p 0 204000p 0 204020p 1.2 212000p 1.2 \
    212020p 0 218000p 0 218020p 1.2 220000p 1.2 220020p 0 224000p 0 224020p 1.2 246000p 1.2 \
    246020p 0 248000p 0 248020p 1.2 254000p 1.2 254020p 0 260000p 0 260020p 1.2 262000p 1.2 \
    262020p 0 264000p 0 264020p 1.2 266000p 1.2 266020p 0 268000p 0 268020p 1.2 270000p 1.2 \
    270020p 0 272000p 0 272020p 1.2 276000p 1.2 276020p 0 278000p 0 278020p 1.2 284000p 1.2 \
    284020p 0 288000p 0 288020p 1.2 ]
VA_2 (A_2 0) vsource type=pwl wave=[ \
    0p 0 56000p 0 56020p 1.2 84000p 1.2 84020p 0 112000p 0 112020p 1.2 168000p 1.2 \
    168020p 0 196000p 0 196020p 1.2 200000p 1.2 200020p 0 204000p 0 204020p 1.2 212000p 1.2 \
    212020p 0 216000p 0 216020p 1.2 218000p 1.2 218020p 0 230000p 0 230020p 1.2 234000p 1.2 \
    234020p 0 236000p 0 236020p 1.2 238000p 1.2 238020p 0 240000p 0 240020p 1.2 242000p 1.2 \
    242020p 0 246000p 0 246020p 1.2 248000p 1.2 248020p 0 252000p 0 252020p 1.2 254000p 1.2 \
    254020p 0 256000p 0 256020p 1.2 262000p 1.2 262020p 0 266000p 0 266020p 1.2 272000p 1.2 \
    272020p 0 274000p 0 274020p 1.2 280000p 1.2 280020p 0 282000p 0 282020p 1.2 284000p 1.2 \
    284020p 0 286000p 0 286020p 1.2 292000p 1.2 292020p 0 ]
VA_3 (A_3 0) vsource type=pwl wave=[ \
    0p 0 56000p 0 56020p 1.2 84000p 1.2 84020p 0 112000p 0 112020p 1.2 140000p 1.2 \
    140020p 0 168000p 0 168020p 1.2 200000p 1.2 200020p 0 204000p 0 204020p 1.2 212000p 1.2 \
    212020p 0 216000p 0 216020p 1.2 218000p 1.2 218020p 0 222000p 0 222020p 1.2 224000p 1.2 \
    224020p 0 226000p 0 226020p 1.2 230000p 1.2 230020p 0 232000p 0 232020p 1.2 234000p 1.2 \
    234020p 0 236000p 0 236020p 1.2 246000p 1.2 246020p 0 250000p 0 250020p 1.2 252000p 1.2 \
    252020p 0 254000p 0 254020p 1.2 260000p 1.2 260020p 0 264000p 0 264020p 1.2 266000p 1.2 \
    266020p 0 268000p 0 268020p 1.2 270000p 1.2 270020p 0 278000p 0 278020p 1.2 280000p 1.2 \
    280020p 0 290000p 0 290020p 1.2 294000p 1.2 294020p 0 ]
VA_4 (A_4 0) vsource type=pwl wave=[ \
    0p 0 56000p 0 56020p 1.2 84000p 1.2 84020p 0 112000p 0 112020p 1.2 168000p 1.2 \
    168020p 0 196000p 0 196020p 1.2 200000p 1.2 200020p 0 208000p 0 208020p 1.2 212000p 1.2 \
    212020p 0 216000p 0 216020p 1.2 220000p 1.2 220020p 0 224000p 0 224020p 1.2 228000p 1.2 \
    228020p 0 230000p 0 230020p 1.2 232000p 1.2 232020p 0 234000p 0 234020p 1.2 240000p 1.2 \
    240020p 0 242000p 0 242020p 1.2 244000p 1.2 244020p 0 246000p 0 246020p 1.2 248000p 1.2 \
    248020p 0 250000p 0 250020p 1.2 254000p 1.2 254020p 0 260000p 0 260020p 1.2 266000p 1.2 \
    266020p 0 268000p 0 268020p 1.2 274000p 1.2 274020p 0 276000p 0 276020p 1.2 280000p 1.2 \
    280020p 0 288000p 0 288020p 1.2 290000p 1.2 290020p 0 292000p 0 292020p 1.2 ]
VA_5 (A_5 0) vsource type=pwl wave=[ \
    0p 0 56000p 0 56020p 1.2 84000p 1.2 84020p 0 112000p 0 112020p 1.2 140000p 1.2 \
    140020p 0 168000p 0 168020p 1.2 200000p 1.2 200020p 0 208000p 0 208020p 1.2 212000p 1.2 \
    212020p 0 216000p 0 216020p 1.2 228000p 1.2 228020p 0 230000p 0 230020p 1.2 234000p 1.2 \
    234020p 0 238000p 0 238020p 1.2 244000p 1.2 244020p 0 246000p 0 246020p 1.2 248000p 1.2 \
    248020p 0 252000p 0 252020p 1.2 256000p 1.2 256020p 0 264000p 0 264020p 1.2 266000p 1.2 \
    266020p 0 268000p 0 268020p 1.2 270000p 1.2 270020p 0 272000p 0 272020p 1.2 284000p 1.2 \
    284020p 0 286000p 0 286020p 1.2 288000p 1.2 288020p 0 292000p 0 292020p 1.2 ]
VA_6 (A_6 0) vsource type=pwl wave=[ \
    0p 0 56000p 0 56020p 1.2 84000p 1.2 84020p 0 112000p 0 112020p 1.2 168000p 1.2 \
    168020p 0 196000p 0 196020p 1.2 200000p 1.2 200020p 0 208000p 0 208020p 1.2 212000p 1.2 \
    212020p 0 218000p 0 218020p 1.2 222000p 1.2 222020p 0 226000p 0 226020p 1.2 230000p 1.2 \
    230020p 0 244000p 0 244020p 1.2 260000p 1.2 260020p 0 264000p 0 264020p 1.2 266000p 1.2 \
    266020p 0 268000p 0 268020p 1.2 270000p 1.2 270020p 0 274000p 0 274020p 1.2 284000p 1.2 \
    284020p 0 286000p 0 286020p 1.2 288000p 1.2 288020p 0 290000p 0 290020p 1.2 ]
VA_7 (A_7 0) vsource type=pwl wave=[ \
    0p 0 84000p 0 84020p 1.2 140000p 1.2 140020p 0 168000p 0 168020p 1.2 200000p 1.2 \
    200020p 0 212000p 0 212020p 1.2 216000p 1.2 216020p 0 220000p 0 220020p 1.2 222000p 1.2 \
    222020p 0 226000p 0 226020p 1.2 240000p 1.2 240020p 0 244000p 0 244020p 1.2 248000p 1.2 \
    248020p 0 250000p 0 250020p 1.2 262000p 1.2 262020p 0 264000p 0 264020p 1.2 272000p 1.2 \
    272020p 0 274000p 0 274020p 1.2 280000p 1.2 280020p 0 282000p 0 282020p 1.2 284000p 1.2 \
    284020p 0 292000p 0 292020p 1.2 ]
VB_0 (B_0 0) vsource type=pwl wave=[ \
    0p 0 4000p 0 4020p 1.2 12000p 1.2 12020p 0 16000p 0 16020p 1.2 24000p 1.2 \
    24020p 0 32000p 0 32020p 1.2 40000p 1.2 40020p 0 44000p 0 44020p 1.2 52000p 1.2 \
    52020p 0 60000p 0 60020p 1.2 68000p 1.2 68020p 0 72000p 0 72020p 1.2 80000p 1.2 \
    80020p 0 88000p 0 88020p 1.2 96000p 1.2 96020p 0 100000p 0 100020p 1.2 108000p 1.2 \
    108020p 0 116000p 0 116020p 1.2 124000p 1.2 124020p 0 128000p 0 128020p 1.2 136000p 1.2 \
    136020p 0 144000p 0 144020p 1.2 152000p 1.2 152020p 0 156000p 0 156020p 1.2 164000p 1.2 \
    164020p 0 172000p 0 172020p 1.2 180000p 1.2 180020p 0 184000p 0 184020p 1.2 192000p 1.2 \
    192020p 0 196000p 0 196020p 1.2 212000p 1.2 212020p 0 216000p 0 216020p 1.2 220000p 1.2 \
    220020p 0 232000p 0 232020p 1.2 234000p 1.2 234020p 0 242000p 0 242020p 1.2 244000p 1.2 \
    244020p 0 248000p 0 248020p 1.2 250000p 1.2 250020p 0 252000p 0 252020p 1.2 254000p 1.2 \
    254020p 0 256000p 0 256020p 1.2 262000p 1.2 262020p 0 274000p 0 274020p 1.2 276000p 1.2 \
    276020p 0 278000p 0 278020p 1.2 280000p 1.2 280020p 0 282000p 0 282020p 1.2 286000p 1.2 \
    286020p 0 288000p 0 288020p 1.2 290000p 1.2 290020p 0 292000p 0 292020p 1.2 ]
VB_1 (B_1 0) vsource type=pwl wave=[ \
    0p 0 8000p 0 8020p 1.2 12000p 1.2 12020p 0 16000p 0 16020p 1.2 20000p 1.2 \
    20020p 0 24000p 0 24020p 1.2 28000p 1.2 28020p 0 36000p 0 36020p 1.2 40000p 1.2 \
    40020p 0 44000p 0 44020p 1.2 48000p 1.2 48020p 0 52000p 0 52020p 1.2 56000p 1.2 \
    56020p 0 64000p 0 64020p 1.2 68000p 1.2 68020p 0 72000p 0 72020p 1.2 76000p 1.2 \
    76020p 0 80000p 0 80020p 1.2 84000p 1.2 84020p 0 92000p 0 92020p 1.2 96000p 1.2 \
    96020p 0 100000p 0 100020p 1.2 104000p 1.2 104020p 0 108000p 0 108020p 1.2 112000p 1.2 \
    112020p 0 120000p 0 120020p 1.2 124000p 1.2 124020p 0 128000p 0 128020p 1.2 132000p 1.2 \
    132020p 0 136000p 0 136020p 1.2 140000p 1.2 140020p 0 148000p 0 148020p 1.2 152000p 1.2 \
    152020p 0 156000p 0 156020p 1.2 160000p 1.2 160020p 0 164000p 0 164020p 1.2 168000p 1.2 \
    168020p 0 176000p 0 176020p 1.2 180000p 1.2 180020p 0 184000p 0 184020p 1.2 188000p 1.2 \
    188020p 0 192000p 0 192020p 1.2 196000p 1.2 196020p 0 200000p 0 200020p 1.2 204000p 1.2 \
    204020p 0 208000p 0 208020p 1.2 212000p 1.2 212020p 0 216000p 0 216020p 1.2 222000p 1.2 \
    222020p 0 224000p 0 224020p 1.2 226000p 1.2 226020p 0 234000p 0 234020p 1.2 236000p 1.2 \
    236020p 0 268000p 0 268020p 1.2 272000p 1.2 272020p 0 280000p 0 280020p 1.2 288000p 1.2 \
    288020p 0 290000p 0 290020p 1.2 292000p 1.2 292020p 0 294000p 0 294020p 1.2 ]
VB_2 (B_2 0) vsource type=pwl wave=[ \
    0p 0 8000p 0 8020p 1.2 12000p 1.2 12020p 0 16000p 0 16020p 1.2 24000p 1.2 \
    24020p 0 36000p 0 36020p 1.2 40000p 1.2 40020p 0 44000p 0 44020p 1.2 52000p 1.2 \
    52020p 0 64000p 0 64020p 1.2 68000p 1.2 68020p 0 72000p 0 72020p 1.2 80000p 1.2 \
    80020p 0 92000p 0 92020p 1.2 96000p 1.2 96020p 0 100000p 0 100020p 1.2 108000p 1.2 \
    108020p 0 120000p 0 120020p 1.2 124000p 1.2 124020p 0 128000p 0 128020p 1.2 136000p 1.2 \
    136020p 0 148000p 0 148020p 1.2 152000p 1.2 152020p 0 156000p 0 156020p 1.2 164000p 1.2 \
    164020p 0 176000p 0 176020p 1.2 180000p 1.2 180020p 0 184000p 0 184020p 1.2 192000p 1.2 \
    192020p 0 200000p 0 200020p 1.2 204000p 1.2 204020p 0 208000p 0 208020p 1.2 212000p 1.2 \
    212020p 0 218000p 0 218020p 1.2 220000p 1.2 220020p 0 224000p 0 224020p 1.2 226000p 1.2 \
    226020p 0 232000p 0 232020p 1.2 234000p 1.2 234020p 0 236000p 0 236020p 1.2 242000p 1.2 \
    242020p 0 244000p 0 244020p 1.2 248000p 1.2 248020p 0 252000p 0 252020p 1.2 254000p 1.2 \
    254020p 0 256000p 0 256020p 1.2 260000p 1.2 260020p 0 262000p 0 262020p 1.2 264000p 1.2 \
    264020p 0 268000p 0 268020p 1.2 270000p 1.2 270020p 0 274000p 0 274020p 1.2 276000p 1.2 \
    276020p 0 278000p 0 278020p 1.2 280000p 1.2 280020p 0 282000p 0 282020p 1.2 288000p 1.2 \
    288020p 0 292000p 0 292020p 1.2 294000p 1.2 294020p 0 ]
VB_3 (B_3 0) vsource type=pwl wave=[ \
    0p 0 8000p 0 8020p 1.2 12000p 1.2 12020p 0 16000p 0 16020p 1.2 20000p 1.2 \
    20020p 0 24000p 0 24020p 1.2 28000p 1.2 28020p 0 36000p 0 36020p 1.2 40000p 1.2 \
    40020p 0 44000p 0 44020p 1.2 48000p 1.2 48020p 0 52000p 0 52020p 1.2 56000p 1.2 \
    56020p 0 64000p 0 64020p 1.2 68000p 1.2 68020p 0 72000p 0 72020p 1.2 76000p 1.2 \
    76020p 0 80000p 0 80020p 1.2 84000p 1.2 84020p 0 92000p 0 92020p 1.2 96000p 1.2 \
    96020p 0 100000p 0 100020p 1.2 104000p 1.2 104020p 0 108000p 0 108020p 1.2 112000p 1.2 \
    112020p 0 120000p 0 120020p 1.2 124000p 1.2 124020p 0 128000p 0 128020p 1.2 132000p 1.2 \
    132020p 0 136000p 0 136020p 1.2 140000p 1.2 140020p 0 148000p 0 148020p 1.2 152000p 1.2 \
    152020p 0 156000p 0 156020p 1.2 160000p 1.2 160020p 0 164000p 0 164020p 1.2 168000p 1.2 \
    168020p 0 176000p 0 176020p 1.2 180000p 1.2 180020p 0 184000p 0 184020p 1.2 188000p 1.2 \
    188020p 0 192000p 0 192020p 1.2 196000p 1.2 196020p 0 200000p 0 200020p 1.2 204000p 1.2 \
    204020p 0 208000p 0 208020p 1.2 212000p 1.2 212020p 0 220000p 0 220020p 1.2 224000p 1.2 \
    224020p 0 232000p 0 232020p 1.2 244000p 1.2 244020p 0 246000p 0 246020p 1.2 250000p 1.2 \
    250020p 0 256000p 0 256020p 1.2 270000p 1.2 270020p 0 274000p 0 274020p 1.2 276000p 1.2 \
    276020p 0 278000p 0 278020p 1.2 280000p 1.2 280020p 0 286000p 0 286020p 1.2 290000p 1.2 \
    290020p 0 ]
VB_4 (B_4 0) vsource type=pwl wave=[ \
    0p 0 8000p 0 8020p 1.2 12000p 1.2 12020p 0 16000p 0 16020p 1.2 24000p 1.2 \
    24020p 0 36000p 0 36020p 1.2 40000p 1.2 40020p 0 44000p 0 44020p 1.2 52000p 1.2 \
    52020p 0 64000p 0 64020p 1.2 68000p 1.2 68020p 0 72000p 0 72020p 1.2 80000p 1.2 \
    80020p 0 92000p 0 92020p 1.2 96000p 1.2 96020p 0 100000p 0 100020p 1.2 108000p 1.2 \
    108020p 0 120000p 0 120020p 1.2 124000p 1.2 124020p 0 128000p 0 128020p 1.2 136000p 1.2 \
    136020p 0 148000p 0 148020p 1.2 152000p 1.2 152020p 0 156000p 0 156020p 1.2 164000p 1.2 \
    164020p 0 176000p 0 176020p 1.2 180000p 1.2 180020p 0 184000p 0 184020p 1.2 192000p 1.2 \
    192020p 0 200000p 0 200020p 1.2 204000p 1.2 204020p 0 208000p 0 208020p 1.2 212000p 1.2 \
    212020p 0 218000p 0 218020p 1.2 224000p 1.2 224020p 0 242000p 0 242020p 1.2 244000p 1.2 \
    244020p 0 248000p 0 248020p 1.2 260000p 1.2 260020p 0 264000p 0 264020p 1.2 270000p 1.2 \
    270020p 0 274000p 0 274020p 1.2 276000p 1.2 276020p 0 278000p 0 278020p 1.2 282000p 1.2 \
    282020p 0 286000p 0 286020p 1.2 288000p 1.2 288020p 0 ]
VB_5 (B_5 0) vsource type=pwl wave=[ \
    0p 0 8000p 0 8020p 1.2 12000p 1.2 12020p 0 16000p 0 16020p 1.2 20000p 1.2 \
    20020p 0 24000p 0 24020p 1.2 28000p 1.2 28020p 0 36000p 0 36020p 1.2 40000p 1.2 \
    40020p 0 44000p 0 44020p 1.2 48000p 1.2 48020p 0 52000p 0 52020p 1.2 56000p 1.2 \
    56020p 0 64000p 0 64020p 1.2 68000p 1.2 68020p 0 72000p 0 72020p 1.2 76000p 1.2 \
    76020p 0 80000p 0 80020p 1.2 84000p 1.2 84020p 0 92000p 0 92020p 1.2 96000p 1.2 \
    96020p 0 100000p 0 100020p 1.2 104000p 1.2 104020p 0 108000p 0 108020p 1.2 112000p 1.2 \
    112020p 0 120000p 0 120020p 1.2 124000p 1.2 124020p 0 128000p 0 128020p 1.2 132000p 1.2 \
    132020p 0 136000p 0 136020p 1.2 140000p 1.2 140020p 0 148000p 0 148020p 1.2 152000p 1.2 \
    152020p 0 156000p 0 156020p 1.2 160000p 1.2 160020p 0 164000p 0 164020p 1.2 168000p 1.2 \
    168020p 0 176000p 0 176020p 1.2 180000p 1.2 180020p 0 184000p 0 184020p 1.2 188000p 1.2 \
    188020p 0 192000p 0 192020p 1.2 196000p 1.2 196020p 0 200000p 0 200020p 1.2 204000p 1.2 \
    204020p 0 208000p 0 208020p 1.2 212000p 1.2 212020p 0 216000p 0 216020p 1.2 218000p 1.2 \
    218020p 0 220000p 0 220020p 1.2 228000p 1.2 228020p 0 232000p 0 232020p 1.2 236000p 1.2 \
    236020p 0 238000p 0 238020p 1.2 240000p 1.2 240020p 0 250000p 0 250020p 1.2 256000p 1.2 \
    256020p 0 264000p 0 264020p 1.2 268000p 1.2 268020p 0 270000p 0 270020p 1.2 274000p 1.2 \
    274020p 0 276000p 0 276020p 1.2 280000p 1.2 280020p 0 284000p 0 284020p 1.2 288000p 1.2 \
    288020p 0 ]
VB_6 (B_6 0) vsource type=pwl wave=[ \
    0p 0 8000p 0 8020p 1.2 12000p 1.2 12020p 0 16000p 0 16020p 1.2 24000p 1.2 \
    24020p 0 36000p 0 36020p 1.2 40000p 1.2 40020p 0 44000p 0 44020p 1.2 52000p 1.2 \
    52020p 0 64000p 0 64020p 1.2 68000p 1.2 68020p 0 72000p 0 72020p 1.2 80000p 1.2 \
    80020p 0 92000p 0 92020p 1.2 96000p 1.2 96020p 0 100000p 0 100020p 1.2 108000p 1.2 \
    108020p 0 120000p 0 120020p 1.2 124000p 1.2 124020p 0 128000p 0 128020p 1.2 136000p 1.2 \
    136020p 0 148000p 0 148020p 1.2 152000p 1.2 152020p 0 156000p 0 156020p 1.2 164000p 1.2 \
    164020p 0 176000p 0 176020p 1.2 180000p 1.2 180020p 0 184000p 0 184020p 1.2 192000p 1.2 \
    192020p 0 200000p 0 200020p 1.2 204000p 1.2 204020p 0 208000p 0 208020p 1.2 212000p 1.2 \
    212020p 0 218000p 0 218020p 1.2 222000p 1.2 222020p 0 224000p 0 224020p 1.2 226000p 1.2 \
    226020p 0 230000p 0 230020p 1.2 232000p 1.2 232020p 0 234000p 0 234020p 1.2 236000p 1.2 \
    236020p 0 238000p 0 238020p 1.2 244000p 1.2 244020p 0 250000p 0 250020p 1.2 256000p 1.2 \
    256020p 0 258000p 0 258020p 1.2 260000p 1.2 260020p 0 262000p 0 262020p 1.2 264000p 1.2 \
    264020p 0 266000p 0 266020p 1.2 270000p 1.2 270020p 0 272000p 0 272020p 1.2 276000p 1.2 \
    276020p 0 280000p 0 280020p 1.2 282000p 1.2 282020p 0 284000p 0 284020p 1.2 288000p 1.2 \
    288020p 0 292000p 0 292020p 1.2 ]
VB_7 (B_7 0) vsource type=pwl wave=[ \
    0p 0 12000p 0 12020p 1.2 20000p 1.2 20020p 0 24000p 0 24020p 1.2 28000p 1.2 \
    28020p 0 40000p 0 40020p 1.2 48000p 1.2 48020p 0 52000p 0 52020p 1.2 56000p 1.2 \
    56020p 0 68000p 0 68020p 1.2 76000p 1.2 76020p 0 80000p 0 80020p 1.2 84000p 1.2 \
    84020p 0 96000p 0 96020p 1.2 104000p 1.2 104020p 0 108000p 0 108020p 1.2 112000p 1.2 \
    112020p 0 124000p 0 124020p 1.2 132000p 1.2 132020p 0 136000p 0 136020p 1.2 140000p 1.2 \
    140020p 0 152000p 0 152020p 1.2 160000p 1.2 160020p 0 164000p 0 164020p 1.2 168000p 1.2 \
    168020p 0 180000p 0 180020p 1.2 188000p 1.2 188020p 0 192000p 0 192020p 1.2 196000p 1.2 \
    196020p 0 200000p 0 200020p 1.2 204000p 1.2 204020p 0 212000p 0 212020p 1.2 220000p 1.2 \
    220020p 0 224000p 0 224020p 1.2 232000p 1.2 232020p 0 234000p 0 234020p 1.2 236000p 1.2 \
    236020p 0 238000p 0 238020p 1.2 246000p 1.2 246020p 0 250000p 0 250020p 1.2 252000p 1.2 \
    252020p 0 254000p 0 254020p 1.2 262000p 1.2 262020p 0 264000p 0 264020p 1.2 274000p 1.2 \
    274020p 0 278000p 0 278020p 1.2 282000p 1.2 282020p 0 284000p 0 284020p 1.2 286000p 1.2 \
    286020p 0 288000p 0 288020p 1.2 290000p 1.2 290020p 0 ]
VCIN (CIN 0) vsource type=pwl wave=[ \
    0p 0 2000p 0 2020p 1.2 4000p 1.2 4020p 0 6000p 0 6020p 1.2 8000p 1.2 \
    8020p 0 10000p 0 10020p 1.2 12000p 1.2 12020p 0 14000p 0 14020p 1.2 16000p 1.2 \
    16020p 0 18000p 0 18020p 1.2 20000p 1.2 20020p 0 22000p 0 22020p 1.2 24000p 1.2 \
    24020p 0 26000p 0 26020p 1.2 28000p 1.2 28020p 0 30000p 0 30020p 1.2 32000p 1.2 \
    32020p 0 34000p 0 34020p 1.2 36000p 1.2 36020p 0 38000p 0 38020p 1.2 40000p 1.2 \
    40020p 0 42000p 0 42020p 1.2 44000p 1.2 44020p 0 46000p 0 46020p 1.2 48000p 1.2 \
    48020p 0 50000p 0 50020p 1.2 52000p 1.2 52020p 0 54000p 0 54020p 1.2 56000p 1.2 \
    56020p 0 58000p 0 58020p 1.2 60000p 1.2 60020p 0 62000p 0 62020p 1.2 64000p 1.2 \
    64020p 0 66000p 0 66020p 1.2 68000p 1.2 68020p 0 70000p 0 70020p 1.2 72000p 1.2 \
    72020p 0 74000p 0 74020p 1.2 76000p 1.2 76020p 0 78000p 0 78020p 1.2 80000p 1.2 \
    80020p 0 82000p 0 82020p 1.2 84000p 1.2 84020p 0 86000p 0 86020p 1.2 88000p 1.2 \
    88020p 0 90000p 0 90020p 1.2 92000p 1.2 92020p 0 94000p 0 94020p 1.2 96000p 1.2 \
    96020p 0 98000p 0 98020p 1.2 100000p 1.2 100020p 0 102000p 0 102020p 1.2 104000p 1.2 \
    104020p 0 106000p 0 106020p 1.2 108000p 1.2 108020p 0 110000p 0 110020p 1.2 112000p 1.2 \
    112020p 0 114000p 0 114020p 1.2 116000p 1.2 116020p 0 118000p 0 118020p 1.2 120000p 1.2 \
    120020p 0 122000p 0 122020p 1.2 124000p 1.2 124020p 0 126000p 0 126020p 1.2 128000p 1.2 \
    128020p 0 130000p 0 130020p 1.2 132000p 1.2 132020p 0 134000p 0 134020p 1.2 136000p 1.2 \
    136020p 0 138000p 0 138020p 1.2 140000p 1.2 140020p 0 142000p 0 142020p 1.2 144000p 1.2 \
    144020p 0 146000p 0 146020p 1.2 148000p 1.2 148020p 0 150000p 0 150020p 1.2 152000p 1.2 \
    152020p 0 154000p 0 154020p 1.2 156000p 1.2 156020p 0 158000p 0 158020p 1.2 160000p 1.2 \
    160020p 0 162000p 0 162020p 1.2 164000p 1.2 164020p 0 166000p 0 166020p 1.2 168000p 1.2 \
    168020p 0 170000p 0 170020p 1.2 172000p 1.2 172020p 0 174000p 0 174020p 1.2 176000p 1.2 \
    176020p 0 178000p 0 178020p 1.2 180000p 1.2 180020p 0 182000p 0 182020p 1.2 184000p 1.2 \
    184020p 0 186000p 0 186020p 1.2 188000p 1.2 188020p 0 190000p 0 190020p 1.2 192000p 1.2 \
    192020p 0 194000p 0 194020p 1.2 196000p 1.2 196020p 0 198000p 0 198020p 1.2 200000p 1.2 \
    200020p 0 202000p 0 202020p 1.2 204000p 1.2 204020p 0 206000p 0 206020p 1.2 208000p 1.2 \
    208020p 0 210000p 0 210020p 1.2 212000p 1.2 212020p 0 214000p 0 214020p 1.2 216000p 1.2 \
    216020p 0 218000p 0 218020p 1.2 220000p 1.2 220020p 0 222000p 0 222020p 1.2 224000p 1.2 \
    224020p 0 228000p 0 228020p 1.2 230000p 1.2 230020p 0 232000p 0 232020p 1.2 234000p 1.2 \
    234020p 0 236000p 0 236020p 1.2 246000p 1.2 246020p 0 254000p 0 254020p 1.2 258000p 1.2 \
    258020p 0 262000p 0 262020p 1.2 264000p 1.2 264020p 0 266000p 0 266020p 1.2 268000p 1.2 \
    268020p 0 270000p 0 270020p 1.2 278000p 1.2 278020p 0 288000p 0 288020p 1.2 292000p 1.2 \
    292020p 0 294000p 0 294020p 1.2 ]
XDUT (A_0 A_1 A_2 A_3 A_4 A_5 A_6 A_7 B_0 B_1 B_2 B_3 B_4 B_5 B_6 B_7 CIN S_0 S_1 S_2 S_3 S_4 S_5 S_6 S_7 C7 C8 VDD VSS) KSA8
XLS_0_0 (S_0 ld_S_0_0 VDD VSS) INV_X1
XLS_0_1 (S_0 ld_S_0_1 VDD VSS) INV_X1
XLS_0_2 (S_0 ld_S_0_2 VDD VSS) INV_X1
XLS_0_3 (S_0 ld_S_0_3 VDD VSS) INV_X1
XLS_1_0 (S_1 ld_S_1_0 VDD VSS) INV_X1
XLS_1_1 (S_1 ld_S_1_1 VDD VSS) INV_X1
XLS_1_2 (S_1 ld_S_1_2 VDD VSS) INV_X1
XLS_1_3 (S_1 ld_S_1_3 VDD VSS) INV_X1
XLS_2_0 (S_2 ld_S_2_0 VDD VSS) INV_X1
XLS_2_1 (S_2 ld_S_2_1 VDD VSS) INV_X1
XLS_2_2 (S_2 ld_S_2_2 VDD VSS) INV_X1
XLS_2_3 (S_2 ld_S_2_3 VDD VSS) INV_X1
XLS_3_0 (S_3 ld_S_3_0 VDD VSS) INV_X1
XLS_3_1 (S_3 ld_S_3_1 VDD VSS) INV_X1
XLS_3_2 (S_3 ld_S_3_2 VDD VSS) INV_X1
XLS_3_3 (S_3 ld_S_3_3 VDD VSS) INV_X1
XLS_4_0 (S_4 ld_S_4_0 VDD VSS) INV_X1
XLS_4_1 (S_4 ld_S_4_1 VDD VSS) INV_X1
XLS_4_2 (S_4 ld_S_4_2 VDD VSS) INV_X1
XLS_4_3 (S_4 ld_S_4_3 VDD VSS) INV_X1
XLS_5_0 (S_5 ld_S_5_0 VDD VSS) INV_X1
XLS_5_1 (S_5 ld_S_5_1 VDD VSS) INV_X1
XLS_5_2 (S_5 ld_S_5_2 VDD VSS) INV_X1
XLS_5_3 (S_5 ld_S_5_3 VDD VSS) INV_X1
XLS_6_0 (S_6 ld_S_6_0 VDD VSS) INV_X1
XLS_6_1 (S_6 ld_S_6_1 VDD VSS) INV_X1
XLS_6_2 (S_6 ld_S_6_2 VDD VSS) INV_X1
XLS_6_3 (S_6 ld_S_6_3 VDD VSS) INV_X1
XLS_7_0 (S_7 ld_S_7_0 VDD VSS) INV_X1
XLS_7_1 (S_7 ld_S_7_1 VDD VSS) INV_X1
XLS_7_2 (S_7 ld_S_7_2 VDD VSS) INV_X1
XLS_7_3 (S_7 ld_S_7_3 VDD VSS) INV_X1
XLC7_0 (C7 ld_C7_0 VDD VSS) INV_X1
XLC7_1 (C7 ld_C7_1 VDD VSS) INV_X1
XLC7_2 (C7 ld_C7_2 VDD VSS) INV_X1
XLC7_3 (C7 ld_C7_3 VDD VSS) INV_X1
XLC8_0 (C8 ld_C8_0 VDD VSS) INV_X1
XLC8_1 (C8 ld_C8_1 VDD VSS) INV_X1
XLC8_2 (C8 ld_C8_2 VDD VSS) INV_X1
XLC8_3 (C8 ld_C8_3 VDD VSS) INV_X1
save S_0 S_1 S_2 S_3 S_4 S_5 S_6 S_7 C7 C8 VVDD:p
opts options save=selected temp=27 reltol=1e-3
tran tran stop=296n maxstep=10p errpreset=moderate
