// KSA8: sinh tu dong boi blocks/gen_blocks.py - khong sua tay
// Can include cac cell A + stub XOR2/XNOR2 va cac khoi con truoc khi dung.
simulator lang=spectre
subckt KSA8 A_0 A_1 A_2 A_3 A_4 A_5 A_6 A_7 B_0 B_1 B_2 B_3 B_4 B_5 B_6 B_7 CIN S_0 S_1 \
    S_2 S_3 S_4 S_5 S_6 S_7 C7 C8 VDD VSS
I0 (A_0 B_0 gn0 VDD VSS) NAND2_X1
I1 (A_1 B_1 gn1 VDD VSS) NAND2_X1
I2 (A_2 B_2 gn2 VDD VSS) NAND2_X1
I3 (A_3 B_3 gn3 VDD VSS) NAND2_X1
I4 (A_4 B_4 gn4 VDD VSS) NAND2_X1
I5 (A_5 B_5 gn5 VDD VSS) NAND2_X1
I6 (A_6 B_6 gn6 VDD VSS) NAND2_X1
I7 (A_7 B_7 gn7 VDD VSS) NAND2_X1
I8 (A_0 B_0 pn0 VDD VSS) XNOR2_X1
I9 (A_1 B_1 pn1 VDD VSS) XNOR2_X1
I10 (A_2 B_2 pn2 VDD VSS) XNOR2_X1
I11 (A_3 B_3 pn3 VDD VSS) XNOR2_X1
I12 (A_4 B_4 pn4 VDD VSS) XNOR2_X1
I13 (A_5 B_5 pn5 VDD VSS) XNOR2_X1
I14 (A_6 B_6 pn6 VDD VSS) XNOR2_X1
I15 (A_7 B_7 pn7 VDD VSS) XNOR2_X1
I16 (CIN cinn VDD VSS) INV_X1
I17 (gn0 pn0 cinn G0_0 VDD VSS) GRY_N
I18 (G0_0 G0_0n VDD VSS) INV_X1
I19 (gn1 pn1 G0_0n G1_0 VDD VSS) GRY_N
I20 (gn2 pn2 gn1 pn1 G2_1 P2_1 VDD VSS) BLK_N
I21 (gn3 pn3 gn2 pn2 G3_2 P3_2 VDD VSS) BLK_N
I22 (gn4 pn4 gn3 pn3 G4_3 P4_3 VDD VSS) BLK_N
I23 (gn5 pn5 gn4 pn4 G5_4 P5_4 VDD VSS) BLK_N
I24 (gn6 pn6 gn5 pn5 G6_5 P6_5 VDD VSS) BLK_N
I25 (gn7 pn7 gn6 pn6 G7_6 P7_6 VDD VSS) BLK_N
I26 (G2_1 P2_1 G0_0 G2_0n VDD VSS) GRY_P
I27 (G3_2 P3_2 G1_0 G3_0n VDD VSS) GRY_P
I28 (G4_3 P4_3 G2_1 P2_1 G4_1n P4_1n VDD VSS) BLK_P
I29 (G5_4 P5_4 G3_2 P3_2 G5_2n P5_2n VDD VSS) BLK_P
I30 (G6_5 P6_5 G4_3 P4_3 G6_3n P6_3n VDD VSS) BLK_P
I31 (G7_6 P7_6 G5_4 P5_4 G7_4n P7_4n VDD VSS) BLK_P
I32 (G4_1n P4_1n G0_0n G4_0 VDD VSS) GRY_N
I33 (G1_0 G1_0n VDD VSS) INV_X1
I34 (G5_2n P5_2n G1_0n G5_0 VDD VSS) GRY_N
I35 (G6_3n P6_3n G2_0n C7 VDD VSS) GRY_N
I36 (G7_4n P7_4n G3_0n C8 VDD VSS) GRY_N
I37 (pn0 CIN S_0 VDD VSS) XNOR2_X1
I38 (pn1 G0_0 S_1 VDD VSS) XNOR2_X1
I39 (pn2 G1_0 S_2 VDD VSS) XNOR2_X1
I40 (pn3 G2_0n S_3 VDD VSS) XOR2_X1
I41 (pn4 G3_0n S_4 VDD VSS) XOR2_X1
I42 (pn5 G4_0 S_5 VDD VSS) XNOR2_X1
I43 (pn6 G5_0 S_6 VDD VSS) XNOR2_X1
I44 (pn7 C7 S_7 VDD VSS) XNOR2_X1
ends KSA8
