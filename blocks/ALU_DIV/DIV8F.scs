// DIV8F: sinh tu dong boi blocks/ALU_DIV/gen_div.py --variant fa
simulator lang=spectre
subckt DIV8F A_0 A_1 A_2 A_3 A_4 A_5 A_6 A_7 B_0 B_1 B_2 B_3 B_4 B_5 B_6 B_7 Q_0 Q_1 Q_2 \
    Q_3 Q_4 Q_5 Q_6 Q_7 R_0 R_1 R_2 R_3 R_4 R_5 R_6 R_7 V DZ VDD VSS
I0 (A_7 A_0 nakn1 VDD VSS) NAND2_X1
I1 (A_1 nakn1 aa1 VDD VSS) XNOR2_X1
I2 (nakn1 nak1 VDD VSS) INV_X1
I3 (A_7 A_1 nak1 nakn2 VDD VSS) AOI21_X1
I4 (A_2 nakn2 aa2 VDD VSS) XNOR2_X1
I5 (nakn2 nak2 VDD VSS) INV_X1
I6 (A_7 A_2 nak2 nakn3 VDD VSS) AOI21_X1
I7 (A_3 nakn3 aa3 VDD VSS) XNOR2_X1
I8 (nakn3 nak3 VDD VSS) INV_X1
I9 (A_7 A_3 nak3 nakn4 VDD VSS) AOI21_X1
I10 (A_4 nakn4 aa4 VDD VSS) XNOR2_X1
I11 (nakn4 nak4 VDD VSS) INV_X1
I12 (A_7 A_4 nak4 nakn5 VDD VSS) AOI21_X1
I13 (A_5 nakn5 aa5 VDD VSS) XNOR2_X1
I14 (nakn5 nak5 VDD VSS) INV_X1
I15 (A_7 A_5 nak5 nakn6 VDD VSS) AOI21_X1
I16 (A_6 nakn6 aa6 VDD VSS) XNOR2_X1
I17 (nakn6 nak6 VDD VSS) INV_X1
I18 (A_7 A_6 nak6 nakn7 VDD VSS) AOI21_X1
I19 (A_7 nakn7 aa7 VDD VSS) XNOR2_X1
I20 (B_7 B_0 nbkn1 VDD VSS) NAND2_X1
I21 (B_1 nbkn1 dd1 VDD VSS) XNOR2_X1
I22 (nbkn1 nbk1 VDD VSS) INV_X1
I23 (B_7 B_1 nbk1 nbkn2 VDD VSS) AOI21_X1
I24 (B_2 nbkn2 dd2 VDD VSS) XNOR2_X1
I25 (nbkn2 nbk2 VDD VSS) INV_X1
I26 (B_7 B_2 nbk2 nbkn3 VDD VSS) AOI21_X1
I27 (B_3 nbkn3 dd3 VDD VSS) XNOR2_X1
I28 (nbkn3 nbk3 VDD VSS) INV_X1
I29 (B_7 B_3 nbk3 nbkn4 VDD VSS) AOI21_X1
I30 (B_4 nbkn4 dd4 VDD VSS) XNOR2_X1
I31 (nbkn4 nbk4 VDD VSS) INV_X1
I32 (B_7 B_4 nbk4 nbkn5 VDD VSS) AOI21_X1
I33 (B_5 nbkn5 dd5 VDD VSS) XNOR2_X1
I34 (nbkn5 nbk5 VDD VSS) INV_X1
I35 (B_7 B_5 nbk5 nbkn6 VDD VSS) AOI21_X1
I36 (B_6 nbkn6 dd6 VDD VSS) XNOR2_X1
I37 (nbkn6 nbk6 VDD VSS) INV_X1
I38 (B_7 B_6 nbk6 nbkn7 VDD VSS) AOI21_X1
I39 (B_7 nbkn7 dd7 VDD VSS) XNOR2_X1
I40 (B_0 VDD b0_0 VDD VSS) XOR2_X1
I41 (aa7 b0_0 VDD p0_0 c0_0 VDD VSS) FA_X1
I42 (dd1 VDD b0_1 VDD VSS) XOR2_X1
I43 (VSS b0_1 c0_0 p0_1 c0_1 VDD VSS) FA_X1
I44 (dd2 VDD b0_2 VDD VSS) XOR2_X1
I45 (VSS b0_2 c0_1 p0_2 c0_2 VDD VSS) FA_X1
I46 (dd3 VDD b0_3 VDD VSS) XOR2_X1
I47 (VSS b0_3 c0_2 p0_3 c0_3 VDD VSS) FA_X1
I48 (dd4 VDD b0_4 VDD VSS) XOR2_X1
I49 (VSS b0_4 c0_3 p0_4 c0_4 VDD VSS) FA_X1
I50 (dd5 VDD b0_5 VDD VSS) XOR2_X1
I51 (VSS b0_5 c0_4 p0_5 c0_5 VDD VSS) FA_X1
I52 (dd6 VDD b0_6 VDD VSS) XOR2_X1
I53 (VSS b0_6 c0_5 p0_6 c0_6 VDD VSS) FA_X1
I54 (dd7 VDD b0_7 VDD VSS) XOR2_X1
I55 (VSS b0_7 c0_6 p0_7 c0_7 VDD VSS) FA_X1
I56 (VSS VDD c0_7 p0_8 c0_8 VDD VSS) FA_X1
I57 (p0_8 qu7 VDD VSS) INV_X4
I58 (B_0 qu7 b1_0 VDD VSS) XOR2_X1
I59 (aa6 b1_0 qu7 p1_0 c1_0 VDD VSS) FA_X1
I60 (dd1 qu7 b1_1 VDD VSS) XOR2_X1
I61 (p0_0 b1_1 c1_0 p1_1 c1_1 VDD VSS) FA_X1
I62 (dd2 qu7 b1_2 VDD VSS) XOR2_X1
I63 (p0_1 b1_2 c1_1 p1_2 c1_2 VDD VSS) FA_X1
I64 (dd3 qu7 b1_3 VDD VSS) XOR2_X1
I65 (p0_2 b1_3 c1_2 p1_3 c1_3 VDD VSS) FA_X1
I66 (dd4 qu7 b1_4 VDD VSS) XOR2_X1
I67 (p0_3 b1_4 c1_3 p1_4 c1_4 VDD VSS) FA_X1
I68 (dd5 qu7 b1_5 VDD VSS) XOR2_X1
I69 (p0_4 b1_5 c1_4 p1_5 c1_5 VDD VSS) FA_X1
I70 (dd6 qu7 b1_6 VDD VSS) XOR2_X1
I71 (p0_5 b1_6 c1_5 p1_6 c1_6 VDD VSS) FA_X1
I72 (dd7 qu7 b1_7 VDD VSS) XOR2_X1
I73 (p0_6 b1_7 c1_6 p1_7 c1_7 VDD VSS) FA_X1
I74 (p0_7 qu7 c1_7 p1_8 c1_8 VDD VSS) FA_X1
I75 (p1_8 qu6 VDD VSS) INV_X4
I76 (B_0 qu6 b2_0 VDD VSS) XOR2_X1
I77 (aa5 b2_0 qu6 p2_0 c2_0 VDD VSS) FA_X1
I78 (dd1 qu6 b2_1 VDD VSS) XOR2_X1
I79 (p1_0 b2_1 c2_0 p2_1 c2_1 VDD VSS) FA_X1
I80 (dd2 qu6 b2_2 VDD VSS) XOR2_X1
I81 (p1_1 b2_2 c2_1 p2_2 c2_2 VDD VSS) FA_X1
I82 (dd3 qu6 b2_3 VDD VSS) XOR2_X1
I83 (p1_2 b2_3 c2_2 p2_3 c2_3 VDD VSS) FA_X1
I84 (dd4 qu6 b2_4 VDD VSS) XOR2_X1
I85 (p1_3 b2_4 c2_3 p2_4 c2_4 VDD VSS) FA_X1
I86 (dd5 qu6 b2_5 VDD VSS) XOR2_X1
I87 (p1_4 b2_5 c2_4 p2_5 c2_5 VDD VSS) FA_X1
I88 (dd6 qu6 b2_6 VDD VSS) XOR2_X1
I89 (p1_5 b2_6 c2_5 p2_6 c2_6 VDD VSS) FA_X1
I90 (dd7 qu6 b2_7 VDD VSS) XOR2_X1
I91 (p1_6 b2_7 c2_6 p2_7 c2_7 VDD VSS) FA_X1
I92 (p1_7 qu6 c2_7 p2_8 c2_8 VDD VSS) FA_X1
I93 (p2_8 qu5 VDD VSS) INV_X4
I94 (B_0 qu5 b3_0 VDD VSS) XOR2_X1
I95 (aa4 b3_0 qu5 p3_0 c3_0 VDD VSS) FA_X1
I96 (dd1 qu5 b3_1 VDD VSS) XOR2_X1
I97 (p2_0 b3_1 c3_0 p3_1 c3_1 VDD VSS) FA_X1
I98 (dd2 qu5 b3_2 VDD VSS) XOR2_X1
I99 (p2_1 b3_2 c3_1 p3_2 c3_2 VDD VSS) FA_X1
I100 (dd3 qu5 b3_3 VDD VSS) XOR2_X1
I101 (p2_2 b3_3 c3_2 p3_3 c3_3 VDD VSS) FA_X1
I102 (dd4 qu5 b3_4 VDD VSS) XOR2_X1
I103 (p2_3 b3_4 c3_3 p3_4 c3_4 VDD VSS) FA_X1
I104 (dd5 qu5 b3_5 VDD VSS) XOR2_X1
I105 (p2_4 b3_5 c3_4 p3_5 c3_5 VDD VSS) FA_X1
I106 (dd6 qu5 b3_6 VDD VSS) XOR2_X1
I107 (p2_5 b3_6 c3_5 p3_6 c3_6 VDD VSS) FA_X1
I108 (dd7 qu5 b3_7 VDD VSS) XOR2_X1
I109 (p2_6 b3_7 c3_6 p3_7 c3_7 VDD VSS) FA_X1
I110 (p2_7 qu5 c3_7 p3_8 c3_8 VDD VSS) FA_X1
I111 (p3_8 qu4 VDD VSS) INV_X4
I112 (B_0 qu4 b4_0 VDD VSS) XOR2_X1
I113 (aa3 b4_0 qu4 p4_0 c4_0 VDD VSS) FA_X1
I114 (dd1 qu4 b4_1 VDD VSS) XOR2_X1
I115 (p3_0 b4_1 c4_0 p4_1 c4_1 VDD VSS) FA_X1
I116 (dd2 qu4 b4_2 VDD VSS) XOR2_X1
I117 (p3_1 b4_2 c4_1 p4_2 c4_2 VDD VSS) FA_X1
I118 (dd3 qu4 b4_3 VDD VSS) XOR2_X1
I119 (p3_2 b4_3 c4_2 p4_3 c4_3 VDD VSS) FA_X1
I120 (dd4 qu4 b4_4 VDD VSS) XOR2_X1
I121 (p3_3 b4_4 c4_3 p4_4 c4_4 VDD VSS) FA_X1
I122 (dd5 qu4 b4_5 VDD VSS) XOR2_X1
I123 (p3_4 b4_5 c4_4 p4_5 c4_5 VDD VSS) FA_X1
I124 (dd6 qu4 b4_6 VDD VSS) XOR2_X1
I125 (p3_5 b4_6 c4_5 p4_6 c4_6 VDD VSS) FA_X1
I126 (dd7 qu4 b4_7 VDD VSS) XOR2_X1
I127 (p3_6 b4_7 c4_6 p4_7 c4_7 VDD VSS) FA_X1
I128 (p3_7 qu4 c4_7 p4_8 c4_8 VDD VSS) FA_X1
I129 (p4_8 qu3 VDD VSS) INV_X4
I130 (B_0 qu3 b5_0 VDD VSS) XOR2_X1
I131 (aa2 b5_0 qu3 p5_0 c5_0 VDD VSS) FA_X1
I132 (dd1 qu3 b5_1 VDD VSS) XOR2_X1
I133 (p4_0 b5_1 c5_0 p5_1 c5_1 VDD VSS) FA_X1
I134 (dd2 qu3 b5_2 VDD VSS) XOR2_X1
I135 (p4_1 b5_2 c5_1 p5_2 c5_2 VDD VSS) FA_X1
I136 (dd3 qu3 b5_3 VDD VSS) XOR2_X1
I137 (p4_2 b5_3 c5_2 p5_3 c5_3 VDD VSS) FA_X1
I138 (dd4 qu3 b5_4 VDD VSS) XOR2_X1
I139 (p4_3 b5_4 c5_3 p5_4 c5_4 VDD VSS) FA_X1
I140 (dd5 qu3 b5_5 VDD VSS) XOR2_X1
I141 (p4_4 b5_5 c5_4 p5_5 c5_5 VDD VSS) FA_X1
I142 (dd6 qu3 b5_6 VDD VSS) XOR2_X1
I143 (p4_5 b5_6 c5_5 p5_6 c5_6 VDD VSS) FA_X1
I144 (dd7 qu3 b5_7 VDD VSS) XOR2_X1
I145 (p4_6 b5_7 c5_6 p5_7 c5_7 VDD VSS) FA_X1
I146 (p4_7 qu3 c5_7 p5_8 c5_8 VDD VSS) FA_X1
I147 (p5_8 qu2 VDD VSS) INV_X4
I148 (B_0 qu2 b6_0 VDD VSS) XOR2_X1
I149 (aa1 b6_0 qu2 p6_0 c6_0 VDD VSS) FA_X1
I150 (dd1 qu2 b6_1 VDD VSS) XOR2_X1
I151 (p5_0 b6_1 c6_0 p6_1 c6_1 VDD VSS) FA_X1
I152 (dd2 qu2 b6_2 VDD VSS) XOR2_X1
I153 (p5_1 b6_2 c6_1 p6_2 c6_2 VDD VSS) FA_X1
I154 (dd3 qu2 b6_3 VDD VSS) XOR2_X1
I155 (p5_2 b6_3 c6_2 p6_3 c6_3 VDD VSS) FA_X1
I156 (dd4 qu2 b6_4 VDD VSS) XOR2_X1
I157 (p5_3 b6_4 c6_3 p6_4 c6_4 VDD VSS) FA_X1
I158 (dd5 qu2 b6_5 VDD VSS) XOR2_X1
I159 (p5_4 b6_5 c6_4 p6_5 c6_5 VDD VSS) FA_X1
I160 (dd6 qu2 b6_6 VDD VSS) XOR2_X1
I161 (p5_5 b6_6 c6_5 p6_6 c6_6 VDD VSS) FA_X1
I162 (dd7 qu2 b6_7 VDD VSS) XOR2_X1
I163 (p5_6 b6_7 c6_6 p6_7 c6_7 VDD VSS) FA_X1
I164 (p5_7 qu2 c6_7 p6_8 c6_8 VDD VSS) FA_X1
I165 (p6_8 qu1 VDD VSS) INV_X4
I166 (B_0 qu1 b7_0 VDD VSS) XOR2_X1
I167 (A_0 b7_0 qu1 p7_0 c7_0 VDD VSS) FA_X1
I168 (dd1 qu1 b7_1 VDD VSS) XOR2_X1
I169 (p6_0 b7_1 c7_0 p7_1 c7_1 VDD VSS) FA_X1
I170 (dd2 qu1 b7_2 VDD VSS) XOR2_X1
I171 (p6_1 b7_2 c7_1 p7_2 c7_2 VDD VSS) FA_X1
I172 (dd3 qu1 b7_3 VDD VSS) XOR2_X1
I173 (p6_2 b7_3 c7_2 p7_3 c7_3 VDD VSS) FA_X1
I174 (dd4 qu1 b7_4 VDD VSS) XOR2_X1
I175 (p6_3 b7_4 c7_3 p7_4 c7_4 VDD VSS) FA_X1
I176 (dd5 qu1 b7_5 VDD VSS) XOR2_X1
I177 (p6_4 b7_5 c7_4 p7_5 c7_5 VDD VSS) FA_X1
I178 (dd6 qu1 b7_6 VDD VSS) XOR2_X1
I179 (p6_5 b7_6 c7_5 p7_6 c7_6 VDD VSS) FA_X1
I180 (dd7 qu1 b7_7 VDD VSS) XOR2_X1
I181 (p6_6 b7_7 c7_6 p7_7 c7_7 VDD VSS) FA_X1
I182 (p6_7 qu1 c7_7 p7_8 c7_8 VDD VSS) FA_X1
I183 (p7_8 Q_0 VDD VSS) INV_X1
I184 (B_0 p7_8 dmn0 VDD VSS) NAND2_X1
I185 (dmn0 dm0 VDD VSS) INV_X1
I186 (p7_0 dm0 VSS R_0 rc0 VDD VSS) FA_X1
I187 (dd1 p7_8 dmn1 VDD VSS) NAND2_X1
I188 (dmn1 dm1 VDD VSS) INV_X1
I189 (p7_1 dm1 rc0 ru1 rc1 VDD VSS) FA_X1
I190 (dd2 p7_8 dmn2 VDD VSS) NAND2_X1
I191 (dmn2 dm2 VDD VSS) INV_X1
I192 (p7_2 dm2 rc1 ru2 rc2 VDD VSS) FA_X1
I193 (dd3 p7_8 dmn3 VDD VSS) NAND2_X1
I194 (dmn3 dm3 VDD VSS) INV_X1
I195 (p7_3 dm3 rc2 ru3 rc3 VDD VSS) FA_X1
I196 (dd4 p7_8 dmn4 VDD VSS) NAND2_X1
I197 (dmn4 dm4 VDD VSS) INV_X1
I198 (p7_4 dm4 rc3 ru4 rc4 VDD VSS) FA_X1
I199 (dd5 p7_8 dmn5 VDD VSS) NAND2_X1
I200 (dmn5 dm5 VDD VSS) INV_X1
I201 (p7_5 dm5 rc4 ru5 rc5 VDD VSS) FA_X1
I202 (dd6 p7_8 dmn6 VDD VSS) NAND2_X1
I203 (dmn6 dm6 VDD VSS) INV_X1
I204 (p7_6 dm6 rc5 ru6 rc6 VDD VSS) FA_X1
I205 (dd7 p7_8 dmn7 VDD VSS) NAND2_X1
I206 (dmn7 dm7 VDD VSS) INV_X1
I207 (p7_7 dm7 rc6 ru7 rc7 VDD VSS) FA_X1
I208 (A_7 B_7 sq VDD VSS) XOR2_X1
I209 (sq Q_0 nqkn1 VDD VSS) NAND2_X1
I210 (qu1 nqkn1 Q_1 VDD VSS) XNOR2_X1
I211 (nqkn1 nqk1 VDD VSS) INV_X1
I212 (sq qu1 nqk1 nqkn2 VDD VSS) AOI21_X1
I213 (qu2 nqkn2 Q_2 VDD VSS) XNOR2_X1
I214 (nqkn2 nqk2 VDD VSS) INV_X1
I215 (sq qu2 nqk2 nqkn3 VDD VSS) AOI21_X1
I216 (qu3 nqkn3 Q_3 VDD VSS) XNOR2_X1
I217 (nqkn3 nqk3 VDD VSS) INV_X1
I218 (sq qu3 nqk3 nqkn4 VDD VSS) AOI21_X1
I219 (qu4 nqkn4 Q_4 VDD VSS) XNOR2_X1
I220 (nqkn4 nqk4 VDD VSS) INV_X1
I221 (sq qu4 nqk4 nqkn5 VDD VSS) AOI21_X1
I222 (qu5 nqkn5 Q_5 VDD VSS) XNOR2_X1
I223 (nqkn5 nqk5 VDD VSS) INV_X1
I224 (sq qu5 nqk5 nqkn6 VDD VSS) AOI21_X1
I225 (qu6 nqkn6 Q_6 VDD VSS) XNOR2_X1
I226 (nqkn6 nqk6 VDD VSS) INV_X1
I227 (sq qu6 nqk6 nqkn7 VDD VSS) AOI21_X1
I228 (qu7 nqkn7 Q_7 VDD VSS) XNOR2_X1
I229 (A_7 R_0 nrkn1 VDD VSS) NAND2_X1
I230 (ru1 nrkn1 R_1 VDD VSS) XNOR2_X1
I231 (nrkn1 nrk1 VDD VSS) INV_X1
I232 (A_7 ru1 nrk1 nrkn2 VDD VSS) AOI21_X1
I233 (ru2 nrkn2 R_2 VDD VSS) XNOR2_X1
I234 (nrkn2 nrk2 VDD VSS) INV_X1
I235 (A_7 ru2 nrk2 nrkn3 VDD VSS) AOI21_X1
I236 (ru3 nrkn3 R_3 VDD VSS) XNOR2_X1
I237 (nrkn3 nrk3 VDD VSS) INV_X1
I238 (A_7 ru3 nrk3 nrkn4 VDD VSS) AOI21_X1
I239 (ru4 nrkn4 R_4 VDD VSS) XNOR2_X1
I240 (nrkn4 nrk4 VDD VSS) INV_X1
I241 (A_7 ru4 nrk4 nrkn5 VDD VSS) AOI21_X1
I242 (ru5 nrkn5 R_5 VDD VSS) XNOR2_X1
I243 (nrkn5 nrk5 VDD VSS) INV_X1
I244 (A_7 ru5 nrk5 nrkn6 VDD VSS) AOI21_X1
I245 (ru6 nrkn6 R_6 VDD VSS) XNOR2_X1
I246 (nrkn6 nrk6 VDD VSS) INV_X1
I247 (A_7 ru6 nrk6 nrkn7 VDD VSS) AOI21_X1
I248 (ru7 nrkn7 R_7 VDD VSS) XNOR2_X1
I249 (B_0 B_1 z1_0 VDD VSS) NOR2_X1
I250 (B_2 B_3 z1_1 VDD VSS) NOR2_X1
I251 (B_4 B_5 z1_2 VDD VSS) NOR2_X1
I252 (B_6 B_7 z1_3 VDD VSS) NOR2_X1
I253 (z1_0 z1_1 z2_0 VDD VSS) NAND2_X1
I254 (z1_2 z1_3 z2_1 VDD VSS) NAND2_X1
I255 (z2_0 z2_1 DZ VDD VSS) NOR2_X1
I256 (sq sqn VDD VSS) INV_X1
I257 (Q_7 sqn vn VDD VSS) NAND2_X1
I258 (vn DZ V VDD VSS) NOR2_X1
ends DIV8F
