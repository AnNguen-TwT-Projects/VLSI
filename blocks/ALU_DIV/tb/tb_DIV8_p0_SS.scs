// DIV8 corner SS
simulator lang=spectre
include "/home/buet/cadence/gpdk090_v4.6/models/spectre/gpdk090.scs" section=SS
include "../../../cells/A/cells_A.scs"
include "../../../cells/_stub_B/XOR2_X1/XOR2_X1.scs"
include "../../../cells/_stub_B/XNOR2_X1/XNOR2_X1.scs"
include "../../../cells/C/INV_X4/INV_X4.scs"
include "../../../cells/D/CAS_X1/CAS_X1.scs"
include "../DIV8.scs"
include "tb_DIV8_p0_slow.scs"
