// Testbench DIV8F: sinh tu dong boi gen_div.py (20 vector)
// 16 ns/vector, suon 20 ps, tai 4x INV_X1 moi ngo ra
simulator lang=spectre
global 0
VVDD (VDD 0) vsource dc=1.2
VVSS (VSS 0) vsource dc=0
VA_0 (A_0 0) vsource type=pwl wave=[ \
    0p 1.2 96000p 1.2 96020p 0 128000p 0 128020p 1.2 160000p 1.2 160020p 0 176000p 0 \
    176020p 1.2 240000p 1.2 240020p 0 256000p 0 256020p 1.2 272000p 1.2 272020p 0 288000p 0 \
    288020p 1.2 ]
VA_1 (A_1 0) vsource type=pwl wave=[ \
    0p 1.2 80000p 1.2 80020p 0 96000p 0 96020p 1.2 112000p 1.2 112020p 0 128000p 0 \
    128020p 1.2 144000p 1.2 144020p 0 160000p 0 160020p 1.2 176000p 1.2 176020p 0 192000p 0 \
    192020p 1.2 208000p 1.2 208020p 0 224000p 0 224020p 1.2 240000p 1.2 240020p 0 256000p 0 \
    256020p 1.2 304000p 1.2 304020p 0 ]
VA_2 (A_2 0) vsource type=pwl wave=[ \
    0p 1.2 96000p 1.2 96020p 0 112000p 0 112020p 1.2 128000p 1.2 128020p 0 144000p 0 \
    144020p 1.2 176000p 1.2 176020p 0 192000p 0 192020p 1.2 208000p 1.2 208020p 0 224000p 0 \
    224020p 1.2 240000p 1.2 240020p 0 256000p 0 256020p 1.2 272000p 1.2 272020p 0 288000p 0 \
    288020p 1.2 304000p 1.2 304020p 0 ]
VA_3 (A_3 0) vsource type=pwl wave=[ \
    0p 1.2 80000p 1.2 80020p 0 96000p 0 96020p 1.2 112000p 1.2 112020p 0 128000p 0 \
    128020p 1.2 144000p 1.2 144020p 0 176000p 0 176020p 1.2 192000p 1.2 192020p 0 240000p 0 \
    240020p 1.2 272000p 1.2 272020p 0 304000p 0 304020p 1.2 ]
VA_4 (A_4 0) vsource type=pwl wave=[ \
    0p 1.2 96000p 1.2 96020p 0 144000p 0 144020p 1.2 160000p 1.2 160020p 0 192000p 0 \
    192020p 1.2 208000p 1.2 208020p 0 272000p 0 272020p 1.2 304000p 1.2 304020p 0 ]
VA_5 (A_5 0) vsource type=pwl wave=[ \
    0p 1.2 80000p 1.2 80020p 0 96000p 0 96020p 1.2 112000p 1.2 112020p 0 128000p 0 \
    128020p 1.2 160000p 1.2 160020p 0 192000p 0 192020p 1.2 208000p 1.2 208020p 0 224000p 0 \
    224020p 1.2 288000p 1.2 288020p 0 304000p 0 304020p 1.2 ]
VA_6 (A_6 0) vsource type=pwl wave=[ \
    0p 1.2 96000p 1.2 96020p 0 128000p 0 128020p 1.2 144000p 1.2 144020p 0 160000p 0 \
    160020p 1.2 192000p 1.2 192020p 0 208000p 0 208020p 1.2 224000p 1.2 224020p 0 256000p 0 \
    256020p 1.2 272000p 1.2 272020p 0 ]
VA_7 (A_7 0) vsource type=pwl wave=[ \
    0p 1.2 80000p 1.2 80020p 0 96000p 0 96020p 1.2 112000p 1.2 112020p 0 128000p 0 \
    128020p 1.2 160000p 1.2 160020p 0 192000p 0 192020p 1.2 240000p 1.2 240020p 0 256000p 0 \
    256020p 1.2 272000p 1.2 272020p 0 288000p 0 288020p 1.2 304000p 1.2 304020p 0 ]
VB_0 (B_0 0) vsource type=pwl wave=[ \
    0p 0 16000p 0 16020p 1.2 48000p 1.2 48020p 0 64000p 0 64020p 1.2 80000p 1.2 \
    80020p 0 96000p 0 96020p 1.2 112000p 1.2 112020p 0 128000p 0 128020p 1.2 208000p 1.2 \
    208020p 0 256000p 0 256020p 1.2 ]
VB_1 (B_1 0) vsource type=pwl wave=[ \
    0p 0 32000p 0 32020p 1.2 48000p 1.2 48020p 0 64000p 0 64020p 1.2 96000p 1.2 \
    96020p 0 128000p 0 128020p 1.2 144000p 1.2 144020p 0 160000p 0 160020p 1.2 176000p 1.2 \
    176020p 0 224000p 0 224020p 1.2 240000p 1.2 240020p 0 288000p 0 288020p 1.2 304000p 1.2 \
    304020p 0 ]
VB_2 (B_2 0) vsource type=pwl wave=[ \
    0p 0 32000p 0 32020p 1.2 48000p 1.2 48020p 0 64000p 0 64020p 1.2 80000p 1.2 \
    80020p 0 96000p 0 96020p 1.2 128000p 1.2 128020p 0 160000p 0 160020p 1.2 176000p 1.2 \
    176020p 0 240000p 0 240020p 1.2 256000p 1.2 256020p 0 272000p 0 272020p 1.2 288000p 1.2 \
    288020p 0 304000p 0 304020p 1.2 ]
VB_3 (B_3 0) vsource type=pwl wave=[ \
    0p 0 32000p 0 32020p 1.2 48000p 1.2 48020p 0 64000p 0 64020p 1.2 96000p 1.2 \
    96020p 0 128000p 0 128020p 1.2 160000p 1.2 160020p 0 192000p 0 192020p 1.2 224000p 1.2 \
    224020p 0 240000p 0 240020p 1.2 256000p 1.2 256020p 0 272000p 0 272020p 1.2 288000p 1.2 \
    288020p 0 ]
VB_4 (B_4 0) vsource type=pwl wave=[ \
    0p 0 32000p 0 32020p 1.2 48000p 1.2 48020p 0 64000p 0 64020p 1.2 80000p 1.2 \
    80020p 0 96000p 0 96020p 1.2 128000p 1.2 128020p 0 144000p 0 144020p 1.2 192000p 1.2 \
    192020p 0 208000p 0 208020p 1.2 224000p 1.2 224020p 0 256000p 0 256020p 1.2 272000p 1.2 \
    272020p 0 288000p 0 288020p 1.2 ]
VB_5 (B_5 0) vsource type=pwl wave=[ \
    0p 0 32000p 0 32020p 1.2 48000p 1.2 48020p 0 64000p 0 64020p 1.2 96000p 1.2 \
    96020p 0 112000p 0 112020p 1.2 128000p 1.2 128020p 0 144000p 0 144020p 1.2 208000p 1.2 \
    208020p 0 240000p 0 240020p 1.2 272000p 1.2 272020p 0 ]
VB_6 (B_6 0) vsource type=pwl wave=[ \
    0p 0 32000p 0 32020p 1.2 48000p 1.2 48020p 0 64000p 0 64020p 1.2 80000p 1.2 \
    80020p 0 96000p 0 96020p 1.2 128000p 1.2 128020p 0 144000p 0 144020p 1.2 160000p 1.2 \
    160020p 0 176000p 0 176020p 1.2 208000p 1.2 208020p 0 240000p 0 240020p 1.2 256000p 1.2 \
    256020p 0 ]
VB_7 (B_7 0) vsource type=pwl wave=[ \
    0p 0 48000p 0 48020p 1.2 96000p 1.2 96020p 0 112000p 0 112020p 1.2 160000p 1.2 \
    160020p 0 192000p 0 192020p 1.2 208000p 1.2 208020p 0 224000p 0 224020p 1.2 288000p 1.2 \
    288020p 0 ]
XDUT (A_0 A_1 A_2 A_3 A_4 A_5 A_6 A_7 B_0 B_1 B_2 B_3 B_4 B_5 B_6 B_7 Q_0 Q_1 Q_2 Q_3 Q_4 Q_5 Q_6 Q_7 R_0 R_1 R_2 R_3 R_4 R_5 R_6 R_7 V DZ VDD VSS) DIV8F
XLQ_0_0 (Q_0 ld_Q_0_0 VDD VSS) INV_X1
XLQ_0_1 (Q_0 ld_Q_0_1 VDD VSS) INV_X1
XLQ_0_2 (Q_0 ld_Q_0_2 VDD VSS) INV_X1
XLQ_0_3 (Q_0 ld_Q_0_3 VDD VSS) INV_X1
XLQ_1_0 (Q_1 ld_Q_1_0 VDD VSS) INV_X1
XLQ_1_1 (Q_1 ld_Q_1_1 VDD VSS) INV_X1
XLQ_1_2 (Q_1 ld_Q_1_2 VDD VSS) INV_X1
XLQ_1_3 (Q_1 ld_Q_1_3 VDD VSS) INV_X1
XLQ_2_0 (Q_2 ld_Q_2_0 VDD VSS) INV_X1
XLQ_2_1 (Q_2 ld_Q_2_1 VDD VSS) INV_X1
XLQ_2_2 (Q_2 ld_Q_2_2 VDD VSS) INV_X1
XLQ_2_3 (Q_2 ld_Q_2_3 VDD VSS) INV_X1
XLQ_3_0 (Q_3 ld_Q_3_0 VDD VSS) INV_X1
XLQ_3_1 (Q_3 ld_Q_3_1 VDD VSS) INV_X1
XLQ_3_2 (Q_3 ld_Q_3_2 VDD VSS) INV_X1
XLQ_3_3 (Q_3 ld_Q_3_3 VDD VSS) INV_X1
XLQ_4_0 (Q_4 ld_Q_4_0 VDD VSS) INV_X1
XLQ_4_1 (Q_4 ld_Q_4_1 VDD VSS) INV_X1
XLQ_4_2 (Q_4 ld_Q_4_2 VDD VSS) INV_X1
XLQ_4_3 (Q_4 ld_Q_4_3 VDD VSS) INV_X1
XLQ_5_0 (Q_5 ld_Q_5_0 VDD VSS) INV_X1
XLQ_5_1 (Q_5 ld_Q_5_1 VDD VSS) INV_X1
XLQ_5_2 (Q_5 ld_Q_5_2 VDD VSS) INV_X1
XLQ_5_3 (Q_5 ld_Q_5_3 VDD VSS) INV_X1
XLQ_6_0 (Q_6 ld_Q_6_0 VDD VSS) INV_X1
XLQ_6_1 (Q_6 ld_Q_6_1 VDD VSS) INV_X1
XLQ_6_2 (Q_6 ld_Q_6_2 VDD VSS) INV_X1
XLQ_6_3 (Q_6 ld_Q_6_3 VDD VSS) INV_X1
XLQ_7_0 (Q_7 ld_Q_7_0 VDD VSS) INV_X1
XLQ_7_1 (Q_7 ld_Q_7_1 VDD VSS) INV_X1
XLQ_7_2 (Q_7 ld_Q_7_2 VDD VSS) INV_X1
XLQ_7_3 (Q_7 ld_Q_7_3 VDD VSS) INV_X1
XLR_0_0 (R_0 ld_R_0_0 VDD VSS) INV_X1
XLR_0_1 (R_0 ld_R_0_1 VDD VSS) INV_X1
XLR_0_2 (R_0 ld_R_0_2 VDD VSS) INV_X1
XLR_0_3 (R_0 ld_R_0_3 VDD VSS) INV_X1
XLR_1_0 (R_1 ld_R_1_0 VDD VSS) INV_X1
XLR_1_1 (R_1 ld_R_1_1 VDD VSS) INV_X1
XLR_1_2 (R_1 ld_R_1_2 VDD VSS) INV_X1
XLR_1_3 (R_1 ld_R_1_3 VDD VSS) INV_X1
XLR_2_0 (R_2 ld_R_2_0 VDD VSS) INV_X1
XLR_2_1 (R_2 ld_R_2_1 VDD VSS) INV_X1
XLR_2_2 (R_2 ld_R_2_2 VDD VSS) INV_X1
XLR_2_3 (R_2 ld_R_2_3 VDD VSS) INV_X1
XLR_3_0 (R_3 ld_R_3_0 VDD VSS) INV_X1
XLR_3_1 (R_3 ld_R_3_1 VDD VSS) INV_X1
XLR_3_2 (R_3 ld_R_3_2 VDD VSS) INV_X1
XLR_3_3 (R_3 ld_R_3_3 VDD VSS) INV_X1
XLR_4_0 (R_4 ld_R_4_0 VDD VSS) INV_X1
XLR_4_1 (R_4 ld_R_4_1 VDD VSS) INV_X1
XLR_4_2 (R_4 ld_R_4_2 VDD VSS) INV_X1
XLR_4_3 (R_4 ld_R_4_3 VDD VSS) INV_X1
XLR_5_0 (R_5 ld_R_5_0 VDD VSS) INV_X1
XLR_5_1 (R_5 ld_R_5_1 VDD VSS) INV_X1
XLR_5_2 (R_5 ld_R_5_2 VDD VSS) INV_X1
XLR_5_3 (R_5 ld_R_5_3 VDD VSS) INV_X1
XLR_6_0 (R_6 ld_R_6_0 VDD VSS) INV_X1
XLR_6_1 (R_6 ld_R_6_1 VDD VSS) INV_X1
XLR_6_2 (R_6 ld_R_6_2 VDD VSS) INV_X1
XLR_6_3 (R_6 ld_R_6_3 VDD VSS) INV_X1
XLR_7_0 (R_7 ld_R_7_0 VDD VSS) INV_X1
XLR_7_1 (R_7 ld_R_7_1 VDD VSS) INV_X1
XLR_7_2 (R_7 ld_R_7_2 VDD VSS) INV_X1
XLR_7_3 (R_7 ld_R_7_3 VDD VSS) INV_X1
XLV_0 (V ld_V_0 VDD VSS) INV_X1
XLV_1 (V ld_V_1 VDD VSS) INV_X1
XLV_2 (V ld_V_2 VDD VSS) INV_X1
XLV_3 (V ld_V_3 VDD VSS) INV_X1
XLDZ_0 (DZ ld_DZ_0 VDD VSS) INV_X1
XLDZ_1 (DZ ld_DZ_1 VDD VSS) INV_X1
XLDZ_2 (DZ ld_DZ_2 VDD VSS) INV_X1
XLDZ_3 (DZ ld_DZ_3 VDD VSS) INV_X1
save A_0 A_1 A_2 A_3 A_4 A_5 A_6 A_7 B_0 B_1 B_2 B_3 B_4 B_5 B_6 B_7 Q_0 Q_1 Q_2 Q_3 Q_4 Q_5 Q_6 Q_7 R_0 R_1 R_2 R_3 R_4 R_5 R_6 R_7 V DZ VVDD:p
opts options save=selected temp=27 reltol=1e-3
tran tran stop=320n maxstep=40p errpreset=moderate
