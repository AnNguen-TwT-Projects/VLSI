// ALU_TOPK: sinh tu dong boi blocks/ALU_TOP/gen_top.py - khong sua tay
// = ALU_CORE + MUL8 + DIV8K. Can include moi cell/khoi con (xem tb/tb_ALU_TOP_NN.scs).
simulator lang=spectre
subckt ALU_TOPK A_0 A_1 A_2 A_3 A_4 A_5 A_6 A_7 B_0 B_1 B_2 B_3 B_4 B_5 B_6 B_7 OP_0 OP_1 \
    OP_2 OP_3 Y_0 Y_1 Y_2 Y_3 Y_4 Y_5 Y_6 Y_7 Y_8 Y_9 Y_10 Y_11 Y_12 Y_13 Y_14 Y_15 Z C V \
    DZ VDD VSS
I0 (A_0 A_1 A_2 A_3 A_4 A_5 A_6 A_7 B_0 B_1 B_2 B_3 B_4 B_5 B_6 B_7 MULP_0 MULP_1 MULP_2 \
    MULP_3 MULP_4 MULP_5 MULP_6 MULP_7 MULP_8 MULP_9 MULP_10 MULP_11 MULP_12 MULP_13 \
    MULP_14 MULP_15 VDD VSS) MUL8
I1 (A_0 A_1 A_2 A_3 A_4 A_5 A_6 A_7 B_0 B_1 B_2 B_3 B_4 B_5 B_6 B_7 DIVQ_0 DIVQ_1 DIVQ_2 \
    DIVQ_3 DIVQ_4 DIVQ_5 DIVQ_6 DIVQ_7 DIVR_0 DIVR_1 DIVR_2 DIVR_3 DIVR_4 DIVR_5 DIVR_6 \
    DIVR_7 DIVV DIVDZ VDD VSS) DIV8K
I2 (A_0 A_1 A_2 A_3 A_4 A_5 A_6 A_7 B_0 B_1 B_2 B_3 B_4 B_5 B_6 B_7 OP_0 OP_1 OP_2 OP_3 \
    MULP_0 MULP_1 MULP_2 MULP_3 MULP_4 MULP_5 MULP_6 MULP_7 MULP_8 MULP_9 MULP_10 MULP_11 \
    MULP_12 MULP_13 MULP_14 MULP_15 DIVQ_0 DIVQ_1 DIVQ_2 DIVQ_3 DIVQ_4 DIVQ_5 DIVQ_6 \
    DIVQ_7 DIVR_0 DIVR_1 DIVR_2 DIVR_3 DIVR_4 DIVR_5 DIVR_6 DIVR_7 DIVV DIVDZ Y_0 Y_1 Y_2 \
    Y_3 Y_4 Y_5 Y_6 Y_7 Y_8 Y_9 Y_10 Y_11 Y_12 Y_13 Y_14 Y_15 Z C V DZ VDD VSS) ALU_CORE
ends ALU_TOPK
