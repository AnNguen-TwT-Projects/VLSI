// Testbench ALU_TOPK: sinh tu dong boi gen_top.py (12 vector)
// 16 ns/vector, suon 20 ps, tai 4x INV_X1 moi ngo ra
simulator lang=spectre
global 0
VVDD (VDD 0) vsource dc=1.2
VVSS (VSS 0) vsource dc=0
VA_0 (A_0 0) vsource type=pwl wave=[ \
    0p 0 16000p 0 16020p 1.2 32000p 1.2 32020p 0 64000p 0 64020p 1.2 80000p 1.2 \
    80020p 0 96000p 0 96020p 1.2 112000p 1.2 112020p 0 128000p 0 128020p 1.2 144000p 1.2 \
    144020p 0 160000p 0 160020p 1.2 ]
VA_1 (A_1 0) vsource type=pwl wave=[ \
    0p 0 16000p 0 16020p 1.2 32000p 1.2 32020p 0 64000p 0 64020p 1.2 96000p 1.2 \
    96020p 0 128000p 0 128020p 1.2 144000p 1.2 144020p 0 ]
VA_2 (A_2 0) vsource type=pwl wave=[ \
    0p 1.2 32000p 1.2 32020p 0 64000p 0 64020p 1.2 80000p 1.2 80020p 0 96000p 0 \
    96020p 1.2 112000p 1.2 112020p 0 128000p 0 128020p 1.2 144000p 1.2 144020p 0 176000p 0 \
    176020p 1.2 ]
VA_3 (A_3 0) vsource type=pwl wave=[ \
    0p 0 16000p 0 16020p 1.2 32000p 1.2 32020p 0 64000p 0 64020p 1.2 96000p 1.2 \
    96020p 0 128000p 0 128020p 1.2 144000p 1.2 144020p 0 160000p 0 160020p 1.2 176000p 1.2 \
    176020p 0 ]
VA_4 (A_4 0) vsource type=pwl wave=[ \
    0p 0 16000p 0 16020p 1.2 32000p 1.2 32020p 0 48000p 0 48020p 1.2 64000p 1.2 \
    64020p 0 96000p 0 96020p 1.2 112000p 1.2 112020p 0 128000p 0 128020p 1.2 144000p 1.2 \
    144020p 0 160000p 0 160020p 1.2 176000p 1.2 176020p 0 ]
VA_5 (A_5 0) vsource type=pwl wave=[ \
    0p 1.2 32000p 1.2 32020p 0 48000p 0 48020p 1.2 64000p 1.2 64020p 0 80000p 0 \
    80020p 1.2 96000p 1.2 96020p 0 128000p 0 128020p 1.2 144000p 1.2 144020p 0 160000p 0 \
    160020p 1.2 176000p 1.2 176020p 0 ]
VA_6 (A_6 0) vsource type=pwl wave=[ \
    0p 1.2 32000p 1.2 32020p 0 48000p 0 48020p 1.2 64000p 1.2 64020p 0 96000p 0 \
    96020p 1.2 112000p 1.2 112020p 0 128000p 0 128020p 1.2 144000p 1.2 144020p 0 160000p 0 \
    160020p 1.2 176000p 1.2 176020p 0 ]
VA_7 (A_7 0) vsource type=pwl wave=[ \
    0p 0 32000p 0 32020p 1.2 64000p 1.2 64020p 0 80000p 0 80020p 1.2 96000p 1.2 \
    96020p 0 112000p 0 112020p 1.2 176000p 1.2 176020p 0 ]
VB_0 (B_0 0) vsource type=pwl wave=[ \
    0p 1.2 48000p 1.2 48020p 0 80000p 0 80020p 1.2 96000p 1.2 96020p 0 128000p 0 \
    128020p 1.2 160000p 1.2 160020p 0 ]
VB_1 (B_1 0) vsource type=pwl wave=[ \
    0p 1.2 16000p 1.2 16020p 0 80000p 0 80020p 1.2 96000p 1.2 96020p 0 128000p 0 \
    128020p 1.2 176000p 1.2 176020p 0 ]
VB_2 (B_2 0) vsource type=pwl wave=[ \
    0p 0 48000p 0 48020p 1.2 64000p 1.2 64020p 0 80000p 0 80020p 1.2 96000p 1.2 \
    96020p 0 128000p 0 128020p 1.2 160000p 1.2 160020p 0 ]
VB_3 (B_3 0) vsource type=pwl wave=[ \
    0p 1.2 16000p 1.2 16020p 0 48000p 0 48020p 1.2 64000p 1.2 64020p 0 80000p 0 \
    80020p 1.2 96000p 1.2 96020p 0 128000p 0 128020p 1.2 160000p 1.2 160020p 0 ]
VB_4 (B_4 0) vsource type=pwl wave=[ \
    0p 1.2 16000p 1.2 16020p 0 48000p 0 48020p 1.2 96000p 1.2 96020p 0 128000p 0 \
    128020p 1.2 160000p 1.2 160020p 0 ]
VB_5 (B_5 0) vsource type=pwl wave=[ \
    0p 0 48000p 0 48020p 1.2 96000p 1.2 96020p 0 128000p 0 128020p 1.2 160000p 1.2 \
    160020p 0 ]
VB_6 (B_6 0) vsource type=pwl wave=[ \
    0p 0 80000p 0 80020p 1.2 96000p 1.2 96020p 0 128000p 0 128020p 1.2 160000p 1.2 \
    160020p 0 ]
VB_7 (B_7 0) vsource type=pwl wave=[ \
    0p 0 80000p 0 80020p 1.2 96000p 1.2 96020p 0 112000p 0 112020p 1.2 128000p 1.2 \
    128020p 0 144000p 0 144020p 1.2 160000p 1.2 160020p 0 ]
VOP_0 (OP_0 0) vsource type=pwl wave=[ \
    0p 0 32000p 0 32020p 1.2 48000p 1.2 48020p 0 64000p 0 64020p 1.2 80000p 1.2 \
    80020p 0 96000p 0 96020p 1.2 ]
VOP_1 (OP_1 0) vsource type=pwl wave=[ \
    0p 0 48000p 0 48020p 1.2 80000p 1.2 80020p 0 144000p 0 144020p 1.2 ]
VOP_2 (OP_2 0) vsource type=pwl wave=[ \
    0p 0 80000p 0 80020p 1.2 112000p 1.2 112020p 0 ]
VOP_3 (OP_3 0) vsource type=pwl wave=[ \
    0p 0 112000p 0 112020p 1.2 ]
XDUT (A_0 A_1 A_2 A_3 A_4 A_5 A_6 A_7 B_0 B_1 B_2 B_3 B_4 B_5 B_6 B_7 OP_0 OP_1 OP_2 OP_3 Y_0 Y_1 Y_2 Y_3 Y_4 Y_5 Y_6 Y_7 Y_8 Y_9 Y_10 Y_11 Y_12 Y_13 Y_14 Y_15 Z C V DZ VDD VSS) ALU_TOPK
XLY_0_0 (Y_0 ld_Y_0_0 VDD VSS) INV_X1
XLY_0_1 (Y_0 ld_Y_0_1 VDD VSS) INV_X1
XLY_0_2 (Y_0 ld_Y_0_2 VDD VSS) INV_X1
XLY_0_3 (Y_0 ld_Y_0_3 VDD VSS) INV_X1
XLY_1_0 (Y_1 ld_Y_1_0 VDD VSS) INV_X1
XLY_1_1 (Y_1 ld_Y_1_1 VDD VSS) INV_X1
XLY_1_2 (Y_1 ld_Y_1_2 VDD VSS) INV_X1
XLY_1_3 (Y_1 ld_Y_1_3 VDD VSS) INV_X1
XLY_2_0 (Y_2 ld_Y_2_0 VDD VSS) INV_X1
XLY_2_1 (Y_2 ld_Y_2_1 VDD VSS) INV_X1
XLY_2_2 (Y_2 ld_Y_2_2 VDD VSS) INV_X1
XLY_2_3 (Y_2 ld_Y_2_3 VDD VSS) INV_X1
XLY_3_0 (Y_3 ld_Y_3_0 VDD VSS) INV_X1
XLY_3_1 (Y_3 ld_Y_3_1 VDD VSS) INV_X1
XLY_3_2 (Y_3 ld_Y_3_2 VDD VSS) INV_X1
XLY_3_3 (Y_3 ld_Y_3_3 VDD VSS) INV_X1
XLY_4_0 (Y_4 ld_Y_4_0 VDD VSS) INV_X1
XLY_4_1 (Y_4 ld_Y_4_1 VDD VSS) INV_X1
XLY_4_2 (Y_4 ld_Y_4_2 VDD VSS) INV_X1
XLY_4_3 (Y_4 ld_Y_4_3 VDD VSS) INV_X1
XLY_5_0 (Y_5 ld_Y_5_0 VDD VSS) INV_X1
XLY_5_1 (Y_5 ld_Y_5_1 VDD VSS) INV_X1
XLY_5_2 (Y_5 ld_Y_5_2 VDD VSS) INV_X1
XLY_5_3 (Y_5 ld_Y_5_3 VDD VSS) INV_X1
XLY_6_0 (Y_6 ld_Y_6_0 VDD VSS) INV_X1
XLY_6_1 (Y_6 ld_Y_6_1 VDD VSS) INV_X1
XLY_6_2 (Y_6 ld_Y_6_2 VDD VSS) INV_X1
XLY_6_3 (Y_6 ld_Y_6_3 VDD VSS) INV_X1
XLY_7_0 (Y_7 ld_Y_7_0 VDD VSS) INV_X1
XLY_7_1 (Y_7 ld_Y_7_1 VDD VSS) INV_X1
XLY_7_2 (Y_7 ld_Y_7_2 VDD VSS) INV_X1
XLY_7_3 (Y_7 ld_Y_7_3 VDD VSS) INV_X1
XLY_8_0 (Y_8 ld_Y_8_0 VDD VSS) INV_X1
XLY_8_1 (Y_8 ld_Y_8_1 VDD VSS) INV_X1
XLY_8_2 (Y_8 ld_Y_8_2 VDD VSS) INV_X1
XLY_8_3 (Y_8 ld_Y_8_3 VDD VSS) INV_X1
XLY_9_0 (Y_9 ld_Y_9_0 VDD VSS) INV_X1
XLY_9_1 (Y_9 ld_Y_9_1 VDD VSS) INV_X1
XLY_9_2 (Y_9 ld_Y_9_2 VDD VSS) INV_X1
XLY_9_3 (Y_9 ld_Y_9_3 VDD VSS) INV_X1
XLY_10_0 (Y_10 ld_Y_10_0 VDD VSS) INV_X1
XLY_10_1 (Y_10 ld_Y_10_1 VDD VSS) INV_X1
XLY_10_2 (Y_10 ld_Y_10_2 VDD VSS) INV_X1
XLY_10_3 (Y_10 ld_Y_10_3 VDD VSS) INV_X1
XLY_11_0 (Y_11 ld_Y_11_0 VDD VSS) INV_X1
XLY_11_1 (Y_11 ld_Y_11_1 VDD VSS) INV_X1
XLY_11_2 (Y_11 ld_Y_11_2 VDD VSS) INV_X1
XLY_11_3 (Y_11 ld_Y_11_3 VDD VSS) INV_X1
XLY_12_0 (Y_12 ld_Y_12_0 VDD VSS) INV_X1
XLY_12_1 (Y_12 ld_Y_12_1 VDD VSS) INV_X1
XLY_12_2 (Y_12 ld_Y_12_2 VDD VSS) INV_X1
XLY_12_3 (Y_12 ld_Y_12_3 VDD VSS) INV_X1
XLY_13_0 (Y_13 ld_Y_13_0 VDD VSS) INV_X1
XLY_13_1 (Y_13 ld_Y_13_1 VDD VSS) INV_X1
XLY_13_2 (Y_13 ld_Y_13_2 VDD VSS) INV_X1
XLY_13_3 (Y_13 ld_Y_13_3 VDD VSS) INV_X1
XLY_14_0 (Y_14 ld_Y_14_0 VDD VSS) INV_X1
XLY_14_1 (Y_14 ld_Y_14_1 VDD VSS) INV_X1
XLY_14_2 (Y_14 ld_Y_14_2 VDD VSS) INV_X1
XLY_14_3 (Y_14 ld_Y_14_3 VDD VSS) INV_X1
XLY_15_0 (Y_15 ld_Y_15_0 VDD VSS) INV_X1
XLY_15_1 (Y_15 ld_Y_15_1 VDD VSS) INV_X1
XLY_15_2 (Y_15 ld_Y_15_2 VDD VSS) INV_X1
XLY_15_3 (Y_15 ld_Y_15_3 VDD VSS) INV_X1
XLZ_0 (Z ld_Z_0 VDD VSS) INV_X1
XLZ_1 (Z ld_Z_1 VDD VSS) INV_X1
XLZ_2 (Z ld_Z_2 VDD VSS) INV_X1
XLZ_3 (Z ld_Z_3 VDD VSS) INV_X1
XLC_0 (C ld_C_0 VDD VSS) INV_X1
XLC_1 (C ld_C_1 VDD VSS) INV_X1
XLC_2 (C ld_C_2 VDD VSS) INV_X1
XLC_3 (C ld_C_3 VDD VSS) INV_X1
XLV_0 (V ld_V_0 VDD VSS) INV_X1
XLV_1 (V ld_V_1 VDD VSS) INV_X1
XLV_2 (V ld_V_2 VDD VSS) INV_X1
XLV_3 (V ld_V_3 VDD VSS) INV_X1
XLDZ_0 (DZ ld_DZ_0 VDD VSS) INV_X1
XLDZ_1 (DZ ld_DZ_1 VDD VSS) INV_X1
XLDZ_2 (DZ ld_DZ_2 VDD VSS) INV_X1
XLDZ_3 (DZ ld_DZ_3 VDD VSS) INV_X1
save A_0 A_1 A_2 A_3 A_4 A_5 A_6 A_7 B_0 B_1 B_2 B_3 B_4 B_5 B_6 B_7 OP_0 OP_1 OP_2 OP_3 Y_0 Y_1 Y_2 Y_3 Y_4 Y_5 Y_6 Y_7 Y_8 Y_9 Y_10 Y_11 Y_12 Y_13 Y_14 Y_15 Z C V DZ VVDD:p
opts options save=selected temp=27 reltol=1e-3
tran tran stop=192n maxstep=40p errpreset=moderate
