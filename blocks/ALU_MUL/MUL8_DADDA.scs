// MUL8_DADDA: signed 8x8 -> 16 bit, Baugh-Wooley AND array + Dadda tree + ripple/KSA8 (baseline).
// Generated by blocks/ALU_MUL/gen_dadda.py - do not edit by hand.
// Needs: cells/A/cells_A.scs, XOR2_X1/XNOR2_X1, cells/C (FA_X1 HA_X1), blocks/ALU_ADD/KSA8.scs
simulator lang=spectre
subckt MUL8_DADDA A_0 A_1 A_2 A_3 A_4 A_5 A_6 A_7 B_0 B_1 B_2 B_3 B_4 B_5 B_6 B_7 P_0 P_1 \
    P_2 P_3 P_4 P_5 P_6 P_7 P_8 P_9 P_10 P_11 P_12 P_13 P_14 P_15 VDD VSS
I0 (A_0 B_0 pn0_0 VDD VSS) NAND2_X1
I1 (pn0_0 P_0 VDD VSS) INV_X1
I2 (A_0 B_1 pn0_1 VDD VSS) NAND2_X1
I3 (pn0_1 pp0_1 VDD VSS) INV_X1
I4 (A_0 B_2 pn0_2 VDD VSS) NAND2_X1
I5 (pn0_2 pp0_2 VDD VSS) INV_X1
I6 (A_0 B_3 pn0_3 VDD VSS) NAND2_X1
I7 (pn0_3 pp0_3 VDD VSS) INV_X1
I8 (A_0 B_4 pn0_4 VDD VSS) NAND2_X1
I9 (pn0_4 pp0_4 VDD VSS) INV_X1
I10 (A_0 B_5 pn0_5 VDD VSS) NAND2_X1
I11 (pn0_5 pp0_5 VDD VSS) INV_X1
I12 (A_0 B_6 pn0_6 VDD VSS) NAND2_X1
I13 (pn0_6 pp0_6 VDD VSS) INV_X1
I14 (A_0 B_7 pn0_7 VDD VSS) NAND2_X1
I15 (A_1 B_0 pn1_0 VDD VSS) NAND2_X1
I16 (pn1_0 pp1_0 VDD VSS) INV_X1
I17 (A_1 B_1 pn1_1 VDD VSS) NAND2_X1
I18 (pn1_1 pp1_1 VDD VSS) INV_X1
I19 (A_1 B_2 pn1_2 VDD VSS) NAND2_X1
I20 (pn1_2 pp1_2 VDD VSS) INV_X1
I21 (A_1 B_3 pn1_3 VDD VSS) NAND2_X1
I22 (pn1_3 pp1_3 VDD VSS) INV_X1
I23 (A_1 B_4 pn1_4 VDD VSS) NAND2_X1
I24 (pn1_4 pp1_4 VDD VSS) INV_X1
I25 (A_1 B_5 pn1_5 VDD VSS) NAND2_X1
I26 (pn1_5 pp1_5 VDD VSS) INV_X1
I27 (A_1 B_6 pn1_6 VDD VSS) NAND2_X1
I28 (pn1_6 pp1_6 VDD VSS) INV_X1
I29 (A_1 B_7 pn1_7 VDD VSS) NAND2_X1
I30 (A_2 B_0 pn2_0 VDD VSS) NAND2_X1
I31 (pn2_0 pp2_0 VDD VSS) INV_X1
I32 (A_2 B_1 pn2_1 VDD VSS) NAND2_X1
I33 (pn2_1 pp2_1 VDD VSS) INV_X1
I34 (A_2 B_2 pn2_2 VDD VSS) NAND2_X1
I35 (pn2_2 pp2_2 VDD VSS) INV_X1
I36 (A_2 B_3 pn2_3 VDD VSS) NAND2_X1
I37 (pn2_3 pp2_3 VDD VSS) INV_X1
I38 (A_2 B_4 pn2_4 VDD VSS) NAND2_X1
I39 (pn2_4 pp2_4 VDD VSS) INV_X1
I40 (A_2 B_5 pn2_5 VDD VSS) NAND2_X1
I41 (pn2_5 pp2_5 VDD VSS) INV_X1
I42 (A_2 B_6 pn2_6 VDD VSS) NAND2_X1
I43 (pn2_6 pp2_6 VDD VSS) INV_X1
I44 (A_2 B_7 pn2_7 VDD VSS) NAND2_X1
I45 (A_3 B_0 pn3_0 VDD VSS) NAND2_X1
I46 (pn3_0 pp3_0 VDD VSS) INV_X1
I47 (A_3 B_1 pn3_1 VDD VSS) NAND2_X1
I48 (pn3_1 pp3_1 VDD VSS) INV_X1
I49 (A_3 B_2 pn3_2 VDD VSS) NAND2_X1
I50 (pn3_2 pp3_2 VDD VSS) INV_X1
I51 (A_3 B_3 pn3_3 VDD VSS) NAND2_X1
I52 (pn3_3 pp3_3 VDD VSS) INV_X1
I53 (A_3 B_4 pn3_4 VDD VSS) NAND2_X1
I54 (pn3_4 pp3_4 VDD VSS) INV_X1
I55 (A_3 B_5 pn3_5 VDD VSS) NAND2_X1
I56 (pn3_5 pp3_5 VDD VSS) INV_X1
I57 (A_3 B_6 pn3_6 VDD VSS) NAND2_X1
I58 (pn3_6 pp3_6 VDD VSS) INV_X1
I59 (A_3 B_7 pn3_7 VDD VSS) NAND2_X1
I60 (A_4 B_0 pn4_0 VDD VSS) NAND2_X1
I61 (pn4_0 pp4_0 VDD VSS) INV_X1
I62 (A_4 B_1 pn4_1 VDD VSS) NAND2_X1
I63 (pn4_1 pp4_1 VDD VSS) INV_X1
I64 (A_4 B_2 pn4_2 VDD VSS) NAND2_X1
I65 (pn4_2 pp4_2 VDD VSS) INV_X1
I66 (A_4 B_3 pn4_3 VDD VSS) NAND2_X1
I67 (pn4_3 pp4_3 VDD VSS) INV_X1
I68 (A_4 B_4 pn4_4 VDD VSS) NAND2_X1
I69 (pn4_4 pp4_4 VDD VSS) INV_X1
I70 (A_4 B_5 pn4_5 VDD VSS) NAND2_X1
I71 (pn4_5 pp4_5 VDD VSS) INV_X1
I72 (A_4 B_6 pn4_6 VDD VSS) NAND2_X1
I73 (pn4_6 pp4_6 VDD VSS) INV_X1
I74 (A_4 B_7 pn4_7 VDD VSS) NAND2_X1
I75 (A_5 B_0 pn5_0 VDD VSS) NAND2_X1
I76 (pn5_0 pp5_0 VDD VSS) INV_X1
I77 (A_5 B_1 pn5_1 VDD VSS) NAND2_X1
I78 (pn5_1 pp5_1 VDD VSS) INV_X1
I79 (A_5 B_2 pn5_2 VDD VSS) NAND2_X1
I80 (pn5_2 pp5_2 VDD VSS) INV_X1
I81 (A_5 B_3 pn5_3 VDD VSS) NAND2_X1
I82 (pn5_3 pp5_3 VDD VSS) INV_X1
I83 (A_5 B_4 pn5_4 VDD VSS) NAND2_X1
I84 (pn5_4 pp5_4 VDD VSS) INV_X1
I85 (A_5 B_5 pn5_5 VDD VSS) NAND2_X1
I86 (pn5_5 pp5_5 VDD VSS) INV_X1
I87 (A_5 B_6 pn5_6 VDD VSS) NAND2_X1
I88 (pn5_6 pp5_6 VDD VSS) INV_X1
I89 (A_5 B_7 pn5_7 VDD VSS) NAND2_X1
I90 (A_6 B_0 pn6_0 VDD VSS) NAND2_X1
I91 (pn6_0 pp6_0 VDD VSS) INV_X1
I92 (A_6 B_1 pn6_1 VDD VSS) NAND2_X1
I93 (pn6_1 pp6_1 VDD VSS) INV_X1
I94 (A_6 B_2 pn6_2 VDD VSS) NAND2_X1
I95 (pn6_2 pp6_2 VDD VSS) INV_X1
I96 (A_6 B_3 pn6_3 VDD VSS) NAND2_X1
I97 (pn6_3 pp6_3 VDD VSS) INV_X1
I98 (A_6 B_4 pn6_4 VDD VSS) NAND2_X1
I99 (pn6_4 pp6_4 VDD VSS) INV_X1
I100 (A_6 B_5 pn6_5 VDD VSS) NAND2_X1
I101 (pn6_5 pp6_5 VDD VSS) INV_X1
I102 (A_6 B_6 pn6_6 VDD VSS) NAND2_X1
I103 (pn6_6 pp6_6 VDD VSS) INV_X1
I104 (A_6 B_7 pn6_7 VDD VSS) NAND2_X1
I105 (A_7 B_0 pn7_0 VDD VSS) NAND2_X1
I106 (A_7 B_1 pn7_1 VDD VSS) NAND2_X1
I107 (A_7 B_2 pn7_2 VDD VSS) NAND2_X1
I108 (A_7 B_3 pn7_3 VDD VSS) NAND2_X1
I109 (A_7 B_4 pn7_4 VDD VSS) NAND2_X1
I110 (A_7 B_5 pn7_5 VDD VSS) NAND2_X1
I111 (A_7 B_6 pn7_6 VDD VSS) NAND2_X1
I112 (A_7 B_7 pn7_7 VDD VSS) NAND2_X1
I113 (pn7_7 pp7_7 VDD VSS) INV_X1
I114 (pp0_6 pp1_5 d1_s d1_c VDD VSS) HA_X1
I115 (pn0_7 pp1_6 pp2_5 d2_s d2_c VDD VSS) FA_X1
I116 (pp3_4 pp4_3 d3_s d3_c VDD VSS) HA_X1
I117 (pn1_7 pp2_6 pp3_5 d4_s d4_c VDD VSS) FA_X1
I118 (pp4_4 pp5_3 pp6_2 d5_s d5_c VDD VSS) FA_X1
I119 (pn2_7 pp3_6 pp4_5 d6_s d6_c VDD VSS) FA_X1
I120 (pp0_4 pp1_3 d7_s d7_c VDD VSS) HA_X1
I121 (pp0_5 pp1_4 pp2_3 d8_s d8_c VDD VSS) FA_X1
I122 (pp3_2 pp4_1 d9_s d9_c VDD VSS) HA_X1
I123 (d1_s pp2_4 pp3_3 d10_s d10_c VDD VSS) FA_X1
I124 (pp4_2 pp5_1 pp6_0 d11_s d11_c VDD VSS) FA_X1
I125 (d1_c d2_s d3_s d12_s d12_c VDD VSS) FA_X1
I126 (pp5_2 pp6_1 pn7_0 d13_s d13_c VDD VSS) FA_X1
I127 (d2_c d3_c d4_s d14_s d14_c VDD VSS) FA_X1
I128 (d5_s pn7_1 VDD d15_s d15_c VDD VSS) FA_X1
I129 (d4_c d5_c d6_s d16_s d16_c VDD VSS) FA_X1
I130 (pp5_4 pp6_3 pn7_2 d17_s d17_c VDD VSS) FA_X1
I131 (d6_c pn3_7 pp4_6 d18_s d18_c VDD VSS) FA_X1
I132 (pp5_5 pp6_4 pn7_3 d19_s d19_c VDD VSS) FA_X1
I133 (pn4_7 pp5_6 pp6_5 d20_s d20_c VDD VSS) FA_X1
I134 (pp0_3 pp1_2 d21_s d21_c VDD VSS) HA_X1
I135 (d7_s pp2_2 pp3_1 d22_s d22_c VDD VSS) FA_X1
I136 (d7_c d8_s d9_s d23_s d23_c VDD VSS) FA_X1
I137 (d8_c d9_c d10_s d24_s d24_c VDD VSS) FA_X1
I138 (d10_c d11_c d12_s d25_s d25_c VDD VSS) FA_X1
I139 (d12_c d13_c d14_s d26_s d26_c VDD VSS) FA_X1
I140 (d14_c d15_c d16_s d27_s d27_c VDD VSS) FA_X1
I141 (d16_c d17_c d18_s d28_s d28_c VDD VSS) FA_X1
I142 (d18_c d19_c d20_s d29_s d29_c VDD VSS) FA_X1
I143 (d20_c pn5_7 pp6_6 d30_s d30_c VDD VSS) FA_X1
I144 (pp0_2 pp1_1 d31_s d31_c VDD VSS) HA_X1
I145 (d21_s pp2_1 pp3_0 d32_s d32_c VDD VSS) FA_X1
I146 (d21_c d22_s pp4_0 d33_s d33_c VDD VSS) FA_X1
I147 (d22_c d23_s pp5_0 d34_s d34_c VDD VSS) FA_X1
I148 (d23_c d24_s d11_s d35_s d35_c VDD VSS) FA_X1
I149 (d24_c d25_s d13_s d36_s d36_c VDD VSS) FA_X1
I150 (d25_c d26_s d15_s d37_s d37_c VDD VSS) FA_X1
I151 (d26_c d27_s d17_s d38_s d38_c VDD VSS) FA_X1
I152 (d27_c d28_s d19_s d39_s d39_c VDD VSS) FA_X1
I153 (d28_c d29_s pn7_4 d40_s d40_c VDD VSS) FA_X1
I154 (d29_c d30_s pn7_5 d41_s d41_c VDD VSS) FA_X1
I155 (d30_c pn6_7 pn7_6 d42_s d42_c VDD VSS) FA_X1
I156 (pp0_1 pp1_0 P_1 rc2 VDD VSS) HA_X1
I157 (d31_s pp2_0 rc2 P_2 rc3 VDD VSS) FA_X1
I158 (d31_c d32_s rc3 P_3 rc4 VDD VSS) FA_X1
I159 (d32_c d33_s rc4 P_4 rc5 VDD VSS) FA_X1
I160 (d33_c d34_s rc5 P_5 rc6 VDD VSS) FA_X1
I161 (d34_c d35_s rc6 P_6 rc7 VDD VSS) FA_X1
I162 (d35_c d36_s rc7 P_7 rc8 VDD VSS) FA_X1
I163 (d36_c d37_c d38_c d39_c d40_c d41_c d42_c VDD d37_s d38_s d39_s d40_s d41_s d42_s \
    pp7_7 VSS rc8 P_8 P_9 P_10 P_11 P_12 P_13 P_14 P_15 kc7 kc8 VDD VSS) KSA8
ends MUL8_DADDA
