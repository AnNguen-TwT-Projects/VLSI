// Testbench MUL8_DADDA: generated by blocks/ALU_MUL/gen_dadda.py (80 vectors, tb/mul8_vectors.csv)
// 3 ns/vector, edges 20 ps, 4x INV_X1 load per output (nhu MUL8)
simulator lang=spectre
global 0
VVDD (VDD 0) vsource dc=1.2
VVSS (VSS 0) vsource dc=0
VA_0 (A_0 0) vsource type=pwl wave=[ \
    0p 0 15000p 0 15020p 1.2 45000p 1.2 45020p 0 60000p 0 60020p 1.2 78000p 1.2 \
    78020p 0 81000p 0 81020p 1.2 87000p 1.2 87020p 0 99000p 0 99020p 1.2 114000p 1.2 \
    114020p 0 117000p 0 117020p 1.2 120000p 1.2 120020p 0 123000p 0 123020p 1.2 126000p 1.2 \
    126020p 0 132000p 0 132020p 1.2 135000p 1.2 135020p 0 141000p 0 141020p 1.2 144000p 1.2 \
    144020p 0 147000p 0 147020p 1.2 153000p 1.2 153020p 0 159000p 0 159020p 1.2 162000p 1.2 \
    162020p 0 165000p 0 165020p 1.2 174000p 1.2 174020p 0 177000p 0 177020p 1.2 180000p 1.2 \
    180020p 0 183000p 0 183020p 1.2 186000p 1.2 186020p 0 195000p 0 195020p 1.2 201000p 1.2 \
    201020p 0 210000p 0 210020p 1.2 216000p 1.2 216020p 0 222000p 0 222020p 1.2 225000p 1.2 \
    225020p 0 237000p 0 237020p 1.2 ]
VA_1 (A_1 0) vsource type=pwl wave=[ \
    0p 0 30000p 0 30020p 1.2 45000p 1.2 45020p 0 60000p 0 60020p 1.2 75000p 1.2 \
    75020p 0 78000p 0 78020p 1.2 87000p 1.2 87020p 0 90000p 0 90020p 1.2 96000p 1.2 \
    96020p 0 105000p 0 105020p 1.2 114000p 1.2 114020p 0 120000p 0 120020p 1.2 132000p 1.2 \
    132020p 0 135000p 0 135020p 1.2 147000p 1.2 147020p 0 159000p 0 159020p 1.2 165000p 1.2 \
    165020p 0 168000p 0 168020p 1.2 174000p 1.2 174020p 0 186000p 0 186020p 1.2 192000p 1.2 \
    192020p 0 195000p 0 195020p 1.2 198000p 1.2 198020p 0 201000p 0 201020p 1.2 204000p 1.2 \
    204020p 0 210000p 0 210020p 1.2 213000p 1.2 213020p 0 216000p 0 216020p 1.2 219000p 1.2 \
    219020p 0 222000p 0 222020p 1.2 228000p 1.2 228020p 0 234000p 0 234020p 1.2 ]
VA_2 (A_2 0) vsource type=pwl wave=[ \
    0p 0 30000p 0 30020p 1.2 45000p 1.2 45020p 0 60000p 0 60020p 1.2 78000p 1.2 \
    78020p 0 87000p 0 87020p 1.2 90000p 1.2 90020p 0 93000p 0 93020p 1.2 96000p 1.2 \
    96020p 0 99000p 0 99020p 1.2 102000p 1.2 102020p 0 105000p 0 105020p 1.2 111000p 1.2 \
    111020p 0 120000p 0 120020p 1.2 123000p 1.2 123020p 0 126000p 0 126020p 1.2 129000p 1.2 \
    129020p 0 138000p 0 138020p 1.2 144000p 1.2 144020p 0 150000p 0 150020p 1.2 156000p 1.2 \
    156020p 0 162000p 0 162020p 1.2 171000p 1.2 171020p 0 174000p 0 174020p 1.2 177000p 1.2 \
    177020p 0 186000p 0 186020p 1.2 195000p 1.2 195020p 0 198000p 0 198020p 1.2 201000p 1.2 \
    201020p 0 210000p 0 210020p 1.2 213000p 1.2 213020p 0 222000p 0 222020p 1.2 225000p 1.2 \
    225020p 0 228000p 0 228020p 1.2 231000p 1.2 231020p 0 ]
VA_3 (A_3 0) vsource type=pwl wave=[ \
    0p 0 30000p 0 30020p 1.2 45000p 1.2 45020p 0 60000p 0 60020p 1.2 75000p 1.2 \
    75020p 0 78000p 0 78020p 1.2 93000p 1.2 93020p 0 96000p 0 96020p 1.2 117000p 1.2 \
    117020p 0 123000p 0 123020p 1.2 147000p 1.2 147020p 0 150000p 0 150020p 1.2 153000p 1.2 \
    153020p 0 156000p 0 156020p 1.2 159000p 1.2 159020p 0 162000p 0 162020p 1.2 168000p 1.2 \
    168020p 0 174000p 0 174020p 1.2 177000p 1.2 177020p 0 180000p 0 180020p 1.2 189000p 1.2 \
    189020p 0 192000p 0 192020p 1.2 198000p 1.2 198020p 0 201000p 0 201020p 1.2 207000p 1.2 \
    207020p 0 210000p 0 210020p 1.2 219000p 1.2 219020p 0 222000p 0 222020p 1.2 225000p 1.2 \
    225020p 0 237000p 0 237020p 1.2 ]
VA_4 (A_4 0) vsource type=pwl wave=[ \
    0p 0 30000p 0 30020p 1.2 45000p 1.2 45020p 0 60000p 0 60020p 1.2 78000p 1.2 \
    78020p 0 81000p 0 81020p 1.2 87000p 1.2 87020p 0 90000p 0 90020p 1.2 93000p 1.2 \
    93020p 0 105000p 0 105020p 1.2 108000p 1.2 108020p 0 111000p 0 111020p 1.2 114000p 1.2 \
    114020p 0 120000p 0 120020p 1.2 126000p 1.2 126020p 0 129000p 0 129020p 1.2 138000p 1.2 \
    138020p 0 147000p 0 147020p 1.2 156000p 1.2 156020p 0 159000p 0 159020p 1.2 162000p 1.2 \
    162020p 0 165000p 0 165020p 1.2 174000p 1.2 174020p 0 177000p 0 177020p 1.2 192000p 1.2 \
    192020p 0 195000p 0 195020p 1.2 204000p 1.2 204020p 0 216000p 0 216020p 1.2 219000p 1.2 \
    219020p 0 222000p 0 222020p 1.2 225000p 1.2 225020p 0 228000p 0 228020p 1.2 231000p 1.2 \
    231020p 0 ]
VA_5 (A_5 0) vsource type=pwl wave=[ \
    0p 0 30000p 0 30020p 1.2 45000p 1.2 45020p 0 60000p 0 60020p 1.2 75000p 1.2 \
    75020p 0 78000p 0 78020p 1.2 84000p 1.2 84020p 0 87000p 0 87020p 1.2 96000p 1.2 \
    96020p 0 129000p 0 129020p 1.2 132000p 1.2 132020p 0 135000p 0 135020p 1.2 141000p 1.2 \
    141020p 0 147000p 0 147020p 1.2 150000p 1.2 150020p 0 153000p 0 153020p 1.2 159000p 1.2 \
    159020p 0 162000p 0 162020p 1.2 165000p 1.2 165020p 0 171000p 0 171020p 1.2 177000p 1.2 \
    177020p 0 183000p 0 183020p 1.2 186000p 1.2 186020p 0 189000p 0 189020p 1.2 210000p 1.2 \
    210020p 0 216000p 0 216020p 1.2 219000p 1.2 219020p 0 222000p 0 222020p 1.2 225000p 1.2 \
    225020p 0 228000p 0 228020p 1.2 231000p 1.2 231020p 0 234000p 0 234020p 1.2 ]
VA_6 (A_6 0) vsource type=pwl wave=[ \
    0p 0 30000p 0 30020p 1.2 45000p 1.2 45020p 0 60000p 0 60020p 1.2 78000p 1.2 \
    78020p 0 81000p 0 81020p 1.2 93000p 1.2 93020p 0 96000p 0 96020p 1.2 105000p 1.2 \
    105020p 0 111000p 0 111020p 1.2 114000p 1.2 114020p 0 117000p 0 117020p 1.2 123000p 1.2 \
    123020p 0 126000p 0 126020p 1.2 132000p 1.2 132020p 0 138000p 0 138020p 1.2 150000p 1.2 \
    150020p 0 159000p 0 159020p 1.2 162000p 1.2 162020p 0 165000p 0 165020p 1.2 183000p 1.2 \
    183020p 0 189000p 0 189020p 1.2 195000p 1.2 195020p 0 204000p 0 204020p 1.2 210000p 1.2 \
    210020p 0 222000p 0 222020p 1.2 225000p 1.2 225020p 0 228000p 0 228020p 1.2 237000p 1.2 \
    237020p 0 ]
VA_7 (A_7 0) vsource type=pwl wave=[ \
    0p 0 45000p 0 45020p 1.2 75000p 1.2 75020p 0 78000p 0 78020p 1.2 81000p 1.2 \
    81020p 0 84000p 0 84020p 1.2 87000p 1.2 87020p 0 90000p 0 90020p 1.2 99000p 1.2 \
    99020p 0 108000p 0 108020p 1.2 111000p 1.2 111020p 0 114000p 0 114020p 1.2 117000p 1.2 \
    117020p 0 129000p 0 129020p 1.2 141000p 1.2 141020p 0 147000p 0 147020p 1.2 150000p 1.2 \
    150020p 0 153000p 0 153020p 1.2 159000p 1.2 159020p 0 165000p 0 165020p 1.2 168000p 1.2 \
    168020p 0 180000p 0 180020p 1.2 192000p 1.2 192020p 0 198000p 0 198020p 1.2 201000p 1.2 \
    201020p 0 213000p 0 213020p 1.2 222000p 1.2 222020p 0 231000p 0 231020p 1.2 234000p 1.2 \
    234020p 0 ]
VB_0 (B_0 0) vsource type=pwl wave=[ \
    0p 0 3000p 0 3020p 1.2 9000p 1.2 9020p 0 12000p 0 12020p 1.2 15000p 1.2 \
    15020p 0 18000p 0 18020p 1.2 24000p 1.2 24020p 0 27000p 0 27020p 1.2 30000p 1.2 \
    30020p 0 33000p 0 33020p 1.2 39000p 1.2 39020p 0 42000p 0 42020p 1.2 45000p 1.2 \
    45020p 0 48000p 0 48020p 1.2 54000p 1.2 54020p 0 57000p 0 57020p 1.2 60000p 1.2 \
    60020p 0 63000p 0 63020p 1.2 69000p 1.2 69020p 0 72000p 0 72020p 1.2 75000p 1.2 \
    75020p 0 78000p 0 78020p 1.2 84000p 1.2 84020p 0 90000p 0 90020p 1.2 93000p 1.2 \
    93020p 0 102000p 0 102020p 1.2 114000p 1.2 114020p 0 120000p 0 120020p 1.2 129000p 1.2 \
    129020p 0 132000p 0 132020p 1.2 138000p 1.2 138020p 0 147000p 0 147020p 1.2 150000p 1.2 \
    150020p 0 153000p 0 153020p 1.2 156000p 1.2 156020p 0 159000p 0 159020p 1.2 162000p 1.2 \
    162020p 0 168000p 0 168020p 1.2 174000p 1.2 174020p 0 180000p 0 180020p 1.2 189000p 1.2 \
    189020p 0 204000p 0 204020p 1.2 210000p 1.2 210020p 0 213000p 0 213020p 1.2 225000p 1.2 \
    225020p 0 228000p 0 228020p 1.2 231000p 1.2 231020p 0 ]
VB_1 (B_1 0) vsource type=pwl wave=[ \
    0p 0 6000p 0 6020p 1.2 9000p 1.2 9020p 0 12000p 0 12020p 1.2 15000p 1.2 \
    15020p 0 21000p 0 21020p 1.2 24000p 1.2 24020p 0 27000p 0 27020p 1.2 30000p 1.2 \
    30020p 0 36000p 0 36020p 1.2 39000p 1.2 39020p 0 42000p 0 42020p 1.2 45000p 1.2 \
    45020p 0 51000p 0 51020p 1.2 54000p 1.2 54020p 0 57000p 0 57020p 1.2 60000p 1.2 \
    60020p 0 66000p 0 66020p 1.2 69000p 1.2 69020p 0 72000p 0 72020p 1.2 78000p 1.2 \
    78020p 0 81000p 0 81020p 1.2 84000p 1.2 84020p 0 87000p 0 87020p 1.2 90000p 1.2 \
    90020p 0 93000p 0 93020p 1.2 96000p 1.2 96020p 0 99000p 0 99020p 1.2 105000p 1.2 \
    105020p 0 111000p 0 111020p 1.2 132000p 1.2 132020p 0 135000p 0 135020p 1.2 138000p 1.2 \
    138020p 0 141000p 0 141020p 1.2 144000p 1.2 144020p 0 147000p 0 147020p 1.2 150000p 1.2 \
    150020p 0 153000p 0 153020p 1.2 159000p 1.2 159020p 0 165000p 0 165020p 1.2 171000p 1.2 \
    171020p 0 174000p 0 174020p 1.2 177000p 1.2 177020p 0 180000p 0 180020p 1.2 186000p 1.2 \
    186020p 0 189000p 0 189020p 1.2 192000p 1.2 192020p 0 207000p 0 207020p 1.2 219000p 1.2 \
    219020p 0 222000p 0 222020p 1.2 228000p 1.2 228020p 0 234000p 0 234020p 1.2 ]
VB_2 (B_2 0) vsource type=pwl wave=[ \
    0p 0 6000p 0 6020p 1.2 9000p 1.2 9020p 0 12000p 0 12020p 1.2 15000p 1.2 \
    15020p 0 21000p 0 21020p 1.2 24000p 1.2 24020p 0 27000p 0 27020p 1.2 30000p 1.2 \
    30020p 0 36000p 0 36020p 1.2 39000p 1.2 39020p 0 42000p 0 42020p 1.2 45000p 1.2 \
    45020p 0 51000p 0 51020p 1.2 54000p 1.2 54020p 0 57000p 0 57020p 1.2 60000p 1.2 \
    60020p 0 66000p 0 66020p 1.2 69000p 1.2 69020p 0 72000p 0 72020p 1.2 75000p 1.2 \
    75020p 0 78000p 0 78020p 1.2 81000p 1.2 81020p 0 90000p 0 90020p 1.2 93000p 1.2 \
    93020p 0 99000p 0 99020p 1.2 102000p 1.2 102020p 0 111000p 0 111020p 1.2 117000p 1.2 \
    117020p 0 120000p 0 120020p 1.2 126000p 1.2 126020p 0 129000p 0 129020p 1.2 132000p 1.2 \
    132020p 0 135000p 0 135020p 1.2 138000p 1.2 138020p 0 141000p 0 141020p 1.2 147000p 1.2 \
    147020p 0 156000p 0 156020p 1.2 159000p 1.2 159020p 0 165000p 0 165020p 1.2 168000p 1.2 \
    168020p 0 171000p 0 171020p 1.2 177000p 1.2 177020p 0 189000p 0 189020p 1.2 195000p 1.2 \
    195020p 0 204000p 0 204020p 1.2 207000p 1.2 207020p 0 222000p 0 222020p 1.2 231000p 1.2 \
    231020p 0 234000p 0 234020p 1.2 ]
VB_3 (B_3 0) vsource type=pwl wave=[ \
    0p 0 6000p 0 6020p 1.2 9000p 1.2 9020p 0 12000p 0 12020p 1.2 15000p 1.2 \
    15020p 0 21000p 0 21020p 1.2 24000p 1.2 24020p 0 27000p 0 27020p 1.2 30000p 1.2 \
    30020p 0 36000p 0 36020p 1.2 39000p 1.2 39020p 0 42000p 0 42020p 1.2 45000p 1.2 \
    45020p 0 51000p 0 51020p 1.2 54000p 1.2 54020p 0 57000p 0 57020p 1.2 60000p 1.2 \
    60020p 0 66000p 0 66020p 1.2 69000p 1.2 69020p 0 72000p 0 72020p 1.2 78000p 1.2 \
    78020p 0 81000p 0 81020p 1.2 84000p 1.2 84020p 0 87000p 0 87020p 1.2 90000p 1.2 \
    90020p 0 93000p 0 93020p 1.2 96000p 1.2 96020p 0 99000p 0 99020p 1.2 102000p 1.2 \
    102020p 0 108000p 0 108020p 1.2 111000p 1.2 111020p 0 117000p 0 117020p 1.2 126000p 1.2 \
    126020p 0 129000p 0 129020p 1.2 132000p 1.2 132020p 0 135000p 0 135020p 1.2 138000p 1.2 \
    138020p 0 156000p 0 156020p 1.2 159000p 1.2 159020p 0 162000p 0 162020p 1.2 165000p 1.2 \
    165020p 0 168000p 0 168020p 1.2 186000p 1.2 186020p 0 189000p 0 189020p 1.2 192000p 1.2 \
    192020p 0 195000p 0 195020p 1.2 198000p 1.2 198020p 0 201000p 0 201020p 1.2 213000p 1.2 \
    213020p 0 216000p 0 216020p 1.2 219000p 1.2 219020p 0 222000p 0 222020p 1.2 231000p 1.2 \
    231020p 0 ]
VB_4 (B_4 0) vsource type=pwl wave=[ \
    0p 0 6000p 0 6020p 1.2 9000p 1.2 9020p 0 12000p 0 12020p 1.2 15000p 1.2 \
    15020p 0 21000p 0 21020p 1.2 24000p 1.2 24020p 0 27000p 0 27020p 1.2 30000p 1.2 \
    30020p 0 36000p 0 36020p 1.2 39000p 1.2 39020p 0 42000p 0 42020p 1.2 45000p 1.2 \
    45020p 0 51000p 0 51020p 1.2 54000p 1.2 54020p 0 57000p 0 57020p 1.2 60000p 1.2 \
    60020p 0 66000p 0 66020p 1.2 69000p 1.2 69020p 0 72000p 0 72020p 1.2 75000p 1.2 \
    75020p 0 78000p 0 78020p 1.2 81000p 1.2 81020p 0 93000p 0 93020p 1.2 96000p 1.2 \
    96020p 0 105000p 0 105020p 1.2 111000p 1.2 111020p 0 114000p 0 114020p 1.2 117000p 1.2 \
    117020p 0 120000p 0 120020p 1.2 129000p 1.2 129020p 0 132000p 0 132020p 1.2 135000p 1.2 \
    135020p 0 138000p 0 138020p 1.2 141000p 1.2 141020p 0 144000p 0 144020p 1.2 147000p 1.2 \
    147020p 0 150000p 0 150020p 1.2 153000p 1.2 153020p 0 162000p 0 162020p 1.2 165000p 1.2 \
    165020p 0 168000p 0 168020p 1.2 180000p 1.2 180020p 0 198000p 0 198020p 1.2 210000p 1.2 \
    210020p 0 213000p 0 213020p 1.2 216000p 1.2 216020p 0 222000p 0 222020p 1.2 231000p 1.2 \
    231020p 0 234000p 0 234020p 1.2 237000p 1.2 237020p 0 ]
VB_5 (B_5 0) vsource type=pwl wave=[ \
    0p 0 6000p 0 6020p 1.2 9000p 1.2 9020p 0 12000p 0 12020p 1.2 15000p 1.2 \
    15020p 0 21000p 0 21020p 1.2 24000p 1.2 24020p 0 27000p 0 27020p 1.2 30000p 1.2 \
    30020p 0 36000p 0 36020p 1.2 39000p 1.2 39020p 0 42000p 0 42020p 1.2 45000p 1.2 \
    45020p 0 51000p 0 51020p 1.2 54000p 1.2 54020p 0 57000p 0 57020p 1.2 60000p 1.2 \
    60020p 0 66000p 0 66020p 1.2 69000p 1.2 69020p 0 72000p 0 72020p 1.2 78000p 1.2 \
    78020p 0 81000p 0 81020p 1.2 84000p 1.2 84020p 0 93000p 0 93020p 1.2 99000p 1.2 \
    99020p 0 114000p 0 114020p 1.2 120000p 1.2 120020p 0 132000p 0 132020p 1.2 138000p 1.2 \
    138020p 0 141000p 0 141020p 1.2 144000p 1.2 144020p 0 150000p 0 150020p 1.2 153000p 1.2 \
    153020p 0 159000p 0 159020p 1.2 162000p 1.2 162020p 0 165000p 0 165020p 1.2 177000p 1.2 \
    177020p 0 180000p 0 180020p 1.2 198000p 1.2 198020p 0 222000p 0 222020p 1.2 231000p 1.2 \
    231020p 0 ]
VB_6 (B_6 0) vsource type=pwl wave=[ \
    0p 0 6000p 0 6020p 1.2 9000p 1.2 9020p 0 12000p 0 12020p 1.2 15000p 1.2 \
    15020p 0 21000p 0 21020p 1.2 24000p 1.2 24020p 0 27000p 0 27020p 1.2 30000p 1.2 \
    30020p 0 36000p 0 36020p 1.2 39000p 1.2 39020p 0 42000p 0 42020p 1.2 45000p 1.2 \
    45020p 0 51000p 0 51020p 1.2 54000p 1.2 54020p 0 57000p 0 57020p 1.2 60000p 1.2 \
    60020p 0 66000p 0 66020p 1.2 69000p 1.2 69020p 0 72000p 0 72020p 1.2 75000p 1.2 \
    75020p 0 78000p 0 78020p 1.2 87000p 1.2 87020p 0 90000p 0 90020p 1.2 93000p 1.2 \
    93020p 0 96000p 0 96020p 1.2 105000p 1.2 105020p 0 111000p 0 111020p 1.2 114000p 1.2 \
    114020p 0 117000p 0 117020p 1.2 129000p 1.2 129020p 0 132000p 0 132020p 1.2 135000p 1.2 \
    135020p 0 138000p 0 138020p 1.2 141000p 1.2 141020p 0 159000p 0 159020p 1.2 174000p 1.2 \
    174020p 0 177000p 0 177020p 1.2 189000p 1.2 189020p 0 192000p 0 192020p 1.2 195000p 1.2 \
    195020p 0 198000p 0 198020p 1.2 213000p 1.2 213020p 0 216000p 0 216020p 1.2 219000p 1.2 \
    219020p 0 222000p 0 222020p 1.2 228000p 1.2 228020p 0 231000p 0 231020p 1.2 234000p 1.2 \
    234020p 0 237000p 0 237020p 1.2 ]
VB_7 (B_7 0) vsource type=pwl wave=[ \
    0p 0 9000p 0 9020p 1.2 15000p 1.2 15020p 0 24000p 0 24020p 1.2 30000p 1.2 \
    30020p 0 39000p 0 39020p 1.2 45000p 1.2 45020p 0 54000p 0 54020p 1.2 60000p 1.2 \
    60020p 0 69000p 0 69020p 1.2 78000p 1.2 78020p 0 87000p 0 87020p 1.2 90000p 1.2 \
    90020p 0 93000p 0 93020p 1.2 96000p 1.2 96020p 0 108000p 0 108020p 1.2 111000p 1.2 \
    111020p 0 114000p 0 114020p 1.2 120000p 1.2 120020p 0 126000p 0 126020p 1.2 129000p 1.2 \
    129020p 0 138000p 0 138020p 1.2 144000p 1.2 144020p 0 153000p 0 153020p 1.2 156000p 1.2 \
    156020p 0 162000p 0 162020p 1.2 165000p 1.2 165020p 0 171000p 0 171020p 1.2 183000p 1.2 \
    183020p 0 186000p 0 186020p 1.2 189000p 1.2 189020p 0 204000p 0 204020p 1.2 210000p 1.2 \
    210020p 0 213000p 0 213020p 1.2 222000p 1.2 222020p 0 225000p 0 225020p 1.2 231000p 1.2 \
    231020p 0 ]
XDUT (A_0 A_1 A_2 A_3 A_4 A_5 A_6 A_7 B_0 B_1 B_2 B_3 B_4 B_5 B_6 B_7 P_0 P_1 P_2 P_3 P_4 P_5 P_6 P_7 P_8 P_9 P_10 P_11 P_12 P_13 P_14 P_15 VDD VSS) MUL8_DADDA
XLP_0_0 (P_0 ld_P_0_0 VDD VSS) INV_X1
XLP_0_1 (P_0 ld_P_0_1 VDD VSS) INV_X1
XLP_0_2 (P_0 ld_P_0_2 VDD VSS) INV_X1
XLP_0_3 (P_0 ld_P_0_3 VDD VSS) INV_X1
XLP_1_0 (P_1 ld_P_1_0 VDD VSS) INV_X1
XLP_1_1 (P_1 ld_P_1_1 VDD VSS) INV_X1
XLP_1_2 (P_1 ld_P_1_2 VDD VSS) INV_X1
XLP_1_3 (P_1 ld_P_1_3 VDD VSS) INV_X1
XLP_2_0 (P_2 ld_P_2_0 VDD VSS) INV_X1
XLP_2_1 (P_2 ld_P_2_1 VDD VSS) INV_X1
XLP_2_2 (P_2 ld_P_2_2 VDD VSS) INV_X1
XLP_2_3 (P_2 ld_P_2_3 VDD VSS) INV_X1
XLP_3_0 (P_3 ld_P_3_0 VDD VSS) INV_X1
XLP_3_1 (P_3 ld_P_3_1 VDD VSS) INV_X1
XLP_3_2 (P_3 ld_P_3_2 VDD VSS) INV_X1
XLP_3_3 (P_3 ld_P_3_3 VDD VSS) INV_X1
XLP_4_0 (P_4 ld_P_4_0 VDD VSS) INV_X1
XLP_4_1 (P_4 ld_P_4_1 VDD VSS) INV_X1
XLP_4_2 (P_4 ld_P_4_2 VDD VSS) INV_X1
XLP_4_3 (P_4 ld_P_4_3 VDD VSS) INV_X1
XLP_5_0 (P_5 ld_P_5_0 VDD VSS) INV_X1
XLP_5_1 (P_5 ld_P_5_1 VDD VSS) INV_X1
XLP_5_2 (P_5 ld_P_5_2 VDD VSS) INV_X1
XLP_5_3 (P_5 ld_P_5_3 VDD VSS) INV_X1
XLP_6_0 (P_6 ld_P_6_0 VDD VSS) INV_X1
XLP_6_1 (P_6 ld_P_6_1 VDD VSS) INV_X1
XLP_6_2 (P_6 ld_P_6_2 VDD VSS) INV_X1
XLP_6_3 (P_6 ld_P_6_3 VDD VSS) INV_X1
XLP_7_0 (P_7 ld_P_7_0 VDD VSS) INV_X1
XLP_7_1 (P_7 ld_P_7_1 VDD VSS) INV_X1
XLP_7_2 (P_7 ld_P_7_2 VDD VSS) INV_X1
XLP_7_3 (P_7 ld_P_7_3 VDD VSS) INV_X1
XLP_8_0 (P_8 ld_P_8_0 VDD VSS) INV_X1
XLP_8_1 (P_8 ld_P_8_1 VDD VSS) INV_X1
XLP_8_2 (P_8 ld_P_8_2 VDD VSS) INV_X1
XLP_8_3 (P_8 ld_P_8_3 VDD VSS) INV_X1
XLP_9_0 (P_9 ld_P_9_0 VDD VSS) INV_X1
XLP_9_1 (P_9 ld_P_9_1 VDD VSS) INV_X1
XLP_9_2 (P_9 ld_P_9_2 VDD VSS) INV_X1
XLP_9_3 (P_9 ld_P_9_3 VDD VSS) INV_X1
XLP_10_0 (P_10 ld_P_10_0 VDD VSS) INV_X1
XLP_10_1 (P_10 ld_P_10_1 VDD VSS) INV_X1
XLP_10_2 (P_10 ld_P_10_2 VDD VSS) INV_X1
XLP_10_3 (P_10 ld_P_10_3 VDD VSS) INV_X1
XLP_11_0 (P_11 ld_P_11_0 VDD VSS) INV_X1
XLP_11_1 (P_11 ld_P_11_1 VDD VSS) INV_X1
XLP_11_2 (P_11 ld_P_11_2 VDD VSS) INV_X1
XLP_11_3 (P_11 ld_P_11_3 VDD VSS) INV_X1
XLP_12_0 (P_12 ld_P_12_0 VDD VSS) INV_X1
XLP_12_1 (P_12 ld_P_12_1 VDD VSS) INV_X1
XLP_12_2 (P_12 ld_P_12_2 VDD VSS) INV_X1
XLP_12_3 (P_12 ld_P_12_3 VDD VSS) INV_X1
XLP_13_0 (P_13 ld_P_13_0 VDD VSS) INV_X1
XLP_13_1 (P_13 ld_P_13_1 VDD VSS) INV_X1
XLP_13_2 (P_13 ld_P_13_2 VDD VSS) INV_X1
XLP_13_3 (P_13 ld_P_13_3 VDD VSS) INV_X1
XLP_14_0 (P_14 ld_P_14_0 VDD VSS) INV_X1
XLP_14_1 (P_14 ld_P_14_1 VDD VSS) INV_X1
XLP_14_2 (P_14 ld_P_14_2 VDD VSS) INV_X1
XLP_14_3 (P_14 ld_P_14_3 VDD VSS) INV_X1
XLP_15_0 (P_15 ld_P_15_0 VDD VSS) INV_X1
XLP_15_1 (P_15 ld_P_15_1 VDD VSS) INV_X1
XLP_15_2 (P_15 ld_P_15_2 VDD VSS) INV_X1
XLP_15_3 (P_15 ld_P_15_3 VDD VSS) INV_X1
save P_0 P_1 P_2 P_3 P_4 P_5 P_6 P_7 P_8 P_9 P_10 P_11 P_12 P_13 P_14 P_15 VVDD:p
opts options save=selected temp=27 reltol=1e-3
tran tran stop=240n maxstep=10p errpreset=moderate
