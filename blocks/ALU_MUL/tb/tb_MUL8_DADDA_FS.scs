// MUL8_DADDA corner FS: generated by blocks/ALU_MUL/gen_dadda.py
simulator lang=spectre
include "/home/buet/cadence/gpdk090_v4.6/models/spectre/gpdk090.scs" section=FS
include "../../../cells/A/cells_A.scs"
include "../../../cells/_stub_B/XOR2_X1/XOR2_X1.scs"
include "../../../cells/_stub_B/XNOR2_X1/XNOR2_X1.scs"
include "../../../cells/C/FA_X1/FA_X1.scs"
include "../../../cells/C/INV_X4/INV_X4.scs"
include "../../../cells/C/HA_X1/HA_X1.scs"
include "../../../blocks/ALU_ADD/KSA8.scs"
include "../../../blocks/ALU_MUL/MUL8_DADDA.scs"
include "tb_MUL8_DADDA.scs"
