// LOGIC8: sinh tu dong boi blocks/gen_blocks.py - khong sua tay
// Can include cac cell A + stub XOR2/XNOR2 va cac khoi con truoc khi dung.
simulator lang=spectre
subckt LOGIC8 A_0 A_1 A_2 A_3 A_4 A_5 A_6 A_7 B_0 B_1 B_2 B_3 B_4 B_5 B_6 B_7 AND_0 AND_1 \
    AND_2 AND_3 AND_4 AND_5 AND_6 AND_7 OR_0 OR_1 OR_2 OR_3 OR_4 OR_5 OR_6 OR_7 XOR_0 \
    XOR_1 XOR_2 XOR_3 XOR_4 XOR_5 XOR_6 XOR_7 NOT_0 NOT_1 NOT_2 NOT_3 NOT_4 NOT_5 NOT_6 \
    NOT_7 VDD VSS
I0 (A_0 B_0 nand0 VDD VSS) NAND2_X1
I1 (nand0 AND_0 VDD VSS) INV_X1
I2 (A_0 B_0 nor0 VDD VSS) NOR2_X1
I3 (nor0 OR_0 VDD VSS) INV_X1
I4 (A_0 B_0 XOR_0 VDD VSS) XOR2_X1
I5 (A_0 NOT_0 VDD VSS) INV_X1
I6 (A_1 B_1 nand1 VDD VSS) NAND2_X1
I7 (nand1 AND_1 VDD VSS) INV_X1
I8 (A_1 B_1 nor1 VDD VSS) NOR2_X1
I9 (nor1 OR_1 VDD VSS) INV_X1
I10 (A_1 B_1 XOR_1 VDD VSS) XOR2_X1
I11 (A_1 NOT_1 VDD VSS) INV_X1
I12 (A_2 B_2 nand2 VDD VSS) NAND2_X1
I13 (nand2 AND_2 VDD VSS) INV_X1
I14 (A_2 B_2 nor2 VDD VSS) NOR2_X1
I15 (nor2 OR_2 VDD VSS) INV_X1
I16 (A_2 B_2 XOR_2 VDD VSS) XOR2_X1
I17 (A_2 NOT_2 VDD VSS) INV_X1
I18 (A_3 B_3 nand3 VDD VSS) NAND2_X1
I19 (nand3 AND_3 VDD VSS) INV_X1
I20 (A_3 B_3 nor3 VDD VSS) NOR2_X1
I21 (nor3 OR_3 VDD VSS) INV_X1
I22 (A_3 B_3 XOR_3 VDD VSS) XOR2_X1
I23 (A_3 NOT_3 VDD VSS) INV_X1
I24 (A_4 B_4 nand4 VDD VSS) NAND2_X1
I25 (nand4 AND_4 VDD VSS) INV_X1
I26 (A_4 B_4 nor4 VDD VSS) NOR2_X1
I27 (nor4 OR_4 VDD VSS) INV_X1
I28 (A_4 B_4 XOR_4 VDD VSS) XOR2_X1
I29 (A_4 NOT_4 VDD VSS) INV_X1
I30 (A_5 B_5 nand5 VDD VSS) NAND2_X1
I31 (nand5 AND_5 VDD VSS) INV_X1
I32 (A_5 B_5 nor5 VDD VSS) NOR2_X1
I33 (nor5 OR_5 VDD VSS) INV_X1
I34 (A_5 B_5 XOR_5 VDD VSS) XOR2_X1
I35 (A_5 NOT_5 VDD VSS) INV_X1
I36 (A_6 B_6 nand6 VDD VSS) NAND2_X1
I37 (nand6 AND_6 VDD VSS) INV_X1
I38 (A_6 B_6 nor6 VDD VSS) NOR2_X1
I39 (nor6 OR_6 VDD VSS) INV_X1
I40 (A_6 B_6 XOR_6 VDD VSS) XOR2_X1
I41 (A_6 NOT_6 VDD VSS) INV_X1
I42 (A_7 B_7 nand7 VDD VSS) NAND2_X1
I43 (nand7 AND_7 VDD VSS) INV_X1
I44 (A_7 B_7 nor7 VDD VSS) NOR2_X1
I45 (nor7 OR_7 VDD VSS) INV_X1
I46 (A_7 B_7 XOR_7 VDD VSS) XOR2_X1
I47 (A_7 NOT_7 VDD VSS) INV_X1
ends LOGIC8
