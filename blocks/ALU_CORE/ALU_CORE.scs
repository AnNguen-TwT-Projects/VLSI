// ALU_CORE: sinh tu dong boi blocks/gen_blocks.py - khong sua tay
// Can include cac cell A + stub XOR2/XNOR2 va cac khoi con truoc khi dung.
simulator lang=spectre
subckt ALU_CORE A_0 A_1 A_2 A_3 A_4 A_5 A_6 A_7 B_0 B_1 B_2 B_3 B_4 B_5 B_6 B_7 OP_0 OP_1 \
    OP_2 OP_3 MULP_0 MULP_1 MULP_2 MULP_3 MULP_4 MULP_5 MULP_6 MULP_7 MULP_8 MULP_9 \
    MULP_10 MULP_11 MULP_12 MULP_13 MULP_14 MULP_15 DIVQ_0 DIVQ_1 DIVQ_2 DIVQ_3 DIVQ_4 \
    DIVQ_5 DIVQ_6 DIVQ_7 DIVR_0 DIVR_1 DIVR_2 DIVR_3 DIVR_4 DIVR_5 DIVR_6 DIVR_7 DIVV \
    DIVDZ Y_0 Y_1 Y_2 Y_3 Y_4 Y_5 Y_6 Y_7 Y_8 Y_9 Y_10 Y_11 Y_12 Y_13 Y_14 Y_15 Z C V DZ \
    VDD VSS
I0 (OP_0 OP_1 OP_2 OP_3 SEL_AS SEL_AND SEL_OR SEL_XOR SEL_NOT SEL_MUL SEL_DIV VDD VSS) \
    DEC_OP
I1 (A_0 A_1 A_2 A_3 A_4 A_5 A_6 A_7 B_0 B_1 B_2 B_3 B_4 B_5 B_6 B_7 OP_0 S_0 S_1 S_2 S_3 \
    S_4 S_5 S_6 S_7 C7 C8 VDD VSS) ADDSUB8
I2 (A_0 A_1 A_2 A_3 A_4 A_5 A_6 A_7 B_0 B_1 B_2 B_3 B_4 B_5 B_6 B_7 AND_0 AND_1 AND_2 \
    AND_3 AND_4 AND_5 AND_6 AND_7 OR_0 OR_1 OR_2 OR_3 OR_4 OR_5 OR_6 OR_7 XOR_0 XOR_1 \
    XOR_2 XOR_3 XOR_4 XOR_5 XOR_6 XOR_7 NOT_0 NOT_1 NOT_2 NOT_3 NOT_4 NOT_5 NOT_6 NOT_7 \
    VDD VSS) LOGIC8
I3 (S_0 S_1 S_2 S_3 S_4 S_5 S_6 S_7 AND_0 AND_1 AND_2 AND_3 AND_4 AND_5 AND_6 AND_7 OR_0 \
    OR_1 OR_2 OR_3 OR_4 OR_5 OR_6 OR_7 XOR_0 XOR_1 XOR_2 XOR_3 XOR_4 XOR_5 XOR_6 XOR_7 \
    NOT_0 NOT_1 NOT_2 NOT_3 NOT_4 NOT_5 NOT_6 NOT_7 MULP_0 MULP_1 MULP_2 MULP_3 MULP_4 \
    MULP_5 MULP_6 MULP_7 MULP_8 MULP_9 MULP_10 MULP_11 MULP_12 MULP_13 MULP_14 MULP_15 \
    DIVQ_0 DIVQ_1 DIVQ_2 DIVQ_3 DIVQ_4 DIVQ_5 DIVQ_6 DIVQ_7 DIVR_0 DIVR_1 DIVR_2 DIVR_3 \
    DIVR_4 DIVR_5 DIVR_6 DIVR_7 SEL_AS SEL_AND SEL_OR SEL_XOR SEL_NOT SEL_MUL SEL_DIV Y_0 \
    Y_1 Y_2 Y_3 Y_4 Y_5 Y_6 Y_7 Y_8 Y_9 Y_10 Y_11 Y_12 Y_13 Y_14 Y_15 VDD VSS) OUTMUX
I4 (Y_0 Y_1 Y_2 Y_3 Y_4 Y_5 Y_6 Y_7 Y_8 Y_9 Y_10 Y_11 Y_12 Y_13 Y_14 Y_15 C7 C8 DIVV DIVDZ \
    SEL_AS SEL_DIV Z C V DZ VDD VSS) FLAGS
ends ALU_CORE
