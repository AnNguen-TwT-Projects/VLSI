// OUTMUX: sinh tu dong boi blocks/gen_blocks.py - khong sua tay
// Can include cac cell A + stub XOR2/XNOR2 va cac khoi con truoc khi dung.
simulator lang=spectre
subckt OUTMUX S_0 S_1 S_2 S_3 S_4 S_5 S_6 S_7 AND_0 AND_1 AND_2 AND_3 AND_4 AND_5 AND_6 \
    AND_7 OR_0 OR_1 OR_2 OR_3 OR_4 OR_5 OR_6 OR_7 XOR_0 XOR_1 XOR_2 XOR_3 XOR_4 XOR_5 \
    XOR_6 XOR_7 NOT_0 NOT_1 NOT_2 NOT_3 NOT_4 NOT_5 NOT_6 NOT_7 MULP_0 MULP_1 MULP_2 \
    MULP_3 MULP_4 MULP_5 MULP_6 MULP_7 MULP_8 MULP_9 MULP_10 MULP_11 MULP_12 MULP_13 \
    MULP_14 MULP_15 DIVQ_0 DIVQ_1 DIVQ_2 DIVQ_3 DIVQ_4 DIVQ_5 DIVQ_6 DIVQ_7 DIVR_0 DIVR_1 \
    DIVR_2 DIVR_3 DIVR_4 DIVR_5 DIVR_6 DIVR_7 SEL_AS SEL_AND SEL_OR SEL_XOR SEL_NOT \
    SEL_MUL SEL_DIV Y_0 Y_1 Y_2 Y_3 Y_4 Y_5 Y_6 Y_7 Y_8 Y_9 Y_10 Y_11 Y_12 Y_13 Y_14 Y_15 \
    VDD VSS
I0 (SEL_AND AND_0 n0_0 VDD VSS) NAND2_X1
I1 (SEL_OR OR_0 n0_1 VDD VSS) NAND2_X1
I2 (SEL_XOR XOR_0 n0_2 VDD VSS) NAND2_X1
I3 (SEL_NOT NOT_0 n0_3 VDD VSS) NAND2_X1
I4 (SEL_MUL MULP_0 n0_4 VDD VSS) NAND2_X1
I5 (SEL_DIV DIVQ_0 n0_5 VDD VSS) NAND2_X1
I6 (n0_0 n0_1 o0_0 VDD VSS) NAND2_X1
I7 (n0_2 n0_3 o0_1 VDD VSS) NAND2_X1
I8 (n0_4 n0_5 o0_2 VDD VSS) NAND2_X1
I9 (o0_0 o0_1 q0_1 VDD VSS) NOR2_X1
I10 (SEL_AS S_0 o0_2 q0_2 VDD VSS) AOI21_X1
I11 (q0_1 q0_2 Y_0 VDD VSS) NAND2_X1
I12 (SEL_AND AND_1 n1_0 VDD VSS) NAND2_X1
I13 (SEL_OR OR_1 n1_1 VDD VSS) NAND2_X1
I14 (SEL_XOR XOR_1 n1_2 VDD VSS) NAND2_X1
I15 (SEL_NOT NOT_1 n1_3 VDD VSS) NAND2_X1
I16 (SEL_MUL MULP_1 n1_4 VDD VSS) NAND2_X1
I17 (SEL_DIV DIVQ_1 n1_5 VDD VSS) NAND2_X1
I18 (n1_0 n1_1 o1_0 VDD VSS) NAND2_X1
I19 (n1_2 n1_3 o1_1 VDD VSS) NAND2_X1
I20 (n1_4 n1_5 o1_2 VDD VSS) NAND2_X1
I21 (o1_0 o1_1 q1_1 VDD VSS) NOR2_X1
I22 (SEL_AS S_1 o1_2 q1_2 VDD VSS) AOI21_X1
I23 (q1_1 q1_2 Y_1 VDD VSS) NAND2_X1
I24 (SEL_AND AND_2 n2_0 VDD VSS) NAND2_X1
I25 (SEL_OR OR_2 n2_1 VDD VSS) NAND2_X1
I26 (SEL_XOR XOR_2 n2_2 VDD VSS) NAND2_X1
I27 (SEL_NOT NOT_2 n2_3 VDD VSS) NAND2_X1
I28 (SEL_MUL MULP_2 n2_4 VDD VSS) NAND2_X1
I29 (SEL_DIV DIVQ_2 n2_5 VDD VSS) NAND2_X1
I30 (n2_0 n2_1 o2_0 VDD VSS) NAND2_X1
I31 (n2_2 n2_3 o2_1 VDD VSS) NAND2_X1
I32 (n2_4 n2_5 o2_2 VDD VSS) NAND2_X1
I33 (o2_0 o2_1 q2_1 VDD VSS) NOR2_X1
I34 (SEL_AS S_2 o2_2 q2_2 VDD VSS) AOI21_X1
I35 (q2_1 q2_2 Y_2 VDD VSS) NAND2_X1
I36 (SEL_AND AND_3 n3_0 VDD VSS) NAND2_X1
I37 (SEL_OR OR_3 n3_1 VDD VSS) NAND2_X1
I38 (SEL_XOR XOR_3 n3_2 VDD VSS) NAND2_X1
I39 (SEL_NOT NOT_3 n3_3 VDD VSS) NAND2_X1
I40 (SEL_MUL MULP_3 n3_4 VDD VSS) NAND2_X1
I41 (SEL_DIV DIVQ_3 n3_5 VDD VSS) NAND2_X1
I42 (n3_0 n3_1 o3_0 VDD VSS) NAND2_X1
I43 (n3_2 n3_3 o3_1 VDD VSS) NAND2_X1
I44 (n3_4 n3_5 o3_2 VDD VSS) NAND2_X1
I45 (o3_0 o3_1 q3_1 VDD VSS) NOR2_X1
I46 (SEL_AS S_3 o3_2 q3_2 VDD VSS) AOI21_X1
I47 (q3_1 q3_2 Y_3 VDD VSS) NAND2_X1
I48 (SEL_AND AND_4 n4_0 VDD VSS) NAND2_X1
I49 (SEL_OR OR_4 n4_1 VDD VSS) NAND2_X1
I50 (SEL_XOR XOR_4 n4_2 VDD VSS) NAND2_X1
I51 (SEL_NOT NOT_4 n4_3 VDD VSS) NAND2_X1
I52 (SEL_MUL MULP_4 n4_4 VDD VSS) NAND2_X1
I53 (SEL_DIV DIVQ_4 n4_5 VDD VSS) NAND2_X1
I54 (n4_0 n4_1 o4_0 VDD VSS) NAND2_X1
I55 (n4_2 n4_3 o4_1 VDD VSS) NAND2_X1
I56 (n4_4 n4_5 o4_2 VDD VSS) NAND2_X1
I57 (o4_0 o4_1 q4_1 VDD VSS) NOR2_X1
I58 (SEL_AS S_4 o4_2 q4_2 VDD VSS) AOI21_X1
I59 (q4_1 q4_2 Y_4 VDD VSS) NAND2_X1
I60 (SEL_AND AND_5 n5_0 VDD VSS) NAND2_X1
I61 (SEL_OR OR_5 n5_1 VDD VSS) NAND2_X1
I62 (SEL_XOR XOR_5 n5_2 VDD VSS) NAND2_X1
I63 (SEL_NOT NOT_5 n5_3 VDD VSS) NAND2_X1
I64 (SEL_MUL MULP_5 n5_4 VDD VSS) NAND2_X1
I65 (SEL_DIV DIVQ_5 n5_5 VDD VSS) NAND2_X1
I66 (n5_0 n5_1 o5_0 VDD VSS) NAND2_X1
I67 (n5_2 n5_3 o5_1 VDD VSS) NAND2_X1
I68 (n5_4 n5_5 o5_2 VDD VSS) NAND2_X1
I69 (o5_0 o5_1 q5_1 VDD VSS) NOR2_X1
I70 (SEL_AS S_5 o5_2 q5_2 VDD VSS) AOI21_X1
I71 (q5_1 q5_2 Y_5 VDD VSS) NAND2_X1
I72 (SEL_AND AND_6 n6_0 VDD VSS) NAND2_X1
I73 (SEL_OR OR_6 n6_1 VDD VSS) NAND2_X1
I74 (SEL_XOR XOR_6 n6_2 VDD VSS) NAND2_X1
I75 (SEL_NOT NOT_6 n6_3 VDD VSS) NAND2_X1
I76 (SEL_MUL MULP_6 n6_4 VDD VSS) NAND2_X1
I77 (SEL_DIV DIVQ_6 n6_5 VDD VSS) NAND2_X1
I78 (n6_0 n6_1 o6_0 VDD VSS) NAND2_X1
I79 (n6_2 n6_3 o6_1 VDD VSS) NAND2_X1
I80 (n6_4 n6_5 o6_2 VDD VSS) NAND2_X1
I81 (o6_0 o6_1 q6_1 VDD VSS) NOR2_X1
I82 (SEL_AS S_6 o6_2 q6_2 VDD VSS) AOI21_X1
I83 (q6_1 q6_2 Y_6 VDD VSS) NAND2_X1
I84 (SEL_AND AND_7 n7_0 VDD VSS) NAND2_X1
I85 (SEL_OR OR_7 n7_1 VDD VSS) NAND2_X1
I86 (SEL_XOR XOR_7 n7_2 VDD VSS) NAND2_X1
I87 (SEL_NOT NOT_7 n7_3 VDD VSS) NAND2_X1
I88 (SEL_MUL MULP_7 n7_4 VDD VSS) NAND2_X1
I89 (SEL_DIV DIVQ_7 n7_5 VDD VSS) NAND2_X1
I90 (n7_0 n7_1 o7_0 VDD VSS) NAND2_X1
I91 (n7_2 n7_3 o7_1 VDD VSS) NAND2_X1
I92 (n7_4 n7_5 o7_2 VDD VSS) NAND2_X1
I93 (o7_0 o7_1 q7_1 VDD VSS) NOR2_X1
I94 (SEL_AS S_7 o7_2 q7_2 VDD VSS) AOI21_X1
I95 (q7_1 q7_2 Y_7 VDD VSS) NAND2_X1
I96 (SEL_MUL MULP_8 hm8 VDD VSS) NAND2_X1
I97 (SEL_DIV DIVR_0 hd8 VDD VSS) NAND2_X1
I98 (hm8 hd8 Y_8 VDD VSS) NAND2_X1
I99 (SEL_MUL MULP_9 hm9 VDD VSS) NAND2_X1
I100 (SEL_DIV DIVR_1 hd9 VDD VSS) NAND2_X1
I101 (hm9 hd9 Y_9 VDD VSS) NAND2_X1
I102 (SEL_MUL MULP_10 hm10 VDD VSS) NAND2_X1
I103 (SEL_DIV DIVR_2 hd10 VDD VSS) NAND2_X1
I104 (hm10 hd10 Y_10 VDD VSS) NAND2_X1
I105 (SEL_MUL MULP_11 hm11 VDD VSS) NAND2_X1
I106 (SEL_DIV DIVR_3 hd11 VDD VSS) NAND2_X1
I107 (hm11 hd11 Y_11 VDD VSS) NAND2_X1
I108 (SEL_MUL MULP_12 hm12 VDD VSS) NAND2_X1
I109 (SEL_DIV DIVR_4 hd12 VDD VSS) NAND2_X1
I110 (hm12 hd12 Y_12 VDD VSS) NAND2_X1
I111 (SEL_MUL MULP_13 hm13 VDD VSS) NAND2_X1
I112 (SEL_DIV DIVR_5 hd13 VDD VSS) NAND2_X1
I113 (hm13 hd13 Y_13 VDD VSS) NAND2_X1
I114 (SEL_MUL MULP_14 hm14 VDD VSS) NAND2_X1
I115 (SEL_DIV DIVR_6 hd14 VDD VSS) NAND2_X1
I116 (hm14 hd14 Y_14 VDD VSS) NAND2_X1
I117 (SEL_MUL MULP_15 hm15 VDD VSS) NAND2_X1
I118 (SEL_DIV DIVR_7 hd15 VDD VSS) NAND2_X1
I119 (hm15 hd15 Y_15 VDD VSS) NAND2_X1
ends OUTMUX
