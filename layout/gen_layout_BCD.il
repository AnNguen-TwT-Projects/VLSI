;; layout/gen_layout_BCD.il -- sinh boi layout/gen_layout_cells.py, khong sua tay.
;; Chay trong VM qua layout/run_layout_A.sh (GEN=layout/gen_layout_BCD.il).
laErr = 0
procedure(laBox(cv lyr purp x1 y1 x2 y2)
  let((fig)
    fig = dbCreateRect(cv list(lyr purp) list(list(x1 y1) list(x2 y2)))
    unless(fig printf("LA_ERROR rect %s %s failed in %s\n" lyr purp cv~>cellName) laErr = laErr + 1)
    fig))
procedure(laPin(cv name dir x1 y1 x2 y2)
  let((fig net lb)
    fig = laBox(cv "Metal1" "pin" x1 y1 x2 y2)
    net = or(dbFindNetByName(cv name) dbCreateNet(cv name))
    unless(dbFindTermByName(cv name) dbCreateTerm(net name dir))
    dbCreatePin(net fig name)
    lb = car(errset(dbCreateLabel(cv list("Metal1" "label") list((x1 + x2) / 2.0 (y1 + y2) / 2.0)
                     name "centerCenter" "R0" "stick" 0.1)))
    unless(lb dbCreateLabel(cv list("Metal1" "pin") list((x1 + x2) / 2.0 (y1 + y2) / 2.0)
                     name "centerCenter" "R0" "stick" 0.1))))
procedure(laDraw(libName cellName w rects pins)
  let((lib cv)
    lib = ddGetObj(libName)
    unless(lib
      lib = ddCreateLib(libName strcat("./" libName))
      techBindTechFile(lib "gpdk090")
      printf("LA_LIB created %s\n" libName))
    cv = dbOpenCellViewByType(libName cellName "layout" "maskLayout" "w")
    foreach(r rects laBox(cv car(r) "drawing" nth(1 r) nth(2 r) nth(3 r) nth(4 r)))
    foreach(p pins laPin(cv car(p) cadr(p) nth(2 p) nth(3 p) nth(4 p) nth(5 p)))
    dbSave(cv)
    printf("LA_CELL %s/%s W=%.3f H=2.760 area=%.4f um2 shapes=%d\n" libName cellName w w * 2.76 length(rects))
    t))

procedure(laMain()
  ;; XOR2_X1: 12 T (sau khi chia finger), 17 cot
  laDraw("ALU_STUB_B" "XOR2_X1" 4.86
    list(list("Oxide" 0 0 4.86 0.24)
      list("Pimp" -0.02 -0.02 4.88 0.26)
      list("Oxide" 0 2.52 4.86 2.76)
      list("Nimp" -0.02 2.42 4.88 2.78)
      list("Nwell" -0.12 1.38 4.98 2.88)
      list("Nimp" 0 0.26 4.86 1)
      list("Pimp" 0 1.5 4.86 2.42)
      list("prBoundary" 0 0 4.86 2.76)
      list("Metal1" 0 0 4.86 0.24)
      list("Metal1" 0 2.52 4.86 2.76)
      list("Cont" 0.21 0.06 0.33 0.18)
      list("Cont" 0.21 2.58 0.33 2.7)
      list("Cont" 0.48 0.06 0.6 0.18)
      list("Cont" 0.48 2.58 0.6 2.7)
      list("Cont" 0.75 0.06 0.87 0.18)
      list("Cont" 0.75 2.58 0.87 2.7)
      list("Cont" 1.02 0.06 1.14 0.18)
      list("Cont" 1.02 2.58 1.14 2.7)
      list("Cont" 1.29 0.06 1.41 0.18)
      list("Cont" 1.29 2.58 1.41 2.7)
      list("Cont" 1.56 0.06 1.68 0.18)
      list("Cont" 1.56 2.58 1.68 2.7)
      list("Cont" 1.83 0.06 1.95 0.18)
      list("Cont" 1.83 2.58 1.95 2.7)
      list("Cont" 2.1 0.06 2.22 0.18)
      list("Cont" 2.1 2.58 2.22 2.7)
      list("Cont" 2.37 0.06 2.49 0.18)
      list("Cont" 2.37 2.58 2.49 2.7)
      list("Cont" 2.64 0.06 2.76 0.18)
      list("Cont" 2.64 2.58 2.76 2.7)
      list("Cont" 2.91 0.06 3.03 0.18)
      list("Cont" 2.91 2.58 3.03 2.7)
      list("Cont" 3.18 0.06 3.3 0.18)
      list("Cont" 3.18 2.58 3.3 2.7)
      list("Cont" 3.45 0.06 3.57 0.18)
      list("Cont" 3.45 2.58 3.57 2.7)
      list("Cont" 3.72 0.06 3.84 0.18)
      list("Cont" 3.72 2.58 3.84 2.7)
      list("Cont" 3.99 0.06 4.11 0.18)
      list("Cont" 3.99 2.58 4.11 2.7)
      list("Cont" 4.26 0.06 4.38 0.18)
      list("Cont" 4.26 2.58 4.38 2.7)
      list("Cont" 4.53 0.06 4.65 0.18)
      list("Cont" 4.53 2.58 4.65 2.7)
      list("Oxide" 0.15 0.52 0.39 0.76)
      list("Cont" 0.21 0.58 0.33 0.7)
      list("Oxide" 0.69 0.52 0.93 0.76)
      list("Cont" 0.75 0.58 0.87 0.7)
      list("Oxide" 1.23 0.52 1.47 0.76)
      list("Cont" 1.29 0.58 1.41 0.7)
      list("Oxide" 1.77 0.52 2.01 0.76)
      list("Oxide" 2.31 0.52 2.55 0.76)
      list("Cont" 2.37 0.58 2.49 0.7)
      list("Oxide" 2.85 0.52 3.09 0.76)
      list("Oxide" 3.39 0.52 3.63 0.76)
      list("Cont" 3.45 0.58 3.57 0.7)
      list("Oxide" 3.93 0.52 4.17 0.76)
      list("Cont" 3.99 0.58 4.11 0.7)
      list("Oxide" 4.47 0.52 4.71 0.76)
      list("Cont" 4.53 0.58 4.65 0.7)
      list("Oxide" 0.39 0.58 0.69 0.7)
      list("Oxide" 1.47 0.52 1.77 0.76)
      list("Oxide" 2.01 0.52 2.31 0.76)
      list("Oxide" 2.55 0.52 2.85 0.76)
      list("Oxide" 3.09 0.52 3.39 0.76)
      list("Oxide" 4.17 0.58 4.47 0.7)
      list("Oxide" 0.15 1.88 0.39 2.12)
      list("Cont" 0.21 1.94 0.33 2.06)
      list("Oxide" 0.69 1.88 0.93 2.12)
      list("Cont" 0.75 1.94 0.87 2.06)
      list("Oxide" 1.23 1.76 1.47 2.24)
      list("Cont" 1.29 1.94 1.41 2.06)
      list("Oxide" 1.77 1.76 2.01 2.24)
      list("Cont" 1.83 1.94 1.95 2.06)
      list("Oxide" 2.31 1.76 2.55 2.24)
      list("Cont" 2.37 1.94 2.49 2.06)
      list("Oxide" 2.85 1.76 3.09 2.24)
      list("Cont" 2.91 1.94 3.03 2.06)
      list("Oxide" 3.39 1.76 3.63 2.24)
      list("Cont" 3.45 1.94 3.57 2.06)
      list("Oxide" 3.93 1.88 4.17 2.12)
      list("Cont" 3.99 1.94 4.11 2.06)
      list("Oxide" 4.47 1.88 4.71 2.12)
      list("Cont" 4.53 1.94 4.65 2.06)
      list("Oxide" 0.39 1.88 0.69 2.12)
      list("Oxide" 1.47 1.76 1.77 2.24)
      list("Oxide" 2.01 1.76 2.31 2.24)
      list("Oxide" 2.55 1.76 2.85 2.24)
      list("Oxide" 3.09 1.76 3.39 2.24)
      list("Oxide" 4.17 1.88 4.47 2.12)
      list("Poly" 0.49 0.4 0.59 2.3)
      list("Poly" 0.44 1.2 0.64 1.44)
      list("Cont" 0.48 1.26 0.6 1.38)
      list("Poly" 1.57 0.34 1.67 2.42)
      list("Poly" 1.52 1.2 1.72 1.44)
      list("Cont" 1.56 1.26 1.68 1.38)
      list("Poly" 2.11 0.34 2.21 2.42)
      list("Poly" 2.06 1.2 2.26 1.44)
      list("Cont" 2.1 1.26 2.22 1.38)
      list("Poly" 2.65 0.34 2.75 2.42)
      list("Poly" 2.6 1.2 2.8 1.44)
      list("Cont" 2.64 1.26 2.76 1.38)
      list("Poly" 3.19 0.34 3.29 2.42)
      list("Poly" 3.14 1.2 3.34 1.44)
      list("Cont" 3.18 1.26 3.3 1.38)
      list("Poly" 4.27 0.4 4.37 2.3)
      list("Poly" 4.22 1.2 4.42 1.44)
      list("Cont" 4.26 1.26 4.38 1.38)
      list("Metal1" 0.195 0 0.345 0.76)
      list("Metal1" 1.275 0 1.425 0.76)
      list("Metal1" 3.435 0 3.585 0.76)
      list("Metal1" 3.975 0 4.125 0.76)
      list("Metal1" 0.735 1.88 0.885 2.76)
      list("Metal1" 2.895 1.88 3.045 2.76)
      list("Metal1" 4.515 1.88 4.665 2.76)
      list("Metal1" 0.465 1.11 0.615 1.59)
      list("Metal1" 3.165 1.11 3.315 1.59)
      list("Via1" 0.47 1.3 0.61 1.44)
      list("Via1" 3.17 1.3 3.31 1.44)
      list("Metal2" 0.41 1.295 3.37 1.445)
      list("Metal1" 4.515 0.52 4.665 1.21)
      list("Metal1" 3.975 0.95 4.125 2.12)
      list("Metal1" 2.085 0.95 2.235 1.44)
      list("Via1" 2.09 1.01 2.23 1.15)
      list("Via1" 3.98 1.01 4.12 1.15)
      list("Via1" 4.52 1.01 4.66 1.15)
      list("Metal2" 2.03 1.005 4.72 1.155)
      list("Metal1" 1.275 1.73 1.425 2.21)
      list("Metal1" 2.355 1.73 2.505 2.21)
      list("Metal1" 3.435 1.73 3.585 2.21)
      list("Via1" 1.28 1.88 1.42 2.02)
      list("Via1" 2.36 1.88 2.5 2.02)
      list("Via1" 3.44 1.88 3.58 2.02)
      list("Metal2" 1.22 1.875 3.64 2.025)
      list("Metal1" 2.625 1.2 2.775 1.79)
      list("Metal1" 4.245 1.2 4.395 1.79)
      list("Via1" 2.63 1.59 2.77 1.73)
      list("Via1" 4.25 1.59 4.39 1.73)
      list("Metal2" 2.57 1.585 4.45 1.735)
      list("Metal1" 0.735 0.52 0.885 1.21)
      list("Metal1" 0.195 0.95 0.345 2.12)
      list("Metal1" 1.545 0.95 1.695 1.44)
      list("Via1" 0.2 1.01 0.34 1.15)
      list("Via1" 0.74 1.01 0.88 1.15)
      list("Via1" 1.55 1.01 1.69 1.15)
      list("Metal2" 0.14 1.005 1.75 1.155)
      list("Metal1" 2.355 0.48 2.505 0.96)
      list("Metal1" 1.815 0.66 1.965 2.12)
      list("Via1" 1.82 0.72 1.96 0.86)
      list("Via1" 2.36 0.72 2.5 0.86)
      list("Metal2" 1.76 0.715 2.56 0.865))
    list(list("VSS" "inputOutput" 0 0 4.86 0.24)
      list("VDD" "inputOutput" 0 2.52 4.86 2.76)
      list("A" "input" 2.625 1.2 2.775 1.44)
      list("B" "input" 0.465 1.2 0.615 1.44)
      list("Y" "output" 1.815 1.88 1.965 2.12)))
  ;; XNOR2_X1: 12 T (sau khi chia finger), 17 cot
  laDraw("ALU_STUB_B" "XNOR2_X1" 4.86
    list(list("Oxide" 0 0 4.86 0.24)
      list("Pimp" -0.02 -0.02 4.88 0.26)
      list("Oxide" 0 2.52 4.86 2.76)
      list("Nimp" -0.02 2.42 4.88 2.78)
      list("Nwell" -0.12 1.38 4.98 2.88)
      list("Nimp" 0 0.26 4.86 1)
      list("Pimp" 0 1.5 4.86 2.42)
      list("prBoundary" 0 0 4.86 2.76)
      list("Metal1" 0 0 4.86 0.24)
      list("Metal1" 0 2.52 4.86 2.76)
      list("Cont" 0.21 0.06 0.33 0.18)
      list("Cont" 0.21 2.58 0.33 2.7)
      list("Cont" 0.48 0.06 0.6 0.18)
      list("Cont" 0.48 2.58 0.6 2.7)
      list("Cont" 0.75 0.06 0.87 0.18)
      list("Cont" 0.75 2.58 0.87 2.7)
      list("Cont" 1.02 0.06 1.14 0.18)
      list("Cont" 1.02 2.58 1.14 2.7)
      list("Cont" 1.29 0.06 1.41 0.18)
      list("Cont" 1.29 2.58 1.41 2.7)
      list("Cont" 1.56 0.06 1.68 0.18)
      list("Cont" 1.56 2.58 1.68 2.7)
      list("Cont" 1.83 0.06 1.95 0.18)
      list("Cont" 1.83 2.58 1.95 2.7)
      list("Cont" 2.1 0.06 2.22 0.18)
      list("Cont" 2.1 2.58 2.22 2.7)
      list("Cont" 2.37 0.06 2.49 0.18)
      list("Cont" 2.37 2.58 2.49 2.7)
      list("Cont" 2.64 0.06 2.76 0.18)
      list("Cont" 2.64 2.58 2.76 2.7)
      list("Cont" 2.91 0.06 3.03 0.18)
      list("Cont" 2.91 2.58 3.03 2.7)
      list("Cont" 3.18 0.06 3.3 0.18)
      list("Cont" 3.18 2.58 3.3 2.7)
      list("Cont" 3.45 0.06 3.57 0.18)
      list("Cont" 3.45 2.58 3.57 2.7)
      list("Cont" 3.72 0.06 3.84 0.18)
      list("Cont" 3.72 2.58 3.84 2.7)
      list("Cont" 3.99 0.06 4.11 0.18)
      list("Cont" 3.99 2.58 4.11 2.7)
      list("Cont" 4.26 0.06 4.38 0.18)
      list("Cont" 4.26 2.58 4.38 2.7)
      list("Cont" 4.53 0.06 4.65 0.18)
      list("Cont" 4.53 2.58 4.65 2.7)
      list("Oxide" 0.15 0.52 0.39 0.76)
      list("Cont" 0.21 0.58 0.33 0.7)
      list("Oxide" 0.69 0.52 0.93 0.76)
      list("Cont" 0.75 0.58 0.87 0.7)
      list("Oxide" 1.23 0.52 1.47 0.76)
      list("Cont" 1.29 0.58 1.41 0.7)
      list("Oxide" 1.77 0.52 2.01 0.76)
      list("Oxide" 2.31 0.52 2.55 0.76)
      list("Cont" 2.37 0.58 2.49 0.7)
      list("Oxide" 2.85 0.52 3.09 0.76)
      list("Oxide" 3.39 0.52 3.63 0.76)
      list("Cont" 3.45 0.58 3.57 0.7)
      list("Oxide" 3.93 0.52 4.17 0.76)
      list("Cont" 3.99 0.58 4.11 0.7)
      list("Oxide" 4.47 0.52 4.71 0.76)
      list("Cont" 4.53 0.58 4.65 0.7)
      list("Oxide" 0.39 0.58 0.69 0.7)
      list("Oxide" 1.47 0.52 1.77 0.76)
      list("Oxide" 2.01 0.52 2.31 0.76)
      list("Oxide" 2.55 0.52 2.85 0.76)
      list("Oxide" 3.09 0.52 3.39 0.76)
      list("Oxide" 4.17 0.58 4.47 0.7)
      list("Oxide" 0.15 1.88 0.39 2.12)
      list("Cont" 0.21 1.94 0.33 2.06)
      list("Oxide" 0.69 1.88 0.93 2.12)
      list("Cont" 0.75 1.94 0.87 2.06)
      list("Oxide" 1.23 1.76 1.47 2.24)
      list("Cont" 1.29 1.94 1.41 2.06)
      list("Oxide" 1.77 1.76 2.01 2.24)
      list("Cont" 1.83 1.94 1.95 2.06)
      list("Oxide" 2.31 1.76 2.55 2.24)
      list("Cont" 2.37 1.94 2.49 2.06)
      list("Oxide" 2.85 1.76 3.09 2.24)
      list("Cont" 2.91 1.94 3.03 2.06)
      list("Oxide" 3.39 1.76 3.63 2.24)
      list("Cont" 3.45 1.94 3.57 2.06)
      list("Oxide" 3.93 1.88 4.17 2.12)
      list("Cont" 3.99 1.94 4.11 2.06)
      list("Oxide" 4.47 1.88 4.71 2.12)
      list("Cont" 4.53 1.94 4.65 2.06)
      list("Oxide" 0.39 1.88 0.69 2.12)
      list("Oxide" 1.47 1.76 1.77 2.24)
      list("Oxide" 2.01 1.76 2.31 2.24)
      list("Oxide" 2.55 1.76 2.85 2.24)
      list("Oxide" 3.09 1.76 3.39 2.24)
      list("Oxide" 4.17 1.88 4.47 2.12)
      list("Poly" 0.49 0.4 0.59 2.3)
      list("Poly" 0.44 1.2 0.64 1.44)
      list("Cont" 0.48 1.26 0.6 1.38)
      list("Poly" 1.57 0.34 1.67 2.42)
      list("Poly" 1.52 1.2 1.72 1.44)
      list("Cont" 1.56 1.26 1.68 1.38)
      list("Poly" 2.11 0.34 2.21 2.42)
      list("Poly" 2.06 1.2 2.26 1.44)
      list("Cont" 2.1 1.26 2.22 1.38)
      list("Poly" 2.65 0.34 2.75 2.42)
      list("Poly" 2.6 1.2 2.8 1.44)
      list("Cont" 2.64 1.26 2.76 1.38)
      list("Poly" 3.19 0.34 3.29 2.42)
      list("Poly" 3.14 1.2 3.34 1.44)
      list("Cont" 3.18 1.26 3.3 1.38)
      list("Poly" 4.27 0.4 4.37 2.3)
      list("Poly" 4.22 1.2 4.42 1.44)
      list("Cont" 4.26 1.26 4.38 1.38)
      list("Metal1" 0.195 0 0.345 0.76)
      list("Metal1" 1.275 0 1.425 0.76)
      list("Metal1" 3.435 0 3.585 0.76)
      list("Metal1" 3.975 0 4.125 0.76)
      list("Metal1" 0.735 1.88 0.885 2.76)
      list("Metal1" 2.895 1.88 3.045 2.76)
      list("Metal1" 4.515 1.88 4.665 2.76)
      list("Metal1" 0.735 0.52 0.885 1.5)
      list("Metal1" 0.195 1.24 0.345 2.12)
      list("Metal1" 3.165 1.11 3.315 1.59)
      list("Via1" 0.2 1.3 0.34 1.44)
      list("Via1" 0.74 1.3 0.88 1.44)
      list("Via1" 3.17 1.3 3.31 1.44)
      list("Metal2" 0.14 1.295 3.37 1.445)
      list("Metal1" 4.515 0.52 4.665 1.21)
      list("Metal1" 3.975 0.95 4.125 2.12)
      list("Metal1" 2.085 0.95 2.235 1.44)
      list("Via1" 2.09 1.01 2.23 1.15)
      list("Via1" 3.98 1.01 4.12 1.15)
      list("Via1" 4.52 1.01 4.66 1.15)
      list("Metal2" 2.03 1.005 4.72 1.155)
      list("Metal1" 1.275 1.73 1.425 2.21)
      list("Metal1" 2.355 1.73 2.505 2.21)
      list("Metal1" 3.435 1.73 3.585 2.21)
      list("Via1" 1.28 1.88 1.42 2.02)
      list("Via1" 2.36 1.88 2.5 2.02)
      list("Via1" 3.44 1.88 3.58 2.02)
      list("Metal2" 1.22 1.875 3.64 2.025)
      list("Metal1" 2.625 1.2 2.775 1.79)
      list("Metal1" 4.245 1.2 4.395 1.79)
      list("Via1" 2.63 1.59 2.77 1.73)
      list("Via1" 4.25 1.59 4.39 1.73)
      list("Metal2" 2.57 1.585 4.45 1.735)
      list("Metal1" 0.465 0.95 0.615 1.44)
      list("Metal1" 1.545 0.95 1.695 1.44)
      list("Via1" 0.47 1.01 0.61 1.15)
      list("Via1" 1.55 1.01 1.69 1.15)
      list("Metal2" 0.41 1.005 1.75 1.155)
      list("Metal1" 2.355 0.48 2.505 0.96)
      list("Metal1" 1.815 0.66 1.965 2.12)
      list("Via1" 1.82 0.72 1.96 0.86)
      list("Via1" 2.36 0.72 2.5 0.86)
      list("Metal2" 1.76 0.715 2.56 0.865))
    list(list("VSS" "inputOutput" 0 0 4.86 0.24)
      list("VDD" "inputOutput" 0 2.52 4.86 2.76)
      list("A" "input" 2.625 1.2 2.775 1.44)
      list("B" "input" 0.465 1.2 0.615 1.44)
      list("Y" "output" 1.815 1.88 1.965 2.12)))
  ;; BOOTH_ENC: 28 T (sau khi chia finger), 39 cot
  laDraw("ALU_CELLS_B" "BOOTH_ENC" 10.8
    list(list("Oxide" 0 0 10.8 0.24)
      list("Pimp" -0.02 -0.02 10.82 0.26)
      list("Oxide" 0 2.52 10.8 2.76)
      list("Nimp" -0.02 2.42 10.82 2.78)
      list("Nwell" -0.12 1.38 10.92 2.88)
      list("Nimp" 0 0.26 10.8 1)
      list("Pimp" 0 1.5 10.8 2.42)
      list("prBoundary" 0 0 10.8 2.76)
      list("Metal1" 0 0 10.8 0.24)
      list("Metal1" 0 2.52 10.8 2.76)
      list("Cont" 0.21 0.06 0.33 0.18)
      list("Cont" 0.21 2.58 0.33 2.7)
      list("Cont" 0.48 0.06 0.6 0.18)
      list("Cont" 0.48 2.58 0.6 2.7)
      list("Cont" 0.75 0.06 0.87 0.18)
      list("Cont" 0.75 2.58 0.87 2.7)
      list("Cont" 1.02 0.06 1.14 0.18)
      list("Cont" 1.02 2.58 1.14 2.7)
      list("Cont" 1.29 0.06 1.41 0.18)
      list("Cont" 1.29 2.58 1.41 2.7)
      list("Cont" 1.56 0.06 1.68 0.18)
      list("Cont" 1.56 2.58 1.68 2.7)
      list("Cont" 1.83 0.06 1.95 0.18)
      list("Cont" 1.83 2.58 1.95 2.7)
      list("Cont" 2.1 0.06 2.22 0.18)
      list("Cont" 2.1 2.58 2.22 2.7)
      list("Cont" 2.37 0.06 2.49 0.18)
      list("Cont" 2.37 2.58 2.49 2.7)
      list("Cont" 2.64 0.06 2.76 0.18)
      list("Cont" 2.64 2.58 2.76 2.7)
      list("Cont" 2.91 0.06 3.03 0.18)
      list("Cont" 2.91 2.58 3.03 2.7)
      list("Cont" 3.18 0.06 3.3 0.18)
      list("Cont" 3.18 2.58 3.3 2.7)
      list("Cont" 3.45 0.06 3.57 0.18)
      list("Cont" 3.45 2.58 3.57 2.7)
      list("Cont" 3.72 0.06 3.84 0.18)
      list("Cont" 3.72 2.58 3.84 2.7)
      list("Cont" 3.99 0.06 4.11 0.18)
      list("Cont" 3.99 2.58 4.11 2.7)
      list("Cont" 4.26 0.06 4.38 0.18)
      list("Cont" 4.26 2.58 4.38 2.7)
      list("Cont" 4.53 0.06 4.65 0.18)
      list("Cont" 4.53 2.58 4.65 2.7)
      list("Cont" 4.8 0.06 4.92 0.18)
      list("Cont" 4.8 2.58 4.92 2.7)
      list("Cont" 5.07 0.06 5.19 0.18)
      list("Cont" 5.07 2.58 5.19 2.7)
      list("Cont" 5.34 0.06 5.46 0.18)
      list("Cont" 5.34 2.58 5.46 2.7)
      list("Cont" 5.61 0.06 5.73 0.18)
      list("Cont" 5.61 2.58 5.73 2.7)
      list("Cont" 5.88 0.06 6 0.18)
      list("Cont" 5.88 2.58 6 2.7)
      list("Cont" 6.15 0.06 6.27 0.18)
      list("Cont" 6.15 2.58 6.27 2.7)
      list("Cont" 6.42 0.06 6.54 0.18)
      list("Cont" 6.42 2.58 6.54 2.7)
      list("Cont" 6.69 0.06 6.81 0.18)
      list("Cont" 6.69 2.58 6.81 2.7)
      list("Cont" 6.96 0.06 7.08 0.18)
      list("Cont" 6.96 2.58 7.08 2.7)
      list("Cont" 7.23 0.06 7.35 0.18)
      list("Cont" 7.23 2.58 7.35 2.7)
      list("Cont" 7.5 0.06 7.62 0.18)
      list("Cont" 7.5 2.58 7.62 2.7)
      list("Cont" 7.77 0.06 7.89 0.18)
      list("Cont" 7.77 2.58 7.89 2.7)
      list("Cont" 8.04 0.06 8.16 0.18)
      list("Cont" 8.04 2.58 8.16 2.7)
      list("Cont" 8.31 0.06 8.43 0.18)
      list("Cont" 8.31 2.58 8.43 2.7)
      list("Cont" 8.58 0.06 8.7 0.18)
      list("Cont" 8.58 2.58 8.7 2.7)
      list("Cont" 8.85 0.06 8.97 0.18)
      list("Cont" 8.85 2.58 8.97 2.7)
      list("Cont" 9.12 0.06 9.24 0.18)
      list("Cont" 9.12 2.58 9.24 2.7)
      list("Cont" 9.39 0.06 9.51 0.18)
      list("Cont" 9.39 2.58 9.51 2.7)
      list("Cont" 9.66 0.06 9.78 0.18)
      list("Cont" 9.66 2.58 9.78 2.7)
      list("Cont" 9.93 0.06 10.05 0.18)
      list("Cont" 9.93 2.58 10.05 2.7)
      list("Cont" 10.2 0.06 10.32 0.18)
      list("Cont" 10.2 2.58 10.32 2.7)
      list("Cont" 10.47 0.06 10.59 0.18)
      list("Cont" 10.47 2.58 10.59 2.7)
      list("Oxide" 0.15 0.52 0.39 0.76)
      list("Cont" 0.21 0.58 0.33 0.7)
      list("Oxide" 0.69 0.52 0.93 0.76)
      list("Cont" 0.75 0.58 0.87 0.7)
      list("Oxide" 1.23 0.52 1.47 0.76)
      list("Cont" 1.29 0.58 1.41 0.7)
      list("Oxide" 1.77 0.52 2.01 0.76)
      list("Oxide" 2.31 0.52 2.55 0.76)
      list("Cont" 2.37 0.58 2.49 0.7)
      list("Oxide" 2.85 0.52 3.09 0.76)
      list("Oxide" 3.39 0.52 3.63 0.76)
      list("Cont" 3.45 0.58 3.57 0.7)
      list("Oxide" 3.93 0.52 4.17 0.76)
      list("Cont" 3.99 0.58 4.11 0.7)
      list("Oxide" 4.47 0.52 4.71 0.76)
      list("Cont" 4.53 0.58 4.65 0.7)
      list("Oxide" 5.01 0.52 5.25 0.76)
      list("Cont" 5.07 0.58 5.19 0.7)
      list("Oxide" 5.55 0.52 5.79 0.76)
      list("Cont" 5.61 0.58 5.73 0.7)
      list("Oxide" 6.09 0.52 6.33 0.76)
      list("Cont" 6.15 0.58 6.27 0.7)
      list("Oxide" 6.63 0.52 6.87 0.76)
      list("Cont" 6.69 0.58 6.81 0.7)
      list("Oxide" 7.17 0.52 7.41 0.76)
      list("Oxide" 7.71 0.52 7.95 0.76)
      list("Cont" 7.77 0.58 7.89 0.7)
      list("Oxide" 8.25 0.52 8.49 0.76)
      list("Cont" 8.31 0.58 8.43 0.7)
      list("Oxide" 8.79 0.52 9.03 0.76)
      list("Cont" 8.85 0.58 8.97 0.7)
      list("Oxide" 9.33 0.52 9.57 0.76)
      list("Cont" 9.39 0.58 9.51 0.7)
      list("Oxide" 9.87 0.52 10.11 0.76)
      list("Cont" 9.93 0.58 10.05 0.7)
      list("Oxide" 10.41 0.52 10.65 0.76)
      list("Cont" 10.47 0.58 10.59 0.7)
      list("Oxide" 0.39 0.58 0.69 0.7)
      list("Oxide" 1.47 0.52 1.77 0.76)
      list("Oxide" 2.01 0.52 2.31 0.76)
      list("Oxide" 2.55 0.52 2.85 0.76)
      list("Oxide" 3.09 0.52 3.39 0.76)
      list("Oxide" 4.17 0.58 4.47 0.7)
      list("Oxide" 4.71 0.58 5.01 0.7)
      list("Oxide" 5.25 0.58 5.55 0.7)
      list("Oxide" 6.33 0.52 6.63 0.76)
      list("Oxide" 6.87 0.52 7.17 0.76)
      list("Oxide" 7.41 0.52 7.71 0.76)
      list("Oxide" 7.95 0.52 8.25 0.76)
      list("Oxide" 9.03 0.58 9.33 0.7)
      list("Oxide" 10.11 0.58 10.41 0.7)
      list("Oxide" 0.15 1.88 0.39 2.12)
      list("Cont" 0.21 1.94 0.33 2.06)
      list("Oxide" 0.69 1.88 0.93 2.12)
      list("Cont" 0.75 1.94 0.87 2.06)
      list("Oxide" 1.23 1.76 1.47 2.24)
      list("Cont" 1.29 1.94 1.41 2.06)
      list("Oxide" 1.77 1.76 2.01 2.24)
      list("Cont" 1.83 1.94 1.95 2.06)
      list("Oxide" 2.31 1.76 2.55 2.24)
      list("Cont" 2.37 1.94 2.49 2.06)
      list("Oxide" 2.85 1.76 3.09 2.24)
      list("Cont" 2.91 1.94 3.03 2.06)
      list("Oxide" 3.39 1.76 3.63 2.24)
      list("Cont" 3.45 1.94 3.57 2.06)
      list("Oxide" 3.93 1.76 4.17 2.24)
      list("Cont" 3.99 1.94 4.11 2.06)
      list("Oxide" 4.47 1.76 4.71 2.24)
      list("Oxide" 5.01 1.76 5.25 2.24)
      list("Cont" 5.07 1.94 5.19 2.06)
      list("Oxide" 5.55 1.88 5.79 2.12)
      list("Cont" 5.61 1.94 5.73 2.06)
      list("Oxide" 6.09 1.76 6.33 2.24)
      list("Cont" 6.15 1.94 6.27 2.06)
      list("Oxide" 6.63 1.76 6.87 2.24)
      list("Cont" 6.69 1.94 6.81 2.06)
      list("Oxide" 7.17 1.76 7.41 2.24)
      list("Cont" 7.23 1.94 7.35 2.06)
      list("Oxide" 7.71 1.76 7.95 2.24)
      list("Cont" 7.77 1.94 7.89 2.06)
      list("Oxide" 8.25 1.76 8.49 2.24)
      list("Cont" 8.31 1.94 8.43 2.06)
      list("Oxide" 8.79 1.88 9.03 2.12)
      list("Cont" 8.85 1.94 8.97 2.06)
      list("Oxide" 9.33 1.88 9.57 2.12)
      list("Cont" 9.39 1.94 9.51 2.06)
      list("Oxide" 9.87 1.88 10.11 2.12)
      list("Cont" 9.93 1.94 10.05 2.06)
      list("Oxide" 10.41 1.88 10.65 2.12)
      list("Cont" 10.47 1.94 10.59 2.06)
      list("Oxide" 0.39 1.88 0.69 2.12)
      list("Oxide" 1.47 1.76 1.77 2.24)
      list("Oxide" 2.01 1.76 2.31 2.24)
      list("Oxide" 2.55 1.76 2.85 2.24)
      list("Oxide" 3.09 1.76 3.39 2.24)
      list("Oxide" 4.17 1.76 4.47 2.24)
      list("Oxide" 4.71 1.76 5.01 2.24)
      list("Oxide" 5.25 1.88 5.55 2.12)
      list("Oxide" 6.33 1.76 6.63 2.24)
      list("Oxide" 6.87 1.76 7.17 2.24)
      list("Oxide" 7.41 1.76 7.71 2.24)
      list("Oxide" 7.95 1.76 8.25 2.24)
      list("Oxide" 9.03 1.88 9.33 2.12)
      list("Oxide" 10.11 1.88 10.41 2.12)
      list("Poly" 0.49 0.4 0.59 2.3)
      list("Poly" 0.44 1.2 0.64 1.44)
      list("Cont" 0.48 1.26 0.6 1.38)
      list("Poly" 1.57 0.34 1.67 2.42)
      list("Poly" 1.52 1.2 1.72 1.44)
      list("Cont" 1.56 1.26 1.68 1.38)
      list("Poly" 2.11 0.34 2.21 2.42)
      list("Poly" 2.06 1.2 2.26 1.44)
      list("Cont" 2.1 1.26 2.22 1.38)
      list("Poly" 2.65 0.34 2.75 2.42)
      list("Poly" 2.6 1.2 2.8 1.44)
      list("Cont" 2.64 1.26 2.76 1.38)
      list("Poly" 3.19 0.34 3.29 2.42)
      list("Poly" 3.14 1.2 3.34 1.44)
      list("Cont" 3.18 1.26 3.3 1.38)
      list("Poly" 4.27 0.4 4.37 2.42)
      list("Poly" 4.22 1.2 4.42 1.44)
      list("Cont" 4.26 1.26 4.38 1.38)
      list("Poly" 4.81 0.4 4.91 2.42)
      list("Poly" 4.76 1.2 4.96 1.44)
      list("Cont" 4.8 1.26 4.92 1.38)
      list("Poly" 5.35 0.4 5.45 2.3)
      list("Poly" 5.3 1.2 5.5 1.44)
      list("Cont" 5.34 1.26 5.46 1.38)
      list("Poly" 6.43 0.34 6.53 2.42)
      list("Poly" 6.38 1.2 6.58 1.44)
      list("Cont" 6.42 1.26 6.54 1.38)
      list("Poly" 6.97 0.34 7.07 2.42)
      list("Poly" 6.92 1.2 7.12 1.44)
      list("Cont" 6.96 1.26 7.08 1.38)
      list("Poly" 7.51 0.34 7.61 2.42)
      list("Poly" 7.46 1.2 7.66 1.44)
      list("Cont" 7.5 1.26 7.62 1.38)
      list("Poly" 8.05 0.34 8.15 2.42)
      list("Poly" 8 1.2 8.2 1.44)
      list("Cont" 8.04 1.26 8.16 1.38)
      list("Poly" 9.13 0.4 9.23 2.3)
      list("Poly" 9.08 1.2 9.28 1.44)
      list("Cont" 9.12 1.26 9.24 1.38)
      list("Poly" 10.21 0.4 10.31 2.3)
      list("Poly" 10.16 1.2 10.36 1.44)
      list("Cont" 10.2 1.26 10.32 1.38)
      list("Metal1" 0.195 0 0.345 0.76)
      list("Metal1" 0.195 1.88 0.345 2.76)
      list("Metal1" 2.355 0 2.505 0.76)
      list("Metal1" 3.975 0 4.125 0.76)
      list("Metal1" 5.055 0 5.205 0.76)
      list("Metal1" 5.055 1.88 5.205 2.76)
      list("Metal1" 7.755 0 7.905 0.76)
      list("Metal1" 8.835 0 8.985 0.76)
      list("Metal1" 10.455 0 10.605 0.76)
      list("Metal1" 2.895 1.88 3.045 2.76)
      list("Metal1" 6.135 1.88 6.285 2.76)
      list("Metal1" 8.295 1.88 8.445 2.76)
      list("Metal1" 9.375 1.88 9.525 2.76)
      list("Metal1" 9.915 1.88 10.065 2.76)
      list("Metal1" 0.735 0.52 0.885 2.12)
      list("Metal1" 1.545 1.11 1.695 1.59)
      list("Via1" 0.74 1.3 0.88 1.44)
      list("Via1" 1.55 1.3 1.69 1.44)
      list("Metal2" 0.68 1.295 1.75 1.445)
      list("Metal1" 0.465 0.95 0.615 1.44)
      list("Metal1" 3.165 0.95 3.315 1.44)
      list("Via1" 0.47 1.01 0.61 1.15)
      list("Via1" 3.17 1.01 3.31 1.15)
      list("Metal2" 0.41 1.005 3.37 1.155)
      list("Metal1" 4.515 0.52 4.665 1.5)
      list("Metal1" 3.975 1.24 4.125 2.12)
      list("Via1" 3.98 1.3 4.12 1.44)
      list("Via1" 4.52 1.3 4.66 1.44)
      list("Metal2" 3.92 1.295 4.72 1.445)
      list("Metal1" 6.675 1.73 6.825 2.21)
      list("Metal1" 7.755 1.73 7.905 2.21)
      list("Via1" 6.68 1.88 6.82 2.02)
      list("Via1" 7.76 1.88 7.9 2.02)
      list("Metal2" 6.62 1.875 7.96 2.025)
      list("Metal1" 6.135 0.36 6.285 0.84)
      list("Metal1" 8.295 0.36 8.445 0.84)
      list("Via1" 6.14 0.43 6.28 0.57)
      list("Via1" 8.3 0.43 8.44 0.57)
      list("Metal2" 6.08 0.425 8.5 0.575)
      list("Metal1" 8.025 1.2 8.175 1.79)
      list("Metal1" 10.185 1.2 10.335 1.79)
      list("Via1" 8.03 1.59 8.17 1.73)
      list("Via1" 10.19 1.59 10.33 1.73)
      list("Metal2" 7.97 1.585 10.39 1.735)
      list("Metal1" 9.915 0.52 10.065 1.5)
      list("Metal1" 10.455 1.24 10.605 2.12)
      list("Metal1" 7.485 1.11 7.635 1.59)
      list("Via1" 7.49 1.3 7.63 1.44)
      list("Via1" 9.92 1.3 10.06 1.44)
      list("Via1" 10.46 1.3 10.6 1.44)
      list("Metal2" 7.43 1.295 10.66 1.445)
      list("Metal1" 6.675 0.48 6.825 0.96)
      list("Metal1" 7.215 0.66 7.365 2.12)
      list("Metal1" 4.245 0.66 4.395 1.44)
      list("Via1" 4.25 0.72 4.39 0.86)
      list("Via1" 6.68 0.72 6.82 0.86)
      list("Via1" 7.22 0.72 7.36 0.86)
      list("Metal2" 4.19 0.715 7.42 0.865)
      list("Metal1" 5.595 0.52 5.745 2.12)
      list("Metal1" 2.625 1.11 2.775 1.59)
      list("Via1" 2.63 1.3 2.77 1.44)
      list("Via2" 2.63 1.3 2.77 1.44)
      list("Via1" 5.6 1.3 5.74 1.44)
      list("Via2" 5.6 1.3 5.74 1.44)
      list("Metal3" 2.57 1.295 5.8 1.445)
      list("Metal2" 2.43 1.295 2.97 1.445)
      list("Metal2" 5.4 1.295 5.94 1.445)
      list("Metal1" 2.085 1.2 2.235 2.37)
      list("Metal1" 5.325 1.2 5.475 2.37)
      list("Metal1" 6.405 1.2 6.555 2.37)
      list("Metal1" 9.105 1.2 9.255 2.37)
      list("Via1" 2.09 2.17 2.23 2.31)
      list("Via1" 5.33 2.17 5.47 2.31)
      list("Via1" 6.41 2.17 6.55 2.31)
      list("Via1" 9.11 2.17 9.25 2.31)
      list("Metal2" 2.03 2.165 9.31 2.315)
      list("Metal1" 1.275 1.73 1.425 2.21)
      list("Metal1" 2.355 1.73 2.505 2.21)
      list("Metal1" 3.435 1.73 3.585 2.21)
      list("Via1" 1.28 1.88 1.42 2.02)
      list("Via1" 2.36 1.88 2.5 2.02)
      list("Via1" 3.44 1.88 3.58 2.02)
      list("Metal2" 1.22 1.875 3.64 2.025)
      list("Metal1" 9.375 0.52 9.525 1.21)
      list("Metal1" 8.835 0.95 8.985 2.12)
      list("Metal1" 6.945 0.95 7.095 1.44)
      list("Via1" 6.95 1.01 7.09 1.15)
      list("Via1" 8.84 1.01 8.98 1.15)
      list("Via1" 9.38 1.01 9.52 1.15)
      list("Metal2" 6.89 1.005 9.58 1.155)
      list("Metal1" 1.275 0.36 1.425 0.84)
      list("Metal1" 3.435 0.36 3.585 0.84)
      list("Metal1" 1.815 0.37 1.965 2.12)
      list("Metal1" 4.785 0.37 4.935 1.44)
      list("Via1" 1.28 0.43 1.42 0.57)
      list("Via1" 1.82 0.43 1.96 0.57)
      list("Via1" 3.44 0.43 3.58 0.57)
      list("Via1" 4.79 0.43 4.93 0.57)
      list("Metal2" 1.22 0.425 4.99 0.575))
    list(list("VSS" "inputOutput" 0 0 10.8 0.24)
      list("VDD" "inputOutput" 0 2.52 10.8 2.76)
      list("X2" "input" 0.465 1.2 0.615 1.44)
      list("X1" "input" 2.085 1.2 2.235 1.44)
      list("X0" "input" 8.025 1.2 8.175 1.44)
      list("ONE" "output" 4.245 1.2 4.395 1.44)
      list("TWO" "output" 3.975 1.88 4.125 2.12)))
  ;; BOOTH_SEL: 20 T (sau khi chia finger), 27 cot
  laDraw("ALU_CELLS_B" "BOOTH_SEL" 7.56
    list(list("Oxide" 0 0 7.56 0.24)
      list("Pimp" -0.02 -0.02 7.58 0.26)
      list("Oxide" 0 2.52 7.56 2.76)
      list("Nimp" -0.02 2.42 7.58 2.78)
      list("Nwell" -0.12 1.38 7.68 2.88)
      list("Nimp" 0 0.26 7.56 1)
      list("Pimp" 0 1.5 7.56 2.42)
      list("prBoundary" 0 0 7.56 2.76)
      list("Metal1" 0 0 7.56 0.24)
      list("Metal1" 0 2.52 7.56 2.76)
      list("Cont" 0.21 0.06 0.33 0.18)
      list("Cont" 0.21 2.58 0.33 2.7)
      list("Cont" 0.48 0.06 0.6 0.18)
      list("Cont" 0.48 2.58 0.6 2.7)
      list("Cont" 0.75 0.06 0.87 0.18)
      list("Cont" 0.75 2.58 0.87 2.7)
      list("Cont" 1.02 0.06 1.14 0.18)
      list("Cont" 1.02 2.58 1.14 2.7)
      list("Cont" 1.29 0.06 1.41 0.18)
      list("Cont" 1.29 2.58 1.41 2.7)
      list("Cont" 1.56 0.06 1.68 0.18)
      list("Cont" 1.56 2.58 1.68 2.7)
      list("Cont" 1.83 0.06 1.95 0.18)
      list("Cont" 1.83 2.58 1.95 2.7)
      list("Cont" 2.1 0.06 2.22 0.18)
      list("Cont" 2.1 2.58 2.22 2.7)
      list("Cont" 2.37 0.06 2.49 0.18)
      list("Cont" 2.37 2.58 2.49 2.7)
      list("Cont" 2.64 0.06 2.76 0.18)
      list("Cont" 2.64 2.58 2.76 2.7)
      list("Cont" 2.91 0.06 3.03 0.18)
      list("Cont" 2.91 2.58 3.03 2.7)
      list("Cont" 3.18 0.06 3.3 0.18)
      list("Cont" 3.18 2.58 3.3 2.7)
      list("Cont" 3.45 0.06 3.57 0.18)
      list("Cont" 3.45 2.58 3.57 2.7)
      list("Cont" 3.72 0.06 3.84 0.18)
      list("Cont" 3.72 2.58 3.84 2.7)
      list("Cont" 3.99 0.06 4.11 0.18)
      list("Cont" 3.99 2.58 4.11 2.7)
      list("Cont" 4.26 0.06 4.38 0.18)
      list("Cont" 4.26 2.58 4.38 2.7)
      list("Cont" 4.53 0.06 4.65 0.18)
      list("Cont" 4.53 2.58 4.65 2.7)
      list("Cont" 4.8 0.06 4.92 0.18)
      list("Cont" 4.8 2.58 4.92 2.7)
      list("Cont" 5.07 0.06 5.19 0.18)
      list("Cont" 5.07 2.58 5.19 2.7)
      list("Cont" 5.34 0.06 5.46 0.18)
      list("Cont" 5.34 2.58 5.46 2.7)
      list("Cont" 5.61 0.06 5.73 0.18)
      list("Cont" 5.61 2.58 5.73 2.7)
      list("Cont" 5.88 0.06 6 0.18)
      list("Cont" 5.88 2.58 6 2.7)
      list("Cont" 6.15 0.06 6.27 0.18)
      list("Cont" 6.15 2.58 6.27 2.7)
      list("Cont" 6.42 0.06 6.54 0.18)
      list("Cont" 6.42 2.58 6.54 2.7)
      list("Cont" 6.69 0.06 6.81 0.18)
      list("Cont" 6.69 2.58 6.81 2.7)
      list("Cont" 6.96 0.06 7.08 0.18)
      list("Cont" 6.96 2.58 7.08 2.7)
      list("Cont" 7.23 0.06 7.35 0.18)
      list("Cont" 7.23 2.58 7.35 2.7)
      list("Oxide" 0.15 0.52 0.39 0.76)
      list("Cont" 0.21 0.58 0.33 0.7)
      list("Oxide" 0.69 0.52 0.93 0.76)
      list("Cont" 0.75 0.58 0.87 0.7)
      list("Oxide" 1.23 0.52 1.47 0.76)
      list("Cont" 1.29 0.58 1.41 0.7)
      list("Oxide" 1.77 0.52 2.01 0.76)
      list("Cont" 1.83 0.58 1.95 0.7)
      list("Oxide" 2.31 0.52 2.55 0.76)
      list("Oxide" 2.85 0.52 3.09 0.76)
      list("Cont" 2.91 0.58 3.03 0.7)
      list("Oxide" 3.39 0.52 3.63 0.76)
      list("Cont" 3.45 0.58 3.57 0.7)
      list("Oxide" 3.93 0.52 4.17 0.76)
      list("Cont" 3.99 0.58 4.11 0.7)
      list("Oxide" 4.47 0.52 4.71 0.76)
      list("Cont" 4.53 0.58 4.65 0.7)
      list("Oxide" 5.01 0.52 5.25 0.76)
      list("Oxide" 5.55 0.52 5.79 0.76)
      list("Cont" 5.61 0.58 5.73 0.7)
      list("Oxide" 6.09 0.52 6.33 0.76)
      list("Cont" 6.15 0.58 6.27 0.7)
      list("Oxide" 6.63 0.52 6.87 0.76)
      list("Cont" 6.69 0.58 6.81 0.7)
      list("Oxide" 7.17 0.52 7.41 0.76)
      list("Cont" 7.23 0.58 7.35 0.7)
      list("Oxide" 0.39 0.58 0.69 0.7)
      list("Oxide" 1.47 0.52 1.77 0.76)
      list("Oxide" 2.01 0.52 2.31 0.76)
      list("Oxide" 2.55 0.52 2.85 0.76)
      list("Oxide" 3.09 0.52 3.39 0.76)
      list("Oxide" 4.17 0.52 4.47 0.76)
      list("Oxide" 4.71 0.52 5.01 0.76)
      list("Oxide" 5.25 0.52 5.55 0.76)
      list("Oxide" 5.79 0.52 6.09 0.76)
      list("Oxide" 6.87 0.58 7.17 0.7)
      list("Oxide" 0.15 1.88 0.39 2.12)
      list("Cont" 0.21 1.94 0.33 2.06)
      list("Oxide" 0.69 1.88 0.93 2.12)
      list("Cont" 0.75 1.94 0.87 2.06)
      list("Oxide" 1.23 1.76 1.47 2.24)
      list("Cont" 1.29 1.94 1.41 2.06)
      list("Oxide" 1.77 1.76 2.01 2.24)
      list("Cont" 1.83 1.94 1.95 2.06)
      list("Oxide" 2.31 1.76 2.55 2.24)
      list("Cont" 2.37 1.94 2.49 2.06)
      list("Oxide" 2.85 1.76 3.09 2.24)
      list("Cont" 2.91 1.94 3.03 2.06)
      list("Oxide" 3.39 1.76 3.63 2.24)
      list("Cont" 3.45 1.94 3.57 2.06)
      list("Oxide" 3.93 1.76 4.17 2.24)
      list("Cont" 3.99 1.94 4.11 2.06)
      list("Oxide" 4.47 1.76 4.71 2.24)
      list("Cont" 4.53 1.94 4.65 2.06)
      list("Oxide" 5.01 1.76 5.25 2.24)
      list("Cont" 5.07 1.94 5.19 2.06)
      list("Oxide" 5.55 1.76 5.79 2.24)
      list("Cont" 5.61 1.94 5.73 2.06)
      list("Oxide" 6.09 1.76 6.33 2.24)
      list("Cont" 6.15 1.94 6.27 2.06)
      list("Oxide" 6.63 1.88 6.87 2.12)
      list("Cont" 6.69 1.94 6.81 2.06)
      list("Oxide" 7.17 1.88 7.41 2.12)
      list("Cont" 7.23 1.94 7.35 2.06)
      list("Oxide" 0.39 1.88 0.69 2.12)
      list("Oxide" 1.47 1.76 1.77 2.24)
      list("Oxide" 2.01 1.76 2.31 2.24)
      list("Oxide" 2.55 1.76 2.85 2.24)
      list("Oxide" 3.09 1.76 3.39 2.24)
      list("Oxide" 4.17 1.76 4.47 2.24)
      list("Oxide" 4.71 1.76 5.01 2.24)
      list("Oxide" 5.25 1.76 5.55 2.24)
      list("Oxide" 5.79 1.76 6.09 2.24)
      list("Oxide" 6.87 1.88 7.17 2.12)
      list("Poly" 0.49 0.4 0.59 2.3)
      list("Poly" 0.44 1.2 0.64 1.44)
      list("Cont" 0.48 1.26 0.6 1.38)
      list("Poly" 1.57 0.34 1.67 2.42)
      list("Poly" 1.52 1.2 1.72 1.44)
      list("Cont" 1.56 1.26 1.68 1.38)
      list("Poly" 2.11 0.34 2.21 2.42)
      list("Poly" 2.06 1.2 2.26 1.44)
      list("Cont" 2.1 1.26 2.22 1.38)
      list("Poly" 2.65 0.34 2.75 2.42)
      list("Poly" 2.6 1.2 2.8 1.44)
      list("Cont" 2.64 1.26 2.76 1.38)
      list("Poly" 3.19 0.34 3.29 2.42)
      list("Poly" 3.14 1.2 3.34 1.44)
      list("Cont" 3.18 1.26 3.3 1.38)
      list("Poly" 4.27 0.34 4.37 2.42)
      list("Poly" 4.22 1.2 4.42 1.44)
      list("Cont" 4.26 1.26 4.38 1.38)
      list("Poly" 4.81 0.34 4.91 2.42)
      list("Poly" 4.76 1.2 4.96 1.44)
      list("Cont" 4.8 1.26 4.92 1.38)
      list("Poly" 5.35 0.34 5.45 2.42)
      list("Poly" 5.3 1.2 5.5 1.44)
      list("Cont" 5.34 1.26 5.46 1.38)
      list("Poly" 5.89 0.34 5.99 2.42)
      list("Poly" 5.84 1.2 6.04 1.44)
      list("Cont" 5.88 1.26 6 1.38)
      list("Poly" 6.97 0.4 7.07 2.3)
      list("Poly" 6.92 1.2 7.12 1.44)
      list("Cont" 6.96 1.26 7.08 1.38)
      list("Metal1" 0.735 0 0.885 0.76)
      list("Metal1" 0.735 1.88 0.885 2.76)
      list("Metal1" 1.815 0 1.965 0.76)
      list("Metal1" 4.515 0 4.665 0.76)
      list("Metal1" 7.215 0 7.365 0.76)
      list("Metal1" 1.275 1.88 1.425 2.76)
      list("Metal1" 3.435 1.88 3.585 2.76)
      list("Metal1" 3.975 1.88 4.125 2.76)
      list("Metal1" 6.135 1.88 6.285 2.76)
      list("Metal1" 6.675 1.88 6.825 2.76)
      list("Metal1" 4.245 1.08 4.395 1.56)
      list("Metal1" 4.785 1.08 4.935 1.56)
      list("Metal1" 5.325 1.08 5.475 1.56)
      list("Metal1" 5.865 1.08 6.015 1.56)
      list("Metal1" 6.675 0.52 6.825 1.5)
      list("Metal1" 7.215 1.24 7.365 2.12)
      list("Metal1" 2.625 1.11 2.775 1.59)
      list("Via1" 2.63 1.3 2.77 1.44)
      list("Via1" 6.68 1.3 6.82 1.44)
      list("Via1" 7.22 1.3 7.36 1.44)
      list("Metal2" 2.57 1.295 7.42 1.445)
      list("Metal1" 5.595 0.52 5.745 1.21)
      list("Metal1" 5.055 0.95 5.205 2.12)
      list("Metal1" 3.165 0.95 3.315 1.44)
      list("Metal1" 6.945 0.95 7.095 1.44)
      list("Via1" 3.17 1.01 3.31 1.15)
      list("Via1" 5.06 1.01 5.2 1.15)
      list("Via1" 5.6 1.01 5.74 1.15)
      list("Via1" 6.95 1.01 7.09 1.15)
      list("Metal2" 3.11 1.005 7.15 1.155)
      list("Metal1" 1.275 0.36 1.425 0.84)
      list("Metal1" 3.435 0.36 3.585 0.84)
      list("Via1" 1.28 0.43 1.42 0.57)
      list("Via1" 3.44 0.43 3.58 0.57)
      list("Metal2" 1.22 0.425 3.64 0.575)
      list("Metal1" 3.975 0.36 4.125 0.84)
      list("Metal1" 6.135 0.36 6.285 0.84)
      list("Via1" 3.98 0.43 4.12 0.57)
      list("Via1" 6.14 0.43 6.28 0.57)
      list("Metal2" 3.92 0.425 6.34 0.575)
      list("Metal1" 0.465 1.11 0.615 1.59)
      list("Metal1" 2.085 1.11 2.235 1.59)
      list("Via1" 0.47 1.3 0.61 1.44)
      list("Via1" 2.09 1.3 2.23 1.44)
      list("Metal2" 0.41 1.295 2.29 1.445)
      list("Metal1" 0.195 0.52 0.345 2.12)
      list("Metal1" 1.545 0.95 1.695 1.44)
      list("Via1" 0.2 1.01 0.34 1.15)
      list("Via1" 1.55 1.01 1.69 1.15)
      list("Metal2" 0.14 1.005 1.75 1.155)
      list("Metal1" 1.815 1.73 1.965 2.21)
      list("Metal1" 2.895 1.73 3.045 2.21)
      list("Via1" 1.82 1.88 1.96 2.02)
      list("Via1" 2.9 1.88 3.04 2.02)
      list("Metal2" 1.76 1.875 3.1 2.025)
      list("Metal1" 4.515 1.73 4.665 2.21)
      list("Metal1" 5.595 1.73 5.745 2.21)
      list("Via1" 4.52 1.88 4.66 2.02)
      list("Via1" 5.6 1.88 5.74 2.02)
      list("Metal2" 4.46 1.875 5.8 2.025)
      list("Metal1" 2.895 0.48 3.045 0.96)
      list("Metal1" 2.355 0.66 2.505 2.12)
      list("Via1" 2.36 0.72 2.5 0.86)
      list("Via1" 2.9 0.72 3.04 0.86)
      list("Metal2" 2.3 0.715 3.1 0.865))
    list(list("VSS" "inputOutput" 0 0 7.56 0.24)
      list("VDD" "inputOutput" 0 2.52 7.56 2.76)
      list("AJ" "input" 4.245 1.2 4.395 1.44)
      list("AJM" "input" 4.785 1.2 4.935 1.44)
      list("ONE" "input" 5.865 1.2 6.015 1.44)
      list("TWO" "input" 5.325 1.2 5.475 1.44)
      list("NEG" "input" 0.465 1.2 0.615 1.44)
      list("PP" "output" 2.355 1.88 2.505 2.12)))
  ;; CMP42: 68 T (sau khi chia finger), 89 cot
  laDraw("ALU_CELLS_B" "CMP42" 24.3
    list(list("Oxide" 0 0 24.3 0.24)
      list("Pimp" -0.02 -0.02 24.32 0.26)
      list("Oxide" 0 2.52 24.3 2.76)
      list("Nimp" -0.02 2.42 24.32 2.78)
      list("Nwell" -0.12 1.38 24.42 2.88)
      list("Nimp" 0 0.26 24.3 1)
      list("Pimp" 0 1.5 24.3 2.42)
      list("prBoundary" 0 0 24.3 2.76)
      list("Metal1" 0 0 24.3 0.24)
      list("Metal1" 0 2.52 24.3 2.76)
      list("Cont" 0.21 0.06 0.33 0.18)
      list("Cont" 0.21 2.58 0.33 2.7)
      list("Cont" 0.48 0.06 0.6 0.18)
      list("Cont" 0.48 2.58 0.6 2.7)
      list("Cont" 0.75 0.06 0.87 0.18)
      list("Cont" 0.75 2.58 0.87 2.7)
      list("Cont" 1.02 0.06 1.14 0.18)
      list("Cont" 1.02 2.58 1.14 2.7)
      list("Cont" 1.29 0.06 1.41 0.18)
      list("Cont" 1.29 2.58 1.41 2.7)
      list("Cont" 1.56 0.06 1.68 0.18)
      list("Cont" 1.56 2.58 1.68 2.7)
      list("Cont" 1.83 0.06 1.95 0.18)
      list("Cont" 1.83 2.58 1.95 2.7)
      list("Cont" 2.1 0.06 2.22 0.18)
      list("Cont" 2.1 2.58 2.22 2.7)
      list("Cont" 2.37 0.06 2.49 0.18)
      list("Cont" 2.37 2.58 2.49 2.7)
      list("Cont" 2.64 0.06 2.76 0.18)
      list("Cont" 2.64 2.58 2.76 2.7)
      list("Cont" 2.91 0.06 3.03 0.18)
      list("Cont" 2.91 2.58 3.03 2.7)
      list("Cont" 3.18 0.06 3.3 0.18)
      list("Cont" 3.18 2.58 3.3 2.7)
      list("Cont" 3.45 0.06 3.57 0.18)
      list("Cont" 3.45 2.58 3.57 2.7)
      list("Cont" 3.72 0.06 3.84 0.18)
      list("Cont" 3.72 2.58 3.84 2.7)
      list("Cont" 3.99 0.06 4.11 0.18)
      list("Cont" 3.99 2.58 4.11 2.7)
      list("Cont" 4.26 0.06 4.38 0.18)
      list("Cont" 4.26 2.58 4.38 2.7)
      list("Cont" 4.53 0.06 4.65 0.18)
      list("Cont" 4.53 2.58 4.65 2.7)
      list("Cont" 4.8 0.06 4.92 0.18)
      list("Cont" 4.8 2.58 4.92 2.7)
      list("Cont" 5.07 0.06 5.19 0.18)
      list("Cont" 5.07 2.58 5.19 2.7)
      list("Cont" 5.34 0.06 5.46 0.18)
      list("Cont" 5.34 2.58 5.46 2.7)
      list("Cont" 5.61 0.06 5.73 0.18)
      list("Cont" 5.61 2.58 5.73 2.7)
      list("Cont" 5.88 0.06 6 0.18)
      list("Cont" 5.88 2.58 6 2.7)
      list("Cont" 6.15 0.06 6.27 0.18)
      list("Cont" 6.15 2.58 6.27 2.7)
      list("Cont" 6.42 0.06 6.54 0.18)
      list("Cont" 6.42 2.58 6.54 2.7)
      list("Cont" 6.69 0.06 6.81 0.18)
      list("Cont" 6.69 2.58 6.81 2.7)
      list("Cont" 6.96 0.06 7.08 0.18)
      list("Cont" 6.96 2.58 7.08 2.7)
      list("Cont" 7.23 0.06 7.35 0.18)
      list("Cont" 7.23 2.58 7.35 2.7)
      list("Cont" 7.5 0.06 7.62 0.18)
      list("Cont" 7.5 2.58 7.62 2.7)
      list("Cont" 7.77 0.06 7.89 0.18)
      list("Cont" 7.77 2.58 7.89 2.7)
      list("Cont" 8.04 0.06 8.16 0.18)
      list("Cont" 8.04 2.58 8.16 2.7)
      list("Cont" 8.31 0.06 8.43 0.18)
      list("Cont" 8.31 2.58 8.43 2.7)
      list("Cont" 8.58 0.06 8.7 0.18)
      list("Cont" 8.58 2.58 8.7 2.7)
      list("Cont" 8.85 0.06 8.97 0.18)
      list("Cont" 8.85 2.58 8.97 2.7)
      list("Cont" 9.12 0.06 9.24 0.18)
      list("Cont" 9.12 2.58 9.24 2.7)
      list("Cont" 9.39 0.06 9.51 0.18)
      list("Cont" 9.39 2.58 9.51 2.7)
      list("Cont" 9.66 0.06 9.78 0.18)
      list("Cont" 9.66 2.58 9.78 2.7)
      list("Cont" 9.93 0.06 10.05 0.18)
      list("Cont" 9.93 2.58 10.05 2.7)
      list("Cont" 10.2 0.06 10.32 0.18)
      list("Cont" 10.2 2.58 10.32 2.7)
      list("Cont" 10.47 0.06 10.59 0.18)
      list("Cont" 10.47 2.58 10.59 2.7)
      list("Cont" 10.74 0.06 10.86 0.18)
      list("Cont" 10.74 2.58 10.86 2.7)
      list("Cont" 11.01 0.06 11.13 0.18)
      list("Cont" 11.01 2.58 11.13 2.7)
      list("Cont" 11.28 0.06 11.4 0.18)
      list("Cont" 11.28 2.58 11.4 2.7)
      list("Cont" 11.55 0.06 11.67 0.18)
      list("Cont" 11.55 2.58 11.67 2.7)
      list("Cont" 11.82 0.06 11.94 0.18)
      list("Cont" 11.82 2.58 11.94 2.7)
      list("Cont" 12.09 0.06 12.21 0.18)
      list("Cont" 12.09 2.58 12.21 2.7)
      list("Cont" 12.36 0.06 12.48 0.18)
      list("Cont" 12.36 2.58 12.48 2.7)
      list("Cont" 12.63 0.06 12.75 0.18)
      list("Cont" 12.63 2.58 12.75 2.7)
      list("Cont" 12.9 0.06 13.02 0.18)
      list("Cont" 12.9 2.58 13.02 2.7)
      list("Cont" 13.17 0.06 13.29 0.18)
      list("Cont" 13.17 2.58 13.29 2.7)
      list("Cont" 13.44 0.06 13.56 0.18)
      list("Cont" 13.44 2.58 13.56 2.7)
      list("Cont" 13.71 0.06 13.83 0.18)
      list("Cont" 13.71 2.58 13.83 2.7)
      list("Cont" 13.98 0.06 14.1 0.18)
      list("Cont" 13.98 2.58 14.1 2.7)
      list("Cont" 14.25 0.06 14.37 0.18)
      list("Cont" 14.25 2.58 14.37 2.7)
      list("Cont" 14.52 0.06 14.64 0.18)
      list("Cont" 14.52 2.58 14.64 2.7)
      list("Cont" 14.79 0.06 14.91 0.18)
      list("Cont" 14.79 2.58 14.91 2.7)
      list("Cont" 15.06 0.06 15.18 0.18)
      list("Cont" 15.06 2.58 15.18 2.7)
      list("Cont" 15.33 0.06 15.45 0.18)
      list("Cont" 15.33 2.58 15.45 2.7)
      list("Cont" 15.6 0.06 15.72 0.18)
      list("Cont" 15.6 2.58 15.72 2.7)
      list("Cont" 15.87 0.06 15.99 0.18)
      list("Cont" 15.87 2.58 15.99 2.7)
      list("Cont" 16.14 0.06 16.26 0.18)
      list("Cont" 16.14 2.58 16.26 2.7)
      list("Cont" 16.41 0.06 16.53 0.18)
      list("Cont" 16.41 2.58 16.53 2.7)
      list("Cont" 16.68 0.06 16.8 0.18)
      list("Cont" 16.68 2.58 16.8 2.7)
      list("Cont" 16.95 0.06 17.07 0.18)
      list("Cont" 16.95 2.58 17.07 2.7)
      list("Cont" 17.22 0.06 17.34 0.18)
      list("Cont" 17.22 2.58 17.34 2.7)
      list("Cont" 17.49 0.06 17.61 0.18)
      list("Cont" 17.49 2.58 17.61 2.7)
      list("Cont" 17.76 0.06 17.88 0.18)
      list("Cont" 17.76 2.58 17.88 2.7)
      list("Cont" 18.03 0.06 18.15 0.18)
      list("Cont" 18.03 2.58 18.15 2.7)
      list("Cont" 18.3 0.06 18.42 0.18)
      list("Cont" 18.3 2.58 18.42 2.7)
      list("Cont" 18.57 0.06 18.69 0.18)
      list("Cont" 18.57 2.58 18.69 2.7)
      list("Cont" 18.84 0.06 18.96 0.18)
      list("Cont" 18.84 2.58 18.96 2.7)
      list("Cont" 19.11 0.06 19.23 0.18)
      list("Cont" 19.11 2.58 19.23 2.7)
      list("Cont" 19.38 0.06 19.5 0.18)
      list("Cont" 19.38 2.58 19.5 2.7)
      list("Cont" 19.65 0.06 19.77 0.18)
      list("Cont" 19.65 2.58 19.77 2.7)
      list("Cont" 19.92 0.06 20.04 0.18)
      list("Cont" 19.92 2.58 20.04 2.7)
      list("Cont" 20.19 0.06 20.31 0.18)
      list("Cont" 20.19 2.58 20.31 2.7)
      list("Cont" 20.46 0.06 20.58 0.18)
      list("Cont" 20.46 2.58 20.58 2.7)
      list("Cont" 20.73 0.06 20.85 0.18)
      list("Cont" 20.73 2.58 20.85 2.7)
      list("Cont" 21 0.06 21.12 0.18)
      list("Cont" 21 2.58 21.12 2.7)
      list("Cont" 21.27 0.06 21.39 0.18)
      list("Cont" 21.27 2.58 21.39 2.7)
      list("Cont" 21.54 0.06 21.66 0.18)
      list("Cont" 21.54 2.58 21.66 2.7)
      list("Cont" 21.81 0.06 21.93 0.18)
      list("Cont" 21.81 2.58 21.93 2.7)
      list("Cont" 22.08 0.06 22.2 0.18)
      list("Cont" 22.08 2.58 22.2 2.7)
      list("Cont" 22.35 0.06 22.47 0.18)
      list("Cont" 22.35 2.58 22.47 2.7)
      list("Cont" 22.62 0.06 22.74 0.18)
      list("Cont" 22.62 2.58 22.74 2.7)
      list("Cont" 22.89 0.06 23.01 0.18)
      list("Cont" 22.89 2.58 23.01 2.7)
      list("Cont" 23.16 0.06 23.28 0.18)
      list("Cont" 23.16 2.58 23.28 2.7)
      list("Cont" 23.43 0.06 23.55 0.18)
      list("Cont" 23.43 2.58 23.55 2.7)
      list("Cont" 23.7 0.06 23.82 0.18)
      list("Cont" 23.7 2.58 23.82 2.7)
      list("Cont" 23.97 0.06 24.09 0.18)
      list("Cont" 23.97 2.58 24.09 2.7)
      list("Oxide" 0.15 0.52 0.39 0.76)
      list("Cont" 0.21 0.58 0.33 0.7)
      list("Oxide" 0.69 0.52 0.93 0.76)
      list("Cont" 0.75 0.58 0.87 0.7)
      list("Oxide" 1.23 0.52 1.47 0.76)
      list("Cont" 1.29 0.58 1.41 0.7)
      list("Oxide" 1.77 0.52 2.01 0.76)
      list("Cont" 1.83 0.58 1.95 0.7)
      list("Oxide" 2.31 0.52 2.55 0.76)
      list("Cont" 2.37 0.58 2.49 0.7)
      list("Oxide" 2.85 0.52 3.09 0.76)
      list("Cont" 2.91 0.58 3.03 0.7)
      list("Oxide" 3.39 0.52 3.63 0.76)
      list("Cont" 3.45 0.58 3.57 0.7)
      list("Oxide" 3.93 0.52 4.17 0.76)
      list("Cont" 3.99 0.58 4.11 0.7)
      list("Oxide" 4.47 0.52 4.71 0.76)
      list("Cont" 4.53 0.58 4.65 0.7)
      list("Oxide" 5.01 0.52 5.25 0.76)
      list("Cont" 5.07 0.58 5.19 0.7)
      list("Oxide" 5.55 0.52 5.79 0.76)
      list("Cont" 5.61 0.58 5.73 0.7)
      list("Oxide" 6.09 0.52 6.33 0.76)
      list("Cont" 6.15 0.58 6.27 0.7)
      list("Oxide" 6.63 0.52 6.87 0.76)
      list("Cont" 6.69 0.58 6.81 0.7)
      list("Oxide" 7.17 0.55 7.41 0.73)
      list("Oxide" 7.71 0.52 7.95 0.76)
      list("Cont" 7.77 0.58 7.89 0.7)
      list("Oxide" 8.25 0.52 8.49 0.76)
      list("Cont" 8.31 0.58 8.43 0.7)
      list("Oxide" 8.79 0.52 9.03 0.76)
      list("Cont" 8.85 0.58 8.97 0.7)
      list("Oxide" 9.33 0.52 9.57 0.76)
      list("Cont" 9.39 0.58 9.51 0.7)
      list("Oxide" 9.87 0.52 10.11 0.76)
      list("Oxide" 10.41 0.52 10.65 0.76)
      list("Cont" 10.47 0.58 10.59 0.7)
      list("Oxide" 10.95 0.52 11.19 0.76)
      list("Cont" 11.01 0.58 11.13 0.7)
      list("Oxide" 11.49 0.52 11.73 0.76)
      list("Cont" 11.55 0.58 11.67 0.7)
      list("Oxide" 12.03 0.52 12.27 0.76)
      list("Cont" 12.09 0.58 12.21 0.7)
      list("Oxide" 12.57 0.52 12.81 0.76)
      list("Cont" 12.63 0.58 12.75 0.7)
      list("Oxide" 13.11 0.52 13.35 0.76)
      list("Cont" 13.17 0.58 13.29 0.7)
      list("Oxide" 13.65 0.52 13.89 0.76)
      list("Cont" 13.71 0.58 13.83 0.7)
      list("Oxide" 14.19 0.52 14.43 0.76)
      list("Cont" 14.25 0.58 14.37 0.7)
      list("Oxide" 14.73 0.55 14.97 0.73)
      list("Oxide" 15.27 0.52 15.51 0.76)
      list("Cont" 15.33 0.58 15.45 0.7)
      list("Oxide" 15.81 0.55 16.05 0.73)
      list("Oxide" 16.35 0.52 16.59 0.76)
      list("Cont" 16.41 0.58 16.53 0.7)
      list("Oxide" 16.89 0.52 17.13 0.76)
      list("Cont" 16.95 0.58 17.07 0.7)
      list("Oxide" 17.43 0.52 17.67 0.76)
      list("Cont" 17.49 0.58 17.61 0.7)
      list("Oxide" 17.97 0.52 18.21 0.76)
      list("Cont" 18.03 0.58 18.15 0.7)
      list("Oxide" 18.51 0.52 18.75 0.76)
      list("Cont" 18.57 0.58 18.69 0.7)
      list("Oxide" 19.05 0.52 19.29 0.76)
      list("Cont" 19.11 0.58 19.23 0.7)
      list("Oxide" 19.59 0.52 19.83 0.76)
      list("Cont" 19.65 0.58 19.77 0.7)
      list("Oxide" 20.13 0.52 20.37 0.76)
      list("Cont" 20.19 0.58 20.31 0.7)
      list("Oxide" 20.67 0.52 20.91 0.76)
      list("Oxide" 21.21 0.52 21.45 0.76)
      list("Cont" 21.27 0.58 21.39 0.7)
      list("Oxide" 21.75 0.52 21.99 0.76)
      list("Cont" 21.81 0.58 21.93 0.7)
      list("Oxide" 22.29 0.52 22.53 0.76)
      list("Oxide" 22.83 0.52 23.07 0.76)
      list("Cont" 22.89 0.58 23.01 0.7)
      list("Oxide" 23.37 0.52 23.61 0.76)
      list("Cont" 23.43 0.58 23.55 0.7)
      list("Oxide" 23.91 0.52 24.15 0.76)
      list("Cont" 23.97 0.58 24.09 0.7)
      list("Oxide" 0.39 0.58 0.69 0.7)
      list("Oxide" 1.47 0.58 1.77 0.7)
      list("Oxide" 2.55 0.55 2.85 0.73)
      list("Oxide" 3.09 0.55 3.39 0.73)
      list("Oxide" 3.63 0.55 3.93 0.73)
      list("Oxide" 4.17 0.55 4.47 0.73)
      list("Oxide" 4.71 0.52 5.01 0.76)
      list("Oxide" 5.25 0.52 5.55 0.76)
      list("Oxide" 5.79 0.52 6.09 0.76)
      list("Oxide" 6.33 0.52 6.63 0.76)
      list("Oxide" 6.87 0.55 7.17 0.73)
      list("Oxide" 7.41 0.55 7.71 0.73)
      list("Oxide" 7.95 0.55 8.25 0.73)
      list("Oxide" 9.03 0.58 9.33 0.7)
      list("Oxide" 9.57 0.52 9.87 0.76)
      list("Oxide" 10.11 0.52 10.41 0.76)
      list("Oxide" 10.65 0.52 10.95 0.76)
      list("Oxide" 11.19 0.52 11.49 0.76)
      list("Oxide" 11.73 0.52 12.03 0.76)
      list("Oxide" 12.81 0.58 13.11 0.7)
      list("Oxide" 13.89 0.55 14.19 0.73)
      list("Oxide" 14.43 0.55 14.73 0.73)
      list("Oxide" 14.97 0.55 15.27 0.73)
      list("Oxide" 15.51 0.55 15.81 0.73)
      list("Oxide" 16.05 0.55 16.35 0.73)
      list("Oxide" 16.59 0.55 16.89 0.73)
      list("Oxide" 17.13 0.52 17.43 0.76)
      list("Oxide" 17.67 0.52 17.97 0.76)
      list("Oxide" 18.21 0.55 18.51 0.73)
      list("Oxide" 18.75 0.55 19.05 0.73)
      list("Oxide" 19.29 0.52 19.59 0.76)
      list("Oxide" 19.83 0.52 20.13 0.76)
      list("Oxide" 20.91 0.52 21.21 0.76)
      list("Oxide" 21.45 0.52 21.75 0.76)
      list("Oxide" 21.99 0.52 22.29 0.76)
      list("Oxide" 22.53 0.52 22.83 0.76)
      list("Oxide" 23.07 0.52 23.37 0.76)
      list("Oxide" 23.61 0.52 23.91 0.76)
      list("Oxide" 0.15 1.88 0.39 2.12)
      list("Cont" 0.21 1.94 0.33 2.06)
      list("Oxide" 0.69 1.88 0.93 2.12)
      list("Cont" 0.75 1.94 0.87 2.06)
      list("Oxide" 1.23 1.88 1.47 2.12)
      list("Cont" 1.29 1.94 1.41 2.06)
      list("Oxide" 1.77 1.88 2.01 2.12)
      list("Cont" 1.83 1.94 1.95 2.06)
      list("Oxide" 2.31 1.82 2.55 2.18)
      list("Cont" 2.37 1.94 2.49 2.06)
      list("Oxide" 2.85 1.82 3.09 2.18)
      list("Cont" 2.91 1.94 3.03 2.06)
      list("Oxide" 3.39 1.82 3.63 2.18)
      list("Cont" 3.45 1.94 3.57 2.06)
      list("Oxide" 3.93 1.82 4.17 2.18)
      list("Cont" 3.99 1.94 4.11 2.06)
      list("Oxide" 4.47 1.76 4.71 2.24)
      list("Cont" 4.53 1.94 4.65 2.06)
      list("Oxide" 5.01 1.76 5.25 2.24)
      list("Oxide" 5.55 1.76 5.79 2.24)
      list("Cont" 5.61 1.94 5.73 2.06)
      list("Oxide" 6.09 1.76 6.33 2.24)
      list("Cont" 6.15 1.94 6.27 2.06)
      list("Oxide" 6.63 1.82 6.87 2.18)
      list("Cont" 6.69 1.94 6.81 2.06)
      list("Oxide" 7.17 1.76 7.41 2.24)
      list("Cont" 7.23 1.94 7.35 2.06)
      list("Oxide" 7.71 1.76 7.95 2.24)
      list("Cont" 7.77 1.94 7.89 2.06)
      list("Oxide" 8.25 1.76 8.49 2.24)
      list("Cont" 8.31 1.94 8.43 2.06)
      list("Oxide" 8.79 1.88 9.03 2.12)
      list("Cont" 8.85 1.94 8.97 2.06)
      list("Oxide" 9.33 1.76 9.57 2.24)
      list("Cont" 9.39 1.94 9.51 2.06)
      list("Oxide" 9.87 1.76 10.11 2.24)
      list("Oxide" 10.41 1.76 10.65 2.24)
      list("Cont" 10.47 1.94 10.59 2.06)
      list("Oxide" 10.95 1.76 11.19 2.24)
      list("Cont" 11.01 1.94 11.13 2.06)
      list("Oxide" 11.49 1.76 11.73 2.24)
      list("Cont" 11.55 1.94 11.67 2.06)
      list("Oxide" 12.03 1.76 12.27 2.24)
      list("Cont" 12.09 1.94 12.21 2.06)
      list("Oxide" 12.57 1.88 12.81 2.12)
      list("Cont" 12.63 1.94 12.75 2.06)
      list("Oxide" 13.11 1.88 13.35 2.12)
      list("Cont" 13.17 1.94 13.29 2.06)
      list("Oxide" 13.65 1.82 13.89 2.18)
      list("Cont" 13.71 1.94 13.83 2.06)
      list("Oxide" 14.19 1.82 14.43 2.18)
      list("Cont" 14.25 1.94 14.37 2.06)
      list("Oxide" 14.73 1.82 14.97 2.18)
      list("Cont" 14.79 1.94 14.91 2.06)
      list("Oxide" 15.27 1.82 15.51 2.18)
      list("Cont" 15.33 1.94 15.45 2.06)
      list("Oxide" 15.81 1.82 16.05 2.18)
      list("Cont" 15.87 1.94 15.99 2.06)
      list("Oxide" 16.35 1.82 16.59 2.18)
      list("Cont" 16.41 1.94 16.53 2.06)
      list("Oxide" 16.89 1.76 17.13 2.24)
      list("Cont" 16.95 1.94 17.07 2.06)
      list("Oxide" 17.43 1.76 17.67 2.24)
      list("Cont" 17.49 1.94 17.61 2.06)
      list("Oxide" 17.97 1.76 18.21 2.24)
      list("Oxide" 18.51 1.88 18.75 2.12)
      list("Cont" 18.57 1.94 18.69 2.06)
      list("Oxide" 19.05 1.76 19.29 2.24)
      list("Oxide" 19.59 1.76 19.83 2.24)
      list("Cont" 19.65 1.94 19.77 2.06)
      list("Oxide" 20.13 1.76 20.37 2.24)
      list("Cont" 20.19 1.94 20.31 2.06)
      list("Oxide" 20.67 1.76 20.91 2.24)
      list("Cont" 20.73 1.94 20.85 2.06)
      list("Oxide" 21.21 1.76 21.45 2.24)
      list("Cont" 21.27 1.94 21.39 2.06)
      list("Oxide" 21.75 1.76 21.99 2.24)
      list("Cont" 21.81 1.94 21.93 2.06)
      list("Oxide" 22.29 1.76 22.53 2.24)
      list("Oxide" 22.83 1.76 23.07 2.24)
      list("Cont" 22.89 1.94 23.01 2.06)
      list("Oxide" 23.37 1.76 23.61 2.24)
      list("Cont" 23.43 1.94 23.55 2.06)
      list("Oxide" 0.39 1.88 0.69 2.12)
      list("Oxide" 1.47 1.88 1.77 2.12)
      list("Oxide" 2.55 1.82 2.85 2.18)
      list("Oxide" 3.09 1.82 3.39 2.18)
      list("Oxide" 3.63 1.82 3.93 2.18)
      list("Oxide" 4.17 1.82 4.47 2.18)
      list("Oxide" 4.71 1.76 5.01 2.24)
      list("Oxide" 5.25 1.76 5.55 2.24)
      list("Oxide" 5.79 1.76 6.09 2.24)
      list("Oxide" 6.33 1.82 6.63 2.18)
      list("Oxide" 6.87 1.82 7.17 2.18)
      list("Oxide" 7.41 1.76 7.71 2.24)
      list("Oxide" 7.95 1.76 8.25 2.24)
      list("Oxide" 9.03 1.88 9.33 2.12)
      list("Oxide" 9.57 1.76 9.87 2.24)
      list("Oxide" 10.11 1.76 10.41 2.24)
      list("Oxide" 10.65 1.76 10.95 2.24)
      list("Oxide" 11.19 1.76 11.49 2.24)
      list("Oxide" 11.73 1.76 12.03 2.24)
      list("Oxide" 12.81 1.88 13.11 2.12)
      list("Oxide" 13.89 1.82 14.19 2.18)
      list("Oxide" 14.43 1.82 14.73 2.18)
      list("Oxide" 14.97 1.82 15.27 2.18)
      list("Oxide" 15.51 1.82 15.81 2.18)
      list("Oxide" 16.05 1.82 16.35 2.18)
      list("Oxide" 16.59 1.82 16.89 2.18)
      list("Oxide" 17.13 1.76 17.43 2.24)
      list("Oxide" 17.67 1.76 17.97 2.24)
      list("Oxide" 18.21 1.88 18.51 2.12)
      list("Oxide" 18.75 1.88 19.05 2.12)
      list("Oxide" 19.29 1.76 19.59 2.24)
      list("Oxide" 19.83 1.76 20.13 2.24)
      list("Oxide" 20.91 1.76 21.21 2.24)
      list("Oxide" 21.45 1.76 21.75 2.24)
      list("Oxide" 21.99 1.76 22.29 2.24)
      list("Oxide" 22.53 1.76 22.83 2.24)
      list("Oxide" 23.07 1.76 23.37 2.24)
      list("Poly" 0.49 0.4 0.59 2.3)
      list("Poly" 0.44 1.2 0.64 1.44)
      list("Cont" 0.48 1.26 0.6 1.38)
      list("Poly" 1.57 0.4 1.67 2.3)
      list("Poly" 1.52 1.2 1.72 1.44)
      list("Cont" 1.56 1.26 1.68 1.38)
      list("Poly" 2.65 0.37 2.75 2.36)
      list("Poly" 2.6 1.2 2.8 1.44)
      list("Cont" 2.64 1.26 2.76 1.38)
      list("Poly" 3.19 0.37 3.29 2.36)
      list("Poly" 3.14 1.2 3.34 1.44)
      list("Cont" 3.18 1.26 3.3 1.38)
      list("Poly" 3.73 0.37 3.83 2.36)
      list("Poly" 3.68 1.2 3.88 1.44)
      list("Cont" 3.72 1.26 3.84 1.38)
      list("Poly" 4.27 0.37 4.37 2.36)
      list("Poly" 4.22 1.2 4.42 1.44)
      list("Cont" 4.26 1.26 4.38 1.38)
      list("Poly" 4.81 0.34 4.91 2.42)
      list("Poly" 4.76 1.2 4.96 1.44)
      list("Cont" 4.8 1.26 4.92 1.38)
      list("Poly" 5.35 0.34 5.45 1.44)
      list("Poly" 5.3 1.2 5.5 1.44)
      list("Cont" 5.34 1.26 5.46 1.38)
      list("Poly" 5.89 0.34 5.99 2.42)
      list("Poly" 5.84 1.2 6.04 1.44)
      list("Cont" 5.88 1.26 6 1.38)
      list("Poly" 6.43 0.34 6.53 2.36)
      list("Poly" 6.38 1.2 6.58 1.44)
      list("Cont" 6.42 1.26 6.54 1.38)
      list("Poly" 6.97 0.37 7.07 2.36)
      list("Poly" 6.92 1.2 7.12 1.44)
      list("Cont" 6.96 1.26 7.08 1.38)
      list("Poly" 7.51 1.2 7.61 2.42)
      list("Poly" 7.46 1.2 7.66 1.44)
      list("Cont" 7.5 1.26 7.62 1.38)
      list("Poly" 8.05 0.37 8.15 2.42)
      list("Poly" 8 1.2 8.2 1.44)
      list("Cont" 8.04 1.26 8.16 1.38)
      list("Poly" 9.13 0.4 9.23 2.3)
      list("Poly" 9.08 1.2 9.28 1.44)
      list("Cont" 9.12 1.26 9.24 1.38)
      list("Poly" 9.67 0.34 9.77 2.42)
      list("Poly" 9.62 1.2 9.82 1.44)
      list("Cont" 9.66 1.26 9.78 1.38)
      list("Poly" 10.21 0.34 10.31 2.42)
      list("Poly" 10.16 1.2 10.36 1.44)
      list("Cont" 10.2 1.26 10.32 1.38)
      list("Poly" 10.75 0.34 10.85 2.42)
      list("Poly" 10.7 1.2 10.9 1.44)
      list("Cont" 10.74 1.26 10.86 1.38)
      list("Poly" 11.29 0.34 11.39 2.42)
      list("Poly" 11.24 1.2 11.44 1.44)
      list("Cont" 11.28 1.26 11.4 1.38)
      list("Poly" 11.83 0.34 11.93 2.42)
      list("Poly" 11.78 1.2 11.98 1.44)
      list("Cont" 11.82 1.26 11.94 1.38)
      list("Poly" 12.91 0.4 13.01 2.3)
      list("Poly" 12.86 1.2 13.06 1.44)
      list("Cont" 12.9 1.26 13.02 1.38)
      list("Poly" 13.99 0.37 14.09 2.36)
      list("Poly" 13.94 1.2 14.14 1.44)
      list("Cont" 13.98 1.26 14.1 1.38)
      list("Poly" 14.53 0.37 14.63 2.36)
      list("Poly" 14.48 1.2 14.68 1.44)
      list("Cont" 14.52 1.26 14.64 1.38)
      list("Poly" 15.07 1.2 15.17 2.36)
      list("Poly" 15.02 1.2 15.22 1.44)
      list("Cont" 15.06 1.26 15.18 1.38)
      list("Poly" 15.61 1.2 15.71 2.36)
      list("Poly" 15.56 1.2 15.76 1.44)
      list("Cont" 15.6 1.26 15.72 1.38)
      list("Poly" 16.15 0.37 16.25 2.36)
      list("Poly" 16.1 1.2 16.3 1.44)
      list("Cont" 16.14 1.26 16.26 1.38)
      list("Poly" 16.69 0.37 16.79 2.36)
      list("Poly" 16.64 1.2 16.84 1.44)
      list("Cont" 16.68 1.26 16.8 1.38)
      list("Poly" 17.23 0.34 17.33 2.42)
      list("Poly" 17.18 1.2 17.38 1.44)
      list("Cont" 17.22 1.26 17.34 1.38)
      list("Poly" 17.77 0.34 17.87 2.42)
      list("Poly" 17.72 1.2 17.92 1.44)
      list("Cont" 17.76 1.26 17.88 1.38)
      list("Poly" 18.31 0.37 18.41 1.44)
      list("Poly" 18.26 1.2 18.46 1.44)
      list("Cont" 18.3 1.26 18.42 1.38)
      list("Poly" 18.85 0.37 18.95 1.44)
      list("Poly" 18.8 1.2 19 1.44)
      list("Cont" 18.84 1.26 18.96 1.38)
      list("Poly" 19.39 0.34 19.49 2.42)
      list("Poly" 19.34 1.2 19.54 1.44)
      list("Cont" 19.38 1.26 19.5 1.38)
      list("Poly" 19.93 0.34 20.03 2.42)
      list("Poly" 19.88 1.2 20.08 1.44)
      list("Cont" 19.92 1.26 20.04 1.38)
      list("Poly" 21.01 1.2 21.11 2.42)
      list("Poly" 20.96 1.2 21.16 1.44)
      list("Cont" 21 1.26 21.12 1.38)
      list("Poly" 21.55 0.34 21.65 2.42)
      list("Poly" 21.5 1.2 21.7 1.44)
      list("Cont" 21.54 1.26 21.66 1.38)
      list("Poly" 22.09 0.34 22.19 2.42)
      list("Poly" 22.04 1.2 22.24 1.44)
      list("Cont" 22.08 1.26 22.2 1.38)
      list("Poly" 22.63 0.34 22.73 2.42)
      list("Poly" 22.58 1.2 22.78 1.44)
      list("Cont" 22.62 1.26 22.74 1.38)
      list("Poly" 23.17 0.34 23.27 2.42)
      list("Poly" 23.12 1.2 23.32 1.44)
      list("Cont" 23.16 1.26 23.28 1.38)
      list("Poly" 23.71 0.34 23.81 1.44)
      list("Poly" 23.66 1.2 23.86 1.44)
      list("Cont" 23.7 1.26 23.82 1.38)
      list("Metal1" 0.195 0 0.345 0.76)
      list("Metal1" 1.275 0 1.425 0.76)
      list("Metal1" 5.595 0 5.745 0.76)
      list("Metal1" 6.675 0 6.825 0.76)
      list("Metal1" 8.295 0 8.445 0.76)
      list("Metal1" 8.295 1.88 8.445 2.76)
      list("Metal1" 9.375 0 9.525 0.76)
      list("Metal1" 9.375 1.88 9.525 2.76)
      list("Metal1" 11.535 0 11.685 0.76)
      list("Metal1" 11.535 1.88 11.685 2.76)
      list("Metal1" 13.155 0 13.305 0.76)
      list("Metal1" 13.155 1.88 13.305 2.76)
      list("Metal1" 18.015 0 18.165 0.76)
      list("Metal1" 19.095 0 19.245 0.76)
      list("Metal1" 20.175 0 20.325 0.76)
      list("Metal1" 20.175 1.88 20.325 2.76)
      list("Metal1" 21.795 0 21.945 0.76)
      list("Metal1" 21.795 1.88 21.945 2.76)
      list("Metal1" 23.955 0 24.105 0.76)
      list("Metal1" 0.735 1.88 0.885 2.76)
      list("Metal1" 1.815 1.88 1.965 2.76)
      list("Metal1" 6.135 1.88 6.285 2.76)
      list("Metal1" 7.215 1.88 7.365 2.76)
      list("Metal1" 15.315 1.88 15.465 2.76)
      list("Metal1" 18.555 1.88 18.705 2.76)
      list("Metal1" 20.715 1.88 20.865 2.76)
      list("Metal1" 12.615 0.52 12.765 2.12)
      list("Metal1" 14.775 1.73 14.925 2.21)
      list("Metal1" 15.855 1.73 16.005 2.21)
      list("Via1" 14.78 1.88 14.92 2.02)
      list("Via1" 15.86 1.88 16 2.02)
      list("Metal2" 14.72 1.875 16.06 2.025)
      list("Metal1" 21.255 1.73 21.405 2.21)
      list("Metal1" 23.415 1.73 23.565 2.21)
      list("Via1" 21.26 1.88 21.4 2.02)
      list("Via1" 23.42 1.88 23.56 2.02)
      list("Metal2" 21.2 1.875 23.62 2.025)
      list("Metal1" 5.055 0.36 5.205 0.84)
      list("Metal1" 6.135 0.36 6.285 0.84)
      list("Via1" 5.06 0.43 5.2 0.57)
      list("Via1" 6.14 0.43 6.28 0.57)
      list("Metal2" 5 0.425 6.34 0.575)
      list("Metal1" 10.455 0.52 10.605 2.12)
      list("Metal1" 4.785 1.11 4.935 1.59)
      list("Metal1" 12.885 1.11 13.035 1.59)
      list("Via1" 4.79 1.3 4.93 1.44)
      list("Via1" 10.46 1.3 10.6 1.44)
      list("Via1" 12.89 1.3 13.03 1.44)
      list("Metal2" 4.73 1.295 13.09 1.445)
      list("Metal1" 10.995 1.73 11.145 2.21)
      list("Metal1" 12.075 1.73 12.225 2.21)
      list("Via1" 11 1.88 11.14 2.02)
      list("Via1" 12.08 1.88 12.22 2.02)
      list("Metal2" 10.94 1.875 12.28 2.025)
      list("Metal1" 15.045 1.11 15.195 1.59)
      list("Metal1" 15.585 1.11 15.735 1.59)
      list("Metal1" 17.745 1.11 17.895 1.59)
      list("Metal1" 18.285 1.11 18.435 1.59)
      list("Metal1" 18.825 1.11 18.975 1.59)
      list("Metal1" 20.985 1.11 21.135 1.59)
      list("Metal1" 22.065 1.11 22.215 1.59)
      list("Metal1" 23.685 1.11 23.835 1.59)
      list("Via1" 15.05 1.3 15.19 1.44)
      list("Via1" 15.59 1.3 15.73 1.44)
      list("Via1" 17.75 1.3 17.89 1.44)
      list("Via1" 18.29 1.3 18.43 1.44)
      list("Via1" 18.83 1.3 18.97 1.44)
      list("Via1" 20.99 1.3 21.13 1.44)
      list("Via1" 22.07 1.3 22.21 1.44)
      list("Via1" 23.69 1.3 23.83 1.44)
      list("Metal2" 14.99 1.295 23.89 1.445)
      list("Metal1" 14.505 0.95 14.655 1.44)
      list("Metal1" 16.125 0.95 16.275 1.44)
      list("Metal1" 19.905 0.95 20.055 1.44)
      list("Metal1" 21.525 0.95 21.675 1.44)
      list("Metal1" 22.605 0.95 22.755 1.44)
      list("Via1" 14.51 1.01 14.65 1.15)
      list("Via1" 16.13 1.01 16.27 1.15)
      list("Via1" 19.91 1.01 20.05 1.15)
      list("Via1" 21.53 1.01 21.67 1.15)
      list("Via1" 22.61 1.01 22.75 1.15)
      list("Metal2" 14.45 1.005 22.81 1.155)
      list("Metal1" 8.835 0.52 8.985 2.12)
      list("Metal1" 6.405 0.95 6.555 1.44)
      list("Metal1" 6.945 0.95 7.095 1.44)
      list("Metal1" 8.025 0.95 8.175 1.44)
      list("Metal1" 9.645 0.95 9.795 1.44)
      list("Metal1" 11.265 0.95 11.415 1.44)
      list("Via1" 6.41 1.01 6.55 1.15)
      list("Via1" 6.95 1.01 7.09 1.15)
      list("Via1" 8.03 1.01 8.17 1.15)
      list("Via1" 8.84 1.01 8.98 1.15)
      list("Via1" 9.65 1.01 9.79 1.15)
      list("Via1" 11.27 1.01 11.41 1.15)
      list("Metal2" 6.35 1.005 11.47 1.155)
      list("Metal1" 2.355 0.52 2.505 2.12)
      list("Metal1" 4.515 0.52 4.665 2.12)
      list("Metal1" 1.545 0.95 1.695 1.44)
      list("Via1" 1.55 1.01 1.69 1.15)
      list("Via1" 2.36 1.01 2.5 1.15)
      list("Via1" 4.52 1.01 4.66 1.15)
      list("Metal2" 1.49 1.005 4.72 1.155)
      list("Metal1" 3.435 1.73 3.585 2.21)
      list("Metal1" 6.675 1.73 6.825 2.21)
      list("Via1" 3.44 1.88 3.58 2.02)
      list("Via1" 6.68 1.88 6.82 2.02)
      list("Metal2" 3.38 1.875 6.88 2.025)
      list("Metal1" 13.965 1.2 14.115 1.79)
      list("Metal1" 16.665 1.2 16.815 1.79)
      list("Metal1" 19.365 1.2 19.515 1.79)
      list("Metal1" 23.145 1.2 23.295 1.79)
      list("Via1" 13.97 1.59 14.11 1.73)
      list("Via1" 16.67 1.59 16.81 1.73)
      list("Via1" 19.37 1.59 19.51 1.73)
      list("Via1" 23.15 1.59 23.29 1.73)
      list("Metal2" 13.91 1.585 23.35 1.735)
      list("Metal1" 21.255 0.36 21.405 0.84)
      list("Metal1" 23.415 0.36 23.565 0.84)
      list("Via1" 21.26 0.43 21.4 0.57)
      list("Via1" 23.42 0.43 23.56 0.57)
      list("Metal2" 21.2 0.425 23.62 0.575)
      list("Metal1" 17.475 1.73 17.625 2.21)
      list("Metal1" 19.635 1.73 19.785 2.21)
      list("Via1" 17.48 1.88 17.62 2.02)
      list("Via1" 19.64 1.88 19.78 2.02)
      list("Metal2" 17.42 1.875 19.84 2.025)
      list("Metal1" 5.595 1.88 5.745 2.37)
      list("Metal1" 7.755 1.88 7.905 2.37)
      list("Via1" 5.6 2.17 5.74 2.31)
      list("Via1" 7.76 2.17 7.9 2.31)
      list("Metal2" 5.54 2.165 7.96 2.315)
      list("Metal1" 1.815 0.52 1.965 1.5)
      list("Metal1" 1.275 1.24 1.425 2.12)
      list("Via1" 1.28 1.3 1.42 1.44)
      list("Via1" 1.82 1.3 1.96 1.44)
      list("Metal2" 1.22 1.295 2.02 1.445)
      list("Metal1" 14.235 0.36 14.385 0.84)
      list("Metal1" 16.395 0.36 16.545 0.84)
      list("Via1" 14.24 0.43 14.38 0.57)
      list("Via1" 16.4 0.43 16.54 0.57)
      list("Metal2" 14.18 0.425 16.6 0.575)
      list("Metal1" 2.895 1.88 3.045 2.37)
      list("Metal1" 3.975 1.88 4.125 2.37)
      list("Via1" 2.9 2.17 3.04 2.31)
      list("Via1" 3.98 2.17 4.12 2.31)
      list("Metal2" 2.84 2.165 4.18 2.315)
      list("Metal1" 10.995 0.36 11.145 0.84)
      list("Metal1" 12.075 0.36 12.225 0.84)
      list("Via1" 11 0.43 11.14 0.57)
      list("Via1" 12.08 0.43 12.22 0.57)
      list("Metal2" 10.94 0.425 12.28 0.575)
      list("Metal1" 0.735 0.52 0.885 1.5)
      list("Metal1" 0.195 1.24 0.345 2.12)
      list("Via1" 0.2 1.3 0.34 1.44)
      list("Via1" 0.74 1.3 0.88 1.44)
      list("Metal2" 0.14 1.295 0.94 1.445)
      list("Metal1" 2.895 0.52 3.045 1.5)
      list("Metal1" 3.975 0.52 4.125 1.5)
      list("Via1" 2.9 1.3 3.04 1.44)
      list("Via1" 3.98 1.3 4.12 1.44)
      list("Metal2" 2.84 1.295 4.18 1.445)
      list("Metal1" 17.475 0.36 17.625 0.84)
      list("Metal1" 19.635 0.36 19.785 0.84)
      list("Via1" 17.48 0.43 17.62 0.57)
      list("Via1" 19.64 0.43 19.78 0.57)
      list("Metal2" 17.42 0.425 19.84 0.575)
      list("Metal1" 2.625 1.2 2.775 1.79)
      list("Metal1" 4.245 1.2 4.395 1.79)
      list("Metal1" 5.325 1.2 5.475 1.79)
      list("Metal1" 7.485 1.2 7.635 1.79)
      list("Metal1" 10.725 1.2 10.875 1.79)
      list("Via1" 2.63 1.59 2.77 1.73)
      list("Via1" 4.25 1.59 4.39 1.73)
      list("Via1" 5.33 1.59 5.47 1.73)
      list("Via1" 7.49 1.59 7.63 1.73)
      list("Via1" 10.73 1.59 10.87 1.73)
      list("Metal2" 2.57 1.585 10.93 1.735)
      list("Metal1" 13.695 0.52 13.845 2.12)
      list("Metal1" 16.935 0.52 17.085 2.12)
      list("Metal1" 9.105 1.2 9.255 2.08)
      list("Via1" 9.11 1.88 9.25 2.02)
      list("Via2" 9.11 1.88 9.25 2.02)
      list("Via1" 13.7 1.88 13.84 2.02)
      list("Via2" 13.7 1.88 13.84 2.02)
      list("Via1" 16.94 1.88 17.08 2.02)
      list("Via2" 16.94 1.88 17.08 2.02)
      list("Metal3" 9.05 1.875 17.14 2.025)
      list("Metal2" 8.91 1.875 9.45 2.025)
      list("Metal2" 13.5 1.875 14.04 2.025)
      list("Metal2" 16.74 1.875 17.28 2.025)
      list("Metal1" 3.435 0.36 3.585 0.84)
      list("Metal1" 7.755 0.36 7.905 0.84)
      list("Via1" 3.44 0.43 3.58 0.57)
      list("Via2" 3.44 0.43 3.58 0.57)
      list("Via1" 7.76 0.43 7.9 0.57)
      list("Via2" 7.76 0.43 7.9 0.57)
      list("Metal3" 3.38 0.425 7.96 0.575)
      list("Metal2" 3.24 0.425 3.78 0.575)
      list("Metal2" 7.56 0.425 8.1 0.575)
      list("Metal1" 22.875 0.52 23.025 2.37)
      list("Metal1" 0.465 1.2 0.615 2.37)
      list("Metal1" 17.205 1.2 17.355 2.37)
      list("Via1" 0.47 2.17 0.61 2.31)
      list("Via2" 0.47 2.17 0.61 2.31)
      list("Via1" 17.21 2.17 17.35 2.31)
      list("Via2" 17.21 2.17 17.35 2.31)
      list("Via1" 22.88 2.17 23.02 2.31)
      list("Via2" 22.88 2.17 23.02 2.31)
      list("Metal3" 0.41 2.165 23.08 2.315)
      list("Metal2" 0.27 2.165 0.81 2.315)
      list("Metal2" 17.01 2.165 17.55 2.315)
      list("Metal2" 22.68 2.165 23.22 2.315)
      list("Metal1" 3.165 0.66 3.315 1.44)
      list("Metal1" 3.705 0.66 3.855 1.44)
      list("Metal1" 5.865 0.66 6.015 1.44)
      list("Metal1" 10.185 0.66 10.335 1.44)
      list("Metal1" 11.805 0.66 11.955 1.44)
      list("Via1" 3.17 0.72 3.31 0.86)
      list("Via1" 3.71 0.72 3.85 0.86)
      list("Via1" 5.87 0.72 6.01 0.86)
      list("Via1" 10.19 0.72 10.33 0.86)
      list("Via1" 11.81 0.72 11.95 0.86)
      list("Metal2" 3.11 0.715 12.01 0.865)
      list("Metal1" 15.315 0.48 15.465 0.96)
      list("Metal1" 18.555 0.48 18.705 0.96)
      list("Via1" 15.32 0.72 15.46 0.86)
      list("Via1" 18.56 0.72 18.7 0.86)
      list("Metal2" 15.26 0.715 18.76 0.865)
      list("Metal1" 14.235 1.88 14.385 2.37)
      list("Metal1" 16.395 1.88 16.545 2.37)
      list("Via1" 14.24 2.17 14.38 2.31)
      list("Via1" 16.4 2.17 16.54 2.31)
      list("Metal2" 14.18 2.165 16.6 2.315))
    list(list("VSS" "inputOutput" 0 0 24.3 0.24)
      list("VDD" "inputOutput" 0 2.52 24.3 2.76)
      list("X1" "input" 15.045 1.2 15.195 1.44)
      list("X2" "input" 14.505 1.2 14.655 1.44)
      list("X3" "input" 13.965 1.2 14.115 1.44)
      list("X4" "input" 3.165 1.2 3.315 1.44)
      list("CI" "input" 2.625 1.2 2.775 1.44)
      list("S" "output" 1.275 1.88 1.425 2.12)
      list("C" "output" 12.615 0.52 12.765 0.76)
      list("CO" "output" 0.195 1.88 0.345 2.12)))
  ;; FA_X1: 34 T (sau khi chia finger), 41 cot
  laDraw("ALU_CELLS_C" "FA_X1" 11.34
    list(list("Oxide" 0 0 11.34 0.24)
      list("Pimp" -0.02 -0.02 11.36 0.26)
      list("Oxide" 0 2.52 11.34 2.76)
      list("Nimp" -0.02 2.42 11.36 2.78)
      list("Nwell" -0.12 1.38 11.46 2.88)
      list("Nimp" 0 0.26 11.34 1)
      list("Pimp" 0 1.5 11.34 2.42)
      list("prBoundary" 0 0 11.34 2.76)
      list("Metal1" 0 0 11.34 0.24)
      list("Metal1" 0 2.52 11.34 2.76)
      list("Cont" 0.21 0.06 0.33 0.18)
      list("Cont" 0.21 2.58 0.33 2.7)
      list("Cont" 0.48 0.06 0.6 0.18)
      list("Cont" 0.48 2.58 0.6 2.7)
      list("Cont" 0.75 0.06 0.87 0.18)
      list("Cont" 0.75 2.58 0.87 2.7)
      list("Cont" 1.02 0.06 1.14 0.18)
      list("Cont" 1.02 2.58 1.14 2.7)
      list("Cont" 1.29 0.06 1.41 0.18)
      list("Cont" 1.29 2.58 1.41 2.7)
      list("Cont" 1.56 0.06 1.68 0.18)
      list("Cont" 1.56 2.58 1.68 2.7)
      list("Cont" 1.83 0.06 1.95 0.18)
      list("Cont" 1.83 2.58 1.95 2.7)
      list("Cont" 2.1 0.06 2.22 0.18)
      list("Cont" 2.1 2.58 2.22 2.7)
      list("Cont" 2.37 0.06 2.49 0.18)
      list("Cont" 2.37 2.58 2.49 2.7)
      list("Cont" 2.64 0.06 2.76 0.18)
      list("Cont" 2.64 2.58 2.76 2.7)
      list("Cont" 2.91 0.06 3.03 0.18)
      list("Cont" 2.91 2.58 3.03 2.7)
      list("Cont" 3.18 0.06 3.3 0.18)
      list("Cont" 3.18 2.58 3.3 2.7)
      list("Cont" 3.45 0.06 3.57 0.18)
      list("Cont" 3.45 2.58 3.57 2.7)
      list("Cont" 3.72 0.06 3.84 0.18)
      list("Cont" 3.72 2.58 3.84 2.7)
      list("Cont" 3.99 0.06 4.11 0.18)
      list("Cont" 3.99 2.58 4.11 2.7)
      list("Cont" 4.26 0.06 4.38 0.18)
      list("Cont" 4.26 2.58 4.38 2.7)
      list("Cont" 4.53 0.06 4.65 0.18)
      list("Cont" 4.53 2.58 4.65 2.7)
      list("Cont" 4.8 0.06 4.92 0.18)
      list("Cont" 4.8 2.58 4.92 2.7)
      list("Cont" 5.07 0.06 5.19 0.18)
      list("Cont" 5.07 2.58 5.19 2.7)
      list("Cont" 5.34 0.06 5.46 0.18)
      list("Cont" 5.34 2.58 5.46 2.7)
      list("Cont" 5.61 0.06 5.73 0.18)
      list("Cont" 5.61 2.58 5.73 2.7)
      list("Cont" 5.88 0.06 6 0.18)
      list("Cont" 5.88 2.58 6 2.7)
      list("Cont" 6.15 0.06 6.27 0.18)
      list("Cont" 6.15 2.58 6.27 2.7)
      list("Cont" 6.42 0.06 6.54 0.18)
      list("Cont" 6.42 2.58 6.54 2.7)
      list("Cont" 6.69 0.06 6.81 0.18)
      list("Cont" 6.69 2.58 6.81 2.7)
      list("Cont" 6.96 0.06 7.08 0.18)
      list("Cont" 6.96 2.58 7.08 2.7)
      list("Cont" 7.23 0.06 7.35 0.18)
      list("Cont" 7.23 2.58 7.35 2.7)
      list("Cont" 7.5 0.06 7.62 0.18)
      list("Cont" 7.5 2.58 7.62 2.7)
      list("Cont" 7.77 0.06 7.89 0.18)
      list("Cont" 7.77 2.58 7.89 2.7)
      list("Cont" 8.04 0.06 8.16 0.18)
      list("Cont" 8.04 2.58 8.16 2.7)
      list("Cont" 8.31 0.06 8.43 0.18)
      list("Cont" 8.31 2.58 8.43 2.7)
      list("Cont" 8.58 0.06 8.7 0.18)
      list("Cont" 8.58 2.58 8.7 2.7)
      list("Cont" 8.85 0.06 8.97 0.18)
      list("Cont" 8.85 2.58 8.97 2.7)
      list("Cont" 9.12 0.06 9.24 0.18)
      list("Cont" 9.12 2.58 9.24 2.7)
      list("Cont" 9.39 0.06 9.51 0.18)
      list("Cont" 9.39 2.58 9.51 2.7)
      list("Cont" 9.66 0.06 9.78 0.18)
      list("Cont" 9.66 2.58 9.78 2.7)
      list("Cont" 9.93 0.06 10.05 0.18)
      list("Cont" 9.93 2.58 10.05 2.7)
      list("Cont" 10.2 0.06 10.32 0.18)
      list("Cont" 10.2 2.58 10.32 2.7)
      list("Cont" 10.47 0.06 10.59 0.18)
      list("Cont" 10.47 2.58 10.59 2.7)
      list("Cont" 10.74 0.06 10.86 0.18)
      list("Cont" 10.74 2.58 10.86 2.7)
      list("Cont" 11.01 0.06 11.13 0.18)
      list("Cont" 11.01 2.58 11.13 2.7)
      list("Oxide" 0.15 0.52 0.39 0.76)
      list("Cont" 0.21 0.58 0.33 0.7)
      list("Oxide" 0.69 0.52 0.93 0.76)
      list("Cont" 0.75 0.58 0.87 0.7)
      list("Oxide" 1.23 0.52 1.47 0.76)
      list("Cont" 1.29 0.58 1.41 0.7)
      list("Oxide" 1.77 0.52 2.01 0.76)
      list("Cont" 1.83 0.58 1.95 0.7)
      list("Oxide" 2.31 0.52 2.55 0.76)
      list("Cont" 2.37 0.58 2.49 0.7)
      list("Oxide" 2.85 0.52 3.09 0.76)
      list("Cont" 2.91 0.58 3.03 0.7)
      list("Oxide" 3.39 0.52 3.63 0.76)
      list("Oxide" 3.93 0.52 4.17 0.76)
      list("Cont" 3.99 0.58 4.11 0.7)
      list("Oxide" 4.47 0.52 4.71 0.76)
      list("Cont" 4.53 0.58 4.65 0.7)
      list("Oxide" 5.01 0.52 5.25 0.76)
      list("Cont" 5.07 0.58 5.19 0.7)
      list("Oxide" 5.55 0.52 5.79 0.76)
      list("Cont" 5.61 0.58 5.73 0.7)
      list("Oxide" 6.09 0.52 6.33 0.76)
      list("Cont" 6.15 0.58 6.27 0.7)
      list("Oxide" 6.63 0.52 6.87 0.76)
      list("Cont" 6.69 0.58 6.81 0.7)
      list("Oxide" 7.17 0.52 7.41 0.76)
      list("Cont" 7.23 0.58 7.35 0.7)
      list("Oxide" 7.71 0.52 7.95 0.76)
      list("Cont" 7.77 0.58 7.89 0.7)
      list("Oxide" 8.25 0.52 8.49 0.76)
      list("Cont" 8.31 0.58 8.43 0.7)
      list("Oxide" 8.79 0.52 9.03 0.76)
      list("Oxide" 9.33 0.52 9.57 0.76)
      list("Cont" 9.39 0.58 9.51 0.7)
      list("Oxide" 9.87 0.52 10.11 0.76)
      list("Cont" 9.93 0.58 10.05 0.7)
      list("Oxide" 10.41 0.52 10.65 0.76)
      list("Cont" 10.47 0.58 10.59 0.7)
      list("Oxide" 10.95 0.52 11.19 0.76)
      list("Cont" 11.01 0.58 11.13 0.7)
      list("Oxide" 0.39 0.55 0.69 0.73)
      list("Oxide" 0.93 0.55 1.23 0.73)
      list("Oxide" 1.47 0.55 1.77 0.73)
      list("Oxide" 2.01 0.55 2.31 0.73)
      list("Oxide" 2.55 0.52 2.85 0.76)
      list("Oxide" 3.09 0.52 3.39 0.76)
      list("Oxide" 3.63 0.52 3.93 0.76)
      list("Oxide" 4.17 0.52 4.47 0.76)
      list("Oxide" 4.71 0.52 5.01 0.76)
      list("Oxide" 5.25 0.55 5.55 0.73)
      list("Oxide" 5.79 0.55 6.09 0.73)
      list("Oxide" 6.87 0.58 7.17 0.7)
      list("Oxide" 7.95 0.52 8.25 0.76)
      list("Oxide" 8.49 0.52 8.79 0.76)
      list("Oxide" 9.03 0.52 9.33 0.76)
      list("Oxide" 9.57 0.52 9.87 0.76)
      list("Oxide" 10.11 0.52 10.41 0.76)
      list("Oxide" 10.65 0.58 10.95 0.7)
      list("Oxide" 0.15 1.82 0.39 2.18)
      list("Cont" 0.21 1.94 0.33 2.06)
      list("Oxide" 0.69 1.82 0.93 2.18)
      list("Cont" 0.75 1.94 0.87 2.06)
      list("Oxide" 1.23 1.82 1.47 2.18)
      list("Cont" 1.29 1.94 1.41 2.06)
      list("Oxide" 1.77 1.82 2.01 2.18)
      list("Cont" 1.83 1.94 1.95 2.06)
      list("Oxide" 2.31 1.82 2.55 2.18)
      list("Oxide" 2.85 1.76 3.09 2.24)
      list("Cont" 2.91 1.94 3.03 2.06)
      list("Oxide" 3.39 1.76 3.63 2.24)
      list("Cont" 3.45 1.94 3.57 2.06)
      list("Oxide" 3.93 1.76 4.17 2.24)
      list("Cont" 3.99 1.94 4.11 2.06)
      list("Oxide" 4.47 1.76 4.71 2.24)
      list("Cont" 4.53 1.94 4.65 2.06)
      list("Oxide" 5.01 1.76 5.25 2.24)
      list("Cont" 5.07 1.94 5.19 2.06)
      list("Oxide" 5.55 1.82 5.79 2.18)
      list("Cont" 5.61 1.94 5.73 2.06)
      list("Oxide" 6.09 1.82 6.33 2.18)
      list("Cont" 6.15 1.94 6.27 2.06)
      list("Oxide" 6.63 1.88 6.87 2.12)
      list("Cont" 6.69 1.94 6.81 2.06)
      list("Oxide" 7.17 1.88 7.41 2.12)
      list("Cont" 7.23 1.94 7.35 2.06)
      list("Oxide" 7.71 1.76 7.95 2.24)
      list("Cont" 7.77 1.94 7.89 2.06)
      list("Oxide" 8.25 1.76 8.49 2.24)
      list("Cont" 8.31 1.94 8.43 2.06)
      list("Oxide" 8.79 1.76 9.03 2.24)
      list("Oxide" 9.33 1.76 9.57 2.24)
      list("Cont" 9.39 1.94 9.51 2.06)
      list("Oxide" 9.87 1.76 10.11 2.24)
      list("Cont" 9.93 1.94 10.05 2.06)
      list("Oxide" 10.41 1.76 10.65 2.24)
      list("Cont" 10.47 1.94 10.59 2.06)
      list("Oxide" 10.95 1.88 11.19 2.12)
      list("Cont" 11.01 1.94 11.13 2.06)
      list("Oxide" 0.39 1.82 0.69 2.18)
      list("Oxide" 0.93 1.82 1.23 2.18)
      list("Oxide" 1.47 1.82 1.77 2.18)
      list("Oxide" 2.01 1.82 2.31 2.18)
      list("Oxide" 2.55 1.82 2.85 2.18)
      list("Oxide" 3.09 1.76 3.39 2.24)
      list("Oxide" 3.63 1.76 3.93 2.24)
      list("Oxide" 4.17 1.76 4.47 2.24)
      list("Oxide" 4.71 1.76 5.01 2.24)
      list("Oxide" 5.25 1.82 5.55 2.18)
      list("Oxide" 5.79 1.82 6.09 2.18)
      list("Oxide" 6.87 1.88 7.17 2.12)
      list("Oxide" 7.95 1.76 8.25 2.24)
      list("Oxide" 8.49 1.76 8.79 2.24)
      list("Oxide" 9.03 1.76 9.33 2.24)
      list("Oxide" 9.57 1.76 9.87 2.24)
      list("Oxide" 10.11 1.76 10.41 2.24)
      list("Oxide" 10.65 1.88 10.95 2.12)
      list("Poly" 0.49 0.37 0.59 2.36)
      list("Poly" 0.44 1.2 0.64 1.44)
      list("Cont" 0.48 1.26 0.6 1.38)
      list("Poly" 1.03 0.37 1.13 2.36)
      list("Poly" 0.98 1.2 1.18 1.44)
      list("Cont" 1.02 1.26 1.14 1.38)
      list("Poly" 1.57 0.37 1.67 2.36)
      list("Poly" 1.52 1.2 1.72 1.44)
      list("Cont" 1.56 1.26 1.68 1.38)
      list("Poly" 2.11 0.37 2.21 2.36)
      list("Poly" 2.06 1.2 2.26 1.44)
      list("Cont" 2.1 1.26 2.22 1.38)
      list("Poly" 2.65 0.34 2.75 1.44)
      list("Poly" 2.6 1.2 2.8 1.44)
      list("Cont" 2.64 1.26 2.76 1.38)
      list("Poly" 3.19 0.34 3.29 2.42)
      list("Poly" 3.14 1.2 3.34 1.44)
      list("Cont" 3.18 1.26 3.3 1.38)
      list("Poly" 3.73 1.2 3.83 2.42)
      list("Poly" 3.68 1.2 3.88 1.44)
      list("Cont" 3.72 1.26 3.84 1.38)
      list("Poly" 4.27 0.34 4.37 2.42)
      list("Poly" 4.22 1.2 4.42 1.44)
      list("Cont" 4.26 1.26 4.38 1.38)
      list("Poly" 4.81 0.34 4.91 2.42)
      list("Poly" 4.76 1.2 4.96 1.44)
      list("Cont" 4.8 1.26 4.92 1.38)
      list("Poly" 5.35 0.37 5.45 2.36)
      list("Poly" 5.3 1.2 5.5 1.44)
      list("Cont" 5.34 1.26 5.46 1.38)
      list("Poly" 5.89 0.37 5.99 2.36)
      list("Poly" 5.84 1.2 6.04 1.44)
      list("Cont" 5.88 1.26 6 1.38)
      list("Poly" 6.97 0.4 7.07 2.3)
      list("Poly" 6.92 1.2 7.12 1.44)
      list("Cont" 6.96 1.26 7.08 1.38)
      list("Poly" 8.05 0.34 8.15 2.42)
      list("Poly" 8 1.2 8.2 1.44)
      list("Cont" 8.04 1.26 8.16 1.38)
      list("Poly" 8.59 0.34 8.69 2.42)
      list("Poly" 8.54 1.2 8.74 1.44)
      list("Cont" 8.58 1.26 8.7 1.38)
      list("Poly" 9.13 0.34 9.23 2.42)
      list("Poly" 9.08 1.2 9.28 1.44)
      list("Cont" 9.12 1.26 9.24 1.38)
      list("Poly" 9.67 0.34 9.77 2.42)
      list("Poly" 9.62 1.2 9.82 1.44)
      list("Cont" 9.66 1.26 9.78 1.38)
      list("Poly" 10.21 0.34 10.31 2.42)
      list("Poly" 10.16 1.2 10.36 1.44)
      list("Cont" 10.2 1.26 10.32 1.38)
      list("Poly" 10.75 0.4 10.85 2.3)
      list("Poly" 10.7 1.2 10.9 1.44)
      list("Cont" 10.74 1.26 10.86 1.38)
      list("Metal1" 0.195 0 0.345 0.76)
      list("Metal1" 0.195 1.88 0.345 2.76)
      list("Metal1" 2.355 0 2.505 0.76)
      list("Metal1" 3.975 0 4.125 0.76)
      list("Metal1" 3.975 1.88 4.125 2.76)
      list("Metal1" 7.215 0 7.365 0.76)
      list("Metal1" 8.295 0 8.445 0.76)
      list("Metal1" 8.295 1.88 8.445 2.76)
      list("Metal1" 10.455 0 10.605 0.76)
      list("Metal1" 10.455 1.88 10.605 2.76)
      list("Metal1" 2.895 1.88 3.045 2.76)
      list("Metal1" 6.675 1.88 6.825 2.76)
      list("Metal1" 10.995 0.52 11.145 2.12)
      list("Metal1" 2.895 0.36 3.045 0.84)
      list("Metal1" 4.515 0.36 4.665 0.84)
      list("Via1" 2.9 0.43 3.04 0.57)
      list("Via1" 4.52 0.43 4.66 0.57)
      list("Metal2" 2.84 0.425 4.72 0.575)
      list("Metal1" 0.735 0.36 0.885 0.84)
      list("Metal1" 1.815 0.36 1.965 0.84)
      list("Via1" 0.74 0.43 0.88 0.57)
      list("Via1" 1.82 0.43 1.96 0.57)
      list("Metal2" 0.68 0.425 2.02 0.575)
      list("Metal1" 9.375 0.52 9.525 2.12)
      list("Metal1" 4.785 1.11 4.935 1.59)
      list("Metal1" 6.945 1.11 7.095 1.59)
      list("Via1" 4.79 1.3 4.93 1.44)
      list("Via1" 6.95 1.3 7.09 1.44)
      list("Via1" 9.38 1.3 9.52 1.44)
      list("Metal2" 4.73 1.295 9.58 1.445)
      list("Metal1" 0.735 1.73 0.885 2.21)
      list("Metal1" 1.815 1.73 1.965 2.21)
      list("Via1" 0.74 1.88 0.88 2.02)
      list("Via1" 1.82 1.88 1.96 2.02)
      list("Metal2" 0.68 1.875 2.02 2.025)
      list("Metal1" 1.275 0.48 1.425 0.96)
      list("Metal1" 5.595 0.48 5.745 0.96)
      list("Via1" 1.28 0.72 1.42 0.86)
      list("Via1" 5.6 0.72 5.74 0.86)
      list("Metal2" 1.22 0.715 5.8 0.865)
      list("Metal1" 1.275 1.88 1.425 2.37)
      list("Metal1" 5.595 1.88 5.745 2.37)
      list("Via1" 1.28 2.17 1.42 2.31)
      list("Via2" 1.28 2.17 1.42 2.31)
      list("Via1" 5.6 2.17 5.74 2.31)
      list("Via2" 5.6 2.17 5.74 2.31)
      list("Metal3" 1.22 2.165 5.8 2.315)
      list("Metal2" 1.08 2.165 1.62 2.315)
      list("Metal2" 5.4 2.165 5.94 2.315)
      list("Metal1" 7.755 1.88 7.905 2.37)
      list("Metal1" 9.915 1.88 10.065 2.37)
      list("Via1" 7.76 2.17 7.9 2.31)
      list("Via1" 9.92 2.17 10.06 2.31)
      list("Metal2" 7.7 2.165 10.12 2.315)
      list("Metal1" 6.675 0.52 6.825 1.21)
      list("Metal1" 7.215 0.95 7.365 2.12)
      list("Via1" 6.68 1.01 6.82 1.15)
      list("Via1" 7.22 1.01 7.36 1.15)
      list("Metal2" 6.62 1.005 7.42 1.155)
      list("Metal1" 0.465 1.2 0.615 1.79)
      list("Metal1" 2.085 1.2 2.235 1.79)
      list("Metal1" 2.625 1.2 2.775 1.79)
      list("Metal1" 3.705 1.2 3.855 1.79)
      list("Metal1" 8.565 1.2 8.715 1.79)
      list("Metal1" 10.185 1.2 10.335 1.79)
      list("Via1" 0.47 1.59 0.61 1.73)
      list("Via1" 2.09 1.59 2.23 1.73)
      list("Via1" 2.63 1.59 2.77 1.73)
      list("Via1" 3.71 1.59 3.85 1.73)
      list("Via1" 8.57 1.59 8.71 1.73)
      list("Via1" 10.19 1.59 10.33 1.73)
      list("Metal2" 0.41 1.585 10.39 1.735)
      list("Metal1" 1.005 0.95 1.155 1.44)
      list("Metal1" 1.545 0.95 1.695 1.44)
      list("Metal1" 3.165 0.95 3.315 1.44)
      list("Metal1" 8.025 0.95 8.175 1.44)
      list("Metal1" 9.105 0.95 9.255 1.44)
      list("Via1" 1.01 1.01 1.15 1.15)
      list("Via2" 1.01 1.01 1.15 1.15)
      list("Via1" 1.55 1.01 1.69 1.15)
      list("Via2" 1.55 1.01 1.69 1.15)
      list("Via1" 3.17 1.01 3.31 1.15)
      list("Via2" 3.17 1.01 3.31 1.15)
      list("Via1" 8.03 1.01 8.17 1.15)
      list("Via2" 8.03 1.01 8.17 1.15)
      list("Via1" 9.11 1.01 9.25 1.15)
      list("Via2" 9.11 1.01 9.25 1.15)
      list("Metal3" 0.95 1.005 9.31 1.155)
      list("Metal2" 0.81 1.005 1.35 1.155)
      list("Metal2" 1.35 1.005 1.89 1.155)
      list("Metal2" 2.97 1.005 3.51 1.155)
      list("Metal2" 7.83 1.005 8.37 1.155)
      list("Metal2" 8.91 1.005 9.45 1.155)
      list("Metal1" 4.245 1.2 4.395 2.08)
      list("Metal1" 5.325 1.2 5.475 2.08)
      list("Metal1" 5.865 1.2 6.015 2.08)
      list("Metal1" 9.645 1.2 9.795 2.08)
      list("Via1" 4.25 1.88 4.39 2.02)
      list("Via1" 5.33 1.88 5.47 2.02)
      list("Via1" 5.87 1.88 6.01 2.02)
      list("Via1" 9.65 1.88 9.79 2.02)
      list("Metal2" 4.19 1.875 9.85 2.025)
      list("Metal1" 3.435 1.88 3.585 2.37)
      list("Metal1" 4.515 1.88 4.665 2.37)
      list("Via1" 3.44 2.17 3.58 2.31)
      list("Via1" 4.52 2.17 4.66 2.31)
      list("Metal2" 3.38 2.165 4.72 2.315)
      list("Metal1" 5.055 0.37 5.205 2.12)
      list("Metal1" 6.135 0.37 6.285 2.12)
      list("Metal1" 10.725 0.37 10.875 1.44)
      list("Via1" 5.06 0.43 5.2 0.57)
      list("Via1" 6.14 0.43 6.28 0.57)
      list("Via1" 10.73 0.43 10.87 0.57)
      list("Metal2" 5 0.425 10.93 0.575)
      list("Metal1" 7.755 0.48 7.905 0.96)
      list("Metal1" 9.915 0.48 10.065 0.96)
      list("Via1" 7.76 0.72 7.9 0.86)
      list("Via1" 9.92 0.72 10.06 0.86)
      list("Metal2" 7.7 0.715 10.12 0.865))
    list(list("VSS" "inputOutput" 0 0 11.34 0.24)
      list("VDD" "inputOutput" 0 2.52 11.34 2.76)
      list("A" "input" 0.465 1.2 0.615 1.44)
      list("B" "input" 1.005 1.2 1.155 1.44)
      list("CI" "input" 4.245 1.2 4.395 1.44)
      list("S" "output" 10.995 0.52 11.145 0.76)
      list("CO" "output" 6.675 0.52 6.825 0.76)))
  ;; HA_X1: 18 T (sau khi chia finger), 25 cot
  laDraw("ALU_CELLS_C" "HA_X1" 7.02
    list(list("Oxide" 0 0 7.02 0.24)
      list("Pimp" -0.02 -0.02 7.04 0.26)
      list("Oxide" 0 2.52 7.02 2.76)
      list("Nimp" -0.02 2.42 7.04 2.78)
      list("Nwell" -0.12 1.38 7.14 2.88)
      list("Nimp" 0 0.26 7.02 1)
      list("Pimp" 0 1.5 7.02 2.42)
      list("prBoundary" 0 0 7.02 2.76)
      list("Metal1" 0 0 7.02 0.24)
      list("Metal1" 0 2.52 7.02 2.76)
      list("Cont" 0.21 0.06 0.33 0.18)
      list("Cont" 0.21 2.58 0.33 2.7)
      list("Cont" 0.48 0.06 0.6 0.18)
      list("Cont" 0.48 2.58 0.6 2.7)
      list("Cont" 0.75 0.06 0.87 0.18)
      list("Cont" 0.75 2.58 0.87 2.7)
      list("Cont" 1.02 0.06 1.14 0.18)
      list("Cont" 1.02 2.58 1.14 2.7)
      list("Cont" 1.29 0.06 1.41 0.18)
      list("Cont" 1.29 2.58 1.41 2.7)
      list("Cont" 1.56 0.06 1.68 0.18)
      list("Cont" 1.56 2.58 1.68 2.7)
      list("Cont" 1.83 0.06 1.95 0.18)
      list("Cont" 1.83 2.58 1.95 2.7)
      list("Cont" 2.1 0.06 2.22 0.18)
      list("Cont" 2.1 2.58 2.22 2.7)
      list("Cont" 2.37 0.06 2.49 0.18)
      list("Cont" 2.37 2.58 2.49 2.7)
      list("Cont" 2.64 0.06 2.76 0.18)
      list("Cont" 2.64 2.58 2.76 2.7)
      list("Cont" 2.91 0.06 3.03 0.18)
      list("Cont" 2.91 2.58 3.03 2.7)
      list("Cont" 3.18 0.06 3.3 0.18)
      list("Cont" 3.18 2.58 3.3 2.7)
      list("Cont" 3.45 0.06 3.57 0.18)
      list("Cont" 3.45 2.58 3.57 2.7)
      list("Cont" 3.72 0.06 3.84 0.18)
      list("Cont" 3.72 2.58 3.84 2.7)
      list("Cont" 3.99 0.06 4.11 0.18)
      list("Cont" 3.99 2.58 4.11 2.7)
      list("Cont" 4.26 0.06 4.38 0.18)
      list("Cont" 4.26 2.58 4.38 2.7)
      list("Cont" 4.53 0.06 4.65 0.18)
      list("Cont" 4.53 2.58 4.65 2.7)
      list("Cont" 4.8 0.06 4.92 0.18)
      list("Cont" 4.8 2.58 4.92 2.7)
      list("Cont" 5.07 0.06 5.19 0.18)
      list("Cont" 5.07 2.58 5.19 2.7)
      list("Cont" 5.34 0.06 5.46 0.18)
      list("Cont" 5.34 2.58 5.46 2.7)
      list("Cont" 5.61 0.06 5.73 0.18)
      list("Cont" 5.61 2.58 5.73 2.7)
      list("Cont" 5.88 0.06 6 0.18)
      list("Cont" 5.88 2.58 6 2.7)
      list("Cont" 6.15 0.06 6.27 0.18)
      list("Cont" 6.15 2.58 6.27 2.7)
      list("Cont" 6.42 0.06 6.54 0.18)
      list("Cont" 6.42 2.58 6.54 2.7)
      list("Cont" 6.69 0.06 6.81 0.18)
      list("Cont" 6.69 2.58 6.81 2.7)
      list("Oxide" 0.15 0.52 0.39 0.76)
      list("Cont" 0.21 0.58 0.33 0.7)
      list("Oxide" 0.69 0.52 0.93 0.76)
      list("Cont" 0.75 0.58 0.87 0.7)
      list("Oxide" 1.23 0.52 1.47 0.76)
      list("Oxide" 1.77 0.52 2.01 0.76)
      list("Cont" 1.83 0.58 1.95 0.7)
      list("Oxide" 2.31 0.52 2.55 0.76)
      list("Cont" 2.37 0.58 2.49 0.7)
      list("Oxide" 2.85 0.52 3.09 0.76)
      list("Cont" 2.91 0.58 3.03 0.7)
      list("Oxide" 3.39 0.52 3.63 0.76)
      list("Cont" 3.45 0.58 3.57 0.7)
      list("Oxide" 3.93 0.52 4.17 0.76)
      list("Oxide" 4.47 0.52 4.71 0.76)
      list("Cont" 4.53 0.58 4.65 0.7)
      list("Oxide" 5.01 0.52 5.25 0.76)
      list("Cont" 5.07 0.58 5.19 0.7)
      list("Oxide" 5.55 0.52 5.79 0.76)
      list("Cont" 5.61 0.58 5.73 0.7)
      list("Oxide" 6.09 0.52 6.33 0.76)
      list("Cont" 6.15 0.58 6.27 0.7)
      list("Oxide" 6.63 0.52 6.87 0.76)
      list("Cont" 6.69 0.58 6.81 0.7)
      list("Oxide" 0.39 0.52 0.69 0.76)
      list("Oxide" 0.93 0.52 1.23 0.76)
      list("Oxide" 1.47 0.52 1.77 0.76)
      list("Oxide" 2.01 0.52 2.31 0.76)
      list("Oxide" 3.09 0.58 3.39 0.7)
      list("Oxide" 3.63 0.52 3.93 0.76)
      list("Oxide" 4.17 0.52 4.47 0.76)
      list("Oxide" 5.25 0.58 5.55 0.7)
      list("Oxide" 6.33 0.58 6.63 0.7)
      list("Oxide" 0.15 1.76 0.39 2.24)
      list("Cont" 0.21 1.94 0.33 2.06)
      list("Oxide" 0.69 1.76 0.93 2.24)
      list("Cont" 0.75 1.94 0.87 2.06)
      list("Oxide" 1.23 1.76 1.47 2.24)
      list("Cont" 1.29 1.94 1.41 2.06)
      list("Oxide" 1.77 1.76 2.01 2.24)
      list("Cont" 1.83 1.94 1.95 2.06)
      list("Oxide" 2.31 1.76 2.55 2.24)
      list("Cont" 2.37 1.94 2.49 2.06)
      list("Oxide" 2.85 1.88 3.09 2.12)
      list("Cont" 2.91 1.94 3.03 2.06)
      list("Oxide" 3.39 1.88 3.63 2.12)
      list("Cont" 3.45 1.94 3.57 2.06)
      list("Oxide" 3.93 1.88 4.17 2.12)
      list("Cont" 3.99 1.94 4.11 2.06)
      list("Oxide" 4.47 1.88 4.71 2.12)
      list("Cont" 4.53 1.94 4.65 2.06)
      list("Oxide" 5.01 1.88 5.25 2.12)
      list("Cont" 5.07 1.94 5.19 2.06)
      list("Oxide" 5.55 1.88 5.79 2.12)
      list("Cont" 5.61 1.94 5.73 2.06)
      list("Oxide" 6.09 1.88 6.33 2.12)
      list("Cont" 6.15 1.94 6.27 2.06)
      list("Oxide" 6.63 1.88 6.87 2.12)
      list("Cont" 6.69 1.94 6.81 2.06)
      list("Oxide" 0.39 1.76 0.69 2.24)
      list("Oxide" 0.93 1.76 1.23 2.24)
      list("Oxide" 1.47 1.76 1.77 2.24)
      list("Oxide" 2.01 1.76 2.31 2.24)
      list("Oxide" 3.09 1.88 3.39 2.12)
      list("Oxide" 3.63 1.88 3.93 2.12)
      list("Oxide" 4.17 1.88 4.47 2.12)
      list("Oxide" 5.25 1.88 5.55 2.12)
      list("Oxide" 6.33 1.88 6.63 2.12)
      list("Poly" 0.49 0.34 0.59 2.42)
      list("Poly" 0.44 1.2 0.64 1.44)
      list("Cont" 0.48 1.26 0.6 1.38)
      list("Poly" 1.03 0.34 1.13 2.42)
      list("Poly" 0.98 1.2 1.18 1.44)
      list("Cont" 1.02 1.26 1.14 1.38)
      list("Poly" 1.57 0.34 1.67 2.42)
      list("Poly" 1.52 1.2 1.72 1.44)
      list("Cont" 1.56 1.26 1.68 1.38)
      list("Poly" 2.11 0.34 2.21 2.42)
      list("Poly" 2.06 1.2 2.26 1.44)
      list("Cont" 2.1 1.26 2.22 1.38)
      list("Poly" 3.19 0.4 3.29 2.3)
      list("Poly" 3.14 1.2 3.34 1.44)
      list("Cont" 3.18 1.26 3.3 1.38)
      list("Poly" 3.73 0.34 3.83 2.3)
      list("Poly" 3.68 1.2 3.88 1.44)
      list("Cont" 3.72 1.26 3.84 1.38)
      list("Poly" 4.27 0.34 4.37 2.3)
      list("Poly" 4.22 1.2 4.42 1.44)
      list("Cont" 4.26 1.26 4.38 1.38)
      list("Poly" 5.35 0.4 5.45 2.3)
      list("Poly" 5.3 1.2 5.5 1.44)
      list("Cont" 5.34 1.26 5.46 1.38)
      list("Poly" 6.43 0.4 6.53 2.3)
      list("Poly" 6.38 1.2 6.58 1.44)
      list("Cont" 6.42 1.26 6.54 1.38)
      list("Metal1" 1.815 0 1.965 0.76)
      list("Metal1" 3.435 0 3.585 0.76)
      list("Metal1" 3.435 1.88 3.585 2.76)
      list("Metal1" 5.055 0 5.205 0.76)
      list("Metal1" 6.675 0 6.825 0.76)
      list("Metal1" 0.195 1.88 0.345 2.76)
      list("Metal1" 2.355 1.88 2.505 2.76)
      list("Metal1" 4.515 1.88 4.665 2.76)
      list("Metal1" 5.595 1.88 5.745 2.76)
      list("Metal1" 6.135 1.88 6.285 2.76)
      list("Metal1" 2.895 0.52 3.045 2.12)
      list("Metal1" 1.005 1.11 1.155 1.59)
      list("Via1" 1.01 1.3 1.15 1.44)
      list("Via1" 2.9 1.3 3.04 1.44)
      list("Metal2" 0.95 1.295 3.1 1.445)
      list("Metal1" 0.195 0.36 0.345 0.84)
      list("Metal1" 2.355 0.36 2.505 0.84)
      list("Via1" 0.2 0.43 0.34 0.57)
      list("Via1" 2.36 0.43 2.5 0.57)
      list("Metal2" 0.14 0.425 2.56 0.575)
      list("Metal1" 5.595 0.52 5.745 1.5)
      list("Metal1" 5.055 1.24 5.205 2.12)
      list("Via1" 5.06 1.3 5.2 1.44)
      list("Via1" 5.6 1.3 5.74 1.44)
      list("Metal2" 5 1.295 5.8 1.445)
      list("Metal1" 2.085 1.2 2.235 1.79)
      list("Metal1" 3.705 1.2 3.855 1.79)
      list("Metal1" 6.405 1.2 6.555 1.79)
      list("Via1" 2.09 1.59 2.23 1.73)
      list("Via1" 3.71 1.59 3.85 1.73)
      list("Via1" 6.41 1.59 6.55 1.73)
      list("Metal2" 2.03 1.585 6.61 1.735)
      list("Metal1" 6.135 0.52 6.285 1.21)
      list("Metal1" 6.675 0.95 6.825 2.12)
      list("Metal1" 1.545 0.95 1.695 1.44)
      list("Via1" 1.55 1.01 1.69 1.15)
      list("Via1" 6.14 1.01 6.28 1.15)
      list("Via1" 6.68 1.01 6.82 1.15)
      list("Metal2" 1.49 1.005 6.88 1.155)
      list("Metal1" 0.735 0.48 0.885 0.96)
      list("Metal1" 1.275 0.66 1.425 2.12)
      list("Via1" 0.74 0.72 0.88 0.86)
      list("Via1" 1.28 0.72 1.42 0.86)
      list("Metal2" 0.68 0.715 1.48 0.865)
      list("Metal1" 0.735 1.73 0.885 2.21)
      list("Metal1" 1.815 1.73 1.965 2.21)
      list("Via1" 0.74 1.88 0.88 2.02)
      list("Via1" 1.82 1.88 1.96 2.02)
      list("Metal2" 0.68 1.875 2.02 2.025)
      list("Metal1" 4.515 0.48 4.665 0.96)
      list("Metal1" 3.975 0.66 4.125 2.12)
      list("Metal1" 5.325 0.66 5.475 1.44)
      list("Via1" 3.98 0.72 4.12 0.86)
      list("Via1" 4.52 0.72 4.66 0.86)
      list("Via1" 5.33 0.72 5.47 0.86)
      list("Metal2" 3.92 0.715 5.53 0.865)
      list("Metal1" 0.465 1.2 0.615 2.37)
      list("Metal1" 3.165 1.2 3.315 2.37)
      list("Metal1" 4.245 1.2 4.395 2.37)
      list("Via1" 0.47 2.17 0.61 2.31)
      list("Via1" 3.17 2.17 3.31 2.31)
      list("Via1" 4.25 2.17 4.39 2.31)
      list("Metal2" 0.41 2.165 4.45 2.315))
    list(list("VSS" "inputOutput" 0 0 7.02 0.24)
      list("VDD" "inputOutput" 0 2.52 7.02 2.76)
      list("A" "input" 0.465 1.2 0.615 1.44)
      list("B" "input" 2.085 1.2 2.235 1.44)
      list("S" "output" 0.735 0.52 0.885 0.76)
      list("CO" "output" 5.055 1.88 5.205 2.12)))
  ;; INV_X4: 4 T (sau khi chia finger), 5 cot
  laDraw("ALU_CELLS_C" "INV_X4" 1.62
    list(list("Oxide" 0 0 1.62 0.24)
      list("Pimp" -0.02 -0.02 1.64 0.26)
      list("Oxide" 0 2.52 1.62 2.76)
      list("Nimp" -0.02 2.42 1.64 2.78)
      list("Nwell" -0.12 1.38 1.74 2.88)
      list("Nimp" 0 0.26 1.62 1)
      list("Pimp" 0 1.5 1.62 2.42)
      list("prBoundary" 0 0 1.62 2.76)
      list("Metal1" 0 0 1.62 0.24)
      list("Metal1" 0 2.52 1.62 2.76)
      list("Cont" 0.21 0.06 0.33 0.18)
      list("Cont" 0.21 2.58 0.33 2.7)
      list("Cont" 0.48 0.06 0.6 0.18)
      list("Cont" 0.48 2.58 0.6 2.7)
      list("Cont" 0.75 0.06 0.87 0.18)
      list("Cont" 0.75 2.58 0.87 2.7)
      list("Cont" 1.02 0.06 1.14 0.18)
      list("Cont" 1.02 2.58 1.14 2.7)
      list("Cont" 1.29 0.06 1.41 0.18)
      list("Cont" 1.29 2.58 1.41 2.7)
      list("Oxide" 0.15 0.52 0.39 0.76)
      list("Cont" 0.21 0.58 0.33 0.7)
      list("Oxide" 0.69 0.52 0.93 0.76)
      list("Cont" 0.75 0.58 0.87 0.7)
      list("Oxide" 1.23 0.52 1.47 0.76)
      list("Cont" 1.29 0.58 1.41 0.7)
      list("Oxide" 0.39 0.52 0.69 0.76)
      list("Oxide" 0.93 0.52 1.23 0.76)
      list("Oxide" 0.15 1.76 0.39 2.24)
      list("Cont" 0.21 1.94 0.33 2.06)
      list("Oxide" 0.69 1.76 0.93 2.24)
      list("Cont" 0.75 1.94 0.87 2.06)
      list("Oxide" 1.23 1.76 1.47 2.24)
      list("Cont" 1.29 1.94 1.41 2.06)
      list("Oxide" 0.39 1.76 0.69 2.24)
      list("Oxide" 0.93 1.76 1.23 2.24)
      list("Poly" 0.49 0.34 0.59 2.42)
      list("Poly" 0.44 1.2 0.64 1.44)
      list("Cont" 0.48 1.26 0.6 1.38)
      list("Poly" 1.03 0.34 1.13 2.42)
      list("Poly" 0.98 1.2 1.18 1.44)
      list("Cont" 1.02 1.26 1.14 1.38)
      list("Metal1" 0.195 0 0.345 0.76)
      list("Metal1" 0.195 1.88 0.345 2.76)
      list("Metal1" 1.275 0 1.425 0.76)
      list("Metal1" 1.275 1.88 1.425 2.76)
      list("Metal1" 0.735 0.52 0.885 2.12)
      list("Metal1" 0.465 1.11 0.615 1.59)
      list("Metal1" 1.005 1.11 1.155 1.59)
      list("Via1" 0.47 1.3 0.61 1.44)
      list("Via1" 1.01 1.3 1.15 1.44)
      list("Metal2" 0.41 1.295 1.21 1.445))
    list(list("VSS" "inputOutput" 0 0 1.62 0.24)
      list("VDD" "inputOutput" 0 2.52 1.62 2.76)
      list("A" "input" 0.465 1.2 0.615 1.44)
      list("Y" "output" 0.735 0.52 0.885 0.76)))
  ;; CAS_X1: 48 T (sau khi chia finger), 73 cot
  laDraw("ALU_CELLS_D" "CAS_X1" 19.98
    list(list("Oxide" 0 0 19.98 0.24)
      list("Pimp" -0.02 -0.02 20 0.26)
      list("Oxide" 0 2.52 19.98 2.76)
      list("Nimp" -0.02 2.42 20 2.78)
      list("Nwell" -0.12 1.38 20.1 2.88)
      list("Nimp" 0 0.26 19.98 1)
      list("Pimp" 0 1.5 19.98 2.42)
      list("prBoundary" 0 0 19.98 2.76)
      list("Metal1" 0 0 19.98 0.24)
      list("Metal1" 0 2.52 19.98 2.76)
      list("Cont" 0.21 0.06 0.33 0.18)
      list("Cont" 0.21 2.58 0.33 2.7)
      list("Cont" 0.48 0.06 0.6 0.18)
      list("Cont" 0.48 2.58 0.6 2.7)
      list("Cont" 0.75 0.06 0.87 0.18)
      list("Cont" 0.75 2.58 0.87 2.7)
      list("Cont" 1.02 0.06 1.14 0.18)
      list("Cont" 1.02 2.58 1.14 2.7)
      list("Cont" 1.29 0.06 1.41 0.18)
      list("Cont" 1.29 2.58 1.41 2.7)
      list("Cont" 1.56 0.06 1.68 0.18)
      list("Cont" 1.56 2.58 1.68 2.7)
      list("Cont" 1.83 0.06 1.95 0.18)
      list("Cont" 1.83 2.58 1.95 2.7)
      list("Cont" 2.1 0.06 2.22 0.18)
      list("Cont" 2.1 2.58 2.22 2.7)
      list("Cont" 2.37 0.06 2.49 0.18)
      list("Cont" 2.37 2.58 2.49 2.7)
      list("Cont" 2.64 0.06 2.76 0.18)
      list("Cont" 2.64 2.58 2.76 2.7)
      list("Cont" 2.91 0.06 3.03 0.18)
      list("Cont" 2.91 2.58 3.03 2.7)
      list("Cont" 3.18 0.06 3.3 0.18)
      list("Cont" 3.18 2.58 3.3 2.7)
      list("Cont" 3.45 0.06 3.57 0.18)
      list("Cont" 3.45 2.58 3.57 2.7)
      list("Cont" 3.72 0.06 3.84 0.18)
      list("Cont" 3.72 2.58 3.84 2.7)
      list("Cont" 3.99 0.06 4.11 0.18)
      list("Cont" 3.99 2.58 4.11 2.7)
      list("Cont" 4.26 0.06 4.38 0.18)
      list("Cont" 4.26 2.58 4.38 2.7)
      list("Cont" 4.53 0.06 4.65 0.18)
      list("Cont" 4.53 2.58 4.65 2.7)
      list("Cont" 4.8 0.06 4.92 0.18)
      list("Cont" 4.8 2.58 4.92 2.7)
      list("Cont" 5.07 0.06 5.19 0.18)
      list("Cont" 5.07 2.58 5.19 2.7)
      list("Cont" 5.34 0.06 5.46 0.18)
      list("Cont" 5.34 2.58 5.46 2.7)
      list("Cont" 5.61 0.06 5.73 0.18)
      list("Cont" 5.61 2.58 5.73 2.7)
      list("Cont" 5.88 0.06 6 0.18)
      list("Cont" 5.88 2.58 6 2.7)
      list("Cont" 6.15 0.06 6.27 0.18)
      list("Cont" 6.15 2.58 6.27 2.7)
      list("Cont" 6.42 0.06 6.54 0.18)
      list("Cont" 6.42 2.58 6.54 2.7)
      list("Cont" 6.69 0.06 6.81 0.18)
      list("Cont" 6.69 2.58 6.81 2.7)
      list("Cont" 6.96 0.06 7.08 0.18)
      list("Cont" 6.96 2.58 7.08 2.7)
      list("Cont" 7.23 0.06 7.35 0.18)
      list("Cont" 7.23 2.58 7.35 2.7)
      list("Cont" 7.5 0.06 7.62 0.18)
      list("Cont" 7.5 2.58 7.62 2.7)
      list("Cont" 7.77 0.06 7.89 0.18)
      list("Cont" 7.77 2.58 7.89 2.7)
      list("Cont" 8.04 0.06 8.16 0.18)
      list("Cont" 8.04 2.58 8.16 2.7)
      list("Cont" 8.31 0.06 8.43 0.18)
      list("Cont" 8.31 2.58 8.43 2.7)
      list("Cont" 8.58 0.06 8.7 0.18)
      list("Cont" 8.58 2.58 8.7 2.7)
      list("Cont" 8.85 0.06 8.97 0.18)
      list("Cont" 8.85 2.58 8.97 2.7)
      list("Cont" 9.12 0.06 9.24 0.18)
      list("Cont" 9.12 2.58 9.24 2.7)
      list("Cont" 9.39 0.06 9.51 0.18)
      list("Cont" 9.39 2.58 9.51 2.7)
      list("Cont" 9.66 0.06 9.78 0.18)
      list("Cont" 9.66 2.58 9.78 2.7)
      list("Cont" 9.93 0.06 10.05 0.18)
      list("Cont" 9.93 2.58 10.05 2.7)
      list("Cont" 10.2 0.06 10.32 0.18)
      list("Cont" 10.2 2.58 10.32 2.7)
      list("Cont" 10.47 0.06 10.59 0.18)
      list("Cont" 10.47 2.58 10.59 2.7)
      list("Cont" 10.74 0.06 10.86 0.18)
      list("Cont" 10.74 2.58 10.86 2.7)
      list("Cont" 11.01 0.06 11.13 0.18)
      list("Cont" 11.01 2.58 11.13 2.7)
      list("Cont" 11.28 0.06 11.4 0.18)
      list("Cont" 11.28 2.58 11.4 2.7)
      list("Cont" 11.55 0.06 11.67 0.18)
      list("Cont" 11.55 2.58 11.67 2.7)
      list("Cont" 11.82 0.06 11.94 0.18)
      list("Cont" 11.82 2.58 11.94 2.7)
      list("Cont" 12.09 0.06 12.21 0.18)
      list("Cont" 12.09 2.58 12.21 2.7)
      list("Cont" 12.36 0.06 12.48 0.18)
      list("Cont" 12.36 2.58 12.48 2.7)
      list("Cont" 12.63 0.06 12.75 0.18)
      list("Cont" 12.63 2.58 12.75 2.7)
      list("Cont" 12.9 0.06 13.02 0.18)
      list("Cont" 12.9 2.58 13.02 2.7)
      list("Cont" 13.17 0.06 13.29 0.18)
      list("Cont" 13.17 2.58 13.29 2.7)
      list("Cont" 13.44 0.06 13.56 0.18)
      list("Cont" 13.44 2.58 13.56 2.7)
      list("Cont" 13.71 0.06 13.83 0.18)
      list("Cont" 13.71 2.58 13.83 2.7)
      list("Cont" 13.98 0.06 14.1 0.18)
      list("Cont" 13.98 2.58 14.1 2.7)
      list("Cont" 14.25 0.06 14.37 0.18)
      list("Cont" 14.25 2.58 14.37 2.7)
      list("Cont" 14.52 0.06 14.64 0.18)
      list("Cont" 14.52 2.58 14.64 2.7)
      list("Cont" 14.79 0.06 14.91 0.18)
      list("Cont" 14.79 2.58 14.91 2.7)
      list("Cont" 15.06 0.06 15.18 0.18)
      list("Cont" 15.06 2.58 15.18 2.7)
      list("Cont" 15.33 0.06 15.45 0.18)
      list("Cont" 15.33 2.58 15.45 2.7)
      list("Cont" 15.6 0.06 15.72 0.18)
      list("Cont" 15.6 2.58 15.72 2.7)
      list("Cont" 15.87 0.06 15.99 0.18)
      list("Cont" 15.87 2.58 15.99 2.7)
      list("Cont" 16.14 0.06 16.26 0.18)
      list("Cont" 16.14 2.58 16.26 2.7)
      list("Cont" 16.41 0.06 16.53 0.18)
      list("Cont" 16.41 2.58 16.53 2.7)
      list("Cont" 16.68 0.06 16.8 0.18)
      list("Cont" 16.68 2.58 16.8 2.7)
      list("Cont" 16.95 0.06 17.07 0.18)
      list("Cont" 16.95 2.58 17.07 2.7)
      list("Cont" 17.22 0.06 17.34 0.18)
      list("Cont" 17.22 2.58 17.34 2.7)
      list("Cont" 17.49 0.06 17.61 0.18)
      list("Cont" 17.49 2.58 17.61 2.7)
      list("Cont" 17.76 0.06 17.88 0.18)
      list("Cont" 17.76 2.58 17.88 2.7)
      list("Cont" 18.03 0.06 18.15 0.18)
      list("Cont" 18.03 2.58 18.15 2.7)
      list("Cont" 18.3 0.06 18.42 0.18)
      list("Cont" 18.3 2.58 18.42 2.7)
      list("Cont" 18.57 0.06 18.69 0.18)
      list("Cont" 18.57 2.58 18.69 2.7)
      list("Cont" 18.84 0.06 18.96 0.18)
      list("Cont" 18.84 2.58 18.96 2.7)
      list("Cont" 19.11 0.06 19.23 0.18)
      list("Cont" 19.11 2.58 19.23 2.7)
      list("Cont" 19.38 0.06 19.5 0.18)
      list("Cont" 19.38 2.58 19.5 2.7)
      list("Cont" 19.65 0.06 19.77 0.18)
      list("Cont" 19.65 2.58 19.77 2.7)
      list("Oxide" 0.15 0.52 0.39 0.76)
      list("Cont" 0.21 0.58 0.33 0.7)
      list("Oxide" 0.69 0.52 0.93 0.76)
      list("Cont" 0.75 0.58 0.87 0.7)
      list("Oxide" 1.23 0.52 1.47 0.76)
      list("Oxide" 1.77 0.52 2.01 0.76)
      list("Cont" 1.83 0.58 1.95 0.7)
      list("Oxide" 2.31 0.52 2.55 0.76)
      list("Oxide" 2.85 0.52 3.09 0.76)
      list("Cont" 2.91 0.58 3.03 0.7)
      list("Oxide" 3.39 0.52 3.63 0.76)
      list("Oxide" 3.93 0.52 4.17 0.76)
      list("Cont" 3.99 0.58 4.11 0.7)
      list("Oxide" 4.47 0.52 4.71 0.76)
      list("Cont" 4.53 0.58 4.65 0.7)
      list("Oxide" 5.01 0.52 5.25 0.76)
      list("Cont" 5.07 0.58 5.19 0.7)
      list("Oxide" 5.55 0.52 5.79 0.76)
      list("Cont" 5.61 0.58 5.73 0.7)
      list("Oxide" 6.09 0.52 6.33 0.76)
      list("Oxide" 6.63 0.52 6.87 0.76)
      list("Cont" 6.69 0.58 6.81 0.7)
      list("Oxide" 7.17 0.52 7.41 0.76)
      list("Cont" 7.23 0.58 7.35 0.7)
      list("Oxide" 7.71 0.52 7.95 0.76)
      list("Oxide" 8.25 0.52 8.49 0.76)
      list("Cont" 8.31 0.58 8.43 0.7)
      list("Oxide" 8.79 0.52 9.03 0.76)
      list("Cont" 8.85 0.58 8.97 0.7)
      list("Oxide" 9.33 0.52 9.57 0.76)
      list("Cont" 9.39 0.58 9.51 0.7)
      list("Oxide" 9.87 0.52 10.11 0.76)
      list("Oxide" 10.41 0.52 10.65 0.76)
      list("Cont" 10.47 0.58 10.59 0.7)
      list("Oxide" 10.95 0.52 11.19 0.76)
      list("Oxide" 11.49 0.52 11.73 0.76)
      list("Cont" 11.55 0.58 11.67 0.7)
      list("Oxide" 12.03 0.52 12.27 0.76)
      list("Oxide" 12.57 0.52 12.81 0.76)
      list("Cont" 12.63 0.58 12.75 0.7)
      list("Oxide" 13.11 0.52 13.35 0.76)
      list("Cont" 13.17 0.58 13.29 0.7)
      list("Oxide" 13.65 0.52 13.89 0.76)
      list("Oxide" 14.19 0.52 14.43 0.76)
      list("Cont" 14.25 0.58 14.37 0.7)
      list("Oxide" 14.73 0.52 14.97 0.76)
      list("Cont" 14.79 0.58 14.91 0.7)
      list("Oxide" 15.27 0.52 15.51 0.76)
      list("Cont" 15.33 0.58 15.45 0.7)
      list("Oxide" 15.81 0.52 16.05 0.76)
      list("Cont" 15.87 0.58 15.99 0.7)
      list("Oxide" 16.35 0.52 16.59 0.76)
      list("Cont" 16.41 0.58 16.53 0.7)
      list("Oxide" 16.89 0.52 17.13 0.76)
      list("Cont" 16.95 0.58 17.07 0.7)
      list("Oxide" 17.43 0.52 17.67 0.76)
      list("Cont" 17.49 0.58 17.61 0.7)
      list("Oxide" 17.97 0.52 18.21 0.76)
      list("Oxide" 18.51 0.52 18.75 0.76)
      list("Cont" 18.57 0.58 18.69 0.7)
      list("Oxide" 19.05 0.52 19.29 0.76)
      list("Oxide" 19.59 0.52 19.83 0.76)
      list("Cont" 19.65 0.58 19.77 0.7)
      list("Oxide" 0.39 0.58 0.69 0.7)
      list("Oxide" 1.47 0.52 1.77 0.76)
      list("Oxide" 2.01 0.52 2.31 0.76)
      list("Oxide" 2.55 0.52 2.85 0.76)
      list("Oxide" 3.09 0.52 3.39 0.76)
      list("Oxide" 3.63 0.52 3.93 0.76)
      list("Oxide" 4.71 0.58 5.01 0.7)
      list("Oxide" 5.79 0.52 6.09 0.76)
      list("Oxide" 6.33 0.52 6.63 0.76)
      list("Oxide" 7.41 0.52 7.71 0.76)
      list("Oxide" 7.95 0.52 8.25 0.76)
      list("Oxide" 9.03 0.58 9.33 0.7)
      list("Oxide" 10.11 0.52 10.41 0.76)
      list("Oxide" 10.65 0.52 10.95 0.76)
      list("Oxide" 11.19 0.52 11.49 0.76)
      list("Oxide" 11.73 0.52 12.03 0.76)
      list("Oxide" 12.27 0.52 12.57 0.76)
      list("Oxide" 13.35 0.52 13.65 0.76)
      list("Oxide" 13.89 0.52 14.19 0.76)
      list("Oxide" 14.97 0.58 15.27 0.7)
      list("Oxide" 16.05 0.58 16.35 0.7)
      list("Oxide" 16.59 0.58 16.89 0.7)
      list("Oxide" 17.67 0.52 17.97 0.76)
      list("Oxide" 18.21 0.52 18.51 0.76)
      list("Oxide" 18.75 0.52 19.05 0.76)
      list("Oxide" 19.29 0.52 19.59 0.76)
      list("Oxide" 0.15 1.88 0.39 2.12)
      list("Cont" 0.21 1.94 0.33 2.06)
      list("Oxide" 0.69 1.88 0.93 2.12)
      list("Cont" 0.75 1.94 0.87 2.06)
      list("Oxide" 1.23 1.76 1.47 2.24)
      list("Cont" 1.29 1.94 1.41 2.06)
      list("Oxide" 1.77 1.76 2.01 2.24)
      list("Cont" 1.83 1.94 1.95 2.06)
      list("Oxide" 2.31 1.76 2.55 2.24)
      list("Cont" 2.37 1.94 2.49 2.06)
      list("Oxide" 2.85 1.76 3.09 2.24)
      list("Cont" 2.91 1.94 3.03 2.06)
      list("Oxide" 3.39 1.76 3.63 2.24)
      list("Oxide" 3.93 1.88 4.17 2.12)
      list("Cont" 3.99 1.94 4.11 2.06)
      list("Oxide" 4.47 1.88 4.71 2.12)
      list("Cont" 4.53 1.94 4.65 2.06)
      list("Oxide" 5.01 1.88 5.25 2.12)
      list("Cont" 5.07 1.94 5.19 2.06)
      list("Oxide" 5.55 1.88 5.79 2.12)
      list("Cont" 5.61 1.94 5.73 2.06)
      list("Oxide" 6.09 1.88 6.33 2.12)
      list("Cont" 6.15 1.94 6.27 2.06)
      list("Oxide" 6.63 1.88 6.87 2.12)
      list("Cont" 6.69 1.94 6.81 2.06)
      list("Oxide" 7.17 1.88 7.41 2.12)
      list("Cont" 7.23 1.94 7.35 2.06)
      list("Oxide" 7.71 1.88 7.95 2.12)
      list("Cont" 7.77 1.94 7.89 2.06)
      list("Oxide" 8.25 1.88 8.49 2.12)
      list("Cont" 8.31 1.94 8.43 2.06)
      list("Oxide" 8.79 1.88 9.03 2.12)
      list("Cont" 8.85 1.94 8.97 2.06)
      list("Oxide" 9.33 1.88 9.57 2.12)
      list("Cont" 9.39 1.94 9.51 2.06)
      list("Oxide" 9.87 1.76 10.11 2.24)
      list("Cont" 9.93 1.94 10.05 2.06)
      list("Oxide" 10.41 1.76 10.65 2.24)
      list("Cont" 10.47 1.94 10.59 2.06)
      list("Oxide" 10.95 1.76 11.19 2.24)
      list("Oxide" 11.49 1.76 11.73 2.24)
      list("Cont" 11.55 1.94 11.67 2.06)
      list("Oxide" 12.03 1.76 12.27 2.24)
      list("Cont" 12.09 1.94 12.21 2.06)
      list("Oxide" 12.57 1.76 12.81 2.24)
      list("Cont" 12.63 1.94 12.75 2.06)
      list("Oxide" 13.11 1.88 13.35 2.12)
      list("Cont" 13.17 1.94 13.29 2.06)
      list("Oxide" 13.65 1.88 13.89 2.12)
      list("Cont" 13.71 1.94 13.83 2.06)
      list("Oxide" 14.19 1.88 14.43 2.12)
      list("Cont" 14.25 1.94 14.37 2.06)
      list("Oxide" 14.73 1.88 14.97 2.12)
      list("Cont" 14.79 1.94 14.91 2.06)
      list("Oxide" 15.27 1.88 15.51 2.12)
      list("Cont" 15.33 1.94 15.45 2.06)
      list("Oxide" 15.81 1.88 16.05 2.12)
      list("Cont" 15.87 1.94 15.99 2.06)
      list("Oxide" 16.35 1.88 16.59 2.12)
      list("Cont" 16.41 1.94 16.53 2.06)
      list("Oxide" 16.89 1.88 17.13 2.12)
      list("Cont" 16.95 1.94 17.07 2.06)
      list("Oxide" 17.43 1.76 17.67 2.24)
      list("Cont" 17.49 1.94 17.61 2.06)
      list("Oxide" 17.97 1.76 18.21 2.24)
      list("Cont" 18.03 1.94 18.15 2.06)
      list("Oxide" 18.51 1.76 18.75 2.24)
      list("Cont" 18.57 1.94 18.69 2.06)
      list("Oxide" 19.05 1.76 19.29 2.24)
      list("Cont" 19.11 1.94 19.23 2.06)
      list("Oxide" 19.59 1.76 19.83 2.24)
      list("Cont" 19.65 1.94 19.77 2.06)
      list("Oxide" 0.39 1.88 0.69 2.12)
      list("Oxide" 1.47 1.76 1.77 2.24)
      list("Oxide" 2.01 1.76 2.31 2.24)
      list("Oxide" 2.55 1.76 2.85 2.24)
      list("Oxide" 3.09 1.76 3.39 2.24)
      list("Oxide" 3.63 1.88 3.93 2.12)
      list("Oxide" 4.71 1.88 5.01 2.12)
      list("Oxide" 5.79 1.88 6.09 2.12)
      list("Oxide" 6.33 1.88 6.63 2.12)
      list("Oxide" 7.41 1.88 7.71 2.12)
      list("Oxide" 7.95 1.88 8.25 2.12)
      list("Oxide" 9.03 1.88 9.33 2.12)
      list("Oxide" 10.11 1.76 10.41 2.24)
      list("Oxide" 10.65 1.76 10.95 2.24)
      list("Oxide" 11.19 1.76 11.49 2.24)
      list("Oxide" 11.73 1.76 12.03 2.24)
      list("Oxide" 12.27 1.76 12.57 2.24)
      list("Oxide" 13.35 1.88 13.65 2.12)
      list("Oxide" 13.89 1.88 14.19 2.12)
      list("Oxide" 14.97 1.88 15.27 2.12)
      list("Oxide" 16.05 1.88 16.35 2.12)
      list("Oxide" 16.59 1.88 16.89 2.12)
      list("Oxide" 17.67 1.76 17.97 2.24)
      list("Oxide" 18.21 1.76 18.51 2.24)
      list("Oxide" 18.75 1.76 19.05 2.24)
      list("Oxide" 19.29 1.76 19.59 2.24)
      list("Poly" 0.49 0.4 0.59 2.3)
      list("Poly" 0.44 1.2 0.64 1.44)
      list("Cont" 0.48 1.26 0.6 1.38)
      list("Poly" 1.57 1.2 1.67 2.42)
      list("Poly" 1.52 1.2 1.72 1.44)
      list("Cont" 1.56 1.26 1.68 1.38)
      list("Poly" 2.11 0.34 2.21 2.42)
      list("Poly" 2.06 1.2 2.26 1.44)
      list("Cont" 2.1 1.26 2.22 1.38)
      list("Poly" 2.65 0.34 2.75 2.42)
      list("Poly" 2.6 1.2 2.8 1.44)
      list("Cont" 2.64 1.26 2.76 1.38)
      list("Poly" 3.19 0.34 3.29 2.42)
      list("Poly" 3.14 1.2 3.34 1.44)
      list("Cont" 3.18 1.26 3.3 1.38)
      list("Poly" 3.73 0.34 3.83 1.44)
      list("Poly" 3.68 1.2 3.88 1.44)
      list("Cont" 3.72 1.26 3.84 1.38)
      list("Poly" 4.81 0.4 4.91 2.3)
      list("Poly" 4.76 1.2 4.96 1.44)
      list("Cont" 4.8 1.26 4.92 1.38)
      list("Poly" 5.89 0.34 5.99 2.3)
      list("Poly" 5.84 1.2 6.04 1.44)
      list("Cont" 5.88 1.26 6 1.38)
      list("Poly" 6.43 0.34 6.53 2.3)
      list("Poly" 6.38 1.2 6.58 1.44)
      list("Cont" 6.42 1.26 6.54 1.38)
      list("Poly" 7.51 0.34 7.61 2.3)
      list("Poly" 7.46 1.2 7.66 1.44)
      list("Cont" 7.5 1.26 7.62 1.38)
      list("Poly" 8.05 0.34 8.15 2.3)
      list("Poly" 8 1.2 8.2 1.44)
      list("Cont" 8.04 1.26 8.16 1.38)
      list("Poly" 9.13 0.4 9.23 2.3)
      list("Poly" 9.08 1.2 9.28 1.44)
      list("Cont" 9.12 1.26 9.24 1.38)
      list("Poly" 10.21 1.2 10.31 2.42)
      list("Poly" 10.16 1.2 10.36 1.44)
      list("Cont" 10.2 1.26 10.32 1.38)
      list("Poly" 10.75 0.34 10.85 2.42)
      list("Poly" 10.7 1.2 10.9 1.44)
      list("Cont" 10.74 1.26 10.86 1.38)
      list("Poly" 11.29 0.34 11.39 1.44)
      list("Poly" 11.24 1.2 11.44 1.44)
      list("Cont" 11.28 1.26 11.4 1.38)
      list("Poly" 11.83 0.34 11.93 2.42)
      list("Poly" 11.78 1.2 11.98 1.44)
      list("Cont" 11.82 1.26 11.94 1.38)
      list("Poly" 12.37 0.34 12.47 2.42)
      list("Poly" 12.32 1.2 12.52 1.44)
      list("Cont" 12.36 1.26 12.48 1.38)
      list("Poly" 13.45 0.34 13.55 2.3)
      list("Poly" 13.4 1.2 13.6 1.44)
      list("Cont" 13.44 1.26 13.56 1.38)
      list("Poly" 13.99 0.34 14.09 2.3)
      list("Poly" 13.94 1.2 14.14 1.44)
      list("Cont" 13.98 1.26 14.1 1.38)
      list("Poly" 15.07 0.4 15.17 2.3)
      list("Poly" 15.02 1.2 15.22 1.44)
      list("Cont" 15.06 1.26 15.18 1.38)
      list("Poly" 16.15 0.4 16.25 2.3)
      list("Poly" 16.1 1.2 16.3 1.44)
      list("Cont" 16.14 1.26 16.26 1.38)
      list("Poly" 16.69 0.4 16.79 2.3)
      list("Poly" 16.64 1.2 16.84 1.44)
      list("Cont" 16.68 1.26 16.8 1.38)
      list("Poly" 17.77 0.34 17.87 2.42)
      list("Poly" 17.72 1.2 17.92 1.44)
      list("Cont" 17.76 1.26 17.88 1.38)
      list("Poly" 18.31 0.34 18.41 2.42)
      list("Poly" 18.26 1.2 18.46 1.44)
      list("Cont" 18.3 1.26 18.42 1.38)
      list("Poly" 18.85 0.34 18.95 2.42)
      list("Poly" 18.8 1.2 19 1.44)
      list("Cont" 18.84 1.26 18.96 1.38)
      list("Poly" 19.39 0.34 19.49 2.42)
      list("Poly" 19.34 1.2 19.54 1.44)
      list("Cont" 19.38 1.26 19.5 1.38)
      list("Metal1" 0.735 0 0.885 0.76)
      list("Metal1" 2.895 0 3.045 0.76)
      list("Metal1" 4.515 0 4.665 0.76)
      list("Metal1" 4.515 1.88 4.665 2.76)
      list("Metal1" 5.595 0 5.745 0.76)
      list("Metal1" 5.595 1.88 5.745 2.76)
      list("Metal1" 8.295 0 8.445 0.76)
      list("Metal1" 9.375 0 9.525 0.76)
      list("Metal1" 9.375 1.88 9.525 2.76)
      list("Metal1" 11.535 0 11.685 0.76)
      list("Metal1" 13.155 0 13.305 0.76)
      list("Metal1" 13.155 1.88 13.305 2.76)
      list("Metal1" 14.775 0 14.925 0.76)
      list("Metal1" 16.395 0 16.545 0.76)
      list("Metal1" 16.395 1.88 16.545 2.76)
      list("Metal1" 18.555 0 18.705 0.76)
      list("Metal1" 0.195 1.88 0.345 2.76)
      list("Metal1" 1.275 1.88 1.425 2.76)
      list("Metal1" 3.975 1.88 4.125 2.76)
      list("Metal1" 6.675 1.88 6.825 2.76)
      list("Metal1" 7.755 1.88 7.905 2.76)
      list("Metal1" 12.075 1.88 12.225 2.76)
      list("Metal1" 14.235 1.88 14.385 2.76)
      list("Metal1" 15.315 1.88 15.465 2.76)
      list("Metal1" 19.095 1.88 19.245 2.76)
      list("Metal1" 1.815 1.73 1.965 2.21)
      list("Metal1" 2.895 1.73 3.045 2.21)
      list("Via1" 1.82 1.88 1.96 2.02)
      list("Via1" 2.9 1.88 3.04 2.02)
      list("Metal2" 1.76 1.875 3.1 2.025)
      list("Metal1" 7.485 1.11 7.635 1.59)
      list("Metal1" 12.345 1.11 12.495 1.59)
      list("Metal1" 16.125 1.11 16.275 1.59)
      list("Via1" 7.49 1.3 7.63 1.44)
      list("Via1" 12.35 1.3 12.49 1.44)
      list("Via1" 16.13 1.3 16.27 1.44)
      list("Metal2" 7.43 1.295 16.33 1.445)
      list("Metal1" 9.915 1.73 10.065 2.21)
      list("Metal1" 11.535 1.73 11.685 2.21)
      list("Metal1" 12.615 1.73 12.765 2.21)
      list("Via1" 9.92 1.88 10.06 2.02)
      list("Via1" 11.54 1.88 11.68 2.02)
      list("Via1" 12.62 1.88 12.76 2.02)
      list("Metal2" 9.86 1.875 12.82 2.025)
      list("Metal1" 0.195 0.52 0.345 1.5)
      list("Metal1" 0.735 1.24 0.885 2.12)
      list("Metal1" 2.085 1.11 2.235 1.59)
      list("Via1" 0.2 1.3 0.34 1.44)
      list("Via1" 0.74 1.3 0.88 1.44)
      list("Via1" 2.09 1.3 2.23 1.44)
      list("Metal2" 0.14 1.295 2.29 1.445)
      list("Metal1" 7.215 0.52 7.365 2.12)
      list("Metal1" 8.295 1.53 8.445 2.12)
      list("Metal1" 6.405 1.2 6.555 1.79)
      list("Via1" 6.41 1.59 6.55 1.73)
      list("Via1" 7.22 1.59 7.36 1.73)
      list("Via1" 8.3 1.59 8.44 1.73)
      list("Metal2" 6.35 1.585 8.5 1.735)
      list("Metal1" 0.465 0.95 0.615 1.44)
      list("Metal1" 1.545 0.95 1.695 1.44)
      list("Metal1" 3.705 0.95 3.855 1.44)
      list("Via1" 0.47 1.01 0.61 1.15)
      list("Via1" 1.55 1.01 1.69 1.15)
      list("Via1" 3.71 1.01 3.85 1.15)
      list("Metal2" 0.41 1.005 3.91 1.155)
      list("Metal1" 15.315 0.52 15.465 1.21)
      list("Metal1" 14.775 0.95 14.925 2.12)
      list("Metal1" 17.745 0.95 17.895 1.44)
      list("Via1" 14.78 1.01 14.92 1.15)
      list("Via1" 15.32 1.01 15.46 1.15)
      list("Via1" 17.75 1.01 17.89 1.15)
      list("Metal2" 14.72 1.005 17.95 1.155)
      list("Metal1" 3.165 1.11 3.315 1.59)
      list("Metal1" 4.785 1.11 4.935 1.59)
      list("Via1" 3.17 1.3 3.31 1.44)
      list("Via1" 4.79 1.3 4.93 1.44)
      list("Metal2" 3.11 1.295 4.99 1.445)
      list("Metal1" 5.055 0.52 5.205 2.12)
      list("Metal1" 2.625 1.2 2.775 1.79)
      list("Via1" 2.63 1.59 2.77 1.73)
      list("Via1" 5.06 1.59 5.2 1.73)
      list("Metal2" 2.57 1.585 5.26 1.735)
      list("Metal1" 8.835 0.52 8.985 2.12)
      list("Metal1" 10.185 0.95 10.335 1.44)
      list("Metal1" 11.265 0.95 11.415 1.44)
      list("Via1" 8.84 1.01 8.98 1.15)
      list("Via1" 10.19 1.01 10.33 1.15)
      list("Via1" 11.27 1.01 11.41 1.15)
      list("Metal2" 8.78 1.005 11.47 1.155)
      list("Metal1" 15.855 0.52 16.005 2.12)
      list("Metal1" 10.725 1.2 10.875 1.79)
      list("Via1" 10.73 1.59 10.87 1.73)
      list("Via1" 15.86 1.59 16 1.73)
      list("Metal2" 10.67 1.585 16.06 1.735)
      list("Metal1" 1.815 0.48 1.965 0.96)
      list("Metal1" 3.975 0.48 4.125 0.96)
      list("Metal1" 2.355 0.66 2.505 2.12)
      list("Metal1" 8.025 0.66 8.175 1.44)
      list("Metal1" 9.105 0.66 9.255 1.44)
      list("Metal1" 11.805 0.66 11.955 1.44)
      list("Via1" 1.82 0.72 1.96 0.86)
      list("Via1" 2.36 0.72 2.5 0.86)
      list("Via1" 3.98 0.72 4.12 0.86)
      list("Via1" 8.03 0.72 8.17 0.86)
      list("Via1" 9.11 0.72 9.25 0.86)
      list("Via1" 11.81 0.72 11.95 0.86)
      list("Metal2" 1.76 0.715 12.01 0.865)
      list("Metal1" 17.475 1.73 17.625 2.21)
      list("Metal1" 18.555 1.73 18.705 2.21)
      list("Metal1" 19.635 1.73 19.785 2.21)
      list("Via1" 17.48 1.88 17.62 2.02)
      list("Via1" 18.56 1.88 18.7 2.02)
      list("Via1" 19.64 1.88 19.78 2.02)
      list("Metal2" 17.42 1.875 19.84 2.025)
      list("Metal1" 13.425 0.66 13.575 1.44)
      list("Metal1" 16.665 0.66 16.815 1.44)
      list("Metal1" 18.825 0.66 18.975 1.44)
      list("Via1" 13.43 0.72 13.57 0.86)
      list("Via1" 16.67 0.72 16.81 0.86)
      list("Via1" 18.83 0.72 18.97 0.86)
      list("Metal2" 13.37 0.715 19.03 0.865)
      list("Metal1" 17.475 0.52 17.625 1.5)
      list("Metal1" 19.635 0.52 19.785 1.5)
      list("Metal1" 18.015 1.24 18.165 2.12)
      list("Via1" 17.48 1.3 17.62 1.44)
      list("Via1" 18.02 1.3 18.16 1.44)
      list("Via1" 19.64 1.3 19.78 1.44)
      list("Metal2" 17.42 1.295 19.84 1.445)
      list("Metal1" 6.675 0.52 6.825 1.5)
      list("Metal1" 6.135 1.24 6.285 2.12)
      list("Via1" 6.14 1.3 6.28 1.44)
      list("Via1" 6.68 1.3 6.82 1.44)
      list("Metal2" 6.08 1.295 6.88 1.445)
      list("Metal1" 16.935 0.52 17.085 2.12)
      list("Metal1" 18.285 1.2 18.435 1.79)
      list("Via1" 16.94 1.59 17.08 1.73)
      list("Via1" 18.29 1.59 18.43 1.73)
      list("Metal2" 16.88 1.585 18.49 1.735)
      list("Metal1" 14.235 0.52 14.385 1.21)
      list("Metal1" 13.695 0.95 13.845 2.12)
      list("Metal1" 5.865 0.95 6.015 1.44)
      list("Via1" 5.87 1.01 6.01 1.15)
      list("Via2" 5.87 1.01 6.01 1.15)
      list("Via1" 13.7 1.01 13.84 1.15)
      list("Via2" 13.7 1.01 13.84 1.15)
      list("Via1" 14.24 1.01 14.38 1.15)
      list("Via2" 14.24 1.01 14.38 1.15)
      list("Metal3" 5.81 1.005 14.44 1.155)
      list("Metal2" 5.67 1.005 6.21 1.155)
      list("Metal2" 13.5 1.005 14.04 1.155)
      list("Metal2" 14.04 1.005 14.58 1.155)
      list("Metal1" 10.455 0.37 10.605 2.12)
      list("Metal1" 12.615 0.36 12.765 0.84)
      list("Metal1" 13.965 0.37 14.115 1.44)
      list("Metal1" 15.045 0.37 15.195 1.44)
      list("Metal1" 19.365 0.37 19.515 1.44)
      list("Via1" 10.46 0.43 10.6 0.57)
      list("Via1" 12.62 0.43 12.76 0.57)
      list("Via1" 13.97 0.43 14.11 0.57)
      list("Via1" 15.05 0.43 15.19 0.57)
      list("Via1" 19.37 0.43 19.51 0.57)
      list("Metal2" 10.4 0.425 19.57 0.575))
    list(list("VSS" "inputOutput" 0 0 19.98 0.24)
      list("VDD" "inputOutput" 0 2.52 19.98 2.76)
      list("X" "input" 7.485 1.2 7.635 1.44)
      list("D" "input" 0.465 1.2 0.615 1.44)
      list("T" "input" 3.165 1.2 3.315 1.44)
      list("CI" "input" 13.425 1.2 13.575 1.44)
      list("S" "output" 17.475 0.52 17.625 0.76)
      list("CO" "output" 6.135 1.88 6.285 2.12)))
  t)
unless(errset(laMain() t) printf("LA_ERROR SKILL error, see message above\n") laErr = laErr + 1)
printf("LA_SUMMARY errors=%d\n" laErr)
exit(if(laErr == 0 0 1))
