* MUL32 phang xuong cell la: sinh boi layout/pnr/prep.py

.SUBCKT AOI21_X1 A1 A2 B Y VDD VSS
MN0 Y A1 n1 VSS nmos1v w=0.24u l=0.1u
MN1 n1 A2 VSS VSS nmos1v w=0.24u l=0.1u
MN2 Y B VSS VSS nmos1v w=0.12u l=0.1u
MP0 p1 A1 VDD VDD pmos1v w=0.48u l=0.1u
MP1 p1 A2 VDD VDD pmos1v w=0.48u l=0.1u
MP2 Y B p1 VDD pmos1v w=0.48u l=0.1u
.ENDS AOI21_X1

.SUBCKT BOOTH_ENC X2 X1 X0 ONE TWO VDD VSS
MN1 aan X1 VSS VSS nmos1v w=0.12u l=0.1u
MP2 aan X1 VDD VDD pmos1v w=0.24u l=0.1u
MN3 abn X0 VSS VSS nmos1v w=0.12u l=0.1u
MP4 abn X0 VDD VDD pmos1v w=0.24u l=0.1u
MN5 ONE X1 an1 VSS nmos1v w=0.24u l=0.1u
MN6 an1 X0 VSS VSS nmos1v w=0.24u l=0.1u
MN7 ONE aan an2 VSS nmos1v w=0.24u l=0.1u
MN8 an2 abn VSS VSS nmos1v w=0.24u l=0.1u
MP9 ap1 X1 VDD VDD pmos1v w=0.48u l=0.1u
MP10 ap1 X0 VDD VDD pmos1v w=0.48u l=0.1u
MP11 ONE aan ap1 VDD pmos1v w=0.48u l=0.1u
MP12 ONE abn ap1 VDD pmos1v w=0.48u l=0.1u
MN13 ban X2 VSS VSS nmos1v w=0.12u l=0.1u
MP14 ban X2 VDD VDD pmos1v w=0.24u l=0.1u
MN15 bbn X1 VSS VSS nmos1v w=0.12u l=0.1u
MP16 bbn X1 VDD VDD pmos1v w=0.24u l=0.1u
MN17 e X2 bn1 VSS nmos1v w=0.24u l=0.1u
MN18 bn1 bbn VSS VSS nmos1v w=0.24u l=0.1u
MN19 e ban bn2 VSS nmos1v w=0.24u l=0.1u
MN20 bn2 X1 VSS VSS nmos1v w=0.24u l=0.1u
MP21 bp1 X2 VDD VDD pmos1v w=0.48u l=0.1u
MP22 bp1 bbn VDD VDD pmos1v w=0.48u l=0.1u
MP23 e ban bp1 VDD pmos1v w=0.48u l=0.1u
MP24 e X1 bp1 VDD pmos1v w=0.48u l=0.1u
MN25 TWO e VSS VSS nmos1v w=0.12u l=0.1u
MN26 TWO ONE VSS VSS nmos1v w=0.12u l=0.1u
MP27 cp e VDD VDD pmos1v w=0.48u l=0.1u
MP28 TWO ONE cp VDD pmos1v w=0.48u l=0.1u
.ENDS BOOTH_ENC

.SUBCKT BOOTH_SEL AJ AJM ONE TWO NEG PP VDD VSS
MN1 xn ONE n1 VSS nmos1v w=0.24u l=0.1u
MN2 n1 AJ VSS VSS nmos1v w=0.24u l=0.1u
MN3 xn TWO n2 VSS nmos1v w=0.24u l=0.1u
MN4 n2 AJM VSS VSS nmos1v w=0.24u l=0.1u
MP5 p1 ONE VDD VDD pmos1v w=0.48u l=0.1u
MP6 p1 AJ VDD VDD pmos1v w=0.48u l=0.1u
MP7 xn TWO p1 VDD pmos1v w=0.48u l=0.1u
MP8 xn AJM p1 VDD pmos1v w=0.48u l=0.1u
MN9 xan xn VSS VSS nmos1v w=0.12u l=0.1u
MP10 xan xn VDD VDD pmos1v w=0.24u l=0.1u
MN11 xbn NEG VSS VSS nmos1v w=0.12u l=0.1u
MP12 xbn NEG VDD VDD pmos1v w=0.24u l=0.1u
MN13 PP xn xn1 VSS nmos1v w=0.24u l=0.1u
MN14 xn1 xbn VSS VSS nmos1v w=0.24u l=0.1u
MN15 PP xan xn2 VSS nmos1v w=0.24u l=0.1u
MN16 xn2 NEG VSS VSS nmos1v w=0.24u l=0.1u
MP17 xp1 xn VDD VDD pmos1v w=0.48u l=0.1u
MP18 xp1 xbn VDD VDD pmos1v w=0.48u l=0.1u
MP19 PP xan xp1 VDD pmos1v w=0.48u l=0.1u
MP20 PP NEG xp1 VDD pmos1v w=0.48u l=0.1u
.ENDS BOOTH_SEL

.SUBCKT CMP42 X1 X2 X3 X4 CI S C CO VDD VSS
MN1 an1 X1 VSS VSS nmos1v w=0.24u l=0.1u
MN2 acon X2 an1 VSS nmos1v w=0.24u l=0.1u
MN3 an2 X1 VSS VSS nmos1v w=0.24u l=0.1u
MN4 an2 X2 VSS VSS nmos1v w=0.24u l=0.1u
MN5 acon X3 an2 VSS nmos1v w=0.24u l=0.1u
MN6 an3 X1 VSS VSS nmos1v w=0.24u l=0.1u
MN7 an3 X2 VSS VSS nmos1v w=0.24u l=0.1u
MN8 an3 X3 VSS VSS nmos1v w=0.24u l=0.1u
MN9 asn acon an3 VSS nmos1v w=0.24u l=0.1u
MN10 an4 X1 VSS VSS nmos1v w=0.36u l=0.1u
MN11 an5 X2 an4 VSS nmos1v w=0.36u l=0.1u
MN12 asn X3 an5 VSS nmos1v w=0.36u l=0.1u
MP13 ap1 X1 VDD VDD pmos1v w=0.48u l=0.1u
MP14 acon X2 ap1 VDD pmos1v w=0.48u l=0.1u
MP15 ap2 X1 VDD VDD pmos1v w=0.48u l=0.1u
MP16 ap2 X2 VDD VDD pmos1v w=0.48u l=0.1u
MP17 acon X3 ap2 VDD pmos1v w=0.48u l=0.1u
MP18 ap3 X1 VDD VDD pmos1v w=0.48u l=0.1u
MP19 ap3 X2 VDD VDD pmos1v w=0.48u l=0.1u
MP20 ap3 X3 VDD VDD pmos1v w=0.48u l=0.1u
MP21 asn acon ap3 VDD pmos1v w=0.48u l=0.1u
MP22 ap4 X1 VDD VDD pmos1v w=0.72u l=0.1u
MP23 ap5 X2 ap4 VDD pmos1v w=0.72u l=0.1u
MP24 asn X3 ap5 VDD pmos1v w=0.72u l=0.1u
MN25 s1 asn VSS VSS nmos1v w=0.12u l=0.1u
MP26 s1 asn VDD VDD pmos1v w=0.24u l=0.1u
MN27 CO acon VSS VSS nmos1v w=0.12u l=0.1u
MP28 CO acon VDD VDD pmos1v w=0.24u l=0.1u
MN29 bn1 s1 VSS VSS nmos1v w=0.24u l=0.1u
MN30 bcon X4 bn1 VSS nmos1v w=0.24u l=0.1u
MN31 bn2 s1 VSS VSS nmos1v w=0.24u l=0.1u
MN32 bn2 X4 VSS VSS nmos1v w=0.24u l=0.1u
MN33 bcon CI bn2 VSS nmos1v w=0.24u l=0.1u
MN34 bn3 s1 VSS VSS nmos1v w=0.24u l=0.1u
MN35 bn3 X4 VSS VSS nmos1v w=0.24u l=0.1u
MN36 bn3 CI VSS VSS nmos1v w=0.24u l=0.1u
MN37 bsn bcon bn3 VSS nmos1v w=0.24u l=0.1u
MN38 bn4 s1 VSS VSS nmos1v w=0.36u l=0.1u
MN39 bn5 X4 bn4 VSS nmos1v w=0.36u l=0.1u
MN40 bsn CI bn5 VSS nmos1v w=0.36u l=0.1u
MP41 bp1 s1 VDD VDD pmos1v w=0.48u l=0.1u
MP42 bcon X4 bp1 VDD pmos1v w=0.48u l=0.1u
MP43 bp2 s1 VDD VDD pmos1v w=0.48u l=0.1u
MP44 bp2 X4 VDD VDD pmos1v w=0.48u l=0.1u
MP45 bcon CI bp2 VDD pmos1v w=0.48u l=0.1u
MP46 bp3 s1 VDD VDD pmos1v w=0.48u l=0.1u
MP47 bp3 X4 VDD VDD pmos1v w=0.48u l=0.1u
MP48 bp3 CI VDD VDD pmos1v w=0.48u l=0.1u
MP49 bsn bcon bp3 VDD pmos1v w=0.48u l=0.1u
MP50 bp4 s1 VDD VDD pmos1v w=0.72u l=0.1u
MP51 bp5 X4 bp4 VDD pmos1v w=0.72u l=0.1u
MP52 bsn CI bp5 VDD pmos1v w=0.72u l=0.1u
MN53 S bsn VSS VSS nmos1v w=0.12u l=0.1u
MP54 S bsn VDD VDD pmos1v w=0.24u l=0.1u
MN55 C bcon VSS VSS nmos1v w=0.12u l=0.1u
MP56 C bcon VDD VDD pmos1v w=0.24u l=0.1u
.ENDS CMP42

.SUBCKT FA_X1 A B CI S CO VDD VSS
MN1 n1 A VSS VSS nmos1v w=0.24u l=0.1u
MN2 con B n1 VSS nmos1v w=0.24u l=0.1u
MN3 n2 A VSS VSS nmos1v w=0.24u l=0.1u
MN4 n2 B VSS VSS nmos1v w=0.24u l=0.1u
MN5 con CI n2 VSS nmos1v w=0.24u l=0.1u
MN6 n3 A VSS VSS nmos1v w=0.24u l=0.1u
MN7 n3 B VSS VSS nmos1v w=0.24u l=0.1u
MN8 n3 CI VSS VSS nmos1v w=0.24u l=0.1u
MN9 sn con n3 VSS nmos1v w=0.24u l=0.1u
MN10 n4 A VSS VSS nmos1v w=0.36u l=0.1u
MN11 n5 B n4 VSS nmos1v w=0.36u l=0.1u
MN12 sn CI n5 VSS nmos1v w=0.36u l=0.1u
MP13 p1 A VDD VDD pmos1v w=0.48u l=0.1u
MP14 con B p1 VDD pmos1v w=0.48u l=0.1u
MP15 p2 A VDD VDD pmos1v w=0.48u l=0.1u
MP16 p2 B VDD VDD pmos1v w=0.48u l=0.1u
MP17 con CI p2 VDD pmos1v w=0.48u l=0.1u
MP18 p3 A VDD VDD pmos1v w=0.48u l=0.1u
MP19 p3 B VDD VDD pmos1v w=0.48u l=0.1u
MP20 p3 CI VDD VDD pmos1v w=0.48u l=0.1u
MP21 sn con p3 VDD pmos1v w=0.48u l=0.1u
MP22 p4 A VDD VDD pmos1v w=0.72u l=0.1u
MP23 p5 B p4 VDD pmos1v w=0.72u l=0.1u
MP24 sn CI p5 VDD pmos1v w=0.72u l=0.1u
MN25 S sn VSS VSS nmos1v w=0.12u l=0.1u
MP26 S sn VDD VDD pmos1v w=0.24u l=0.1u
MN27 CO con VSS VSS nmos1v w=0.12u l=0.1u
MP28 CO con VDD VDD pmos1v w=0.24u l=0.1u
.ENDS FA_X1

.SUBCKT HA_X1 A B S CO VDD VSS
MN1 xan A VSS VSS nmos1v w=0.12u l=0.1u
MP2 xan A VDD VDD pmos1v w=0.24u l=0.1u
MN3 xbn B VSS VSS nmos1v w=0.12u l=0.1u
MP4 xbn B VDD VDD pmos1v w=0.24u l=0.1u
MN5 S A xn1 VSS nmos1v w=0.24u l=0.1u
MN6 xn1 B VSS VSS nmos1v w=0.24u l=0.1u
MN7 S xan xn2 VSS nmos1v w=0.24u l=0.1u
MN8 xn2 xbn VSS VSS nmos1v w=0.24u l=0.1u
MP9 xp1 A VDD VDD pmos1v w=0.48u l=0.1u
MP10 xp1 B VDD VDD pmos1v w=0.48u l=0.1u
MP11 S xan xp1 VDD pmos1v w=0.48u l=0.1u
MP12 S xbn xp1 VDD pmos1v w=0.48u l=0.1u
MN13 con A an VSS nmos1v w=0.24u l=0.1u
MN14 an B VSS VSS nmos1v w=0.24u l=0.1u
MP15 con A VDD VDD pmos1v w=0.24u l=0.1u
MP16 con B VDD VDD pmos1v w=0.24u l=0.1u
MN17 CO con VSS VSS nmos1v w=0.12u l=0.1u
MP18 CO con VDD VDD pmos1v w=0.24u l=0.1u
.ENDS HA_X1

.SUBCKT INV_X1 A Y VDD VSS
MN0 Y A VSS VSS nmos1v w=0.12u l=0.1u
MP0 Y A VDD VDD pmos1v w=0.24u l=0.1u
.ENDS INV_X1

.SUBCKT INV_X4 A Y VDD VSS
MN1 Y A VSS VSS nmos1v w=0.48u l=0.1u
MP2 Y A VDD VDD pmos1v w=0.96u l=0.1u
.ENDS INV_X4

.SUBCKT NAND2_X1 A B Y VDD VSS
MN0 Y A n1 VSS nmos1v w=0.24u l=0.1u
MN1 n1 B VSS VSS nmos1v w=0.24u l=0.1u
MP0 Y A VDD VDD pmos1v w=0.24u l=0.1u
MP1 Y B VDD VDD pmos1v w=0.24u l=0.1u
.ENDS NAND2_X1

.SUBCKT NOR2_X1 A B Y VDD VSS
MN0 Y A VSS VSS nmos1v w=0.12u l=0.1u
MN1 Y B VSS VSS nmos1v w=0.12u l=0.1u
MP0 p1 A VDD VDD pmos1v w=0.48u l=0.1u
MP1 Y B p1 VDD pmos1v w=0.48u l=0.1u
.ENDS NOR2_X1

.SUBCKT OAI21_X1 A1 A2 B Y VDD VSS
MN0 Y A1 n1 VSS nmos1v w=0.24u l=0.1u
MN1 Y A2 n1 VSS nmos1v w=0.24u l=0.1u
MN2 n1 B VSS VSS nmos1v w=0.24u l=0.1u
MP0 p1 A1 VDD VDD pmos1v w=0.48u l=0.1u
MP1 Y A2 p1 VDD pmos1v w=0.48u l=0.1u
MP2 Y B VDD VDD pmos1v w=0.24u l=0.1u
.ENDS OAI21_X1

.SUBCKT XNOR2_X1 A B Y VDD VSS
MN0 An A VSS VSS nmos1v w=0.12u l=0.1u
MP0 An A VDD VDD pmos1v w=0.24u l=0.1u
MN1 Bn B VSS VSS nmos1v w=0.12u l=0.1u
MP1 Bn B VDD VDD pmos1v w=0.24u l=0.1u
MN2 Y A n1 VSS nmos1v w=0.24u l=0.1u
MN3 n1 Bn VSS VSS nmos1v w=0.24u l=0.1u
MN4 Y An n2 VSS nmos1v w=0.24u l=0.1u
MN5 n2 B VSS VSS nmos1v w=0.24u l=0.1u
MP2 p1 A VDD VDD pmos1v w=0.48u l=0.1u
MP3 p1 Bn VDD VDD pmos1v w=0.48u l=0.1u
MP4 Y An p1 VDD pmos1v w=0.48u l=0.1u
MP5 Y B p1 VDD pmos1v w=0.48u l=0.1u
.ENDS XNOR2_X1

.SUBCKT XOR2_X1 A B Y VDD VSS
MN0 An A VSS VSS nmos1v w=0.12u l=0.1u
MP0 An A VDD VDD pmos1v w=0.24u l=0.1u
MN1 Bn B VSS VSS nmos1v w=0.12u l=0.1u
MP1 Bn B VDD VDD pmos1v w=0.24u l=0.1u
MN2 Y A n1 VSS nmos1v w=0.24u l=0.1u
MN3 n1 B VSS VSS nmos1v w=0.24u l=0.1u
MN4 Y An n2 VSS nmos1v w=0.24u l=0.1u
MN5 n2 Bn VSS VSS nmos1v w=0.24u l=0.1u
MP2 p1 A VDD VDD pmos1v w=0.48u l=0.1u
MP3 p1 B VDD VDD pmos1v w=0.48u l=0.1u
MP4 Y An p1 VDD pmos1v w=0.48u l=0.1u
MP5 Y Bn p1 VDD pmos1v w=0.48u l=0.1u
.ENDS XOR2_X1

.SUBCKT MUL32 A_0 A_1 A_2 A_3 A_4 A_5 A_6 A_7 A_8 A_9 A_10 A_11 A_12 A_13 A_14 A_15 A_16 A_17 A_18 A_19 A_20 A_21 A_22 A_23 A_24 A_25 A_26 A_27 A_28 A_29 A_30 A_31 B_0 B_1 B_2 B_3 B_4 B_5 B_6 B_7 B_8 B_9 B_10 B_11 B_12 B_13 B_14 B_15 B_16 B_17 B_18 B_19 B_20 B_21 B_22 B_23 B_24 B_25 B_26 B_27 B_28 B_29 B_30 B_31 P_0 P_1 P_2 P_3 P_4 P_5 P_6 P_7 P_8 P_9 P_10 P_11 P_12 P_13 P_14 P_15 P_16 P_17 P_18 P_19 P_20 P_21 P_22 P_23 P_24 P_25 P_26 P_27 P_28 P_29 P_30 P_31 P_32 P_33 P_34 P_35 P_36 P_37 P_38 P_39 P_40 P_41 P_42 P_43 P_44 P_45 P_46 P_47 P_48 P_49 P_50 P_51 P_52 P_53 P_54 P_55 P_56 P_57 P_58 P_59 P_60 P_61 P_62 P_63 VDD VSS
XI0 B_1 B_1_b0 VDD VSS INV_X1
XI1 B_1_b0 B_1_b1_0 VDD VSS INV_X4
XI2 B_1_b1_0 B_1_b2_0 VDD VSS INV_X4
XI3 B_1_b1_0 B_1_b2_1 VDD VSS INV_X4
XI4 B_1_b2_0 B_1_b3_0 VDD VSS INV_X4
XI5 B_1_b2_0 B_1_b3_1 VDD VSS INV_X4
XI6 B_1_b2_0 B_1_b3_2 VDD VSS INV_X4
XI7 B_1_b2_1 B_1_b3_3 VDD VSS INV_X4
XI8 B_1_b2_1 B_1_b3_4 VDD VSS INV_X4
XI9 B_1_b2_1 B_1_b3_5 VDD VSS INV_X4
XI10 A_0 A_0_b0 VDD VSS INV_X1
XI11 A_0_b0 A_0_b1_0 VDD VSS INV_X4
XI12 A_0_b1_0 A_0_b2_0 VDD VSS INV_X4
XI13 A_0_b1_0 A_0_b2_1 VDD VSS INV_X4
XI14 A_0_b2_0 A_0_b3_0 VDD VSS INV_X4
XI15 A_0_b2_0 A_0_b3_1 VDD VSS INV_X4
XI16 A_0_b2_0 A_0_b3_2 VDD VSS INV_X4
XI17 A_0_b2_1 A_0_b3_3 VDD VSS INV_X4
XI18 A_0_b2_1 A_0_b3_4 VDD VSS INV_X4
XI19 A_0_b2_1 A_0_b3_5 VDD VSS INV_X4
XI20 A_1 A_1_b0 VDD VSS INV_X1
XI21 A_1_b0 A_1_b1_0 VDD VSS INV_X4
XI22 A_1_b1_0 A_1_b2_0 VDD VSS INV_X4
XI23 A_1_b1_0 A_1_b2_1 VDD VSS INV_X4
XI24 A_1_b2_0 A_1_b3_0 VDD VSS INV_X4
XI25 A_1_b2_0 A_1_b3_1 VDD VSS INV_X4
XI26 A_1_b2_0 A_1_b3_2 VDD VSS INV_X4
XI27 A_1_b2_1 A_1_b3_3 VDD VSS INV_X4
XI28 A_1_b2_1 A_1_b3_4 VDD VSS INV_X4
XI29 A_1_b2_1 A_1_b3_5 VDD VSS INV_X4
XI30 A_2 A_2_b0 VDD VSS INV_X1
XI31 A_2_b0 A_2_b1_0 VDD VSS INV_X4
XI32 A_2_b1_0 A_2_b2_0 VDD VSS INV_X4
XI33 A_2_b1_0 A_2_b2_1 VDD VSS INV_X4
XI34 A_2_b2_0 A_2_b3_0 VDD VSS INV_X4
XI35 A_2_b2_0 A_2_b3_1 VDD VSS INV_X4
XI36 A_2_b2_0 A_2_b3_2 VDD VSS INV_X4
XI37 A_2_b2_1 A_2_b3_3 VDD VSS INV_X4
XI38 A_2_b2_1 A_2_b3_4 VDD VSS INV_X4
XI39 A_2_b2_1 A_2_b3_5 VDD VSS INV_X4
XI40 A_3 A_3_b0 VDD VSS INV_X1
XI41 A_3_b0 A_3_b1_0 VDD VSS INV_X4
XI42 A_3_b1_0 A_3_b2_0 VDD VSS INV_X4
XI43 A_3_b1_0 A_3_b2_1 VDD VSS INV_X4
XI44 A_3_b2_0 A_3_b3_0 VDD VSS INV_X4
XI45 A_3_b2_0 A_3_b3_1 VDD VSS INV_X4
XI46 A_3_b2_0 A_3_b3_2 VDD VSS INV_X4
XI47 A_3_b2_1 A_3_b3_3 VDD VSS INV_X4
XI48 A_3_b2_1 A_3_b3_4 VDD VSS INV_X4
XI49 A_3_b2_1 A_3_b3_5 VDD VSS INV_X4
XI50 A_4 A_4_b0 VDD VSS INV_X1
XI51 A_4_b0 A_4_b1_0 VDD VSS INV_X4
XI52 A_4_b1_0 A_4_b2_0 VDD VSS INV_X4
XI53 A_4_b1_0 A_4_b2_1 VDD VSS INV_X4
XI54 A_4_b2_0 A_4_b3_0 VDD VSS INV_X4
XI55 A_4_b2_0 A_4_b3_1 VDD VSS INV_X4
XI56 A_4_b2_0 A_4_b3_2 VDD VSS INV_X4
XI57 A_4_b2_1 A_4_b3_3 VDD VSS INV_X4
XI58 A_4_b2_1 A_4_b3_4 VDD VSS INV_X4
XI59 A_4_b2_1 A_4_b3_5 VDD VSS INV_X4
XI60 A_5 A_5_b0 VDD VSS INV_X1
XI61 A_5_b0 A_5_b1_0 VDD VSS INV_X4
XI62 A_5_b1_0 A_5_b2_0 VDD VSS INV_X4
XI63 A_5_b1_0 A_5_b2_1 VDD VSS INV_X4
XI64 A_5_b2_0 A_5_b3_0 VDD VSS INV_X4
XI65 A_5_b2_0 A_5_b3_1 VDD VSS INV_X4
XI66 A_5_b2_0 A_5_b3_2 VDD VSS INV_X4
XI67 A_5_b2_1 A_5_b3_3 VDD VSS INV_X4
XI68 A_5_b2_1 A_5_b3_4 VDD VSS INV_X4
XI69 A_5_b2_1 A_5_b3_5 VDD VSS INV_X4
XI70 A_6 A_6_b0 VDD VSS INV_X1
XI71 A_6_b0 A_6_b1_0 VDD VSS INV_X4
XI72 A_6_b1_0 A_6_b2_0 VDD VSS INV_X4
XI73 A_6_b1_0 A_6_b2_1 VDD VSS INV_X4
XI74 A_6_b2_0 A_6_b3_0 VDD VSS INV_X4
XI75 A_6_b2_0 A_6_b3_1 VDD VSS INV_X4
XI76 A_6_b2_0 A_6_b3_2 VDD VSS INV_X4
XI77 A_6_b2_1 A_6_b3_3 VDD VSS INV_X4
XI78 A_6_b2_1 A_6_b3_4 VDD VSS INV_X4
XI79 A_6_b2_1 A_6_b3_5 VDD VSS INV_X4
XI80 A_7 A_7_b0 VDD VSS INV_X1
XI81 A_7_b0 A_7_b1_0 VDD VSS INV_X4
XI82 A_7_b1_0 A_7_b2_0 VDD VSS INV_X4
XI83 A_7_b1_0 A_7_b2_1 VDD VSS INV_X4
XI84 A_7_b2_0 A_7_b3_0 VDD VSS INV_X4
XI85 A_7_b2_0 A_7_b3_1 VDD VSS INV_X4
XI86 A_7_b2_0 A_7_b3_2 VDD VSS INV_X4
XI87 A_7_b2_1 A_7_b3_3 VDD VSS INV_X4
XI88 A_7_b2_1 A_7_b3_4 VDD VSS INV_X4
XI89 A_7_b2_1 A_7_b3_5 VDD VSS INV_X4
XI90 A_8 A_8_b0 VDD VSS INV_X1
XI91 A_8_b0 A_8_b1_0 VDD VSS INV_X4
XI92 A_8_b1_0 A_8_b2_0 VDD VSS INV_X4
XI93 A_8_b1_0 A_8_b2_1 VDD VSS INV_X4
XI94 A_8_b2_0 A_8_b3_0 VDD VSS INV_X4
XI95 A_8_b2_0 A_8_b3_1 VDD VSS INV_X4
XI96 A_8_b2_0 A_8_b3_2 VDD VSS INV_X4
XI97 A_8_b2_1 A_8_b3_3 VDD VSS INV_X4
XI98 A_8_b2_1 A_8_b3_4 VDD VSS INV_X4
XI99 A_8_b2_1 A_8_b3_5 VDD VSS INV_X4
XI100 A_9 A_9_b0 VDD VSS INV_X1
XI101 A_9_b0 A_9_b1_0 VDD VSS INV_X4
XI102 A_9_b1_0 A_9_b2_0 VDD VSS INV_X4
XI103 A_9_b1_0 A_9_b2_1 VDD VSS INV_X4
XI104 A_9_b2_0 A_9_b3_0 VDD VSS INV_X4
XI105 A_9_b2_0 A_9_b3_1 VDD VSS INV_X4
XI106 A_9_b2_0 A_9_b3_2 VDD VSS INV_X4
XI107 A_9_b2_1 A_9_b3_3 VDD VSS INV_X4
XI108 A_9_b2_1 A_9_b3_4 VDD VSS INV_X4
XI109 A_9_b2_1 A_9_b3_5 VDD VSS INV_X4
XI110 A_10 A_10_b0 VDD VSS INV_X1
XI111 A_10_b0 A_10_b1_0 VDD VSS INV_X4
XI112 A_10_b1_0 A_10_b2_0 VDD VSS INV_X4
XI113 A_10_b1_0 A_10_b2_1 VDD VSS INV_X4
XI114 A_10_b2_0 A_10_b3_0 VDD VSS INV_X4
XI115 A_10_b2_0 A_10_b3_1 VDD VSS INV_X4
XI116 A_10_b2_0 A_10_b3_2 VDD VSS INV_X4
XI117 A_10_b2_1 A_10_b3_3 VDD VSS INV_X4
XI118 A_10_b2_1 A_10_b3_4 VDD VSS INV_X4
XI119 A_10_b2_1 A_10_b3_5 VDD VSS INV_X4
XI120 A_11 A_11_b0 VDD VSS INV_X1
XI121 A_11_b0 A_11_b1_0 VDD VSS INV_X4
XI122 A_11_b1_0 A_11_b2_0 VDD VSS INV_X4
XI123 A_11_b1_0 A_11_b2_1 VDD VSS INV_X4
XI124 A_11_b2_0 A_11_b3_0 VDD VSS INV_X4
XI125 A_11_b2_0 A_11_b3_1 VDD VSS INV_X4
XI126 A_11_b2_0 A_11_b3_2 VDD VSS INV_X4
XI127 A_11_b2_1 A_11_b3_3 VDD VSS INV_X4
XI128 A_11_b2_1 A_11_b3_4 VDD VSS INV_X4
XI129 A_11_b2_1 A_11_b3_5 VDD VSS INV_X4
XI130 A_12 A_12_b0 VDD VSS INV_X1
XI131 A_12_b0 A_12_b1_0 VDD VSS INV_X4
XI132 A_12_b1_0 A_12_b2_0 VDD VSS INV_X4
XI133 A_12_b1_0 A_12_b2_1 VDD VSS INV_X4
XI134 A_12_b2_0 A_12_b3_0 VDD VSS INV_X4
XI135 A_12_b2_0 A_12_b3_1 VDD VSS INV_X4
XI136 A_12_b2_0 A_12_b3_2 VDD VSS INV_X4
XI137 A_12_b2_1 A_12_b3_3 VDD VSS INV_X4
XI138 A_12_b2_1 A_12_b3_4 VDD VSS INV_X4
XI139 A_12_b2_1 A_12_b3_5 VDD VSS INV_X4
XI140 A_13 A_13_b0 VDD VSS INV_X1
XI141 A_13_b0 A_13_b1_0 VDD VSS INV_X4
XI142 A_13_b1_0 A_13_b2_0 VDD VSS INV_X4
XI143 A_13_b1_0 A_13_b2_1 VDD VSS INV_X4
XI144 A_13_b2_0 A_13_b3_0 VDD VSS INV_X4
XI145 A_13_b2_0 A_13_b3_1 VDD VSS INV_X4
XI146 A_13_b2_0 A_13_b3_2 VDD VSS INV_X4
XI147 A_13_b2_1 A_13_b3_3 VDD VSS INV_X4
XI148 A_13_b2_1 A_13_b3_4 VDD VSS INV_X4
XI149 A_13_b2_1 A_13_b3_5 VDD VSS INV_X4
XI150 A_14 A_14_b0 VDD VSS INV_X1
XI151 A_14_b0 A_14_b1_0 VDD VSS INV_X4
XI152 A_14_b1_0 A_14_b2_0 VDD VSS INV_X4
XI153 A_14_b1_0 A_14_b2_1 VDD VSS INV_X4
XI154 A_14_b2_0 A_14_b3_0 VDD VSS INV_X4
XI155 A_14_b2_0 A_14_b3_1 VDD VSS INV_X4
XI156 A_14_b2_0 A_14_b3_2 VDD VSS INV_X4
XI157 A_14_b2_1 A_14_b3_3 VDD VSS INV_X4
XI158 A_14_b2_1 A_14_b3_4 VDD VSS INV_X4
XI159 A_14_b2_1 A_14_b3_5 VDD VSS INV_X4
XI160 A_15 A_15_b0 VDD VSS INV_X1
XI161 A_15_b0 A_15_b1_0 VDD VSS INV_X4
XI162 A_15_b1_0 A_15_b2_0 VDD VSS INV_X4
XI163 A_15_b1_0 A_15_b2_1 VDD VSS INV_X4
XI164 A_15_b2_0 A_15_b3_0 VDD VSS INV_X4
XI165 A_15_b2_0 A_15_b3_1 VDD VSS INV_X4
XI166 A_15_b2_0 A_15_b3_2 VDD VSS INV_X4
XI167 A_15_b2_1 A_15_b3_3 VDD VSS INV_X4
XI168 A_15_b2_1 A_15_b3_4 VDD VSS INV_X4
XI169 A_15_b2_1 A_15_b3_5 VDD VSS INV_X4
XI170 A_16 A_16_b0 VDD VSS INV_X1
XI171 A_16_b0 A_16_b1_0 VDD VSS INV_X4
XI172 A_16_b1_0 A_16_b2_0 VDD VSS INV_X4
XI173 A_16_b1_0 A_16_b2_1 VDD VSS INV_X4
XI174 A_16_b2_0 A_16_b3_0 VDD VSS INV_X4
XI175 A_16_b2_0 A_16_b3_1 VDD VSS INV_X4
XI176 A_16_b2_0 A_16_b3_2 VDD VSS INV_X4
XI177 A_16_b2_1 A_16_b3_3 VDD VSS INV_X4
XI178 A_16_b2_1 A_16_b3_4 VDD VSS INV_X4
XI179 A_16_b2_1 A_16_b3_5 VDD VSS INV_X4
XI180 A_17 A_17_b0 VDD VSS INV_X1
XI181 A_17_b0 A_17_b1_0 VDD VSS INV_X4
XI182 A_17_b1_0 A_17_b2_0 VDD VSS INV_X4
XI183 A_17_b1_0 A_17_b2_1 VDD VSS INV_X4
XI184 A_17_b2_0 A_17_b3_0 VDD VSS INV_X4
XI185 A_17_b2_0 A_17_b3_1 VDD VSS INV_X4
XI186 A_17_b2_0 A_17_b3_2 VDD VSS INV_X4
XI187 A_17_b2_1 A_17_b3_3 VDD VSS INV_X4
XI188 A_17_b2_1 A_17_b3_4 VDD VSS INV_X4
XI189 A_17_b2_1 A_17_b3_5 VDD VSS INV_X4
XI190 A_18 A_18_b0 VDD VSS INV_X1
XI191 A_18_b0 A_18_b1_0 VDD VSS INV_X4
XI192 A_18_b1_0 A_18_b2_0 VDD VSS INV_X4
XI193 A_18_b1_0 A_18_b2_1 VDD VSS INV_X4
XI194 A_18_b2_0 A_18_b3_0 VDD VSS INV_X4
XI195 A_18_b2_0 A_18_b3_1 VDD VSS INV_X4
XI196 A_18_b2_0 A_18_b3_2 VDD VSS INV_X4
XI197 A_18_b2_1 A_18_b3_3 VDD VSS INV_X4
XI198 A_18_b2_1 A_18_b3_4 VDD VSS INV_X4
XI199 A_18_b2_1 A_18_b3_5 VDD VSS INV_X4
XI200 A_19 A_19_b0 VDD VSS INV_X1
XI201 A_19_b0 A_19_b1_0 VDD VSS INV_X4
XI202 A_19_b1_0 A_19_b2_0 VDD VSS INV_X4
XI203 A_19_b1_0 A_19_b2_1 VDD VSS INV_X4
XI204 A_19_b2_0 A_19_b3_0 VDD VSS INV_X4
XI205 A_19_b2_0 A_19_b3_1 VDD VSS INV_X4
XI206 A_19_b2_0 A_19_b3_2 VDD VSS INV_X4
XI207 A_19_b2_1 A_19_b3_3 VDD VSS INV_X4
XI208 A_19_b2_1 A_19_b3_4 VDD VSS INV_X4
XI209 A_19_b2_1 A_19_b3_5 VDD VSS INV_X4
XI210 A_20 A_20_b0 VDD VSS INV_X1
XI211 A_20_b0 A_20_b1_0 VDD VSS INV_X4
XI212 A_20_b1_0 A_20_b2_0 VDD VSS INV_X4
XI213 A_20_b1_0 A_20_b2_1 VDD VSS INV_X4
XI214 A_20_b2_0 A_20_b3_0 VDD VSS INV_X4
XI215 A_20_b2_0 A_20_b3_1 VDD VSS INV_X4
XI216 A_20_b2_0 A_20_b3_2 VDD VSS INV_X4
XI217 A_20_b2_1 A_20_b3_3 VDD VSS INV_X4
XI218 A_20_b2_1 A_20_b3_4 VDD VSS INV_X4
XI219 A_20_b2_1 A_20_b3_5 VDD VSS INV_X4
XI220 A_21 A_21_b0 VDD VSS INV_X1
XI221 A_21_b0 A_21_b1_0 VDD VSS INV_X4
XI222 A_21_b1_0 A_21_b2_0 VDD VSS INV_X4
XI223 A_21_b1_0 A_21_b2_1 VDD VSS INV_X4
XI224 A_21_b2_0 A_21_b3_0 VDD VSS INV_X4
XI225 A_21_b2_0 A_21_b3_1 VDD VSS INV_X4
XI226 A_21_b2_0 A_21_b3_2 VDD VSS INV_X4
XI227 A_21_b2_1 A_21_b3_3 VDD VSS INV_X4
XI228 A_21_b2_1 A_21_b3_4 VDD VSS INV_X4
XI229 A_21_b2_1 A_21_b3_5 VDD VSS INV_X4
XI230 A_22 A_22_b0 VDD VSS INV_X1
XI231 A_22_b0 A_22_b1_0 VDD VSS INV_X4
XI232 A_22_b1_0 A_22_b2_0 VDD VSS INV_X4
XI233 A_22_b1_0 A_22_b2_1 VDD VSS INV_X4
XI234 A_22_b2_0 A_22_b3_0 VDD VSS INV_X4
XI235 A_22_b2_0 A_22_b3_1 VDD VSS INV_X4
XI236 A_22_b2_0 A_22_b3_2 VDD VSS INV_X4
XI237 A_22_b2_1 A_22_b3_3 VDD VSS INV_X4
XI238 A_22_b2_1 A_22_b3_4 VDD VSS INV_X4
XI239 A_22_b2_1 A_22_b3_5 VDD VSS INV_X4
XI240 A_23 A_23_b0 VDD VSS INV_X1
XI241 A_23_b0 A_23_b1_0 VDD VSS INV_X4
XI242 A_23_b1_0 A_23_b2_0 VDD VSS INV_X4
XI243 A_23_b1_0 A_23_b2_1 VDD VSS INV_X4
XI244 A_23_b2_0 A_23_b3_0 VDD VSS INV_X4
XI245 A_23_b2_0 A_23_b3_1 VDD VSS INV_X4
XI246 A_23_b2_0 A_23_b3_2 VDD VSS INV_X4
XI247 A_23_b2_1 A_23_b3_3 VDD VSS INV_X4
XI248 A_23_b2_1 A_23_b3_4 VDD VSS INV_X4
XI249 A_23_b2_1 A_23_b3_5 VDD VSS INV_X4
XI250 A_24 A_24_b0 VDD VSS INV_X1
XI251 A_24_b0 A_24_b1_0 VDD VSS INV_X4
XI252 A_24_b1_0 A_24_b2_0 VDD VSS INV_X4
XI253 A_24_b1_0 A_24_b2_1 VDD VSS INV_X4
XI254 A_24_b2_0 A_24_b3_0 VDD VSS INV_X4
XI255 A_24_b2_0 A_24_b3_1 VDD VSS INV_X4
XI256 A_24_b2_0 A_24_b3_2 VDD VSS INV_X4
XI257 A_24_b2_1 A_24_b3_3 VDD VSS INV_X4
XI258 A_24_b2_1 A_24_b3_4 VDD VSS INV_X4
XI259 A_24_b2_1 A_24_b3_5 VDD VSS INV_X4
XI260 A_25 A_25_b0 VDD VSS INV_X1
XI261 A_25_b0 A_25_b1_0 VDD VSS INV_X4
XI262 A_25_b1_0 A_25_b2_0 VDD VSS INV_X4
XI263 A_25_b1_0 A_25_b2_1 VDD VSS INV_X4
XI264 A_25_b2_0 A_25_b3_0 VDD VSS INV_X4
XI265 A_25_b2_0 A_25_b3_1 VDD VSS INV_X4
XI266 A_25_b2_0 A_25_b3_2 VDD VSS INV_X4
XI267 A_25_b2_1 A_25_b3_3 VDD VSS INV_X4
XI268 A_25_b2_1 A_25_b3_4 VDD VSS INV_X4
XI269 A_25_b2_1 A_25_b3_5 VDD VSS INV_X4
XI270 A_26 A_26_b0 VDD VSS INV_X1
XI271 A_26_b0 A_26_b1_0 VDD VSS INV_X4
XI272 A_26_b1_0 A_26_b2_0 VDD VSS INV_X4
XI273 A_26_b1_0 A_26_b2_1 VDD VSS INV_X4
XI274 A_26_b2_0 A_26_b3_0 VDD VSS INV_X4
XI275 A_26_b2_0 A_26_b3_1 VDD VSS INV_X4
XI276 A_26_b2_0 A_26_b3_2 VDD VSS INV_X4
XI277 A_26_b2_1 A_26_b3_3 VDD VSS INV_X4
XI278 A_26_b2_1 A_26_b3_4 VDD VSS INV_X4
XI279 A_26_b2_1 A_26_b3_5 VDD VSS INV_X4
XI280 A_27 A_27_b0 VDD VSS INV_X1
XI281 A_27_b0 A_27_b1_0 VDD VSS INV_X4
XI282 A_27_b1_0 A_27_b2_0 VDD VSS INV_X4
XI283 A_27_b1_0 A_27_b2_1 VDD VSS INV_X4
XI284 A_27_b2_0 A_27_b3_0 VDD VSS INV_X4
XI285 A_27_b2_0 A_27_b3_1 VDD VSS INV_X4
XI286 A_27_b2_0 A_27_b3_2 VDD VSS INV_X4
XI287 A_27_b2_1 A_27_b3_3 VDD VSS INV_X4
XI288 A_27_b2_1 A_27_b3_4 VDD VSS INV_X4
XI289 A_27_b2_1 A_27_b3_5 VDD VSS INV_X4
XI290 A_28 A_28_b0 VDD VSS INV_X1
XI291 A_28_b0 A_28_b1_0 VDD VSS INV_X4
XI292 A_28_b1_0 A_28_b2_0 VDD VSS INV_X4
XI293 A_28_b1_0 A_28_b2_1 VDD VSS INV_X4
XI294 A_28_b2_0 A_28_b3_0 VDD VSS INV_X4
XI295 A_28_b2_0 A_28_b3_1 VDD VSS INV_X4
XI296 A_28_b2_0 A_28_b3_2 VDD VSS INV_X4
XI297 A_28_b2_1 A_28_b3_3 VDD VSS INV_X4
XI298 A_28_b2_1 A_28_b3_4 VDD VSS INV_X4
XI299 A_28_b2_1 A_28_b3_5 VDD VSS INV_X4
XI300 A_29 A_29_b0 VDD VSS INV_X1
XI301 A_29_b0 A_29_b1_0 VDD VSS INV_X4
XI302 A_29_b1_0 A_29_b2_0 VDD VSS INV_X4
XI303 A_29_b1_0 A_29_b2_1 VDD VSS INV_X4
XI304 A_29_b2_0 A_29_b3_0 VDD VSS INV_X4
XI305 A_29_b2_0 A_29_b3_1 VDD VSS INV_X4
XI306 A_29_b2_0 A_29_b3_2 VDD VSS INV_X4
XI307 A_29_b2_1 A_29_b3_3 VDD VSS INV_X4
XI308 A_29_b2_1 A_29_b3_4 VDD VSS INV_X4
XI309 A_29_b2_1 A_29_b3_5 VDD VSS INV_X4
XI310 A_30 A_30_b0 VDD VSS INV_X1
XI311 A_30_b0 A_30_b1_0 VDD VSS INV_X4
XI312 A_30_b1_0 A_30_b2_0 VDD VSS INV_X4
XI313 A_30_b1_0 A_30_b2_1 VDD VSS INV_X4
XI314 A_30_b2_0 A_30_b3_0 VDD VSS INV_X4
XI315 A_30_b2_0 A_30_b3_1 VDD VSS INV_X4
XI316 A_30_b2_0 A_30_b3_2 VDD VSS INV_X4
XI317 A_30_b2_1 A_30_b3_3 VDD VSS INV_X4
XI318 A_30_b2_1 A_30_b3_4 VDD VSS INV_X4
XI319 A_30_b2_1 A_30_b3_5 VDD VSS INV_X4
XI320 A_31 A_31_b0 VDD VSS INV_X1
XI321 A_31_b0 A_31_b1_0 VDD VSS INV_X4
XI322 A_31_b1_0 A_31_b2_0 VDD VSS INV_X4
XI323 A_31_b1_0 A_31_b2_1 VDD VSS INV_X4
XI324 A_31_b2_0 A_31_b3_0 VDD VSS INV_X4
XI325 A_31_b2_0 A_31_b3_1 VDD VSS INV_X4
XI326 A_31_b2_0 A_31_b3_2 VDD VSS INV_X4
XI327 A_31_b2_0 A_31_b3_3 VDD VSS INV_X4
XI328 A_31_b2_1 A_31_b3_4 VDD VSS INV_X4
XI329 A_31_b2_1 A_31_b3_5 VDD VSS INV_X4
XI330 A_31_b2_1 A_31_b3_6 VDD VSS INV_X4
XI331 A_31_b2_1 A_31_b3_7 VDD VSS INV_X4
XI332 B_3 B_3_b0 VDD VSS INV_X1
XI333 B_3_b0 B_3_b1_0 VDD VSS INV_X4
XI334 B_3_b1_0 B_3_b2_0 VDD VSS INV_X4
XI335 B_3_b1_0 B_3_b2_1 VDD VSS INV_X4
XI336 B_3_b2_0 B_3_b3_0 VDD VSS INV_X4
XI337 B_3_b2_0 B_3_b3_1 VDD VSS INV_X4
XI338 B_3_b2_0 B_3_b3_2 VDD VSS INV_X4
XI339 B_3_b2_1 B_3_b3_3 VDD VSS INV_X4
XI340 B_3_b2_1 B_3_b3_4 VDD VSS INV_X4
XI341 B_3_b2_1 B_3_b3_5 VDD VSS INV_X4
XI342 B_5 B_5_b0 VDD VSS INV_X1
XI343 B_5_b0 B_5_b1_0 VDD VSS INV_X4
XI344 B_5_b1_0 B_5_b2_0 VDD VSS INV_X4
XI345 B_5_b1_0 B_5_b2_1 VDD VSS INV_X4
XI346 B_5_b2_0 B_5_b3_0 VDD VSS INV_X4
XI347 B_5_b2_0 B_5_b3_1 VDD VSS INV_X4
XI348 B_5_b2_0 B_5_b3_2 VDD VSS INV_X4
XI349 B_5_b2_1 B_5_b3_3 VDD VSS INV_X4
XI350 B_5_b2_1 B_5_b3_4 VDD VSS INV_X4
XI351 B_5_b2_1 B_5_b3_5 VDD VSS INV_X4
XI352 B_7 B_7_b0 VDD VSS INV_X1
XI353 B_7_b0 B_7_b1_0 VDD VSS INV_X4
XI354 B_7_b1_0 B_7_b2_0 VDD VSS INV_X4
XI355 B_7_b1_0 B_7_b2_1 VDD VSS INV_X4
XI356 B_7_b2_0 B_7_b3_0 VDD VSS INV_X4
XI357 B_7_b2_0 B_7_b3_1 VDD VSS INV_X4
XI358 B_7_b2_0 B_7_b3_2 VDD VSS INV_X4
XI359 B_7_b2_1 B_7_b3_3 VDD VSS INV_X4
XI360 B_7_b2_1 B_7_b3_4 VDD VSS INV_X4
XI361 B_7_b2_1 B_7_b3_5 VDD VSS INV_X4
XI362 B_9 B_9_b0 VDD VSS INV_X1
XI363 B_9_b0 B_9_b1_0 VDD VSS INV_X4
XI364 B_9_b1_0 B_9_b2_0 VDD VSS INV_X4
XI365 B_9_b1_0 B_9_b2_1 VDD VSS INV_X4
XI366 B_9_b2_0 B_9_b3_0 VDD VSS INV_X4
XI367 B_9_b2_0 B_9_b3_1 VDD VSS INV_X4
XI368 B_9_b2_0 B_9_b3_2 VDD VSS INV_X4
XI369 B_9_b2_1 B_9_b3_3 VDD VSS INV_X4
XI370 B_9_b2_1 B_9_b3_4 VDD VSS INV_X4
XI371 B_9_b2_1 B_9_b3_5 VDD VSS INV_X4
XI372 B_11 B_11_b0 VDD VSS INV_X1
XI373 B_11_b0 B_11_b1_0 VDD VSS INV_X4
XI374 B_11_b1_0 B_11_b2_0 VDD VSS INV_X4
XI375 B_11_b1_0 B_11_b2_1 VDD VSS INV_X4
XI376 B_11_b2_0 B_11_b3_0 VDD VSS INV_X4
XI377 B_11_b2_0 B_11_b3_1 VDD VSS INV_X4
XI378 B_11_b2_0 B_11_b3_2 VDD VSS INV_X4
XI379 B_11_b2_1 B_11_b3_3 VDD VSS INV_X4
XI380 B_11_b2_1 B_11_b3_4 VDD VSS INV_X4
XI381 B_11_b2_1 B_11_b3_5 VDD VSS INV_X4
XI382 B_13 B_13_b0 VDD VSS INV_X1
XI383 B_13_b0 B_13_b1_0 VDD VSS INV_X4
XI384 B_13_b1_0 B_13_b2_0 VDD VSS INV_X4
XI385 B_13_b1_0 B_13_b2_1 VDD VSS INV_X4
XI386 B_13_b2_0 B_13_b3_0 VDD VSS INV_X4
XI387 B_13_b2_0 B_13_b3_1 VDD VSS INV_X4
XI388 B_13_b2_0 B_13_b3_2 VDD VSS INV_X4
XI389 B_13_b2_1 B_13_b3_3 VDD VSS INV_X4
XI390 B_13_b2_1 B_13_b3_4 VDD VSS INV_X4
XI391 B_13_b2_1 B_13_b3_5 VDD VSS INV_X4
XI392 B_15 B_15_b0 VDD VSS INV_X1
XI393 B_15_b0 B_15_b1_0 VDD VSS INV_X4
XI394 B_15_b1_0 B_15_b2_0 VDD VSS INV_X4
XI395 B_15_b1_0 B_15_b2_1 VDD VSS INV_X4
XI396 B_15_b2_0 B_15_b3_0 VDD VSS INV_X4
XI397 B_15_b2_0 B_15_b3_1 VDD VSS INV_X4
XI398 B_15_b2_0 B_15_b3_2 VDD VSS INV_X4
XI399 B_15_b2_1 B_15_b3_3 VDD VSS INV_X4
XI400 B_15_b2_1 B_15_b3_4 VDD VSS INV_X4
XI401 B_15_b2_1 B_15_b3_5 VDD VSS INV_X4
XI402 B_17 B_17_b0 VDD VSS INV_X1
XI403 B_17_b0 B_17_b1_0 VDD VSS INV_X4
XI404 B_17_b1_0 B_17_b2_0 VDD VSS INV_X4
XI405 B_17_b1_0 B_17_b2_1 VDD VSS INV_X4
XI406 B_17_b2_0 B_17_b3_0 VDD VSS INV_X4
XI407 B_17_b2_0 B_17_b3_1 VDD VSS INV_X4
XI408 B_17_b2_0 B_17_b3_2 VDD VSS INV_X4
XI409 B_17_b2_1 B_17_b3_3 VDD VSS INV_X4
XI410 B_17_b2_1 B_17_b3_4 VDD VSS INV_X4
XI411 B_17_b2_1 B_17_b3_5 VDD VSS INV_X4
XI412 B_19 B_19_b0 VDD VSS INV_X1
XI413 B_19_b0 B_19_b1_0 VDD VSS INV_X4
XI414 B_19_b1_0 B_19_b2_0 VDD VSS INV_X4
XI415 B_19_b1_0 B_19_b2_1 VDD VSS INV_X4
XI416 B_19_b2_0 B_19_b3_0 VDD VSS INV_X4
XI417 B_19_b2_0 B_19_b3_1 VDD VSS INV_X4
XI418 B_19_b2_0 B_19_b3_2 VDD VSS INV_X4
XI419 B_19_b2_1 B_19_b3_3 VDD VSS INV_X4
XI420 B_19_b2_1 B_19_b3_4 VDD VSS INV_X4
XI421 B_19_b2_1 B_19_b3_5 VDD VSS INV_X4
XI422 B_21 B_21_b0 VDD VSS INV_X1
XI423 B_21_b0 B_21_b1_0 VDD VSS INV_X4
XI424 B_21_b1_0 B_21_b2_0 VDD VSS INV_X4
XI425 B_21_b1_0 B_21_b2_1 VDD VSS INV_X4
XI426 B_21_b2_0 B_21_b3_0 VDD VSS INV_X4
XI427 B_21_b2_0 B_21_b3_1 VDD VSS INV_X4
XI428 B_21_b2_0 B_21_b3_2 VDD VSS INV_X4
XI429 B_21_b2_1 B_21_b3_3 VDD VSS INV_X4
XI430 B_21_b2_1 B_21_b3_4 VDD VSS INV_X4
XI431 B_21_b2_1 B_21_b3_5 VDD VSS INV_X4
XI432 B_23 B_23_b0 VDD VSS INV_X1
XI433 B_23_b0 B_23_b1_0 VDD VSS INV_X4
XI434 B_23_b1_0 B_23_b2_0 VDD VSS INV_X4
XI435 B_23_b1_0 B_23_b2_1 VDD VSS INV_X4
XI436 B_23_b2_0 B_23_b3_0 VDD VSS INV_X4
XI437 B_23_b2_0 B_23_b3_1 VDD VSS INV_X4
XI438 B_23_b2_0 B_23_b3_2 VDD VSS INV_X4
XI439 B_23_b2_1 B_23_b3_3 VDD VSS INV_X4
XI440 B_23_b2_1 B_23_b3_4 VDD VSS INV_X4
XI441 B_23_b2_1 B_23_b3_5 VDD VSS INV_X4
XI442 B_25 B_25_b0 VDD VSS INV_X1
XI443 B_25_b0 B_25_b1_0 VDD VSS INV_X4
XI444 B_25_b1_0 B_25_b2_0 VDD VSS INV_X4
XI445 B_25_b1_0 B_25_b2_1 VDD VSS INV_X4
XI446 B_25_b2_0 B_25_b3_0 VDD VSS INV_X4
XI447 B_25_b2_0 B_25_b3_1 VDD VSS INV_X4
XI448 B_25_b2_0 B_25_b3_2 VDD VSS INV_X4
XI449 B_25_b2_1 B_25_b3_3 VDD VSS INV_X4
XI450 B_25_b2_1 B_25_b3_4 VDD VSS INV_X4
XI451 B_25_b2_1 B_25_b3_5 VDD VSS INV_X4
XI452 B_27 B_27_b0 VDD VSS INV_X1
XI453 B_27_b0 B_27_b1_0 VDD VSS INV_X4
XI454 B_27_b1_0 B_27_b2_0 VDD VSS INV_X4
XI455 B_27_b1_0 B_27_b2_1 VDD VSS INV_X4
XI456 B_27_b2_0 B_27_b3_0 VDD VSS INV_X4
XI457 B_27_b2_0 B_27_b3_1 VDD VSS INV_X4
XI458 B_27_b2_0 B_27_b3_2 VDD VSS INV_X4
XI459 B_27_b2_1 B_27_b3_3 VDD VSS INV_X4
XI460 B_27_b2_1 B_27_b3_4 VDD VSS INV_X4
XI461 B_27_b2_1 B_27_b3_5 VDD VSS INV_X4
XI462 B_29 B_29_b0 VDD VSS INV_X1
XI463 B_29_b0 B_29_b1_0 VDD VSS INV_X4
XI464 B_29_b1_0 B_29_b2_0 VDD VSS INV_X4
XI465 B_29_b1_0 B_29_b2_1 VDD VSS INV_X4
XI466 B_29_b2_0 B_29_b3_0 VDD VSS INV_X4
XI467 B_29_b2_0 B_29_b3_1 VDD VSS INV_X4
XI468 B_29_b2_0 B_29_b3_2 VDD VSS INV_X4
XI469 B_29_b2_1 B_29_b3_3 VDD VSS INV_X4
XI470 B_29_b2_1 B_29_b3_4 VDD VSS INV_X4
XI471 B_29_b2_1 B_29_b3_5 VDD VSS INV_X4
XI472 B_31 B_31_b0 VDD VSS INV_X1
XI473 B_31_b0 B_31_b1_0 VDD VSS INV_X4
XI474 B_31_b1_0 B_31_b2_0 VDD VSS INV_X4
XI475 B_31_b1_0 B_31_b2_1 VDD VSS INV_X4
XI476 B_31_b2_0 B_31_b3_0 VDD VSS INV_X4
XI477 B_31_b2_0 B_31_b3_1 VDD VSS INV_X4
XI478 B_31_b2_0 B_31_b3_2 VDD VSS INV_X4
XI479 B_31_b2_1 B_31_b3_3 VDD VSS INV_X4
XI480 B_31_b2_1 B_31_b3_4 VDD VSS INV_X4
XI481 B_31_b2_1 B_31_b3_5 VDD VSS INV_X4
XI482 B_1_b3_0 B_0 VSS one0 two0 VDD VSS BOOTH_ENC
XI483 one0 one0_b0 VDD VSS INV_X1
XI484 one0_b0 one0_b1_0 VDD VSS INV_X4
XI485 one0_b1_0 one0_b2_0 VDD VSS INV_X4
XI486 one0_b1_0 one0_b2_1 VDD VSS INV_X4
XI487 one0_b2_0 one0_b3_0 VDD VSS INV_X4
XI488 one0_b2_0 one0_b3_1 VDD VSS INV_X4
XI489 one0_b2_0 one0_b3_2 VDD VSS INV_X4
XI490 one0_b2_1 one0_b3_3 VDD VSS INV_X4
XI491 one0_b2_1 one0_b3_4 VDD VSS INV_X4
XI492 one0_b2_1 one0_b3_5 VDD VSS INV_X4
XI493 two0 two0_b0 VDD VSS INV_X1
XI494 two0_b0 two0_b1_0 VDD VSS INV_X4
XI495 two0_b1_0 two0_b2_0 VDD VSS INV_X4
XI496 two0_b1_0 two0_b2_1 VDD VSS INV_X4
XI497 two0_b2_0 two0_b3_0 VDD VSS INV_X4
XI498 two0_b2_0 two0_b3_1 VDD VSS INV_X4
XI499 two0_b2_0 two0_b3_2 VDD VSS INV_X4
XI500 two0_b2_1 two0_b3_3 VDD VSS INV_X4
XI501 two0_b2_1 two0_b3_4 VDD VSS INV_X4
XI502 two0_b2_1 two0_b3_5 VDD VSS INV_X4
XI503 A_0_b3_0 VSS one0_b3_0 two0_b3_0 B_1_b3_0 pp0_0 VDD VSS BOOTH_SEL
XI504 A_1_b3_0 A_0_b3_0 one0_b3_0 two0_b3_0 B_1_b3_0 pp0_1 VDD VSS BOOTH_SEL
XI505 A_2_b3_0 A_1_b3_0 one0_b3_0 two0_b3_0 B_1_b3_0 pp0_2 VDD VSS BOOTH_SEL
XI506 A_3_b3_0 A_2_b3_0 one0_b3_0 two0_b3_0 B_1_b3_0 pp0_3 VDD VSS BOOTH_SEL
XI507 A_4_b3_0 A_3_b3_0 one0_b3_0 two0_b3_0 B_1_b3_0 pp0_4 VDD VSS BOOTH_SEL
XI508 A_5_b3_0 A_4_b3_0 one0_b3_0 two0_b3_0 B_1_b3_1 pp0_5 VDD VSS BOOTH_SEL
XI509 A_6_b3_0 A_5_b3_0 one0_b3_1 two0_b3_1 B_1_b3_1 pp0_6 VDD VSS BOOTH_SEL
XI510 A_7_b3_0 A_6_b3_0 one0_b3_1 two0_b3_1 B_1_b3_1 pp0_7 VDD VSS BOOTH_SEL
XI511 A_8_b3_0 A_7_b3_0 one0_b3_1 two0_b3_1 B_1_b3_1 pp0_8 VDD VSS BOOTH_SEL
XI512 A_9_b3_0 A_8_b3_0 one0_b3_1 two0_b3_1 B_1_b3_1 pp0_9 VDD VSS BOOTH_SEL
XI513 A_10_b3_0 A_9_b3_0 one0_b3_1 two0_b3_1 B_1_b3_1 pp0_10 VDD VSS BOOTH_SEL
XI514 A_11_b3_0 A_10_b3_0 one0_b3_2 two0_b3_2 B_1_b3_2 pp0_11 VDD VSS BOOTH_SEL
XI515 A_12_b3_0 A_11_b3_0 one0_b3_2 two0_b3_2 B_1_b3_2 pp0_12 VDD VSS BOOTH_SEL
XI516 A_13_b3_0 A_12_b3_0 one0_b3_2 two0_b3_2 B_1_b3_2 pp0_13 VDD VSS BOOTH_SEL
XI517 A_14_b3_0 A_13_b3_0 one0_b3_2 two0_b3_2 B_1_b3_2 pp0_14 VDD VSS BOOTH_SEL
XI518 A_15_b3_0 A_14_b3_0 one0_b3_2 two0_b3_2 B_1_b3_2 pp0_15 VDD VSS BOOTH_SEL
XI519 A_16_b3_0 A_15_b3_0 one0_b3_2 two0_b3_2 B_1_b3_2 pp0_16 VDD VSS BOOTH_SEL
XI520 A_17_b3_0 A_16_b3_0 one0_b3_3 two0_b3_3 B_1_b3_3 pp0_17 VDD VSS BOOTH_SEL
XI521 A_18_b3_0 A_17_b3_0 one0_b3_3 two0_b3_3 B_1_b3_3 pp0_18 VDD VSS BOOTH_SEL
XI522 A_19_b3_0 A_18_b3_0 one0_b3_3 two0_b3_3 B_1_b3_3 pp0_19 VDD VSS BOOTH_SEL
XI523 A_20_b3_0 A_19_b3_0 one0_b3_3 two0_b3_3 B_1_b3_3 pp0_20 VDD VSS BOOTH_SEL
XI524 A_21_b3_0 A_20_b3_0 one0_b3_3 two0_b3_3 B_1_b3_3 pp0_21 VDD VSS BOOTH_SEL
XI525 A_22_b3_0 A_21_b3_0 one0_b3_4 two0_b3_4 B_1_b3_3 pp0_22 VDD VSS BOOTH_SEL
XI526 A_23_b3_0 A_22_b3_0 one0_b3_4 two0_b3_4 B_1_b3_4 pp0_23 VDD VSS BOOTH_SEL
XI527 A_24_b3_0 A_23_b3_0 one0_b3_4 two0_b3_4 B_1_b3_4 pp0_24 VDD VSS BOOTH_SEL
XI528 A_25_b3_0 A_24_b3_0 one0_b3_4 two0_b3_4 B_1_b3_4 pp0_25 VDD VSS BOOTH_SEL
XI529 A_26_b3_0 A_25_b3_0 one0_b3_4 two0_b3_4 B_1_b3_4 pp0_26 VDD VSS BOOTH_SEL
XI530 A_27_b3_0 A_26_b3_0 one0_b3_4 two0_b3_4 B_1_b3_4 pp0_27 VDD VSS BOOTH_SEL
XI531 A_28_b3_0 A_27_b3_0 one0_b3_5 two0_b3_5 B_1_b3_4 pp0_28 VDD VSS BOOTH_SEL
XI532 A_29_b3_0 A_28_b3_0 one0_b3_5 two0_b3_5 B_1_b3_5 pp0_29 VDD VSS BOOTH_SEL
XI533 A_30_b3_0 A_29_b3_0 one0_b3_5 two0_b3_5 B_1_b3_5 pp0_30 VDD VSS BOOTH_SEL
XI534 A_31_b3_0 A_30_b3_0 one0_b3_5 two0_b3_5 B_1_b3_5 pp0_31 VDD VSS BOOTH_SEL
XI535 A_31_b3_0 A_31_b3_0 one0_b3_5 two0_b3_5 B_1_b3_5 pp0_32 VDD VSS BOOTH_SEL
XI536 pp0_32 sn0 VDD VSS INV_X1
XI537 B_3_b3_0 B_2 B_1_b3_5 one1 two1 VDD VSS BOOTH_ENC
XI538 one1 one1_b0 VDD VSS INV_X1
XI539 one1_b0 one1_b1_0 VDD VSS INV_X4
XI540 one1_b1_0 one1_b2_0 VDD VSS INV_X4
XI541 one1_b1_0 one1_b2_1 VDD VSS INV_X4
XI542 one1_b2_0 one1_b3_0 VDD VSS INV_X4
XI543 one1_b2_0 one1_b3_1 VDD VSS INV_X4
XI544 one1_b2_0 one1_b3_2 VDD VSS INV_X4
XI545 one1_b2_1 one1_b3_3 VDD VSS INV_X4
XI546 one1_b2_1 one1_b3_4 VDD VSS INV_X4
XI547 one1_b2_1 one1_b3_5 VDD VSS INV_X4
XI548 two1 two1_b0 VDD VSS INV_X1
XI549 two1_b0 two1_b1_0 VDD VSS INV_X4
XI550 two1_b1_0 two1_b2_0 VDD VSS INV_X4
XI551 two1_b1_0 two1_b2_1 VDD VSS INV_X4
XI552 two1_b2_0 two1_b3_0 VDD VSS INV_X4
XI553 two1_b2_0 two1_b3_1 VDD VSS INV_X4
XI554 two1_b2_0 two1_b3_2 VDD VSS INV_X4
XI555 two1_b2_1 two1_b3_3 VDD VSS INV_X4
XI556 two1_b2_1 two1_b3_4 VDD VSS INV_X4
XI557 two1_b2_1 two1_b3_5 VDD VSS INV_X4
XI558 A_0_b3_0 VSS one1_b3_0 two1_b3_0 B_3_b3_0 pp1_0 VDD VSS BOOTH_SEL
XI559 A_1_b3_0 A_0_b3_0 one1_b3_0 two1_b3_0 B_3_b3_0 pp1_1 VDD VSS BOOTH_SEL
XI560 A_2_b3_0 A_1_b3_0 one1_b3_0 two1_b3_0 B_3_b3_0 pp1_2 VDD VSS BOOTH_SEL
XI561 A_3_b3_0 A_2_b3_0 one1_b3_0 two1_b3_0 B_3_b3_0 pp1_3 VDD VSS BOOTH_SEL
XI562 A_4_b3_0 A_3_b3_0 one1_b3_0 two1_b3_0 B_3_b3_0 pp1_4 VDD VSS BOOTH_SEL
XI563 A_5_b3_0 A_4_b3_0 one1_b3_0 two1_b3_0 B_3_b3_1 pp1_5 VDD VSS BOOTH_SEL
XI564 A_6_b3_0 A_5_b3_0 one1_b3_1 two1_b3_1 B_3_b3_1 pp1_6 VDD VSS BOOTH_SEL
XI565 A_7_b3_0 A_6_b3_0 one1_b3_1 two1_b3_1 B_3_b3_1 pp1_7 VDD VSS BOOTH_SEL
XI566 A_8_b3_0 A_7_b3_0 one1_b3_1 two1_b3_1 B_3_b3_1 pp1_8 VDD VSS BOOTH_SEL
XI567 A_9_b3_0 A_8_b3_0 one1_b3_1 two1_b3_1 B_3_b3_1 pp1_9 VDD VSS BOOTH_SEL
XI568 A_10_b3_0 A_9_b3_0 one1_b3_1 two1_b3_1 B_3_b3_1 pp1_10 VDD VSS BOOTH_SEL
XI569 A_11_b3_0 A_10_b3_0 one1_b3_2 two1_b3_2 B_3_b3_2 pp1_11 VDD VSS BOOTH_SEL
XI570 A_12_b3_0 A_11_b3_0 one1_b3_2 two1_b3_2 B_3_b3_2 pp1_12 VDD VSS BOOTH_SEL
XI571 A_13_b3_0 A_12_b3_0 one1_b3_2 two1_b3_2 B_3_b3_2 pp1_13 VDD VSS BOOTH_SEL
XI572 A_14_b3_0 A_13_b3_0 one1_b3_2 two1_b3_2 B_3_b3_2 pp1_14 VDD VSS BOOTH_SEL
XI573 A_15_b3_0 A_14_b3_0 one1_b3_2 two1_b3_2 B_3_b3_2 pp1_15 VDD VSS BOOTH_SEL
XI574 A_16_b3_0 A_15_b3_0 one1_b3_2 two1_b3_2 B_3_b3_2 pp1_16 VDD VSS BOOTH_SEL
XI575 A_17_b3_0 A_16_b3_0 one1_b3_3 two1_b3_3 B_3_b3_3 pp1_17 VDD VSS BOOTH_SEL
XI576 A_18_b3_0 A_17_b3_0 one1_b3_3 two1_b3_3 B_3_b3_3 pp1_18 VDD VSS BOOTH_SEL
XI577 A_19_b3_0 A_18_b3_0 one1_b3_3 two1_b3_3 B_3_b3_3 pp1_19 VDD VSS BOOTH_SEL
XI578 A_20_b3_0 A_19_b3_0 one1_b3_3 two1_b3_3 B_3_b3_3 pp1_20 VDD VSS BOOTH_SEL
XI579 A_21_b3_0 A_20_b3_0 one1_b3_3 two1_b3_3 B_3_b3_3 pp1_21 VDD VSS BOOTH_SEL
XI580 A_22_b3_0 A_21_b3_0 one1_b3_4 two1_b3_4 B_3_b3_3 pp1_22 VDD VSS BOOTH_SEL
XI581 A_23_b3_0 A_22_b3_0 one1_b3_4 two1_b3_4 B_3_b3_4 pp1_23 VDD VSS BOOTH_SEL
XI582 A_24_b3_0 A_23_b3_0 one1_b3_4 two1_b3_4 B_3_b3_4 pp1_24 VDD VSS BOOTH_SEL
XI583 A_25_b3_0 A_24_b3_0 one1_b3_4 two1_b3_4 B_3_b3_4 pp1_25 VDD VSS BOOTH_SEL
XI584 A_26_b3_0 A_25_b3_0 one1_b3_4 two1_b3_4 B_3_b3_4 pp1_26 VDD VSS BOOTH_SEL
XI585 A_27_b3_0 A_26_b3_0 one1_b3_4 two1_b3_4 B_3_b3_4 pp1_27 VDD VSS BOOTH_SEL
XI586 A_28_b3_0 A_27_b3_0 one1_b3_5 two1_b3_5 B_3_b3_4 pp1_28 VDD VSS BOOTH_SEL
XI587 A_29_b3_0 A_28_b3_0 one1_b3_5 two1_b3_5 B_3_b3_5 pp1_29 VDD VSS BOOTH_SEL
XI588 A_30_b3_0 A_29_b3_0 one1_b3_5 two1_b3_5 B_3_b3_5 pp1_30 VDD VSS BOOTH_SEL
XI589 A_31_b3_0 A_30_b3_0 one1_b3_5 two1_b3_5 B_3_b3_5 pp1_31 VDD VSS BOOTH_SEL
XI590 A_31_b3_0 A_31_b3_0 one1_b3_5 two1_b3_5 B_3_b3_5 pp1_32 VDD VSS BOOTH_SEL
XI591 pp1_32 sn1 VDD VSS INV_X1
XI592 B_5_b3_0 B_4 B_3_b3_5 one2 two2 VDD VSS BOOTH_ENC
XI593 one2 one2_b0 VDD VSS INV_X1
XI594 one2_b0 one2_b1_0 VDD VSS INV_X4
XI595 one2_b1_0 one2_b2_0 VDD VSS INV_X4
XI596 one2_b1_0 one2_b2_1 VDD VSS INV_X4
XI597 one2_b2_0 one2_b3_0 VDD VSS INV_X4
XI598 one2_b2_0 one2_b3_1 VDD VSS INV_X4
XI599 one2_b2_0 one2_b3_2 VDD VSS INV_X4
XI600 one2_b2_1 one2_b3_3 VDD VSS INV_X4
XI601 one2_b2_1 one2_b3_4 VDD VSS INV_X4
XI602 one2_b2_1 one2_b3_5 VDD VSS INV_X4
XI603 two2 two2_b0 VDD VSS INV_X1
XI604 two2_b0 two2_b1_0 VDD VSS INV_X4
XI605 two2_b1_0 two2_b2_0 VDD VSS INV_X4
XI606 two2_b1_0 two2_b2_1 VDD VSS INV_X4
XI607 two2_b2_0 two2_b3_0 VDD VSS INV_X4
XI608 two2_b2_0 two2_b3_1 VDD VSS INV_X4
XI609 two2_b2_0 two2_b3_2 VDD VSS INV_X4
XI610 two2_b2_1 two2_b3_3 VDD VSS INV_X4
XI611 two2_b2_1 two2_b3_4 VDD VSS INV_X4
XI612 two2_b2_1 two2_b3_5 VDD VSS INV_X4
XI613 A_0_b3_0 VSS one2_b3_0 two2_b3_0 B_5_b3_0 pp2_0 VDD VSS BOOTH_SEL
XI614 A_1_b3_0 A_0_b3_0 one2_b3_0 two2_b3_0 B_5_b3_0 pp2_1 VDD VSS BOOTH_SEL
XI615 A_2_b3_0 A_1_b3_0 one2_b3_0 two2_b3_0 B_5_b3_0 pp2_2 VDD VSS BOOTH_SEL
XI616 A_3_b3_0 A_2_b3_0 one2_b3_0 two2_b3_0 B_5_b3_0 pp2_3 VDD VSS BOOTH_SEL
XI617 A_4_b3_0 A_3_b3_0 one2_b3_0 two2_b3_0 B_5_b3_0 pp2_4 VDD VSS BOOTH_SEL
XI618 A_5_b3_0 A_4_b3_0 one2_b3_0 two2_b3_0 B_5_b3_1 pp2_5 VDD VSS BOOTH_SEL
XI619 A_6_b3_0 A_5_b3_0 one2_b3_1 two2_b3_1 B_5_b3_1 pp2_6 VDD VSS BOOTH_SEL
XI620 A_7_b3_0 A_6_b3_0 one2_b3_1 two2_b3_1 B_5_b3_1 pp2_7 VDD VSS BOOTH_SEL
XI621 A_8_b3_0 A_7_b3_0 one2_b3_1 two2_b3_1 B_5_b3_1 pp2_8 VDD VSS BOOTH_SEL
XI622 A_9_b3_0 A_8_b3_0 one2_b3_1 two2_b3_1 B_5_b3_1 pp2_9 VDD VSS BOOTH_SEL
XI623 A_10_b3_0 A_9_b3_0 one2_b3_1 two2_b3_1 B_5_b3_1 pp2_10 VDD VSS BOOTH_SEL
XI624 A_11_b3_0 A_10_b3_0 one2_b3_2 two2_b3_2 B_5_b3_2 pp2_11 VDD VSS BOOTH_SEL
XI625 A_12_b3_0 A_11_b3_0 one2_b3_2 two2_b3_2 B_5_b3_2 pp2_12 VDD VSS BOOTH_SEL
XI626 A_13_b3_0 A_12_b3_0 one2_b3_2 two2_b3_2 B_5_b3_2 pp2_13 VDD VSS BOOTH_SEL
XI627 A_14_b3_0 A_13_b3_0 one2_b3_2 two2_b3_2 B_5_b3_2 pp2_14 VDD VSS BOOTH_SEL
XI628 A_15_b3_0 A_14_b3_0 one2_b3_2 two2_b3_2 B_5_b3_2 pp2_15 VDD VSS BOOTH_SEL
XI629 A_16_b3_0 A_15_b3_0 one2_b3_2 two2_b3_2 B_5_b3_2 pp2_16 VDD VSS BOOTH_SEL
XI630 A_17_b3_0 A_16_b3_0 one2_b3_3 two2_b3_3 B_5_b3_3 pp2_17 VDD VSS BOOTH_SEL
XI631 A_18_b3_0 A_17_b3_0 one2_b3_3 two2_b3_3 B_5_b3_3 pp2_18 VDD VSS BOOTH_SEL
XI632 A_19_b3_0 A_18_b3_0 one2_b3_3 two2_b3_3 B_5_b3_3 pp2_19 VDD VSS BOOTH_SEL
XI633 A_20_b3_0 A_19_b3_0 one2_b3_3 two2_b3_3 B_5_b3_3 pp2_20 VDD VSS BOOTH_SEL
XI634 A_21_b3_0 A_20_b3_0 one2_b3_3 two2_b3_3 B_5_b3_3 pp2_21 VDD VSS BOOTH_SEL
XI635 A_22_b3_0 A_21_b3_0 one2_b3_4 two2_b3_4 B_5_b3_3 pp2_22 VDD VSS BOOTH_SEL
XI636 A_23_b3_0 A_22_b3_0 one2_b3_4 two2_b3_4 B_5_b3_4 pp2_23 VDD VSS BOOTH_SEL
XI637 A_24_b3_0 A_23_b3_0 one2_b3_4 two2_b3_4 B_5_b3_4 pp2_24 VDD VSS BOOTH_SEL
XI638 A_25_b3_0 A_24_b3_0 one2_b3_4 two2_b3_4 B_5_b3_4 pp2_25 VDD VSS BOOTH_SEL
XI639 A_26_b3_0 A_25_b3_0 one2_b3_4 two2_b3_4 B_5_b3_4 pp2_26 VDD VSS BOOTH_SEL
XI640 A_27_b3_0 A_26_b3_0 one2_b3_4 two2_b3_4 B_5_b3_4 pp2_27 VDD VSS BOOTH_SEL
XI641 A_28_b3_0 A_27_b3_0 one2_b3_5 two2_b3_5 B_5_b3_4 pp2_28 VDD VSS BOOTH_SEL
XI642 A_29_b3_0 A_28_b3_0 one2_b3_5 two2_b3_5 B_5_b3_5 pp2_29 VDD VSS BOOTH_SEL
XI643 A_30_b3_0 A_29_b3_0 one2_b3_5 two2_b3_5 B_5_b3_5 pp2_30 VDD VSS BOOTH_SEL
XI644 A_31_b3_1 A_30_b3_0 one2_b3_5 two2_b3_5 B_5_b3_5 pp2_31 VDD VSS BOOTH_SEL
XI645 A_31_b3_1 A_31_b3_1 one2_b3_5 two2_b3_5 B_5_b3_5 pp2_32 VDD VSS BOOTH_SEL
XI646 pp2_32 sn2 VDD VSS INV_X1
XI647 B_7_b3_0 B_6 B_5_b3_5 one3 two3 VDD VSS BOOTH_ENC
XI648 one3 one3_b0 VDD VSS INV_X1
XI649 one3_b0 one3_b1_0 VDD VSS INV_X4
XI650 one3_b1_0 one3_b2_0 VDD VSS INV_X4
XI651 one3_b1_0 one3_b2_1 VDD VSS INV_X4
XI652 one3_b2_0 one3_b3_0 VDD VSS INV_X4
XI653 one3_b2_0 one3_b3_1 VDD VSS INV_X4
XI654 one3_b2_0 one3_b3_2 VDD VSS INV_X4
XI655 one3_b2_1 one3_b3_3 VDD VSS INV_X4
XI656 one3_b2_1 one3_b3_4 VDD VSS INV_X4
XI657 one3_b2_1 one3_b3_5 VDD VSS INV_X4
XI658 two3 two3_b0 VDD VSS INV_X1
XI659 two3_b0 two3_b1_0 VDD VSS INV_X4
XI660 two3_b1_0 two3_b2_0 VDD VSS INV_X4
XI661 two3_b1_0 two3_b2_1 VDD VSS INV_X4
XI662 two3_b2_0 two3_b3_0 VDD VSS INV_X4
XI663 two3_b2_0 two3_b3_1 VDD VSS INV_X4
XI664 two3_b2_0 two3_b3_2 VDD VSS INV_X4
XI665 two3_b2_1 two3_b3_3 VDD VSS INV_X4
XI666 two3_b2_1 two3_b3_4 VDD VSS INV_X4
XI667 two3_b2_1 two3_b3_5 VDD VSS INV_X4
XI668 A_0_b3_1 VSS one3_b3_0 two3_b3_0 B_7_b3_0 pp3_0 VDD VSS BOOTH_SEL
XI669 A_1_b3_1 A_0_b3_1 one3_b3_0 two3_b3_0 B_7_b3_0 pp3_1 VDD VSS BOOTH_SEL
XI670 A_2_b3_1 A_1_b3_1 one3_b3_0 two3_b3_0 B_7_b3_0 pp3_2 VDD VSS BOOTH_SEL
XI671 A_3_b3_1 A_2_b3_1 one3_b3_0 two3_b3_0 B_7_b3_0 pp3_3 VDD VSS BOOTH_SEL
XI672 A_4_b3_1 A_3_b3_1 one3_b3_0 two3_b3_0 B_7_b3_0 pp3_4 VDD VSS BOOTH_SEL
XI673 A_5_b3_1 A_4_b3_1 one3_b3_0 two3_b3_0 B_7_b3_1 pp3_5 VDD VSS BOOTH_SEL
XI674 A_6_b3_1 A_5_b3_1 one3_b3_1 two3_b3_1 B_7_b3_1 pp3_6 VDD VSS BOOTH_SEL
XI675 A_7_b3_1 A_6_b3_1 one3_b3_1 two3_b3_1 B_7_b3_1 pp3_7 VDD VSS BOOTH_SEL
XI676 A_8_b3_1 A_7_b3_1 one3_b3_1 two3_b3_1 B_7_b3_1 pp3_8 VDD VSS BOOTH_SEL
XI677 A_9_b3_1 A_8_b3_1 one3_b3_1 two3_b3_1 B_7_b3_1 pp3_9 VDD VSS BOOTH_SEL
XI678 A_10_b3_1 A_9_b3_1 one3_b3_1 two3_b3_1 B_7_b3_1 pp3_10 VDD VSS BOOTH_SEL
XI679 A_11_b3_1 A_10_b3_1 one3_b3_2 two3_b3_2 B_7_b3_2 pp3_11 VDD VSS BOOTH_SEL
XI680 A_12_b3_1 A_11_b3_1 one3_b3_2 two3_b3_2 B_7_b3_2 pp3_12 VDD VSS BOOTH_SEL
XI681 A_13_b3_1 A_12_b3_1 one3_b3_2 two3_b3_2 B_7_b3_2 pp3_13 VDD VSS BOOTH_SEL
XI682 A_14_b3_1 A_13_b3_1 one3_b3_2 two3_b3_2 B_7_b3_2 pp3_14 VDD VSS BOOTH_SEL
XI683 A_15_b3_1 A_14_b3_1 one3_b3_2 two3_b3_2 B_7_b3_2 pp3_15 VDD VSS BOOTH_SEL
XI684 A_16_b3_1 A_15_b3_1 one3_b3_2 two3_b3_2 B_7_b3_2 pp3_16 VDD VSS BOOTH_SEL
XI685 A_17_b3_1 A_16_b3_1 one3_b3_3 two3_b3_3 B_7_b3_3 pp3_17 VDD VSS BOOTH_SEL
XI686 A_18_b3_1 A_17_b3_1 one3_b3_3 two3_b3_3 B_7_b3_3 pp3_18 VDD VSS BOOTH_SEL
XI687 A_19_b3_1 A_18_b3_1 one3_b3_3 two3_b3_3 B_7_b3_3 pp3_19 VDD VSS BOOTH_SEL
XI688 A_20_b3_1 A_19_b3_1 one3_b3_3 two3_b3_3 B_7_b3_3 pp3_20 VDD VSS BOOTH_SEL
XI689 A_21_b3_1 A_20_b3_1 one3_b3_3 two3_b3_3 B_7_b3_3 pp3_21 VDD VSS BOOTH_SEL
XI690 A_22_b3_1 A_21_b3_1 one3_b3_4 two3_b3_4 B_7_b3_3 pp3_22 VDD VSS BOOTH_SEL
XI691 A_23_b3_1 A_22_b3_1 one3_b3_4 two3_b3_4 B_7_b3_4 pp3_23 VDD VSS BOOTH_SEL
XI692 A_24_b3_1 A_23_b3_1 one3_b3_4 two3_b3_4 B_7_b3_4 pp3_24 VDD VSS BOOTH_SEL
XI693 A_25_b3_1 A_24_b3_1 one3_b3_4 two3_b3_4 B_7_b3_4 pp3_25 VDD VSS BOOTH_SEL
XI694 A_26_b3_1 A_25_b3_1 one3_b3_4 two3_b3_4 B_7_b3_4 pp3_26 VDD VSS BOOTH_SEL
XI695 A_27_b3_1 A_26_b3_1 one3_b3_4 two3_b3_4 B_7_b3_4 pp3_27 VDD VSS BOOTH_SEL
XI696 A_28_b3_1 A_27_b3_1 one3_b3_5 two3_b3_5 B_7_b3_4 pp3_28 VDD VSS BOOTH_SEL
XI697 A_29_b3_1 A_28_b3_1 one3_b3_5 two3_b3_5 B_7_b3_5 pp3_29 VDD VSS BOOTH_SEL
XI698 A_30_b3_1 A_29_b3_1 one3_b3_5 two3_b3_5 B_7_b3_5 pp3_30 VDD VSS BOOTH_SEL
XI699 A_31_b3_1 A_30_b3_1 one3_b3_5 two3_b3_5 B_7_b3_5 pp3_31 VDD VSS BOOTH_SEL
XI700 A_31_b3_1 A_31_b3_1 one3_b3_5 two3_b3_5 B_7_b3_5 pp3_32 VDD VSS BOOTH_SEL
XI701 pp3_32 sn3 VDD VSS INV_X1
XI702 B_9_b3_0 B_8 B_7_b3_5 one4 two4 VDD VSS BOOTH_ENC
XI703 one4 one4_b0 VDD VSS INV_X1
XI704 one4_b0 one4_b1_0 VDD VSS INV_X4
XI705 one4_b1_0 one4_b2_0 VDD VSS INV_X4
XI706 one4_b1_0 one4_b2_1 VDD VSS INV_X4
XI707 one4_b2_0 one4_b3_0 VDD VSS INV_X4
XI708 one4_b2_0 one4_b3_1 VDD VSS INV_X4
XI709 one4_b2_0 one4_b3_2 VDD VSS INV_X4
XI710 one4_b2_1 one4_b3_3 VDD VSS INV_X4
XI711 one4_b2_1 one4_b3_4 VDD VSS INV_X4
XI712 one4_b2_1 one4_b3_5 VDD VSS INV_X4
XI713 two4 two4_b0 VDD VSS INV_X1
XI714 two4_b0 two4_b1_0 VDD VSS INV_X4
XI715 two4_b1_0 two4_b2_0 VDD VSS INV_X4
XI716 two4_b1_0 two4_b2_1 VDD VSS INV_X4
XI717 two4_b2_0 two4_b3_0 VDD VSS INV_X4
XI718 two4_b2_0 two4_b3_1 VDD VSS INV_X4
XI719 two4_b2_0 two4_b3_2 VDD VSS INV_X4
XI720 two4_b2_1 two4_b3_3 VDD VSS INV_X4
XI721 two4_b2_1 two4_b3_4 VDD VSS INV_X4
XI722 two4_b2_1 two4_b3_5 VDD VSS INV_X4
XI723 A_0_b3_1 VSS one4_b3_0 two4_b3_0 B_9_b3_0 pp4_0 VDD VSS BOOTH_SEL
XI724 A_1_b3_1 A_0_b3_1 one4_b3_0 two4_b3_0 B_9_b3_0 pp4_1 VDD VSS BOOTH_SEL
XI725 A_2_b3_1 A_1_b3_1 one4_b3_0 two4_b3_0 B_9_b3_0 pp4_2 VDD VSS BOOTH_SEL
XI726 A_3_b3_1 A_2_b3_1 one4_b3_0 two4_b3_0 B_9_b3_0 pp4_3 VDD VSS BOOTH_SEL
XI727 A_4_b3_1 A_3_b3_1 one4_b3_0 two4_b3_0 B_9_b3_0 pp4_4 VDD VSS BOOTH_SEL
XI728 A_5_b3_1 A_4_b3_1 one4_b3_0 two4_b3_0 B_9_b3_1 pp4_5 VDD VSS BOOTH_SEL
XI729 A_6_b3_1 A_5_b3_1 one4_b3_1 two4_b3_1 B_9_b3_1 pp4_6 VDD VSS BOOTH_SEL
XI730 A_7_b3_1 A_6_b3_1 one4_b3_1 two4_b3_1 B_9_b3_1 pp4_7 VDD VSS BOOTH_SEL
XI731 A_8_b3_1 A_7_b3_1 one4_b3_1 two4_b3_1 B_9_b3_1 pp4_8 VDD VSS BOOTH_SEL
XI732 A_9_b3_1 A_8_b3_1 one4_b3_1 two4_b3_1 B_9_b3_1 pp4_9 VDD VSS BOOTH_SEL
XI733 A_10_b3_1 A_9_b3_1 one4_b3_1 two4_b3_1 B_9_b3_1 pp4_10 VDD VSS BOOTH_SEL
XI734 A_11_b3_1 A_10_b3_1 one4_b3_2 two4_b3_2 B_9_b3_2 pp4_11 VDD VSS BOOTH_SEL
XI735 A_12_b3_1 A_11_b3_1 one4_b3_2 two4_b3_2 B_9_b3_2 pp4_12 VDD VSS BOOTH_SEL
XI736 A_13_b3_1 A_12_b3_1 one4_b3_2 two4_b3_2 B_9_b3_2 pp4_13 VDD VSS BOOTH_SEL
XI737 A_14_b3_1 A_13_b3_1 one4_b3_2 two4_b3_2 B_9_b3_2 pp4_14 VDD VSS BOOTH_SEL
XI738 A_15_b3_1 A_14_b3_1 one4_b3_2 two4_b3_2 B_9_b3_2 pp4_15 VDD VSS BOOTH_SEL
XI739 A_16_b3_1 A_15_b3_1 one4_b3_2 two4_b3_2 B_9_b3_2 pp4_16 VDD VSS BOOTH_SEL
XI740 A_17_b3_1 A_16_b3_1 one4_b3_3 two4_b3_3 B_9_b3_3 pp4_17 VDD VSS BOOTH_SEL
XI741 A_18_b3_1 A_17_b3_1 one4_b3_3 two4_b3_3 B_9_b3_3 pp4_18 VDD VSS BOOTH_SEL
XI742 A_19_b3_1 A_18_b3_1 one4_b3_3 two4_b3_3 B_9_b3_3 pp4_19 VDD VSS BOOTH_SEL
XI743 A_20_b3_1 A_19_b3_1 one4_b3_3 two4_b3_3 B_9_b3_3 pp4_20 VDD VSS BOOTH_SEL
XI744 A_21_b3_1 A_20_b3_1 one4_b3_3 two4_b3_3 B_9_b3_3 pp4_21 VDD VSS BOOTH_SEL
XI745 A_22_b3_1 A_21_b3_1 one4_b3_4 two4_b3_4 B_9_b3_3 pp4_22 VDD VSS BOOTH_SEL
XI746 A_23_b3_1 A_22_b3_1 one4_b3_4 two4_b3_4 B_9_b3_4 pp4_23 VDD VSS BOOTH_SEL
XI747 A_24_b3_1 A_23_b3_1 one4_b3_4 two4_b3_4 B_9_b3_4 pp4_24 VDD VSS BOOTH_SEL
XI748 A_25_b3_1 A_24_b3_1 one4_b3_4 two4_b3_4 B_9_b3_4 pp4_25 VDD VSS BOOTH_SEL
XI749 A_26_b3_1 A_25_b3_1 one4_b3_4 two4_b3_4 B_9_b3_4 pp4_26 VDD VSS BOOTH_SEL
XI750 A_27_b3_1 A_26_b3_1 one4_b3_4 two4_b3_4 B_9_b3_4 pp4_27 VDD VSS BOOTH_SEL
XI751 A_28_b3_1 A_27_b3_1 one4_b3_5 two4_b3_5 B_9_b3_4 pp4_28 VDD VSS BOOTH_SEL
XI752 A_29_b3_1 A_28_b3_1 one4_b3_5 two4_b3_5 B_9_b3_5 pp4_29 VDD VSS BOOTH_SEL
XI753 A_30_b3_1 A_29_b3_1 one4_b3_5 two4_b3_5 B_9_b3_5 pp4_30 VDD VSS BOOTH_SEL
XI754 A_31_b3_2 A_30_b3_1 one4_b3_5 two4_b3_5 B_9_b3_5 pp4_31 VDD VSS BOOTH_SEL
XI755 A_31_b3_2 A_31_b3_2 one4_b3_5 two4_b3_5 B_9_b3_5 pp4_32 VDD VSS BOOTH_SEL
XI756 pp4_32 sn4 VDD VSS INV_X1
XI757 B_11_b3_0 B_10 B_9_b3_5 one5 two5 VDD VSS BOOTH_ENC
XI758 one5 one5_b0 VDD VSS INV_X1
XI759 one5_b0 one5_b1_0 VDD VSS INV_X4
XI760 one5_b1_0 one5_b2_0 VDD VSS INV_X4
XI761 one5_b1_0 one5_b2_1 VDD VSS INV_X4
XI762 one5_b2_0 one5_b3_0 VDD VSS INV_X4
XI763 one5_b2_0 one5_b3_1 VDD VSS INV_X4
XI764 one5_b2_0 one5_b3_2 VDD VSS INV_X4
XI765 one5_b2_1 one5_b3_3 VDD VSS INV_X4
XI766 one5_b2_1 one5_b3_4 VDD VSS INV_X4
XI767 one5_b2_1 one5_b3_5 VDD VSS INV_X4
XI768 two5 two5_b0 VDD VSS INV_X1
XI769 two5_b0 two5_b1_0 VDD VSS INV_X4
XI770 two5_b1_0 two5_b2_0 VDD VSS INV_X4
XI771 two5_b1_0 two5_b2_1 VDD VSS INV_X4
XI772 two5_b2_0 two5_b3_0 VDD VSS INV_X4
XI773 two5_b2_0 two5_b3_1 VDD VSS INV_X4
XI774 two5_b2_0 two5_b3_2 VDD VSS INV_X4
XI775 two5_b2_1 two5_b3_3 VDD VSS INV_X4
XI776 two5_b2_1 two5_b3_4 VDD VSS INV_X4
XI777 two5_b2_1 two5_b3_5 VDD VSS INV_X4
XI778 A_0_b3_1 VSS one5_b3_0 two5_b3_0 B_11_b3_0 pp5_0 VDD VSS BOOTH_SEL
XI779 A_1_b3_1 A_0_b3_2 one5_b3_0 two5_b3_0 B_11_b3_0 pp5_1 VDD VSS BOOTH_SEL
XI780 A_2_b3_1 A_1_b3_2 one5_b3_0 two5_b3_0 B_11_b3_0 pp5_2 VDD VSS BOOTH_SEL
XI781 A_3_b3_1 A_2_b3_2 one5_b3_0 two5_b3_0 B_11_b3_0 pp5_3 VDD VSS BOOTH_SEL
XI782 A_4_b3_1 A_3_b3_2 one5_b3_0 two5_b3_0 B_11_b3_0 pp5_4 VDD VSS BOOTH_SEL
XI783 A_5_b3_1 A_4_b3_2 one5_b3_0 two5_b3_0 B_11_b3_1 pp5_5 VDD VSS BOOTH_SEL
XI784 A_6_b3_1 A_5_b3_2 one5_b3_1 two5_b3_1 B_11_b3_1 pp5_6 VDD VSS BOOTH_SEL
XI785 A_7_b3_1 A_6_b3_2 one5_b3_1 two5_b3_1 B_11_b3_1 pp5_7 VDD VSS BOOTH_SEL
XI786 A_8_b3_1 A_7_b3_2 one5_b3_1 two5_b3_1 B_11_b3_1 pp5_8 VDD VSS BOOTH_SEL
XI787 A_9_b3_1 A_8_b3_2 one5_b3_1 two5_b3_1 B_11_b3_1 pp5_9 VDD VSS BOOTH_SEL
XI788 A_10_b3_1 A_9_b3_2 one5_b3_1 two5_b3_1 B_11_b3_1 pp5_10 VDD VSS BOOTH_SEL
XI789 A_11_b3_1 A_10_b3_2 one5_b3_2 two5_b3_2 B_11_b3_2 pp5_11 VDD VSS BOOTH_SEL
XI790 A_12_b3_1 A_11_b3_2 one5_b3_2 two5_b3_2 B_11_b3_2 pp5_12 VDD VSS BOOTH_SEL
XI791 A_13_b3_1 A_12_b3_2 one5_b3_2 two5_b3_2 B_11_b3_2 pp5_13 VDD VSS BOOTH_SEL
XI792 A_14_b3_1 A_13_b3_2 one5_b3_2 two5_b3_2 B_11_b3_2 pp5_14 VDD VSS BOOTH_SEL
XI793 A_15_b3_1 A_14_b3_2 one5_b3_2 two5_b3_2 B_11_b3_2 pp5_15 VDD VSS BOOTH_SEL
XI794 A_16_b3_1 A_15_b3_2 one5_b3_2 two5_b3_2 B_11_b3_2 pp5_16 VDD VSS BOOTH_SEL
XI795 A_17_b3_1 A_16_b3_2 one5_b3_3 two5_b3_3 B_11_b3_3 pp5_17 VDD VSS BOOTH_SEL
XI796 A_18_b3_1 A_17_b3_2 one5_b3_3 two5_b3_3 B_11_b3_3 pp5_18 VDD VSS BOOTH_SEL
XI797 A_19_b3_1 A_18_b3_2 one5_b3_3 two5_b3_3 B_11_b3_3 pp5_19 VDD VSS BOOTH_SEL
XI798 A_20_b3_1 A_19_b3_2 one5_b3_3 two5_b3_3 B_11_b3_3 pp5_20 VDD VSS BOOTH_SEL
XI799 A_21_b3_1 A_20_b3_2 one5_b3_3 two5_b3_3 B_11_b3_3 pp5_21 VDD VSS BOOTH_SEL
XI800 A_22_b3_1 A_21_b3_2 one5_b3_4 two5_b3_4 B_11_b3_3 pp5_22 VDD VSS BOOTH_SEL
XI801 A_23_b3_1 A_22_b3_2 one5_b3_4 two5_b3_4 B_11_b3_4 pp5_23 VDD VSS BOOTH_SEL
XI802 A_24_b3_1 A_23_b3_2 one5_b3_4 two5_b3_4 B_11_b3_4 pp5_24 VDD VSS BOOTH_SEL
XI803 A_25_b3_1 A_24_b3_2 one5_b3_4 two5_b3_4 B_11_b3_4 pp5_25 VDD VSS BOOTH_SEL
XI804 A_26_b3_1 A_25_b3_2 one5_b3_4 two5_b3_4 B_11_b3_4 pp5_26 VDD VSS BOOTH_SEL
XI805 A_27_b3_1 A_26_b3_2 one5_b3_4 two5_b3_4 B_11_b3_4 pp5_27 VDD VSS BOOTH_SEL
XI806 A_28_b3_1 A_27_b3_2 one5_b3_5 two5_b3_5 B_11_b3_4 pp5_28 VDD VSS BOOTH_SEL
XI807 A_29_b3_1 A_28_b3_2 one5_b3_5 two5_b3_5 B_11_b3_5 pp5_29 VDD VSS BOOTH_SEL
XI808 A_30_b3_1 A_29_b3_2 one5_b3_5 two5_b3_5 B_11_b3_5 pp5_30 VDD VSS BOOTH_SEL
XI809 A_31_b3_2 A_30_b3_2 one5_b3_5 two5_b3_5 B_11_b3_5 pp5_31 VDD VSS BOOTH_SEL
XI810 A_31_b3_2 A_31_b3_2 one5_b3_5 two5_b3_5 B_11_b3_5 pp5_32 VDD VSS BOOTH_SEL
XI811 pp5_32 sn5 VDD VSS INV_X1
XI812 B_13_b3_0 B_12 B_11_b3_5 one6 two6 VDD VSS BOOTH_ENC
XI813 one6 one6_b0 VDD VSS INV_X1
XI814 one6_b0 one6_b1_0 VDD VSS INV_X4
XI815 one6_b1_0 one6_b2_0 VDD VSS INV_X4
XI816 one6_b1_0 one6_b2_1 VDD VSS INV_X4
XI817 one6_b2_0 one6_b3_0 VDD VSS INV_X4
XI818 one6_b2_0 one6_b3_1 VDD VSS INV_X4
XI819 one6_b2_0 one6_b3_2 VDD VSS INV_X4
XI820 one6_b2_1 one6_b3_3 VDD VSS INV_X4
XI821 one6_b2_1 one6_b3_4 VDD VSS INV_X4
XI822 one6_b2_1 one6_b3_5 VDD VSS INV_X4
XI823 two6 two6_b0 VDD VSS INV_X1
XI824 two6_b0 two6_b1_0 VDD VSS INV_X4
XI825 two6_b1_0 two6_b2_0 VDD VSS INV_X4
XI826 two6_b1_0 two6_b2_1 VDD VSS INV_X4
XI827 two6_b2_0 two6_b3_0 VDD VSS INV_X4
XI828 two6_b2_0 two6_b3_1 VDD VSS INV_X4
XI829 two6_b2_0 two6_b3_2 VDD VSS INV_X4
XI830 two6_b2_1 two6_b3_3 VDD VSS INV_X4
XI831 two6_b2_1 two6_b3_4 VDD VSS INV_X4
XI832 two6_b2_1 two6_b3_5 VDD VSS INV_X4
XI833 A_0_b3_2 VSS one6_b3_0 two6_b3_0 B_13_b3_0 pp6_0 VDD VSS BOOTH_SEL
XI834 A_1_b3_2 A_0_b3_2 one6_b3_0 two6_b3_0 B_13_b3_0 pp6_1 VDD VSS BOOTH_SEL
XI835 A_2_b3_2 A_1_b3_2 one6_b3_0 two6_b3_0 B_13_b3_0 pp6_2 VDD VSS BOOTH_SEL
XI836 A_3_b3_2 A_2_b3_2 one6_b3_0 two6_b3_0 B_13_b3_0 pp6_3 VDD VSS BOOTH_SEL
XI837 A_4_b3_2 A_3_b3_2 one6_b3_0 two6_b3_0 B_13_b3_0 pp6_4 VDD VSS BOOTH_SEL
XI838 A_5_b3_2 A_4_b3_2 one6_b3_0 two6_b3_0 B_13_b3_1 pp6_5 VDD VSS BOOTH_SEL
XI839 A_6_b3_2 A_5_b3_2 one6_b3_1 two6_b3_1 B_13_b3_1 pp6_6 VDD VSS BOOTH_SEL
XI840 A_7_b3_2 A_6_b3_2 one6_b3_1 two6_b3_1 B_13_b3_1 pp6_7 VDD VSS BOOTH_SEL
XI841 A_8_b3_2 A_7_b3_2 one6_b3_1 two6_b3_1 B_13_b3_1 pp6_8 VDD VSS BOOTH_SEL
XI842 A_9_b3_2 A_8_b3_2 one6_b3_1 two6_b3_1 B_13_b3_1 pp6_9 VDD VSS BOOTH_SEL
XI843 A_10_b3_2 A_9_b3_2 one6_b3_1 two6_b3_1 B_13_b3_1 pp6_10 VDD VSS BOOTH_SEL
XI844 A_11_b3_2 A_10_b3_2 one6_b3_2 two6_b3_2 B_13_b3_2 pp6_11 VDD VSS BOOTH_SEL
XI845 A_12_b3_2 A_11_b3_2 one6_b3_2 two6_b3_2 B_13_b3_2 pp6_12 VDD VSS BOOTH_SEL
XI846 A_13_b3_2 A_12_b3_2 one6_b3_2 two6_b3_2 B_13_b3_2 pp6_13 VDD VSS BOOTH_SEL
XI847 A_14_b3_2 A_13_b3_2 one6_b3_2 two6_b3_2 B_13_b3_2 pp6_14 VDD VSS BOOTH_SEL
XI848 A_15_b3_2 A_14_b3_2 one6_b3_2 two6_b3_2 B_13_b3_2 pp6_15 VDD VSS BOOTH_SEL
XI849 A_16_b3_2 A_15_b3_2 one6_b3_2 two6_b3_2 B_13_b3_2 pp6_16 VDD VSS BOOTH_SEL
XI850 A_17_b3_2 A_16_b3_2 one6_b3_3 two6_b3_3 B_13_b3_3 pp6_17 VDD VSS BOOTH_SEL
XI851 A_18_b3_2 A_17_b3_2 one6_b3_3 two6_b3_3 B_13_b3_3 pp6_18 VDD VSS BOOTH_SEL
XI852 A_19_b3_2 A_18_b3_2 one6_b3_3 two6_b3_3 B_13_b3_3 pp6_19 VDD VSS BOOTH_SEL
XI853 A_20_b3_2 A_19_b3_2 one6_b3_3 two6_b3_3 B_13_b3_3 pp6_20 VDD VSS BOOTH_SEL
XI854 A_21_b3_2 A_20_b3_2 one6_b3_3 two6_b3_3 B_13_b3_3 pp6_21 VDD VSS BOOTH_SEL
XI855 A_22_b3_2 A_21_b3_2 one6_b3_4 two6_b3_4 B_13_b3_3 pp6_22 VDD VSS BOOTH_SEL
XI856 A_23_b3_2 A_22_b3_2 one6_b3_4 two6_b3_4 B_13_b3_4 pp6_23 VDD VSS BOOTH_SEL
XI857 A_24_b3_2 A_23_b3_2 one6_b3_4 two6_b3_4 B_13_b3_4 pp6_24 VDD VSS BOOTH_SEL
XI858 A_25_b3_2 A_24_b3_2 one6_b3_4 two6_b3_4 B_13_b3_4 pp6_25 VDD VSS BOOTH_SEL
XI859 A_26_b3_2 A_25_b3_2 one6_b3_4 two6_b3_4 B_13_b3_4 pp6_26 VDD VSS BOOTH_SEL
XI860 A_27_b3_2 A_26_b3_2 one6_b3_4 two6_b3_4 B_13_b3_4 pp6_27 VDD VSS BOOTH_SEL
XI861 A_28_b3_2 A_27_b3_2 one6_b3_5 two6_b3_5 B_13_b3_4 pp6_28 VDD VSS BOOTH_SEL
XI862 A_29_b3_2 A_28_b3_2 one6_b3_5 two6_b3_5 B_13_b3_5 pp6_29 VDD VSS BOOTH_SEL
XI863 A_30_b3_2 A_29_b3_2 one6_b3_5 two6_b3_5 B_13_b3_5 pp6_30 VDD VSS BOOTH_SEL
XI864 A_31_b3_3 A_30_b3_2 one6_b3_5 two6_b3_5 B_13_b3_5 pp6_31 VDD VSS BOOTH_SEL
XI865 A_31_b3_3 A_31_b3_3 one6_b3_5 two6_b3_5 B_13_b3_5 pp6_32 VDD VSS BOOTH_SEL
XI866 pp6_32 sn6 VDD VSS INV_X1
XI867 B_15_b3_0 B_14 B_13_b3_5 one7 two7 VDD VSS BOOTH_ENC
XI868 one7 one7_b0 VDD VSS INV_X1
XI869 one7_b0 one7_b1_0 VDD VSS INV_X4
XI870 one7_b1_0 one7_b2_0 VDD VSS INV_X4
XI871 one7_b1_0 one7_b2_1 VDD VSS INV_X4
XI872 one7_b2_0 one7_b3_0 VDD VSS INV_X4
XI873 one7_b2_0 one7_b3_1 VDD VSS INV_X4
XI874 one7_b2_0 one7_b3_2 VDD VSS INV_X4
XI875 one7_b2_1 one7_b3_3 VDD VSS INV_X4
XI876 one7_b2_1 one7_b3_4 VDD VSS INV_X4
XI877 one7_b2_1 one7_b3_5 VDD VSS INV_X4
XI878 two7 two7_b0 VDD VSS INV_X1
XI879 two7_b0 two7_b1_0 VDD VSS INV_X4
XI880 two7_b1_0 two7_b2_0 VDD VSS INV_X4
XI881 two7_b1_0 two7_b2_1 VDD VSS INV_X4
XI882 two7_b2_0 two7_b3_0 VDD VSS INV_X4
XI883 two7_b2_0 two7_b3_1 VDD VSS INV_X4
XI884 two7_b2_0 two7_b3_2 VDD VSS INV_X4
XI885 two7_b2_1 two7_b3_3 VDD VSS INV_X4
XI886 two7_b2_1 two7_b3_4 VDD VSS INV_X4
XI887 two7_b2_1 two7_b3_5 VDD VSS INV_X4
XI888 A_0_b3_2 VSS one7_b3_0 two7_b3_0 B_15_b3_0 pp7_0 VDD VSS BOOTH_SEL
XI889 A_1_b3_2 A_0_b3_2 one7_b3_0 two7_b3_0 B_15_b3_0 pp7_1 VDD VSS BOOTH_SEL
XI890 A_2_b3_2 A_1_b3_2 one7_b3_0 two7_b3_0 B_15_b3_0 pp7_2 VDD VSS BOOTH_SEL
XI891 A_3_b3_2 A_2_b3_2 one7_b3_0 two7_b3_0 B_15_b3_0 pp7_3 VDD VSS BOOTH_SEL
XI892 A_4_b3_2 A_3_b3_2 one7_b3_0 two7_b3_0 B_15_b3_0 pp7_4 VDD VSS BOOTH_SEL
XI893 A_5_b3_2 A_4_b3_2 one7_b3_0 two7_b3_0 B_15_b3_1 pp7_5 VDD VSS BOOTH_SEL
XI894 A_6_b3_2 A_5_b3_2 one7_b3_1 two7_b3_1 B_15_b3_1 pp7_6 VDD VSS BOOTH_SEL
XI895 A_7_b3_2 A_6_b3_2 one7_b3_1 two7_b3_1 B_15_b3_1 pp7_7 VDD VSS BOOTH_SEL
XI896 A_8_b3_2 A_7_b3_2 one7_b3_1 two7_b3_1 B_15_b3_1 pp7_8 VDD VSS BOOTH_SEL
XI897 A_9_b3_2 A_8_b3_2 one7_b3_1 two7_b3_1 B_15_b3_1 pp7_9 VDD VSS BOOTH_SEL
XI898 A_10_b3_2 A_9_b3_2 one7_b3_1 two7_b3_1 B_15_b3_1 pp7_10 VDD VSS BOOTH_SEL
XI899 A_11_b3_2 A_10_b3_2 one7_b3_2 two7_b3_2 B_15_b3_2 pp7_11 VDD VSS BOOTH_SEL
XI900 A_12_b3_2 A_11_b3_2 one7_b3_2 two7_b3_2 B_15_b3_2 pp7_12 VDD VSS BOOTH_SEL
XI901 A_13_b3_2 A_12_b3_2 one7_b3_2 two7_b3_2 B_15_b3_2 pp7_13 VDD VSS BOOTH_SEL
XI902 A_14_b3_2 A_13_b3_2 one7_b3_2 two7_b3_2 B_15_b3_2 pp7_14 VDD VSS BOOTH_SEL
XI903 A_15_b3_2 A_14_b3_2 one7_b3_2 two7_b3_2 B_15_b3_2 pp7_15 VDD VSS BOOTH_SEL
XI904 A_16_b3_2 A_15_b3_2 one7_b3_2 two7_b3_2 B_15_b3_2 pp7_16 VDD VSS BOOTH_SEL
XI905 A_17_b3_2 A_16_b3_2 one7_b3_3 two7_b3_3 B_15_b3_3 pp7_17 VDD VSS BOOTH_SEL
XI906 A_18_b3_2 A_17_b3_2 one7_b3_3 two7_b3_3 B_15_b3_3 pp7_18 VDD VSS BOOTH_SEL
XI907 A_19_b3_2 A_18_b3_2 one7_b3_3 two7_b3_3 B_15_b3_3 pp7_19 VDD VSS BOOTH_SEL
XI908 A_20_b3_2 A_19_b3_2 one7_b3_3 two7_b3_3 B_15_b3_3 pp7_20 VDD VSS BOOTH_SEL
XI909 A_21_b3_2 A_20_b3_2 one7_b3_3 two7_b3_3 B_15_b3_3 pp7_21 VDD VSS BOOTH_SEL
XI910 A_22_b3_2 A_21_b3_2 one7_b3_4 two7_b3_4 B_15_b3_3 pp7_22 VDD VSS BOOTH_SEL
XI911 A_23_b3_2 A_22_b3_2 one7_b3_4 two7_b3_4 B_15_b3_4 pp7_23 VDD VSS BOOTH_SEL
XI912 A_24_b3_2 A_23_b3_2 one7_b3_4 two7_b3_4 B_15_b3_4 pp7_24 VDD VSS BOOTH_SEL
XI913 A_25_b3_2 A_24_b3_2 one7_b3_4 two7_b3_4 B_15_b3_4 pp7_25 VDD VSS BOOTH_SEL
XI914 A_26_b3_2 A_25_b3_2 one7_b3_4 two7_b3_4 B_15_b3_4 pp7_26 VDD VSS BOOTH_SEL
XI915 A_27_b3_2 A_26_b3_2 one7_b3_4 two7_b3_4 B_15_b3_4 pp7_27 VDD VSS BOOTH_SEL
XI916 A_28_b3_2 A_27_b3_2 one7_b3_5 two7_b3_5 B_15_b3_4 pp7_28 VDD VSS BOOTH_SEL
XI917 A_29_b3_2 A_28_b3_2 one7_b3_5 two7_b3_5 B_15_b3_5 pp7_29 VDD VSS BOOTH_SEL
XI918 A_30_b3_2 A_29_b3_2 one7_b3_5 two7_b3_5 B_15_b3_5 pp7_30 VDD VSS BOOTH_SEL
XI919 A_31_b3_3 A_30_b3_2 one7_b3_5 two7_b3_5 B_15_b3_5 pp7_31 VDD VSS BOOTH_SEL
XI920 A_31_b3_3 A_31_b3_3 one7_b3_5 two7_b3_5 B_15_b3_5 pp7_32 VDD VSS BOOTH_SEL
XI921 pp7_32 sn7 VDD VSS INV_X1
XI922 B_17_b3_0 B_16 B_15_b3_5 one8 two8 VDD VSS BOOTH_ENC
XI923 one8 one8_b0 VDD VSS INV_X1
XI924 one8_b0 one8_b1_0 VDD VSS INV_X4
XI925 one8_b1_0 one8_b2_0 VDD VSS INV_X4
XI926 one8_b1_0 one8_b2_1 VDD VSS INV_X4
XI927 one8_b2_0 one8_b3_0 VDD VSS INV_X4
XI928 one8_b2_0 one8_b3_1 VDD VSS INV_X4
XI929 one8_b2_0 one8_b3_2 VDD VSS INV_X4
XI930 one8_b2_1 one8_b3_3 VDD VSS INV_X4
XI931 one8_b2_1 one8_b3_4 VDD VSS INV_X4
XI932 one8_b2_1 one8_b3_5 VDD VSS INV_X4
XI933 two8 two8_b0 VDD VSS INV_X1
XI934 two8_b0 two8_b1_0 VDD VSS INV_X4
XI935 two8_b1_0 two8_b2_0 VDD VSS INV_X4
XI936 two8_b1_0 two8_b2_1 VDD VSS INV_X4
XI937 two8_b2_0 two8_b3_0 VDD VSS INV_X4
XI938 two8_b2_0 two8_b3_1 VDD VSS INV_X4
XI939 two8_b2_0 two8_b3_2 VDD VSS INV_X4
XI940 two8_b2_1 two8_b3_3 VDD VSS INV_X4
XI941 two8_b2_1 two8_b3_4 VDD VSS INV_X4
XI942 two8_b2_1 two8_b3_5 VDD VSS INV_X4
XI943 A_0_b3_3 VSS one8_b3_0 two8_b3_0 B_17_b3_0 pp8_0 VDD VSS BOOTH_SEL
XI944 A_1_b3_3 A_0_b3_3 one8_b3_0 two8_b3_0 B_17_b3_0 pp8_1 VDD VSS BOOTH_SEL
XI945 A_2_b3_3 A_1_b3_3 one8_b3_0 two8_b3_0 B_17_b3_0 pp8_2 VDD VSS BOOTH_SEL
XI946 A_3_b3_3 A_2_b3_3 one8_b3_0 two8_b3_0 B_17_b3_0 pp8_3 VDD VSS BOOTH_SEL
XI947 A_4_b3_3 A_3_b3_3 one8_b3_0 two8_b3_0 B_17_b3_0 pp8_4 VDD VSS BOOTH_SEL
XI948 A_5_b3_3 A_4_b3_3 one8_b3_0 two8_b3_0 B_17_b3_1 pp8_5 VDD VSS BOOTH_SEL
XI949 A_6_b3_3 A_5_b3_3 one8_b3_1 two8_b3_1 B_17_b3_1 pp8_6 VDD VSS BOOTH_SEL
XI950 A_7_b3_3 A_6_b3_3 one8_b3_1 two8_b3_1 B_17_b3_1 pp8_7 VDD VSS BOOTH_SEL
XI951 A_8_b3_3 A_7_b3_3 one8_b3_1 two8_b3_1 B_17_b3_1 pp8_8 VDD VSS BOOTH_SEL
XI952 A_9_b3_3 A_8_b3_3 one8_b3_1 two8_b3_1 B_17_b3_1 pp8_9 VDD VSS BOOTH_SEL
XI953 A_10_b3_3 A_9_b3_3 one8_b3_1 two8_b3_1 B_17_b3_1 pp8_10 VDD VSS BOOTH_SEL
XI954 A_11_b3_3 A_10_b3_3 one8_b3_2 two8_b3_2 B_17_b3_2 pp8_11 VDD VSS BOOTH_SEL
XI955 A_12_b3_3 A_11_b3_3 one8_b3_2 two8_b3_2 B_17_b3_2 pp8_12 VDD VSS BOOTH_SEL
XI956 A_13_b3_3 A_12_b3_3 one8_b3_2 two8_b3_2 B_17_b3_2 pp8_13 VDD VSS BOOTH_SEL
XI957 A_14_b3_3 A_13_b3_3 one8_b3_2 two8_b3_2 B_17_b3_2 pp8_14 VDD VSS BOOTH_SEL
XI958 A_15_b3_3 A_14_b3_3 one8_b3_2 two8_b3_2 B_17_b3_2 pp8_15 VDD VSS BOOTH_SEL
XI959 A_16_b3_3 A_15_b3_3 one8_b3_2 two8_b3_2 B_17_b3_2 pp8_16 VDD VSS BOOTH_SEL
XI960 A_17_b3_3 A_16_b3_3 one8_b3_3 two8_b3_3 B_17_b3_3 pp8_17 VDD VSS BOOTH_SEL
XI961 A_18_b3_3 A_17_b3_3 one8_b3_3 two8_b3_3 B_17_b3_3 pp8_18 VDD VSS BOOTH_SEL
XI962 A_19_b3_3 A_18_b3_3 one8_b3_3 two8_b3_3 B_17_b3_3 pp8_19 VDD VSS BOOTH_SEL
XI963 A_20_b3_3 A_19_b3_3 one8_b3_3 two8_b3_3 B_17_b3_3 pp8_20 VDD VSS BOOTH_SEL
XI964 A_21_b3_3 A_20_b3_3 one8_b3_3 two8_b3_3 B_17_b3_3 pp8_21 VDD VSS BOOTH_SEL
XI965 A_22_b3_3 A_21_b3_3 one8_b3_4 two8_b3_4 B_17_b3_3 pp8_22 VDD VSS BOOTH_SEL
XI966 A_23_b3_3 A_22_b3_3 one8_b3_4 two8_b3_4 B_17_b3_4 pp8_23 VDD VSS BOOTH_SEL
XI967 A_24_b3_3 A_23_b3_3 one8_b3_4 two8_b3_4 B_17_b3_4 pp8_24 VDD VSS BOOTH_SEL
XI968 A_25_b3_3 A_24_b3_3 one8_b3_4 two8_b3_4 B_17_b3_4 pp8_25 VDD VSS BOOTH_SEL
XI969 A_26_b3_3 A_25_b3_3 one8_b3_4 two8_b3_4 B_17_b3_4 pp8_26 VDD VSS BOOTH_SEL
XI970 A_27_b3_3 A_26_b3_3 one8_b3_4 two8_b3_4 B_17_b3_4 pp8_27 VDD VSS BOOTH_SEL
XI971 A_28_b3_3 A_27_b3_3 one8_b3_5 two8_b3_5 B_17_b3_4 pp8_28 VDD VSS BOOTH_SEL
XI972 A_29_b3_3 A_28_b3_3 one8_b3_5 two8_b3_5 B_17_b3_5 pp8_29 VDD VSS BOOTH_SEL
XI973 A_30_b3_3 A_29_b3_3 one8_b3_5 two8_b3_5 B_17_b3_5 pp8_30 VDD VSS BOOTH_SEL
XI974 A_31_b3_4 A_30_b3_3 one8_b3_5 two8_b3_5 B_17_b3_5 pp8_31 VDD VSS BOOTH_SEL
XI975 A_31_b3_4 A_31_b3_4 one8_b3_5 two8_b3_5 B_17_b3_5 pp8_32 VDD VSS BOOTH_SEL
XI976 pp8_32 sn8 VDD VSS INV_X1
XI977 B_19_b3_0 B_18 B_17_b3_5 one9 two9 VDD VSS BOOTH_ENC
XI978 one9 one9_b0 VDD VSS INV_X1
XI979 one9_b0 one9_b1_0 VDD VSS INV_X4
XI980 one9_b1_0 one9_b2_0 VDD VSS INV_X4
XI981 one9_b1_0 one9_b2_1 VDD VSS INV_X4
XI982 one9_b2_0 one9_b3_0 VDD VSS INV_X4
XI983 one9_b2_0 one9_b3_1 VDD VSS INV_X4
XI984 one9_b2_0 one9_b3_2 VDD VSS INV_X4
XI985 one9_b2_1 one9_b3_3 VDD VSS INV_X4
XI986 one9_b2_1 one9_b3_4 VDD VSS INV_X4
XI987 one9_b2_1 one9_b3_5 VDD VSS INV_X4
XI988 two9 two9_b0 VDD VSS INV_X1
XI989 two9_b0 two9_b1_0 VDD VSS INV_X4
XI990 two9_b1_0 two9_b2_0 VDD VSS INV_X4
XI991 two9_b1_0 two9_b2_1 VDD VSS INV_X4
XI992 two9_b2_0 two9_b3_0 VDD VSS INV_X4
XI993 two9_b2_0 two9_b3_1 VDD VSS INV_X4
XI994 two9_b2_0 two9_b3_2 VDD VSS INV_X4
XI995 two9_b2_1 two9_b3_3 VDD VSS INV_X4
XI996 two9_b2_1 two9_b3_4 VDD VSS INV_X4
XI997 two9_b2_1 two9_b3_5 VDD VSS INV_X4
XI998 A_0_b3_3 VSS one9_b3_0 two9_b3_0 B_19_b3_0 pp9_0 VDD VSS BOOTH_SEL
XI999 A_1_b3_3 A_0_b3_3 one9_b3_0 two9_b3_0 B_19_b3_0 pp9_1 VDD VSS BOOTH_SEL
XI1000 A_2_b3_3 A_1_b3_3 one9_b3_0 two9_b3_0 B_19_b3_0 pp9_2 VDD VSS BOOTH_SEL
XI1001 A_3_b3_3 A_2_b3_3 one9_b3_0 two9_b3_0 B_19_b3_0 pp9_3 VDD VSS BOOTH_SEL
XI1002 A_4_b3_3 A_3_b3_3 one9_b3_0 two9_b3_0 B_19_b3_0 pp9_4 VDD VSS BOOTH_SEL
XI1003 A_5_b3_3 A_4_b3_3 one9_b3_0 two9_b3_0 B_19_b3_1 pp9_5 VDD VSS BOOTH_SEL
XI1004 A_6_b3_3 A_5_b3_3 one9_b3_1 two9_b3_1 B_19_b3_1 pp9_6 VDD VSS BOOTH_SEL
XI1005 A_7_b3_3 A_6_b3_3 one9_b3_1 two9_b3_1 B_19_b3_1 pp9_7 VDD VSS BOOTH_SEL
XI1006 A_8_b3_3 A_7_b3_3 one9_b3_1 two9_b3_1 B_19_b3_1 pp9_8 VDD VSS BOOTH_SEL
XI1007 A_9_b3_3 A_8_b3_3 one9_b3_1 two9_b3_1 B_19_b3_1 pp9_9 VDD VSS BOOTH_SEL
XI1008 A_10_b3_3 A_9_b3_3 one9_b3_1 two9_b3_1 B_19_b3_1 pp9_10 VDD VSS BOOTH_SEL
XI1009 A_11_b3_3 A_10_b3_3 one9_b3_2 two9_b3_2 B_19_b3_2 pp9_11 VDD VSS BOOTH_SEL
XI1010 A_12_b3_3 A_11_b3_3 one9_b3_2 two9_b3_2 B_19_b3_2 pp9_12 VDD VSS BOOTH_SEL
XI1011 A_13_b3_3 A_12_b3_3 one9_b3_2 two9_b3_2 B_19_b3_2 pp9_13 VDD VSS BOOTH_SEL
XI1012 A_14_b3_3 A_13_b3_3 one9_b3_2 two9_b3_2 B_19_b3_2 pp9_14 VDD VSS BOOTH_SEL
XI1013 A_15_b3_3 A_14_b3_3 one9_b3_2 two9_b3_2 B_19_b3_2 pp9_15 VDD VSS BOOTH_SEL
XI1014 A_16_b3_3 A_15_b3_3 one9_b3_2 two9_b3_2 B_19_b3_2 pp9_16 VDD VSS BOOTH_SEL
XI1015 A_17_b3_3 A_16_b3_3 one9_b3_3 two9_b3_3 B_19_b3_3 pp9_17 VDD VSS BOOTH_SEL
XI1016 A_18_b3_3 A_17_b3_3 one9_b3_3 two9_b3_3 B_19_b3_3 pp9_18 VDD VSS BOOTH_SEL
XI1017 A_19_b3_3 A_18_b3_3 one9_b3_3 two9_b3_3 B_19_b3_3 pp9_19 VDD VSS BOOTH_SEL
XI1018 A_20_b3_3 A_19_b3_3 one9_b3_3 two9_b3_3 B_19_b3_3 pp9_20 VDD VSS BOOTH_SEL
XI1019 A_21_b3_3 A_20_b3_3 one9_b3_3 two9_b3_3 B_19_b3_3 pp9_21 VDD VSS BOOTH_SEL
XI1020 A_22_b3_3 A_21_b3_3 one9_b3_4 two9_b3_4 B_19_b3_3 pp9_22 VDD VSS BOOTH_SEL
XI1021 A_23_b3_3 A_22_b3_3 one9_b3_4 two9_b3_4 B_19_b3_4 pp9_23 VDD VSS BOOTH_SEL
XI1022 A_24_b3_3 A_23_b3_3 one9_b3_4 two9_b3_4 B_19_b3_4 pp9_24 VDD VSS BOOTH_SEL
XI1023 A_25_b3_3 A_24_b3_3 one9_b3_4 two9_b3_4 B_19_b3_4 pp9_25 VDD VSS BOOTH_SEL
XI1024 A_26_b3_3 A_25_b3_3 one9_b3_4 two9_b3_4 B_19_b3_4 pp9_26 VDD VSS BOOTH_SEL
XI1025 A_27_b3_3 A_26_b3_3 one9_b3_4 two9_b3_4 B_19_b3_4 pp9_27 VDD VSS BOOTH_SEL
XI1026 A_28_b3_3 A_27_b3_3 one9_b3_5 two9_b3_5 B_19_b3_4 pp9_28 VDD VSS BOOTH_SEL
XI1027 A_29_b3_3 A_28_b3_3 one9_b3_5 two9_b3_5 B_19_b3_5 pp9_29 VDD VSS BOOTH_SEL
XI1028 A_30_b3_3 A_29_b3_3 one9_b3_5 two9_b3_5 B_19_b3_5 pp9_30 VDD VSS BOOTH_SEL
XI1029 A_31_b3_4 A_30_b3_3 one9_b3_5 two9_b3_5 B_19_b3_5 pp9_31 VDD VSS BOOTH_SEL
XI1030 A_31_b3_4 A_31_b3_4 one9_b3_5 two9_b3_5 B_19_b3_5 pp9_32 VDD VSS BOOTH_SEL
XI1031 pp9_32 sn9 VDD VSS INV_X1
XI1032 B_21_b3_0 B_20 B_19_b3_5 one10 two10 VDD VSS BOOTH_ENC
XI1033 one10 one10_b0 VDD VSS INV_X1
XI1034 one10_b0 one10_b1_0 VDD VSS INV_X4
XI1035 one10_b1_0 one10_b2_0 VDD VSS INV_X4
XI1036 one10_b1_0 one10_b2_1 VDD VSS INV_X4
XI1037 one10_b2_0 one10_b3_0 VDD VSS INV_X4
XI1038 one10_b2_0 one10_b3_1 VDD VSS INV_X4
XI1039 one10_b2_0 one10_b3_2 VDD VSS INV_X4
XI1040 one10_b2_1 one10_b3_3 VDD VSS INV_X4
XI1041 one10_b2_1 one10_b3_4 VDD VSS INV_X4
XI1042 one10_b2_1 one10_b3_5 VDD VSS INV_X4
XI1043 two10 two10_b0 VDD VSS INV_X1
XI1044 two10_b0 two10_b1_0 VDD VSS INV_X4
XI1045 two10_b1_0 two10_b2_0 VDD VSS INV_X4
XI1046 two10_b1_0 two10_b2_1 VDD VSS INV_X4
XI1047 two10_b2_0 two10_b3_0 VDD VSS INV_X4
XI1048 two10_b2_0 two10_b3_1 VDD VSS INV_X4
XI1049 two10_b2_0 two10_b3_2 VDD VSS INV_X4
XI1050 two10_b2_1 two10_b3_3 VDD VSS INV_X4
XI1051 two10_b2_1 two10_b3_4 VDD VSS INV_X4
XI1052 two10_b2_1 two10_b3_5 VDD VSS INV_X4
XI1053 A_0_b3_3 VSS one10_b3_0 two10_b3_0 B_21_b3_0 pp10_0 VDD VSS BOOTH_SEL
XI1054 A_1_b3_3 A_0_b3_3 one10_b3_0 two10_b3_0 B_21_b3_0 pp10_1 VDD VSS BOOTH_SEL
XI1055 A_2_b3_3 A_1_b3_3 one10_b3_0 two10_b3_0 B_21_b3_0 pp10_2 VDD VSS BOOTH_SEL
XI1056 A_3_b3_3 A_2_b3_3 one10_b3_0 two10_b3_0 B_21_b3_0 pp10_3 VDD VSS BOOTH_SEL
XI1057 A_4_b3_3 A_3_b3_3 one10_b3_0 two10_b3_0 B_21_b3_0 pp10_4 VDD VSS BOOTH_SEL
XI1058 A_5_b3_3 A_4_b3_3 one10_b3_0 two10_b3_0 B_21_b3_1 pp10_5 VDD VSS BOOTH_SEL
XI1059 A_6_b3_3 A_5_b3_3 one10_b3_1 two10_b3_1 B_21_b3_1 pp10_6 VDD VSS BOOTH_SEL
XI1060 A_7_b3_3 A_6_b3_3 one10_b3_1 two10_b3_1 B_21_b3_1 pp10_7 VDD VSS BOOTH_SEL
XI1061 A_8_b3_3 A_7_b3_3 one10_b3_1 two10_b3_1 B_21_b3_1 pp10_8 VDD VSS BOOTH_SEL
XI1062 A_9_b3_3 A_8_b3_3 one10_b3_1 two10_b3_1 B_21_b3_1 pp10_9 VDD VSS BOOTH_SEL
XI1063 A_10_b3_3 A_9_b3_3 one10_b3_1 two10_b3_1 B_21_b3_1 pp10_10 VDD VSS BOOTH_SEL
XI1064 A_11_b3_3 A_10_b3_3 one10_b3_2 two10_b3_2 B_21_b3_2 pp10_11 VDD VSS BOOTH_SEL
XI1065 A_12_b3_3 A_11_b3_3 one10_b3_2 two10_b3_2 B_21_b3_2 pp10_12 VDD VSS BOOTH_SEL
XI1066 A_13_b3_3 A_12_b3_3 one10_b3_2 two10_b3_2 B_21_b3_2 pp10_13 VDD VSS BOOTH_SEL
XI1067 A_14_b3_3 A_13_b3_3 one10_b3_2 two10_b3_2 B_21_b3_2 pp10_14 VDD VSS BOOTH_SEL
XI1068 A_15_b3_3 A_14_b3_3 one10_b3_2 two10_b3_2 B_21_b3_2 pp10_15 VDD VSS BOOTH_SEL
XI1069 A_16_b3_3 A_15_b3_3 one10_b3_2 two10_b3_2 B_21_b3_2 pp10_16 VDD VSS BOOTH_SEL
XI1070 A_17_b3_3 A_16_b3_3 one10_b3_3 two10_b3_3 B_21_b3_3 pp10_17 VDD VSS BOOTH_SEL
XI1071 A_18_b3_3 A_17_b3_3 one10_b3_3 two10_b3_3 B_21_b3_3 pp10_18 VDD VSS BOOTH_SEL
XI1072 A_19_b3_3 A_18_b3_3 one10_b3_3 two10_b3_3 B_21_b3_3 pp10_19 VDD VSS BOOTH_SEL
XI1073 A_20_b3_3 A_19_b3_3 one10_b3_3 two10_b3_3 B_21_b3_3 pp10_20 VDD VSS BOOTH_SEL
XI1074 A_21_b3_3 A_20_b3_3 one10_b3_3 two10_b3_3 B_21_b3_3 pp10_21 VDD VSS BOOTH_SEL
XI1075 A_22_b3_3 A_21_b3_3 one10_b3_4 two10_b3_4 B_21_b3_3 pp10_22 VDD VSS BOOTH_SEL
XI1076 A_23_b3_3 A_22_b3_3 one10_b3_4 two10_b3_4 B_21_b3_4 pp10_23 VDD VSS BOOTH_SEL
XI1077 A_24_b3_3 A_23_b3_3 one10_b3_4 two10_b3_4 B_21_b3_4 pp10_24 VDD VSS BOOTH_SEL
XI1078 A_25_b3_3 A_24_b3_3 one10_b3_4 two10_b3_4 B_21_b3_4 pp10_25 VDD VSS BOOTH_SEL
XI1079 A_26_b3_3 A_25_b3_3 one10_b3_4 two10_b3_4 B_21_b3_4 pp10_26 VDD VSS BOOTH_SEL
XI1080 A_27_b3_3 A_26_b3_3 one10_b3_4 two10_b3_4 B_21_b3_4 pp10_27 VDD VSS BOOTH_SEL
XI1081 A_28_b3_3 A_27_b3_3 one10_b3_5 two10_b3_5 B_21_b3_4 pp10_28 VDD VSS BOOTH_SEL
XI1082 A_29_b3_3 A_28_b3_3 one10_b3_5 two10_b3_5 B_21_b3_5 pp10_29 VDD VSS BOOTH_SEL
XI1083 A_30_b3_3 A_29_b3_3 one10_b3_5 two10_b3_5 B_21_b3_5 pp10_30 VDD VSS BOOTH_SEL
XI1084 A_31_b3_5 A_30_b3_3 one10_b3_5 two10_b3_5 B_21_b3_5 pp10_31 VDD VSS BOOTH_SEL
XI1085 A_31_b3_5 A_31_b3_5 one10_b3_5 two10_b3_5 B_21_b3_5 pp10_32 VDD VSS BOOTH_SEL
XI1086 pp10_32 sn10 VDD VSS INV_X1
XI1087 B_23_b3_0 B_22 B_21_b3_5 one11 two11 VDD VSS BOOTH_ENC
XI1088 one11 one11_b0 VDD VSS INV_X1
XI1089 one11_b0 one11_b1_0 VDD VSS INV_X4
XI1090 one11_b1_0 one11_b2_0 VDD VSS INV_X4
XI1091 one11_b1_0 one11_b2_1 VDD VSS INV_X4
XI1092 one11_b2_0 one11_b3_0 VDD VSS INV_X4
XI1093 one11_b2_0 one11_b3_1 VDD VSS INV_X4
XI1094 one11_b2_0 one11_b3_2 VDD VSS INV_X4
XI1095 one11_b2_1 one11_b3_3 VDD VSS INV_X4
XI1096 one11_b2_1 one11_b3_4 VDD VSS INV_X4
XI1097 one11_b2_1 one11_b3_5 VDD VSS INV_X4
XI1098 two11 two11_b0 VDD VSS INV_X1
XI1099 two11_b0 two11_b1_0 VDD VSS INV_X4
XI1100 two11_b1_0 two11_b2_0 VDD VSS INV_X4
XI1101 two11_b1_0 two11_b2_1 VDD VSS INV_X4
XI1102 two11_b2_0 two11_b3_0 VDD VSS INV_X4
XI1103 two11_b2_0 two11_b3_1 VDD VSS INV_X4
XI1104 two11_b2_0 two11_b3_2 VDD VSS INV_X4
XI1105 two11_b2_1 two11_b3_3 VDD VSS INV_X4
XI1106 two11_b2_1 two11_b3_4 VDD VSS INV_X4
XI1107 two11_b2_1 two11_b3_5 VDD VSS INV_X4
XI1108 A_0_b3_4 VSS one11_b3_0 two11_b3_0 B_23_b3_0 pp11_0 VDD VSS BOOTH_SEL
XI1109 A_1_b3_4 A_0_b3_4 one11_b3_0 two11_b3_0 B_23_b3_0 pp11_1 VDD VSS BOOTH_SEL
XI1110 A_2_b3_4 A_1_b3_4 one11_b3_0 two11_b3_0 B_23_b3_0 pp11_2 VDD VSS BOOTH_SEL
XI1111 A_3_b3_4 A_2_b3_4 one11_b3_0 two11_b3_0 B_23_b3_0 pp11_3 VDD VSS BOOTH_SEL
XI1112 A_4_b3_4 A_3_b3_4 one11_b3_0 two11_b3_0 B_23_b3_0 pp11_4 VDD VSS BOOTH_SEL
XI1113 A_5_b3_4 A_4_b3_4 one11_b3_0 two11_b3_0 B_23_b3_1 pp11_5 VDD VSS BOOTH_SEL
XI1114 A_6_b3_4 A_5_b3_4 one11_b3_1 two11_b3_1 B_23_b3_1 pp11_6 VDD VSS BOOTH_SEL
XI1115 A_7_b3_4 A_6_b3_4 one11_b3_1 two11_b3_1 B_23_b3_1 pp11_7 VDD VSS BOOTH_SEL
XI1116 A_8_b3_4 A_7_b3_4 one11_b3_1 two11_b3_1 B_23_b3_1 pp11_8 VDD VSS BOOTH_SEL
XI1117 A_9_b3_4 A_8_b3_4 one11_b3_1 two11_b3_1 B_23_b3_1 pp11_9 VDD VSS BOOTH_SEL
XI1118 A_10_b3_4 A_9_b3_4 one11_b3_1 two11_b3_1 B_23_b3_1 pp11_10 VDD VSS BOOTH_SEL
XI1119 A_11_b3_4 A_10_b3_4 one11_b3_2 two11_b3_2 B_23_b3_2 pp11_11 VDD VSS BOOTH_SEL
XI1120 A_12_b3_4 A_11_b3_4 one11_b3_2 two11_b3_2 B_23_b3_2 pp11_12 VDD VSS BOOTH_SEL
XI1121 A_13_b3_4 A_12_b3_4 one11_b3_2 two11_b3_2 B_23_b3_2 pp11_13 VDD VSS BOOTH_SEL
XI1122 A_14_b3_4 A_13_b3_4 one11_b3_2 two11_b3_2 B_23_b3_2 pp11_14 VDD VSS BOOTH_SEL
XI1123 A_15_b3_4 A_14_b3_4 one11_b3_2 two11_b3_2 B_23_b3_2 pp11_15 VDD VSS BOOTH_SEL
XI1124 A_16_b3_4 A_15_b3_4 one11_b3_2 two11_b3_2 B_23_b3_2 pp11_16 VDD VSS BOOTH_SEL
XI1125 A_17_b3_4 A_16_b3_4 one11_b3_3 two11_b3_3 B_23_b3_3 pp11_17 VDD VSS BOOTH_SEL
XI1126 A_18_b3_4 A_17_b3_4 one11_b3_3 two11_b3_3 B_23_b3_3 pp11_18 VDD VSS BOOTH_SEL
XI1127 A_19_b3_4 A_18_b3_4 one11_b3_3 two11_b3_3 B_23_b3_3 pp11_19 VDD VSS BOOTH_SEL
XI1128 A_20_b3_4 A_19_b3_4 one11_b3_3 two11_b3_3 B_23_b3_3 pp11_20 VDD VSS BOOTH_SEL
XI1129 A_21_b3_4 A_20_b3_4 one11_b3_3 two11_b3_3 B_23_b3_3 pp11_21 VDD VSS BOOTH_SEL
XI1130 A_22_b3_4 A_21_b3_4 one11_b3_4 two11_b3_4 B_23_b3_3 pp11_22 VDD VSS BOOTH_SEL
XI1131 A_23_b3_4 A_22_b3_4 one11_b3_4 two11_b3_4 B_23_b3_4 pp11_23 VDD VSS BOOTH_SEL
XI1132 A_24_b3_4 A_23_b3_4 one11_b3_4 two11_b3_4 B_23_b3_4 pp11_24 VDD VSS BOOTH_SEL
XI1133 A_25_b3_4 A_24_b3_4 one11_b3_4 two11_b3_4 B_23_b3_4 pp11_25 VDD VSS BOOTH_SEL
XI1134 A_26_b3_4 A_25_b3_4 one11_b3_4 two11_b3_4 B_23_b3_4 pp11_26 VDD VSS BOOTH_SEL
XI1135 A_27_b3_4 A_26_b3_4 one11_b3_4 two11_b3_4 B_23_b3_4 pp11_27 VDD VSS BOOTH_SEL
XI1136 A_28_b3_4 A_27_b3_4 one11_b3_5 two11_b3_5 B_23_b3_4 pp11_28 VDD VSS BOOTH_SEL
XI1137 A_29_b3_4 A_28_b3_4 one11_b3_5 two11_b3_5 B_23_b3_5 pp11_29 VDD VSS BOOTH_SEL
XI1138 A_30_b3_4 A_29_b3_4 one11_b3_5 two11_b3_5 B_23_b3_5 pp11_30 VDD VSS BOOTH_SEL
XI1139 A_31_b3_5 A_30_b3_4 one11_b3_5 two11_b3_5 B_23_b3_5 pp11_31 VDD VSS BOOTH_SEL
XI1140 A_31_b3_5 A_31_b3_5 one11_b3_5 two11_b3_5 B_23_b3_5 pp11_32 VDD VSS BOOTH_SEL
XI1141 pp11_32 sn11 VDD VSS INV_X1
XI1142 B_25_b3_0 B_24 B_23_b3_5 one12 two12 VDD VSS BOOTH_ENC
XI1143 one12 one12_b0 VDD VSS INV_X1
XI1144 one12_b0 one12_b1_0 VDD VSS INV_X4
XI1145 one12_b1_0 one12_b2_0 VDD VSS INV_X4
XI1146 one12_b1_0 one12_b2_1 VDD VSS INV_X4
XI1147 one12_b2_0 one12_b3_0 VDD VSS INV_X4
XI1148 one12_b2_0 one12_b3_1 VDD VSS INV_X4
XI1149 one12_b2_0 one12_b3_2 VDD VSS INV_X4
XI1150 one12_b2_1 one12_b3_3 VDD VSS INV_X4
XI1151 one12_b2_1 one12_b3_4 VDD VSS INV_X4
XI1152 one12_b2_1 one12_b3_5 VDD VSS INV_X4
XI1153 two12 two12_b0 VDD VSS INV_X1
XI1154 two12_b0 two12_b1_0 VDD VSS INV_X4
XI1155 two12_b1_0 two12_b2_0 VDD VSS INV_X4
XI1156 two12_b1_0 two12_b2_1 VDD VSS INV_X4
XI1157 two12_b2_0 two12_b3_0 VDD VSS INV_X4
XI1158 two12_b2_0 two12_b3_1 VDD VSS INV_X4
XI1159 two12_b2_0 two12_b3_2 VDD VSS INV_X4
XI1160 two12_b2_1 two12_b3_3 VDD VSS INV_X4
XI1161 two12_b2_1 two12_b3_4 VDD VSS INV_X4
XI1162 two12_b2_1 two12_b3_5 VDD VSS INV_X4
XI1163 A_0_b3_4 VSS one12_b3_0 two12_b3_0 B_25_b3_0 pp12_0 VDD VSS BOOTH_SEL
XI1164 A_1_b3_4 A_0_b3_4 one12_b3_0 two12_b3_0 B_25_b3_0 pp12_1 VDD VSS BOOTH_SEL
XI1165 A_2_b3_4 A_1_b3_4 one12_b3_0 two12_b3_0 B_25_b3_0 pp12_2 VDD VSS BOOTH_SEL
XI1166 A_3_b3_4 A_2_b3_4 one12_b3_0 two12_b3_0 B_25_b3_0 pp12_3 VDD VSS BOOTH_SEL
XI1167 A_4_b3_4 A_3_b3_4 one12_b3_0 two12_b3_0 B_25_b3_0 pp12_4 VDD VSS BOOTH_SEL
XI1168 A_5_b3_4 A_4_b3_4 one12_b3_0 two12_b3_0 B_25_b3_1 pp12_5 VDD VSS BOOTH_SEL
XI1169 A_6_b3_4 A_5_b3_4 one12_b3_1 two12_b3_1 B_25_b3_1 pp12_6 VDD VSS BOOTH_SEL
XI1170 A_7_b3_4 A_6_b3_4 one12_b3_1 two12_b3_1 B_25_b3_1 pp12_7 VDD VSS BOOTH_SEL
XI1171 A_8_b3_4 A_7_b3_4 one12_b3_1 two12_b3_1 B_25_b3_1 pp12_8 VDD VSS BOOTH_SEL
XI1172 A_9_b3_4 A_8_b3_4 one12_b3_1 two12_b3_1 B_25_b3_1 pp12_9 VDD VSS BOOTH_SEL
XI1173 A_10_b3_4 A_9_b3_4 one12_b3_1 two12_b3_1 B_25_b3_1 pp12_10 VDD VSS BOOTH_SEL
XI1174 A_11_b3_4 A_10_b3_4 one12_b3_2 two12_b3_2 B_25_b3_2 pp12_11 VDD VSS BOOTH_SEL
XI1175 A_12_b3_4 A_11_b3_4 one12_b3_2 two12_b3_2 B_25_b3_2 pp12_12 VDD VSS BOOTH_SEL
XI1176 A_13_b3_4 A_12_b3_4 one12_b3_2 two12_b3_2 B_25_b3_2 pp12_13 VDD VSS BOOTH_SEL
XI1177 A_14_b3_4 A_13_b3_4 one12_b3_2 two12_b3_2 B_25_b3_2 pp12_14 VDD VSS BOOTH_SEL
XI1178 A_15_b3_4 A_14_b3_4 one12_b3_2 two12_b3_2 B_25_b3_2 pp12_15 VDD VSS BOOTH_SEL
XI1179 A_16_b3_4 A_15_b3_4 one12_b3_2 two12_b3_2 B_25_b3_2 pp12_16 VDD VSS BOOTH_SEL
XI1180 A_17_b3_4 A_16_b3_4 one12_b3_3 two12_b3_3 B_25_b3_3 pp12_17 VDD VSS BOOTH_SEL
XI1181 A_18_b3_4 A_17_b3_4 one12_b3_3 two12_b3_3 B_25_b3_3 pp12_18 VDD VSS BOOTH_SEL
XI1182 A_19_b3_4 A_18_b3_4 one12_b3_3 two12_b3_3 B_25_b3_3 pp12_19 VDD VSS BOOTH_SEL
XI1183 A_20_b3_4 A_19_b3_4 one12_b3_3 two12_b3_3 B_25_b3_3 pp12_20 VDD VSS BOOTH_SEL
XI1184 A_21_b3_4 A_20_b3_4 one12_b3_3 two12_b3_3 B_25_b3_3 pp12_21 VDD VSS BOOTH_SEL
XI1185 A_22_b3_4 A_21_b3_4 one12_b3_4 two12_b3_4 B_25_b3_3 pp12_22 VDD VSS BOOTH_SEL
XI1186 A_23_b3_4 A_22_b3_4 one12_b3_4 two12_b3_4 B_25_b3_4 pp12_23 VDD VSS BOOTH_SEL
XI1187 A_24_b3_4 A_23_b3_4 one12_b3_4 two12_b3_4 B_25_b3_4 pp12_24 VDD VSS BOOTH_SEL
XI1188 A_25_b3_4 A_24_b3_4 one12_b3_4 two12_b3_4 B_25_b3_4 pp12_25 VDD VSS BOOTH_SEL
XI1189 A_26_b3_4 A_25_b3_4 one12_b3_4 two12_b3_4 B_25_b3_4 pp12_26 VDD VSS BOOTH_SEL
XI1190 A_27_b3_4 A_26_b3_4 one12_b3_4 two12_b3_4 B_25_b3_4 pp12_27 VDD VSS BOOTH_SEL
XI1191 A_28_b3_4 A_27_b3_4 one12_b3_5 two12_b3_5 B_25_b3_4 pp12_28 VDD VSS BOOTH_SEL
XI1192 A_29_b3_4 A_28_b3_4 one12_b3_5 two12_b3_5 B_25_b3_5 pp12_29 VDD VSS BOOTH_SEL
XI1193 A_30_b3_4 A_29_b3_4 one12_b3_5 two12_b3_5 B_25_b3_5 pp12_30 VDD VSS BOOTH_SEL
XI1194 A_31_b3_6 A_30_b3_4 one12_b3_5 two12_b3_5 B_25_b3_5 pp12_31 VDD VSS BOOTH_SEL
XI1195 A_31_b3_6 A_31_b3_6 one12_b3_5 two12_b3_5 B_25_b3_5 pp12_32 VDD VSS BOOTH_SEL
XI1196 pp12_32 sn12 VDD VSS INV_X1
XI1197 B_27_b3_0 B_26 B_25_b3_5 one13 two13 VDD VSS BOOTH_ENC
XI1198 one13 one13_b0 VDD VSS INV_X1
XI1199 one13_b0 one13_b1_0 VDD VSS INV_X4
XI1200 one13_b1_0 one13_b2_0 VDD VSS INV_X4
XI1201 one13_b1_0 one13_b2_1 VDD VSS INV_X4
XI1202 one13_b2_0 one13_b3_0 VDD VSS INV_X4
XI1203 one13_b2_0 one13_b3_1 VDD VSS INV_X4
XI1204 one13_b2_0 one13_b3_2 VDD VSS INV_X4
XI1205 one13_b2_1 one13_b3_3 VDD VSS INV_X4
XI1206 one13_b2_1 one13_b3_4 VDD VSS INV_X4
XI1207 one13_b2_1 one13_b3_5 VDD VSS INV_X4
XI1208 two13 two13_b0 VDD VSS INV_X1
XI1209 two13_b0 two13_b1_0 VDD VSS INV_X4
XI1210 two13_b1_0 two13_b2_0 VDD VSS INV_X4
XI1211 two13_b1_0 two13_b2_1 VDD VSS INV_X4
XI1212 two13_b2_0 two13_b3_0 VDD VSS INV_X4
XI1213 two13_b2_0 two13_b3_1 VDD VSS INV_X4
XI1214 two13_b2_0 two13_b3_2 VDD VSS INV_X4
XI1215 two13_b2_1 two13_b3_3 VDD VSS INV_X4
XI1216 two13_b2_1 two13_b3_4 VDD VSS INV_X4
XI1217 two13_b2_1 two13_b3_5 VDD VSS INV_X4
XI1218 A_0_b3_4 VSS one13_b3_0 two13_b3_0 B_27_b3_0 pp13_0 VDD VSS BOOTH_SEL
XI1219 A_1_b3_4 A_0_b3_5 one13_b3_0 two13_b3_0 B_27_b3_0 pp13_1 VDD VSS BOOTH_SEL
XI1220 A_2_b3_4 A_1_b3_5 one13_b3_0 two13_b3_0 B_27_b3_0 pp13_2 VDD VSS BOOTH_SEL
XI1221 A_3_b3_4 A_2_b3_5 one13_b3_0 two13_b3_0 B_27_b3_0 pp13_3 VDD VSS BOOTH_SEL
XI1222 A_4_b3_4 A_3_b3_5 one13_b3_0 two13_b3_0 B_27_b3_0 pp13_4 VDD VSS BOOTH_SEL
XI1223 A_5_b3_4 A_4_b3_5 one13_b3_0 two13_b3_0 B_27_b3_1 pp13_5 VDD VSS BOOTH_SEL
XI1224 A_6_b3_4 A_5_b3_5 one13_b3_1 two13_b3_1 B_27_b3_1 pp13_6 VDD VSS BOOTH_SEL
XI1225 A_7_b3_4 A_6_b3_5 one13_b3_1 two13_b3_1 B_27_b3_1 pp13_7 VDD VSS BOOTH_SEL
XI1226 A_8_b3_4 A_7_b3_5 one13_b3_1 two13_b3_1 B_27_b3_1 pp13_8 VDD VSS BOOTH_SEL
XI1227 A_9_b3_4 A_8_b3_5 one13_b3_1 two13_b3_1 B_27_b3_1 pp13_9 VDD VSS BOOTH_SEL
XI1228 A_10_b3_4 A_9_b3_5 one13_b3_1 two13_b3_1 B_27_b3_1 pp13_10 VDD VSS BOOTH_SEL
XI1229 A_11_b3_4 A_10_b3_5 one13_b3_2 two13_b3_2 B_27_b3_2 pp13_11 VDD VSS BOOTH_SEL
XI1230 A_12_b3_4 A_11_b3_5 one13_b3_2 two13_b3_2 B_27_b3_2 pp13_12 VDD VSS BOOTH_SEL
XI1231 A_13_b3_4 A_12_b3_5 one13_b3_2 two13_b3_2 B_27_b3_2 pp13_13 VDD VSS BOOTH_SEL
XI1232 A_14_b3_4 A_13_b3_5 one13_b3_2 two13_b3_2 B_27_b3_2 pp13_14 VDD VSS BOOTH_SEL
XI1233 A_15_b3_4 A_14_b3_5 one13_b3_2 two13_b3_2 B_27_b3_2 pp13_15 VDD VSS BOOTH_SEL
XI1234 A_16_b3_4 A_15_b3_5 one13_b3_2 two13_b3_2 B_27_b3_2 pp13_16 VDD VSS BOOTH_SEL
XI1235 A_17_b3_4 A_16_b3_5 one13_b3_3 two13_b3_3 B_27_b3_3 pp13_17 VDD VSS BOOTH_SEL
XI1236 A_18_b3_4 A_17_b3_5 one13_b3_3 two13_b3_3 B_27_b3_3 pp13_18 VDD VSS BOOTH_SEL
XI1237 A_19_b3_4 A_18_b3_5 one13_b3_3 two13_b3_3 B_27_b3_3 pp13_19 VDD VSS BOOTH_SEL
XI1238 A_20_b3_4 A_19_b3_5 one13_b3_3 two13_b3_3 B_27_b3_3 pp13_20 VDD VSS BOOTH_SEL
XI1239 A_21_b3_4 A_20_b3_5 one13_b3_3 two13_b3_3 B_27_b3_3 pp13_21 VDD VSS BOOTH_SEL
XI1240 A_22_b3_4 A_21_b3_5 one13_b3_4 two13_b3_4 B_27_b3_3 pp13_22 VDD VSS BOOTH_SEL
XI1241 A_23_b3_4 A_22_b3_5 one13_b3_4 two13_b3_4 B_27_b3_4 pp13_23 VDD VSS BOOTH_SEL
XI1242 A_24_b3_4 A_23_b3_5 one13_b3_4 two13_b3_4 B_27_b3_4 pp13_24 VDD VSS BOOTH_SEL
XI1243 A_25_b3_4 A_24_b3_5 one13_b3_4 two13_b3_4 B_27_b3_4 pp13_25 VDD VSS BOOTH_SEL
XI1244 A_26_b3_4 A_25_b3_5 one13_b3_4 two13_b3_4 B_27_b3_4 pp13_26 VDD VSS BOOTH_SEL
XI1245 A_27_b3_4 A_26_b3_5 one13_b3_4 two13_b3_4 B_27_b3_4 pp13_27 VDD VSS BOOTH_SEL
XI1246 A_28_b3_4 A_27_b3_5 one13_b3_5 two13_b3_5 B_27_b3_4 pp13_28 VDD VSS BOOTH_SEL
XI1247 A_29_b3_4 A_28_b3_5 one13_b3_5 two13_b3_5 B_27_b3_5 pp13_29 VDD VSS BOOTH_SEL
XI1248 A_30_b3_4 A_29_b3_5 one13_b3_5 two13_b3_5 B_27_b3_5 pp13_30 VDD VSS BOOTH_SEL
XI1249 A_31_b3_6 A_30_b3_5 one13_b3_5 two13_b3_5 B_27_b3_5 pp13_31 VDD VSS BOOTH_SEL
XI1250 A_31_b3_6 A_31_b3_6 one13_b3_5 two13_b3_5 B_27_b3_5 pp13_32 VDD VSS BOOTH_SEL
XI1251 pp13_32 sn13 VDD VSS INV_X1
XI1252 B_29_b3_0 B_28 B_27_b3_5 one14 two14 VDD VSS BOOTH_ENC
XI1253 one14 one14_b0 VDD VSS INV_X1
XI1254 one14_b0 one14_b1_0 VDD VSS INV_X4
XI1255 one14_b1_0 one14_b2_0 VDD VSS INV_X4
XI1256 one14_b1_0 one14_b2_1 VDD VSS INV_X4
XI1257 one14_b2_0 one14_b3_0 VDD VSS INV_X4
XI1258 one14_b2_0 one14_b3_1 VDD VSS INV_X4
XI1259 one14_b2_0 one14_b3_2 VDD VSS INV_X4
XI1260 one14_b2_1 one14_b3_3 VDD VSS INV_X4
XI1261 one14_b2_1 one14_b3_4 VDD VSS INV_X4
XI1262 one14_b2_1 one14_b3_5 VDD VSS INV_X4
XI1263 two14 two14_b0 VDD VSS INV_X1
XI1264 two14_b0 two14_b1_0 VDD VSS INV_X4
XI1265 two14_b1_0 two14_b2_0 VDD VSS INV_X4
XI1266 two14_b1_0 two14_b2_1 VDD VSS INV_X4
XI1267 two14_b2_0 two14_b3_0 VDD VSS INV_X4
XI1268 two14_b2_0 two14_b3_1 VDD VSS INV_X4
XI1269 two14_b2_0 two14_b3_2 VDD VSS INV_X4
XI1270 two14_b2_1 two14_b3_3 VDD VSS INV_X4
XI1271 two14_b2_1 two14_b3_4 VDD VSS INV_X4
XI1272 two14_b2_1 two14_b3_5 VDD VSS INV_X4
XI1273 A_0_b3_5 VSS one14_b3_0 two14_b3_0 B_29_b3_0 pp14_0 VDD VSS BOOTH_SEL
XI1274 A_1_b3_5 A_0_b3_5 one14_b3_0 two14_b3_0 B_29_b3_0 pp14_1 VDD VSS BOOTH_SEL
XI1275 A_2_b3_5 A_1_b3_5 one14_b3_0 two14_b3_0 B_29_b3_0 pp14_2 VDD VSS BOOTH_SEL
XI1276 A_3_b3_5 A_2_b3_5 one14_b3_0 two14_b3_0 B_29_b3_0 pp14_3 VDD VSS BOOTH_SEL
XI1277 A_4_b3_5 A_3_b3_5 one14_b3_0 two14_b3_0 B_29_b3_0 pp14_4 VDD VSS BOOTH_SEL
XI1278 A_5_b3_5 A_4_b3_5 one14_b3_0 two14_b3_0 B_29_b3_1 pp14_5 VDD VSS BOOTH_SEL
XI1279 A_6_b3_5 A_5_b3_5 one14_b3_1 two14_b3_1 B_29_b3_1 pp14_6 VDD VSS BOOTH_SEL
XI1280 A_7_b3_5 A_6_b3_5 one14_b3_1 two14_b3_1 B_29_b3_1 pp14_7 VDD VSS BOOTH_SEL
XI1281 A_8_b3_5 A_7_b3_5 one14_b3_1 two14_b3_1 B_29_b3_1 pp14_8 VDD VSS BOOTH_SEL
XI1282 A_9_b3_5 A_8_b3_5 one14_b3_1 two14_b3_1 B_29_b3_1 pp14_9 VDD VSS BOOTH_SEL
XI1283 A_10_b3_5 A_9_b3_5 one14_b3_1 two14_b3_1 B_29_b3_1 pp14_10 VDD VSS BOOTH_SEL
XI1284 A_11_b3_5 A_10_b3_5 one14_b3_2 two14_b3_2 B_29_b3_2 pp14_11 VDD VSS BOOTH_SEL
XI1285 A_12_b3_5 A_11_b3_5 one14_b3_2 two14_b3_2 B_29_b3_2 pp14_12 VDD VSS BOOTH_SEL
XI1286 A_13_b3_5 A_12_b3_5 one14_b3_2 two14_b3_2 B_29_b3_2 pp14_13 VDD VSS BOOTH_SEL
XI1287 A_14_b3_5 A_13_b3_5 one14_b3_2 two14_b3_2 B_29_b3_2 pp14_14 VDD VSS BOOTH_SEL
XI1288 A_15_b3_5 A_14_b3_5 one14_b3_2 two14_b3_2 B_29_b3_2 pp14_15 VDD VSS BOOTH_SEL
XI1289 A_16_b3_5 A_15_b3_5 one14_b3_2 two14_b3_2 B_29_b3_2 pp14_16 VDD VSS BOOTH_SEL
XI1290 A_17_b3_5 A_16_b3_5 one14_b3_3 two14_b3_3 B_29_b3_3 pp14_17 VDD VSS BOOTH_SEL
XI1291 A_18_b3_5 A_17_b3_5 one14_b3_3 two14_b3_3 B_29_b3_3 pp14_18 VDD VSS BOOTH_SEL
XI1292 A_19_b3_5 A_18_b3_5 one14_b3_3 two14_b3_3 B_29_b3_3 pp14_19 VDD VSS BOOTH_SEL
XI1293 A_20_b3_5 A_19_b3_5 one14_b3_3 two14_b3_3 B_29_b3_3 pp14_20 VDD VSS BOOTH_SEL
XI1294 A_21_b3_5 A_20_b3_5 one14_b3_3 two14_b3_3 B_29_b3_3 pp14_21 VDD VSS BOOTH_SEL
XI1295 A_22_b3_5 A_21_b3_5 one14_b3_4 two14_b3_4 B_29_b3_3 pp14_22 VDD VSS BOOTH_SEL
XI1296 A_23_b3_5 A_22_b3_5 one14_b3_4 two14_b3_4 B_29_b3_4 pp14_23 VDD VSS BOOTH_SEL
XI1297 A_24_b3_5 A_23_b3_5 one14_b3_4 two14_b3_4 B_29_b3_4 pp14_24 VDD VSS BOOTH_SEL
XI1298 A_25_b3_5 A_24_b3_5 one14_b3_4 two14_b3_4 B_29_b3_4 pp14_25 VDD VSS BOOTH_SEL
XI1299 A_26_b3_5 A_25_b3_5 one14_b3_4 two14_b3_4 B_29_b3_4 pp14_26 VDD VSS BOOTH_SEL
XI1300 A_27_b3_5 A_26_b3_5 one14_b3_4 two14_b3_4 B_29_b3_4 pp14_27 VDD VSS BOOTH_SEL
XI1301 A_28_b3_5 A_27_b3_5 one14_b3_5 two14_b3_5 B_29_b3_4 pp14_28 VDD VSS BOOTH_SEL
XI1302 A_29_b3_5 A_28_b3_5 one14_b3_5 two14_b3_5 B_29_b3_5 pp14_29 VDD VSS BOOTH_SEL
XI1303 A_30_b3_5 A_29_b3_5 one14_b3_5 two14_b3_5 B_29_b3_5 pp14_30 VDD VSS BOOTH_SEL
XI1304 A_31_b3_7 A_30_b3_5 one14_b3_5 two14_b3_5 B_29_b3_5 pp14_31 VDD VSS BOOTH_SEL
XI1305 A_31_b3_7 A_31_b3_7 one14_b3_5 two14_b3_5 B_29_b3_5 pp14_32 VDD VSS BOOTH_SEL
XI1306 pp14_32 sn14 VDD VSS INV_X1
XI1307 B_31_b3_0 B_30 B_29_b3_5 one15 two15 VDD VSS BOOTH_ENC
XI1308 one15 one15_b0 VDD VSS INV_X1
XI1309 one15_b0 one15_b1_0 VDD VSS INV_X4
XI1310 one15_b1_0 one15_b2_0 VDD VSS INV_X4
XI1311 one15_b1_0 one15_b2_1 VDD VSS INV_X4
XI1312 one15_b2_0 one15_b3_0 VDD VSS INV_X4
XI1313 one15_b2_0 one15_b3_1 VDD VSS INV_X4
XI1314 one15_b2_0 one15_b3_2 VDD VSS INV_X4
XI1315 one15_b2_1 one15_b3_3 VDD VSS INV_X4
XI1316 one15_b2_1 one15_b3_4 VDD VSS INV_X4
XI1317 one15_b2_1 one15_b3_5 VDD VSS INV_X4
XI1318 two15 two15_b0 VDD VSS INV_X1
XI1319 two15_b0 two15_b1_0 VDD VSS INV_X4
XI1320 two15_b1_0 two15_b2_0 VDD VSS INV_X4
XI1321 two15_b1_0 two15_b2_1 VDD VSS INV_X4
XI1322 two15_b2_0 two15_b3_0 VDD VSS INV_X4
XI1323 two15_b2_0 two15_b3_1 VDD VSS INV_X4
XI1324 two15_b2_0 two15_b3_2 VDD VSS INV_X4
XI1325 two15_b2_1 two15_b3_3 VDD VSS INV_X4
XI1326 two15_b2_1 two15_b3_4 VDD VSS INV_X4
XI1327 two15_b2_1 two15_b3_5 VDD VSS INV_X4
XI1328 A_0_b3_5 VSS one15_b3_0 two15_b3_0 B_31_b3_0 pp15_0 VDD VSS BOOTH_SEL
XI1329 A_1_b3_5 A_0_b3_5 one15_b3_0 two15_b3_0 B_31_b3_0 pp15_1 VDD VSS BOOTH_SEL
XI1330 A_2_b3_5 A_1_b3_5 one15_b3_0 two15_b3_0 B_31_b3_0 pp15_2 VDD VSS BOOTH_SEL
XI1331 A_3_b3_5 A_2_b3_5 one15_b3_0 two15_b3_0 B_31_b3_0 pp15_3 VDD VSS BOOTH_SEL
XI1332 A_4_b3_5 A_3_b3_5 one15_b3_0 two15_b3_0 B_31_b3_0 pp15_4 VDD VSS BOOTH_SEL
XI1333 A_5_b3_5 A_4_b3_5 one15_b3_0 two15_b3_0 B_31_b3_1 pp15_5 VDD VSS BOOTH_SEL
XI1334 A_6_b3_5 A_5_b3_5 one15_b3_1 two15_b3_1 B_31_b3_1 pp15_6 VDD VSS BOOTH_SEL
XI1335 A_7_b3_5 A_6_b3_5 one15_b3_1 two15_b3_1 B_31_b3_1 pp15_7 VDD VSS BOOTH_SEL
XI1336 A_8_b3_5 A_7_b3_5 one15_b3_1 two15_b3_1 B_31_b3_1 pp15_8 VDD VSS BOOTH_SEL
XI1337 A_9_b3_5 A_8_b3_5 one15_b3_1 two15_b3_1 B_31_b3_1 pp15_9 VDD VSS BOOTH_SEL
XI1338 A_10_b3_5 A_9_b3_5 one15_b3_1 two15_b3_1 B_31_b3_1 pp15_10 VDD VSS BOOTH_SEL
XI1339 A_11_b3_5 A_10_b3_5 one15_b3_2 two15_b3_2 B_31_b3_2 pp15_11 VDD VSS BOOTH_SEL
XI1340 A_12_b3_5 A_11_b3_5 one15_b3_2 two15_b3_2 B_31_b3_2 pp15_12 VDD VSS BOOTH_SEL
XI1341 A_13_b3_5 A_12_b3_5 one15_b3_2 two15_b3_2 B_31_b3_2 pp15_13 VDD VSS BOOTH_SEL
XI1342 A_14_b3_5 A_13_b3_5 one15_b3_2 two15_b3_2 B_31_b3_2 pp15_14 VDD VSS BOOTH_SEL
XI1343 A_15_b3_5 A_14_b3_5 one15_b3_2 two15_b3_2 B_31_b3_2 pp15_15 VDD VSS BOOTH_SEL
XI1344 A_16_b3_5 A_15_b3_5 one15_b3_2 two15_b3_2 B_31_b3_2 pp15_16 VDD VSS BOOTH_SEL
XI1345 A_17_b3_5 A_16_b3_5 one15_b3_3 two15_b3_3 B_31_b3_3 pp15_17 VDD VSS BOOTH_SEL
XI1346 A_18_b3_5 A_17_b3_5 one15_b3_3 two15_b3_3 B_31_b3_3 pp15_18 VDD VSS BOOTH_SEL
XI1347 A_19_b3_5 A_18_b3_5 one15_b3_3 two15_b3_3 B_31_b3_3 pp15_19 VDD VSS BOOTH_SEL
XI1348 A_20_b3_5 A_19_b3_5 one15_b3_3 two15_b3_3 B_31_b3_3 pp15_20 VDD VSS BOOTH_SEL
XI1349 A_21_b3_5 A_20_b3_5 one15_b3_3 two15_b3_3 B_31_b3_3 pp15_21 VDD VSS BOOTH_SEL
XI1350 A_22_b3_5 A_21_b3_5 one15_b3_4 two15_b3_4 B_31_b3_3 pp15_22 VDD VSS BOOTH_SEL
XI1351 A_23_b3_5 A_22_b3_5 one15_b3_4 two15_b3_4 B_31_b3_4 pp15_23 VDD VSS BOOTH_SEL
XI1352 A_24_b3_5 A_23_b3_5 one15_b3_4 two15_b3_4 B_31_b3_4 pp15_24 VDD VSS BOOTH_SEL
XI1353 A_25_b3_5 A_24_b3_5 one15_b3_4 two15_b3_4 B_31_b3_4 pp15_25 VDD VSS BOOTH_SEL
XI1354 A_26_b3_5 A_25_b3_5 one15_b3_4 two15_b3_4 B_31_b3_4 pp15_26 VDD VSS BOOTH_SEL
XI1355 A_27_b3_5 A_26_b3_5 one15_b3_4 two15_b3_4 B_31_b3_4 pp15_27 VDD VSS BOOTH_SEL
XI1356 A_28_b3_5 A_27_b3_5 one15_b3_5 two15_b3_5 B_31_b3_4 pp15_28 VDD VSS BOOTH_SEL
XI1357 A_29_b3_5 A_28_b3_5 one15_b3_5 two15_b3_5 B_31_b3_5 pp15_29 VDD VSS BOOTH_SEL
XI1358 A_30_b3_5 A_29_b3_5 one15_b3_5 two15_b3_5 B_31_b3_5 pp15_30 VDD VSS BOOTH_SEL
XI1359 A_31_b3_7 A_30_b3_5 one15_b3_5 two15_b3_5 B_31_b3_5 pp15_31 VDD VSS BOOTH_SEL
XI1360 A_31_b3_7 A_31_b3_7 one15_b3_5 two15_b3_5 B_31_b3_5 pp15_32 VDD VSS BOOTH_SEL
XI1361 pp15_32 sn15 VDD VSS INV_X1
XI1362 pp0_2 pp1_0 B_3_b3_5 fa1_0 fa1_1 VDD VSS FA_X1
XI1363 pp0_4 pp1_2 pp2_0 fa2_0 fa2_1 VDD VSS FA_X1
XI1364 pp0_5 pp1_3 pp2_1 fa3_0 fa3_1 VDD VSS FA_X1
XI1365 pp0_6 pp1_4 pp2_2 pp3_0 B_7_b3_5 cm4_0 cm4_1 cm4_2 VDD VSS CMP42
XI1366 pp0_7 pp1_5 pp2_3 pp3_1 cm4_2 cm5_0 cm5_1 cm5_2 VDD VSS CMP42
XI1367 pp0_8 pp1_6 pp2_4 pp3_2 cm5_2 cm6_0 cm6_1 cm6_2 VDD VSS CMP42
XI1368 pp0_9 pp1_7 pp2_5 pp3_3 cm6_2 cm7_0 cm7_1 cm7_2 VDD VSS CMP42
XI1369 pp0_10 pp1_8 pp2_6 pp3_4 cm7_2 cm8_0 cm8_1 cm8_2 VDD VSS CMP42
XI1370 pp4_2 pp5_0 B_11_b3_5 fa9_0 fa9_1 VDD VSS FA_X1
XI1371 pp0_11 pp1_9 pp2_7 pp3_5 cm8_2 cm10_0 cm10_1 cm10_2 VDD VSS CMP42
XI1372 pp0_12 pp1_10 pp2_8 pp3_6 cm10_2 cm11_0 cm11_1 cm11_2 VDD VSS CMP42
XI1373 pp4_4 pp5_2 pp6_0 fa12_0 fa12_1 VDD VSS FA_X1
XI1374 pp0_13 pp1_11 pp2_9 pp3_7 cm11_2 cm13_0 cm13_1 cm13_2 VDD VSS CMP42
XI1375 pp4_5 pp5_3 pp6_1 fa14_0 fa14_1 VDD VSS FA_X1
XI1376 pp0_14 pp1_12 pp2_10 pp3_8 cm13_2 cm15_0 cm15_1 cm15_2 VDD VSS CMP42
XI1377 pp4_6 pp5_4 pp6_2 pp7_0 B_15_b3_5 cm16_0 cm16_1 cm16_2 VDD VSS CMP42
XI1378 pp0_15 pp1_13 pp2_11 pp3_9 cm15_2 cm17_0 cm17_1 cm17_2 VDD VSS CMP42
XI1379 pp4_7 pp5_5 pp6_3 pp7_1 cm16_2 cm18_0 cm18_1 cm18_2 VDD VSS CMP42
XI1380 pp0_16 pp1_14 pp2_12 pp3_10 cm17_2 cm19_0 cm19_1 cm19_2 VDD VSS CMP42
XI1381 pp4_8 pp5_6 pp6_4 pp7_2 cm18_2 cm20_0 cm20_1 cm20_2 VDD VSS CMP42
XI1382 pp0_17 pp1_15 pp2_13 pp3_11 cm19_2 cm21_0 cm21_1 cm21_2 VDD VSS CMP42
XI1383 pp4_9 pp5_7 pp6_5 pp7_3 cm20_2 cm22_0 cm22_1 cm22_2 VDD VSS CMP42
XI1384 pp0_18 pp1_16 pp2_14 pp3_12 cm21_2 cm23_0 cm23_1 cm23_2 VDD VSS CMP42
XI1385 pp4_10 pp5_8 pp6_6 pp7_4 cm22_2 cm24_0 cm24_1 cm24_2 VDD VSS CMP42
XI1386 pp8_2 pp9_0 B_19_b3_5 fa25_0 fa25_1 VDD VSS FA_X1
XI1387 pp0_19 pp1_17 pp2_15 pp3_13 cm23_2 cm26_0 cm26_1 cm26_2 VDD VSS CMP42
XI1388 pp4_11 pp5_9 pp6_7 pp7_5 cm24_2 cm27_0 cm27_1 cm27_2 VDD VSS CMP42
XI1389 pp0_20 pp1_18 pp2_16 pp3_14 cm26_2 cm28_0 cm28_1 cm28_2 VDD VSS CMP42
XI1390 pp4_12 pp5_10 pp6_8 pp7_6 cm27_2 cm29_0 cm29_1 cm29_2 VDD VSS CMP42
XI1391 pp8_4 pp9_2 pp10_0 fa30_0 fa30_1 VDD VSS FA_X1
XI1392 pp0_21 pp1_19 pp2_17 pp3_15 cm28_2 cm31_0 cm31_1 cm31_2 VDD VSS CMP42
XI1393 pp4_13 pp5_11 pp6_9 pp7_7 cm29_2 cm32_0 cm32_1 cm32_2 VDD VSS CMP42
XI1394 pp8_5 pp9_3 pp10_1 fa33_0 fa33_1 VDD VSS FA_X1
XI1395 pp0_22 pp1_20 pp2_18 pp3_16 cm31_2 cm34_0 cm34_1 cm34_2 VDD VSS CMP42
XI1396 pp4_14 pp5_12 pp6_10 pp7_8 cm32_2 cm35_0 cm35_1 cm35_2 VDD VSS CMP42
XI1397 pp8_6 pp9_4 pp10_2 pp11_0 B_23_b3_5 cm36_0 cm36_1 cm36_2 VDD VSS CMP42
XI1398 pp0_23 pp1_21 pp2_19 pp3_17 cm34_2 cm37_0 cm37_1 cm37_2 VDD VSS CMP42
XI1399 pp4_15 pp5_13 pp6_11 pp7_9 cm35_2 cm38_0 cm38_1 cm38_2 VDD VSS CMP42
XI1400 pp8_7 pp9_5 pp10_3 pp11_1 cm36_2 cm39_0 cm39_1 cm39_2 VDD VSS CMP42
XI1401 pp0_24 pp1_22 pp2_20 pp3_18 cm37_2 cm40_0 cm40_1 cm40_2 VDD VSS CMP42
XI1402 pp4_16 pp5_14 pp6_12 pp7_10 cm38_2 cm41_0 cm41_1 cm41_2 VDD VSS CMP42
XI1403 pp8_8 pp9_6 pp10_4 pp11_2 cm39_2 cm42_0 cm42_1 cm42_2 VDD VSS CMP42
XI1404 pp0_25 pp1_23 pp2_21 pp3_19 cm40_2 cm43_0 cm43_1 cm43_2 VDD VSS CMP42
XI1405 pp4_17 pp5_15 pp6_13 pp7_11 cm41_2 cm44_0 cm44_1 cm44_2 VDD VSS CMP42
XI1406 pp8_9 pp9_7 pp10_5 pp11_3 cm42_2 cm45_0 cm45_1 cm45_2 VDD VSS CMP42
XI1407 pp0_26 pp1_24 pp2_22 pp3_20 cm43_2 cm46_0 cm46_1 cm46_2 VDD VSS CMP42
XI1408 pp4_18 pp5_16 pp6_14 pp7_12 cm44_2 cm47_0 cm47_1 cm47_2 VDD VSS CMP42
XI1409 pp8_10 pp9_8 pp10_6 pp11_4 cm45_2 cm48_0 cm48_1 cm48_2 VDD VSS CMP42
XI1410 pp12_2 pp13_0 B_27_b3_5 fa49_0 fa49_1 VDD VSS FA_X1
XI1411 pp0_27 pp1_25 pp2_23 pp3_21 cm46_2 cm50_0 cm50_1 cm50_2 VDD VSS CMP42
XI1412 pp4_19 pp5_17 pp6_15 pp7_13 cm47_2 cm51_0 cm51_1 cm51_2 VDD VSS CMP42
XI1413 pp8_11 pp9_9 pp10_7 pp11_5 cm48_2 cm52_0 cm52_1 cm52_2 VDD VSS CMP42
XI1414 pp0_28 pp1_26 pp2_24 pp3_22 cm50_2 cm53_0 cm53_1 cm53_2 VDD VSS CMP42
XI1415 pp4_20 pp5_18 pp6_16 pp7_14 cm51_2 cm54_0 cm54_1 cm54_2 VDD VSS CMP42
XI1416 pp8_12 pp9_10 pp10_8 pp11_6 cm52_2 cm55_0 cm55_1 cm55_2 VDD VSS CMP42
XI1417 pp12_4 pp13_2 pp14_0 fa56_0 fa56_1 VDD VSS FA_X1
XI1418 pp0_29 pp1_27 pp2_25 pp3_23 cm53_2 cm57_0 cm57_1 cm57_2 VDD VSS CMP42
XI1419 pp4_21 pp5_19 pp6_17 pp7_15 cm54_2 cm58_0 cm58_1 cm58_2 VDD VSS CMP42
XI1420 pp8_13 pp9_11 pp10_9 pp11_7 cm55_2 cm59_0 cm59_1 cm59_2 VDD VSS CMP42
XI1421 pp12_5 pp13_3 pp14_1 fa60_0 fa60_1 VDD VSS FA_X1
XI1422 pp0_30 pp1_28 pp2_26 pp3_24 cm57_2 cm61_0 cm61_1 cm61_2 VDD VSS CMP42
XI1423 pp4_22 pp5_20 pp6_18 pp7_16 cm58_2 cm62_0 cm62_1 cm62_2 VDD VSS CMP42
XI1424 pp8_14 pp9_12 pp10_10 pp11_8 cm59_2 cm63_0 cm63_1 cm63_2 VDD VSS CMP42
XI1425 pp12_6 pp13_4 pp14_2 pp15_0 B_31_b3_5 cm64_0 cm64_1 cm64_2 VDD VSS CMP42
XI1426 pp0_31 pp1_29 pp2_27 pp3_25 cm61_2 cm65_0 cm65_1 cm65_2 VDD VSS CMP42
XI1427 pp4_23 pp5_21 pp6_19 pp7_17 cm62_2 cm66_0 cm66_1 cm66_2 VDD VSS CMP42
XI1428 pp8_15 pp9_13 pp10_11 pp11_9 cm63_2 cm67_0 cm67_1 cm67_2 VDD VSS CMP42
XI1429 pp12_7 pp13_5 pp14_3 pp15_1 cm64_2 cm68_0 cm68_1 cm68_2 VDD VSS CMP42
XI1430 pp0_32 pp1_30 pp2_28 pp3_26 cm65_2 cm69_0 cm69_1 cm69_2 VDD VSS CMP42
XI1431 pp4_24 pp5_22 pp6_20 pp7_18 cm66_2 cm70_0 cm70_1 cm70_2 VDD VSS CMP42
XI1432 pp8_16 pp9_14 pp10_12 pp11_10 cm67_2 cm71_0 cm71_1 cm71_2 VDD VSS CMP42
XI1433 pp12_8 pp13_6 pp14_4 pp15_2 cm68_2 cm72_0 cm72_1 cm72_2 VDD VSS CMP42
XI1434 pp0_32 pp1_31 pp2_29 pp3_27 cm69_2 cm73_0 cm73_1 cm73_2 VDD VSS CMP42
XI1435 pp4_25 pp5_23 pp6_21 pp7_19 cm70_2 cm74_0 cm74_1 cm74_2 VDD VSS CMP42
XI1436 pp8_17 pp9_15 pp10_13 pp11_11 cm71_2 cm75_0 cm75_1 cm75_2 VDD VSS CMP42
XI1437 pp12_9 pp13_7 pp14_5 pp15_3 cm72_2 cm76_0 cm76_1 cm76_2 VDD VSS CMP42
XI1438 pp0_32 pp1_32 pp2_30 pp3_28 cm73_2 cm77_0 cm77_1 cm77_2 VDD VSS CMP42
XI1439 pp4_26 pp5_24 pp6_22 pp7_20 cm74_2 cm78_0 cm78_1 cm78_2 VDD VSS CMP42
XI1440 pp8_18 pp9_16 pp10_14 pp11_12 cm75_2 cm79_0 cm79_1 cm79_2 VDD VSS CMP42
XI1441 pp12_10 pp13_8 pp14_6 pp15_4 cm76_2 cm80_0 cm80_1 cm80_2 VDD VSS CMP42
XI1442 sn0 sn1 pp2_31 pp3_29 cm77_2 cm81_0 cm81_1 cm81_2 VDD VSS CMP42
XI1443 pp4_27 pp5_25 pp6_23 pp7_21 cm78_2 cm82_0 cm82_1 cm82_2 VDD VSS CMP42
XI1444 pp8_19 pp9_17 pp10_15 pp11_13 cm79_2 cm83_0 cm83_1 cm83_2 VDD VSS CMP42
XI1445 pp12_11 pp13_9 pp14_7 pp15_5 cm80_2 cm84_0 cm84_1 cm84_2 VDD VSS CMP42
XI1446 VDD pp2_32 pp3_30 pp4_28 cm81_2 cm85_0 cm85_1 cm85_2 VDD VSS CMP42
XI1447 pp5_26 pp6_24 pp7_22 pp8_20 cm82_2 cm86_0 cm86_1 cm86_2 VDD VSS CMP42
XI1448 pp9_18 pp10_16 pp11_14 pp12_12 cm83_2 cm87_0 cm87_1 cm87_2 VDD VSS CMP42
XI1449 pp13_10 pp14_8 pp15_6 fa88_0 fa88_1 VDD VSS FA_X1
XI1450 sn2 pp3_31 pp4_29 pp5_27 cm85_2 cm89_0 cm89_1 cm89_2 VDD VSS CMP42
XI1451 pp6_25 pp7_23 pp8_21 pp9_19 cm86_2 cm90_0 cm90_1 cm90_2 VDD VSS CMP42
XI1452 pp10_17 pp11_15 pp12_13 pp13_11 cm87_2 cm91_0 cm91_1 cm91_2 VDD VSS CMP42
XI1453 VDD pp3_32 pp4_30 pp5_28 cm89_2 cm92_0 cm92_1 cm92_2 VDD VSS CMP42
XI1454 pp6_26 pp7_24 pp8_22 pp9_20 cm90_2 cm93_0 cm93_1 cm93_2 VDD VSS CMP42
XI1455 pp10_18 pp11_16 pp12_14 pp13_12 cm91_2 cm94_0 cm94_1 cm94_2 VDD VSS CMP42
XI1456 sn3 pp4_31 pp5_29 pp6_27 cm92_2 cm95_0 cm95_1 cm95_2 VDD VSS CMP42
XI1457 pp7_25 pp8_23 pp9_21 pp10_19 cm93_2 cm96_0 cm96_1 cm96_2 VDD VSS CMP42
XI1458 pp11_17 pp12_15 pp13_13 pp14_11 cm94_2 cm97_0 cm97_1 cm97_2 VDD VSS CMP42
XI1459 VDD pp4_32 pp5_30 pp6_28 cm95_2 cm98_0 cm98_1 cm98_2 VDD VSS CMP42
XI1460 pp7_26 pp8_24 pp9_22 pp10_20 cm96_2 cm99_0 cm99_1 cm99_2 VDD VSS CMP42
XI1461 pp11_18 pp12_16 pp13_14 pp14_12 cm97_2 cm100_0 cm100_1 cm100_2 VDD VSS CMP42
XI1462 sn4 pp5_31 pp6_29 pp7_27 cm98_2 cm101_0 cm101_1 cm101_2 VDD VSS CMP42
XI1463 pp8_25 pp9_23 pp10_21 pp11_19 cm99_2 cm102_0 cm102_1 cm102_2 VDD VSS CMP42
XI1464 pp12_17 pp13_15 pp14_13 pp15_11 cm100_2 cm103_0 cm103_1 cm103_2 VDD VSS CMP42
XI1465 VDD pp5_32 pp6_30 pp7_28 cm101_2 cm104_0 cm104_1 cm104_2 VDD VSS CMP42
XI1466 pp8_26 pp9_24 pp10_22 pp11_20 cm102_2 cm105_0 cm105_1 cm105_2 VDD VSS CMP42
XI1467 pp12_18 pp13_16 pp14_14 pp15_12 cm103_2 cm106_0 cm106_1 cm106_2 VDD VSS CMP42
XI1468 sn5 pp6_31 pp7_29 pp8_27 cm104_2 cm107_0 cm107_1 cm107_2 VDD VSS CMP42
XI1469 pp9_25 pp10_23 pp11_21 pp12_19 cm105_2 cm108_0 cm108_1 cm108_2 VDD VSS CMP42
XI1470 pp13_17 pp14_15 pp15_13 fa109_0 fa109_1 VDD VSS FA_X1
XI1471 VDD pp6_32 pp7_30 pp8_28 cm107_2 cm110_0 cm110_1 cm110_2 VDD VSS CMP42
XI1472 pp9_26 pp10_24 pp11_22 pp12_20 cm108_2 cm111_0 cm111_1 cm111_2 VDD VSS CMP42
XI1473 pp13_18 pp14_16 pp15_14 fa112_0 fa112_1 VDD VSS FA_X1
XI1474 sn6 pp7_31 pp8_29 pp9_27 cm110_2 cm113_0 cm113_1 cm113_2 VDD VSS CMP42
XI1475 pp10_25 pp11_23 pp12_21 pp13_19 cm111_2 cm114_0 cm114_1 cm114_2 VDD VSS CMP42
XI1476 VDD pp7_32 pp8_30 pp9_28 cm113_2 cm115_0 cm115_1 cm115_2 VDD VSS CMP42
XI1477 pp10_26 pp11_24 pp12_22 pp13_20 cm114_2 cm116_0 cm116_1 cm116_2 VDD VSS CMP42
XI1478 sn7 pp8_31 pp9_29 pp10_27 cm115_2 cm117_0 cm117_1 cm117_2 VDD VSS CMP42
XI1479 pp11_25 pp12_23 pp13_21 pp14_19 cm116_2 cm118_0 cm118_1 cm118_2 VDD VSS CMP42
XI1480 VDD pp8_32 pp9_30 pp10_28 cm117_2 cm119_0 cm119_1 cm119_2 VDD VSS CMP42
XI1481 pp11_26 pp12_24 pp13_22 pp14_20 cm118_2 cm120_0 cm120_1 cm120_2 VDD VSS CMP42
XI1482 sn8 pp9_31 pp10_29 pp11_27 cm119_2 cm121_0 cm121_1 cm121_2 VDD VSS CMP42
XI1483 pp12_25 pp13_23 pp14_21 pp15_19 cm120_2 cm122_0 cm122_1 cm122_2 VDD VSS CMP42
XI1484 VDD pp9_32 pp10_30 pp11_28 cm121_2 cm123_0 cm123_1 cm123_2 VDD VSS CMP42
XI1485 pp12_26 pp13_24 pp14_22 pp15_20 cm122_2 cm124_0 cm124_1 cm124_2 VDD VSS CMP42
XI1486 sn9 pp10_31 pp11_29 pp12_27 cm123_2 cm125_0 cm125_1 cm125_2 VDD VSS CMP42
XI1487 pp13_25 pp14_23 pp15_21 fa126_0 fa126_1 VDD VSS FA_X1
XI1488 VDD pp10_32 pp11_30 pp12_28 cm125_2 cm127_0 cm127_1 cm127_2 VDD VSS CMP42
XI1489 pp13_26 pp14_24 pp15_22 fa128_0 fa128_1 VDD VSS FA_X1
XI1490 sn10 pp11_31 pp12_29 pp13_27 cm127_2 cm129_0 cm129_1 cm129_2 VDD VSS CMP42
XI1491 VDD pp11_32 pp12_30 pp13_28 cm129_2 cm130_0 cm130_1 cm130_2 VDD VSS CMP42
XI1492 sn11 pp12_31 pp13_29 pp14_27 cm130_2 cm131_0 cm131_1 cm131_2 VDD VSS CMP42
XI1493 VDD pp12_32 pp13_30 pp14_28 cm131_2 cm132_0 cm132_1 cm132_2 VDD VSS CMP42
XI1494 sn12 pp13_31 pp14_29 pp15_27 cm132_2 cm133_0 cm133_1 cm133_2 VDD VSS CMP42
XI1495 VDD pp13_32 pp14_30 pp15_28 cm133_2 cm134_0 cm134_1 cm134_2 VDD VSS CMP42
XI1496 sn13 pp14_31 pp15_29 fa135_0 fa135_1 VDD VSS FA_X1
XI1497 VDD pp14_32 pp15_30 fa136_0 fa136_1 VDD VSS FA_X1
XI1498 fa1_1 pp0_3 pp1_1 fa137_0 fa137_1 VDD VSS FA_X1
XI1499 cm5_1 cm6_0 pp4_0 fa138_0 fa138_1 VDD VSS FA_X1
XI1500 cm6_1 cm7_0 pp4_1 fa139_0 fa139_1 VDD VSS FA_X1
XI1501 cm7_1 cm8_0 fa9_0 fa140_0 fa140_1 VDD VSS FA_X1
XI1502 cm8_1 fa9_1 cm10_0 pp4_3 pp5_1 cm141_0 cm141_1 cm141_2 VDD VSS CMP42
XI1503 cm10_1 cm11_0 fa12_0 B_13_b3_5 cm141_2 cm142_0 cm142_1 cm142_2 VDD VSS CMP42
XI1504 cm11_1 fa12_1 cm13_0 fa14_0 cm142_2 cm143_0 cm143_1 cm143_2 VDD VSS CMP42
XI1505 cm13_1 fa14_1 cm15_0 cm16_0 cm143_2 cm144_0 cm144_1 cm144_2 VDD VSS CMP42
XI1506 cm15_1 cm16_1 cm17_0 cm18_0 cm144_2 cm145_0 cm145_1 cm145_2 VDD VSS CMP42
XI1507 cm17_1 cm18_1 cm19_0 cm20_0 cm145_2 cm146_0 cm146_1 cm146_2 VDD VSS CMP42
XI1508 cm19_1 cm20_1 cm21_0 cm22_0 cm146_2 cm147_0 cm147_1 cm147_2 VDD VSS CMP42
XI1509 cm21_1 cm22_1 cm23_0 cm24_0 cm147_2 cm148_0 cm148_1 cm148_2 VDD VSS CMP42
XI1510 cm23_1 cm24_1 fa25_1 cm26_0 cm148_2 cm149_0 cm149_1 cm149_2 VDD VSS CMP42
XI1511 cm27_0 pp8_3 pp9_1 fa150_0 fa150_1 VDD VSS FA_X1
XI1512 cm26_1 cm27_1 cm28_0 cm29_0 cm149_2 cm151_0 cm151_1 cm151_2 VDD VSS CMP42
XI1513 cm28_1 cm29_1 fa30_1 cm31_0 cm151_2 cm152_0 cm152_1 cm152_2 VDD VSS CMP42
XI1514 cm31_1 cm32_1 fa33_1 cm34_0 cm152_2 cm153_0 cm153_1 cm153_2 VDD VSS CMP42
XI1515 cm34_1 cm35_1 cm36_1 cm37_0 cm153_2 cm154_0 cm154_1 cm154_2 VDD VSS CMP42
XI1516 cm37_1 cm38_1 cm39_1 cm40_0 cm154_2 cm155_0 cm155_1 cm155_2 VDD VSS CMP42
XI1517 cm41_0 cm42_0 pp12_0 fa156_0 fa156_1 VDD VSS FA_X1
XI1518 cm40_1 cm41_1 cm42_1 cm43_0 cm155_2 cm157_0 cm157_1 cm157_2 VDD VSS CMP42
XI1519 cm44_0 cm45_0 pp12_1 fa158_0 fa158_1 VDD VSS FA_X1
XI1520 cm43_1 cm44_1 cm45_1 cm46_0 cm157_2 cm159_0 cm159_1 cm159_2 VDD VSS CMP42
XI1521 cm47_0 cm48_0 fa49_0 fa160_0 fa160_1 VDD VSS FA_X1
XI1522 cm46_1 cm47_1 cm48_1 fa49_1 cm159_2 cm161_0 cm161_1 cm161_2 VDD VSS CMP42
XI1523 cm50_0 cm51_0 cm52_0 pp12_3 pp13_1 cm162_0 cm162_1 cm162_2 VDD VSS CMP42
XI1524 cm50_1 cm51_1 cm52_1 cm53_0 cm161_2 cm163_0 cm163_1 cm163_2 VDD VSS CMP42
XI1525 cm54_0 cm55_0 fa56_0 B_29_b3_5 cm162_2 cm164_0 cm164_1 cm164_2 VDD VSS CMP42
XI1526 cm53_1 cm54_1 cm55_1 fa56_1 cm163_2 cm165_0 cm165_1 cm165_2 VDD VSS CMP42
XI1527 cm57_0 cm58_0 cm59_0 fa60_0 cm164_2 cm166_0 cm166_1 cm166_2 VDD VSS CMP42
XI1528 cm57_1 cm58_1 cm59_1 fa60_1 cm165_2 cm167_0 cm167_1 cm167_2 VDD VSS CMP42
XI1529 cm61_0 cm62_0 cm63_0 cm64_0 cm166_2 cm168_0 cm168_1 cm168_2 VDD VSS CMP42
XI1530 cm61_1 cm62_1 cm63_1 cm64_1 cm167_2 cm169_0 cm169_1 cm169_2 VDD VSS CMP42
XI1531 cm65_0 cm66_0 cm67_0 cm68_0 cm168_2 cm170_0 cm170_1 cm170_2 VDD VSS CMP42
XI1532 cm65_1 cm66_1 cm67_1 cm68_1 cm169_2 cm171_0 cm171_1 cm171_2 VDD VSS CMP42
XI1533 cm69_0 cm70_0 cm71_0 cm72_0 cm170_2 cm172_0 cm172_1 cm172_2 VDD VSS CMP42
XI1534 cm69_1 cm70_1 cm71_1 cm72_1 cm171_2 cm173_0 cm173_1 cm173_2 VDD VSS CMP42
XI1535 cm73_0 cm74_0 cm75_0 cm76_0 cm172_2 cm174_0 cm174_1 cm174_2 VDD VSS CMP42
XI1536 cm73_1 cm74_1 cm75_1 cm76_1 cm173_2 cm175_0 cm175_1 cm175_2 VDD VSS CMP42
XI1537 cm77_0 cm78_0 cm79_0 cm80_0 cm174_2 cm176_0 cm176_1 cm176_2 VDD VSS CMP42
XI1538 cm77_1 cm78_1 cm79_1 cm80_1 cm175_2 cm177_0 cm177_1 cm177_2 VDD VSS CMP42
XI1539 cm81_0 cm82_0 cm83_0 cm84_0 cm176_2 cm178_0 cm178_1 cm178_2 VDD VSS CMP42
XI1540 cm81_1 cm82_1 cm83_1 cm84_1 cm177_2 cm179_0 cm179_1 cm179_2 VDD VSS CMP42
XI1541 cm85_0 cm86_0 cm87_0 fa88_0 cm178_2 cm180_0 cm180_1 cm180_2 VDD VSS CMP42
XI1542 cm85_1 cm86_1 cm87_1 fa88_1 cm179_2 cm181_0 cm181_1 cm181_2 VDD VSS CMP42
XI1543 cm89_0 cm90_0 cm91_0 pp14_9 cm180_2 cm182_0 cm182_1 cm182_2 VDD VSS CMP42
XI1544 cm89_1 cm90_1 cm91_1 cm92_0 cm181_2 cm183_0 cm183_1 cm183_2 VDD VSS CMP42
XI1545 cm93_0 cm94_0 pp14_10 pp15_8 cm182_2 cm184_0 cm184_1 cm184_2 VDD VSS CMP42
XI1546 cm92_1 cm93_1 cm94_1 cm95_0 cm183_2 cm185_0 cm185_1 cm185_2 VDD VSS CMP42
XI1547 cm96_0 cm97_0 pp15_9 fa186_0 fa186_1 VDD VSS FA_X1
XI1548 cm95_1 cm96_1 cm97_1 cm98_0 cm185_2 cm187_0 cm187_1 cm187_2 VDD VSS CMP42
XI1549 cm99_0 cm100_0 pp15_10 fa188_0 fa188_1 VDD VSS FA_X1
XI1550 cm98_1 cm99_1 cm100_1 cm101_0 cm187_2 cm189_0 cm189_1 cm189_2 VDD VSS CMP42
XI1551 cm101_1 cm102_1 cm103_1 cm104_0 cm189_2 cm190_0 cm190_1 cm190_2 VDD VSS CMP42
XI1552 cm104_1 cm105_1 cm106_1 cm107_0 cm190_2 cm191_0 cm191_1 cm191_2 VDD VSS CMP42
XI1553 cm108_0 fa109_0 cm106_2 fa192_0 fa192_1 VDD VSS FA_X1
XI1554 cm107_1 cm108_1 fa109_1 cm110_0 cm191_2 cm193_0 cm193_1 cm193_2 VDD VSS CMP42
XI1555 cm110_1 cm111_1 fa112_1 cm113_0 cm193_2 cm194_0 cm194_1 cm194_2 VDD VSS CMP42
XI1556 cm114_0 pp14_17 pp15_15 fa195_0 fa195_1 VDD VSS FA_X1
XI1557 cm113_1 cm114_1 cm115_0 cm116_0 cm194_2 cm196_0 cm196_1 cm196_2 VDD VSS CMP42
XI1558 cm115_1 cm116_1 cm117_0 cm118_0 cm196_2 cm197_0 cm197_1 cm197_2 VDD VSS CMP42
XI1559 cm117_1 cm118_1 cm119_0 cm120_0 cm197_2 cm198_0 cm198_1 cm198_2 VDD VSS CMP42
XI1560 cm119_1 cm120_1 cm121_0 cm122_0 cm198_2 cm199_0 cm199_1 cm199_2 VDD VSS CMP42
XI1561 cm121_1 cm122_1 cm123_0 cm124_0 cm199_2 cm200_0 cm200_1 cm200_2 VDD VSS CMP42
XI1562 cm123_1 cm124_1 cm125_0 fa126_0 cm200_2 cm201_0 cm201_1 cm201_2 VDD VSS CMP42
XI1563 cm125_1 fa126_1 cm127_0 fa128_0 cm201_2 cm202_0 cm202_1 cm202_2 VDD VSS CMP42
XI1564 cm127_1 fa128_1 cm129_0 pp14_25 cm202_2 cm203_0 cm203_1 cm203_2 VDD VSS CMP42
XI1565 cm129_1 cm130_0 pp14_26 pp15_24 cm203_2 cm204_0 cm204_1 cm204_2 VDD VSS CMP42
XI1566 cm130_1 cm131_0 pp15_25 fa205_0 fa205_1 VDD VSS FA_X1
XI1567 cm131_1 cm132_0 pp15_26 fa206_0 fa206_1 VDD VSS FA_X1
XI1568 cm134_1 fa135_0 cm134_2 fa207_0 fa207_1 VDD VSS FA_X1
XI1569 fa136_1 sn14 pp15_31 fa208_0 fa208_1 VDD VSS FA_X1
XI1570 fa137_1 fa2_0 B_5_b3_5 fa209_0 fa209_1 VDD VSS FA_X1
XI1571 cm145_1 cm146_0 pp8_0 fa210_0 fa210_1 VDD VSS FA_X1
XI1572 cm146_1 cm147_0 pp8_1 fa211_0 fa211_1 VDD VSS FA_X1
XI1573 cm147_1 cm148_0 fa25_0 fa212_0 fa212_1 VDD VSS FA_X1
XI1574 cm148_1 cm149_0 fa150_0 fa213_0 fa213_1 VDD VSS FA_X1
XI1575 cm149_1 fa150_1 cm151_0 fa30_0 B_21_b3_5 cm214_0 cm214_1 cm214_2 VDD VSS CMP42
XI1576 cm151_1 cm152_0 cm32_0 fa33_0 cm214_2 cm215_0 cm215_1 cm215_2 VDD VSS CMP42
XI1577 cm152_1 cm153_0 cm35_0 cm36_0 cm215_2 cm216_0 cm216_1 cm216_2 VDD VSS CMP42
XI1578 cm153_1 cm154_0 cm38_0 cm39_0 cm216_2 cm217_0 cm217_1 cm217_2 VDD VSS CMP42
XI1579 cm154_1 cm155_0 fa156_0 B_25_b3_5 cm217_2 cm218_0 cm218_1 cm218_2 VDD VSS CMP42
XI1580 cm155_1 fa156_1 cm157_0 fa158_0 cm218_2 cm219_0 cm219_1 cm219_2 VDD VSS CMP42
XI1581 cm157_1 fa158_1 cm159_0 fa160_0 cm219_2 cm220_0 cm220_1 cm220_2 VDD VSS CMP42
XI1582 cm159_1 fa160_1 cm161_0 cm162_0 cm220_2 cm221_0 cm221_1 cm221_2 VDD VSS CMP42
XI1583 cm161_1 cm162_1 cm163_0 cm164_0 cm221_2 cm222_0 cm222_1 cm222_2 VDD VSS CMP42
XI1584 cm163_1 cm164_1 cm165_0 cm166_0 cm222_2 cm223_0 cm223_1 cm223_2 VDD VSS CMP42
XI1585 cm165_1 cm166_1 cm167_0 cm168_0 cm223_2 cm224_0 cm224_1 cm224_2 VDD VSS CMP42
XI1586 cm167_1 cm168_1 cm169_0 cm170_0 cm224_2 cm225_0 cm225_1 cm225_2 VDD VSS CMP42
XI1587 cm169_1 cm170_1 cm171_0 cm172_0 cm225_2 cm226_0 cm226_1 cm226_2 VDD VSS CMP42
XI1588 cm171_1 cm172_1 cm173_0 cm174_0 cm226_2 cm227_0 cm227_1 cm227_2 VDD VSS CMP42
XI1589 cm173_1 cm174_1 cm175_0 cm176_0 cm227_2 cm228_0 cm228_1 cm228_2 VDD VSS CMP42
XI1590 cm175_1 cm176_1 cm177_0 cm178_0 cm228_2 cm229_0 cm229_1 cm229_2 VDD VSS CMP42
XI1591 cm177_1 cm178_1 cm179_0 cm180_0 cm229_2 cm230_0 cm230_1 cm230_2 VDD VSS CMP42
XI1592 cm179_1 cm180_1 cm181_0 cm182_0 cm230_2 cm231_0 cm231_1 cm231_2 VDD VSS CMP42
XI1593 cm181_1 cm182_1 cm183_0 cm184_0 cm231_2 cm232_0 cm232_1 cm232_2 VDD VSS CMP42
XI1594 cm183_1 cm184_1 cm185_0 fa186_0 cm232_2 cm233_0 cm233_1 cm233_2 VDD VSS CMP42
XI1595 cm185_1 fa186_1 cm187_0 fa188_0 cm233_2 cm234_0 cm234_1 cm234_2 VDD VSS CMP42
XI1596 cm187_1 fa188_1 cm189_0 cm102_0 cm234_2 cm235_0 cm235_1 cm235_2 VDD VSS CMP42
XI1597 cm189_1 cm190_0 cm105_0 cm106_0 cm235_2 cm236_0 cm236_1 cm236_2 VDD VSS CMP42
XI1598 cm190_1 cm191_0 fa192_0 fa237_0 fa237_1 VDD VSS FA_X1
XI1599 cm191_1 fa192_1 cm193_0 cm111_0 fa112_0 cm238_0 cm238_1 cm238_2 VDD VSS CMP42
XI1600 cm193_1 cm194_0 fa195_0 fa239_0 fa239_1 VDD VSS FA_X1
XI1601 cm194_1 fa195_1 cm196_0 pp14_18 pp15_16 cm240_0 cm240_1 cm240_2 VDD VSS CMP42
XI1602 cm196_1 cm197_0 pp15_17 fa241_0 fa241_1 VDD VSS FA_X1
XI1603 cm197_1 cm198_0 pp15_18 fa242_0 fa242_1 VDD VSS FA_X1
XI1604 cm200_1 cm201_0 cm124_2 fa243_0 fa243_1 VDD VSS FA_X1
XI1605 cm202_1 cm203_0 pp15_23 fa244_0 fa244_1 VDD VSS FA_X1
XI1606 cm204_1 fa205_0 cm204_2 fa245_0 fa245_1 VDD VSS FA_X1
XI1607 fa206_1 cm132_1 cm133_0 fa246_0 fa246_1 VDD VSS FA_X1
XI1608 fa207_1 fa135_1 fa136_0 fa247_0 fa247_1 VDD VSS FA_X1
XI1609 fa208_1 VDD pp15_32 fa248_0 fa248_1 VDD VSS FA_X1
XI1610 fa209_1 fa2_1 fa3_0 fa249_0 fa249_1 VDD VSS FA_X1
XI1611 fa3_1 cm4_0 ha250_0 ha250_1 VDD VSS HA_X1
XI1612 cm4_1 cm5_0 ha251_0 ha251_1 VDD VSS HA_X1
XI1613 fa138_0 B_9_b3_5 ha252_0 ha252_1 VDD VSS HA_X1
XI1614 fa138_1 fa139_0 ha253_0 ha253_1 VDD VSS HA_X1
XI1615 fa139_1 fa140_0 ha254_0 ha254_1 VDD VSS HA_X1
XI1616 fa140_1 cm141_0 ha255_0 ha255_1 VDD VSS HA_X1
XI1617 cm141_1 cm142_0 ha256_0 ha256_1 VDD VSS HA_X1
XI1618 cm142_1 cm143_0 ha257_0 ha257_1 VDD VSS HA_X1
XI1619 cm143_1 cm144_0 ha258_0 ha258_1 VDD VSS HA_X1
XI1620 cm144_1 cm145_0 ha259_0 ha259_1 VDD VSS HA_X1
XI1621 fa210_0 B_17_b3_5 ha260_0 ha260_1 VDD VSS HA_X1
XI1622 fa210_1 fa211_0 ha261_0 ha261_1 VDD VSS HA_X1
XI1623 fa211_1 fa212_0 ha262_0 ha262_1 VDD VSS HA_X1
XI1624 fa212_1 fa213_0 ha263_0 ha263_1 VDD VSS HA_X1
XI1625 fa213_1 cm214_0 ha264_0 ha264_1 VDD VSS HA_X1
XI1626 cm214_1 cm215_0 ha265_0 ha265_1 VDD VSS HA_X1
XI1627 cm215_1 cm216_0 ha266_0 ha266_1 VDD VSS HA_X1
XI1628 cm216_1 cm217_0 ha267_0 ha267_1 VDD VSS HA_X1
XI1629 cm217_1 cm218_0 ha268_0 ha268_1 VDD VSS HA_X1
XI1630 cm218_1 cm219_0 ha269_0 ha269_1 VDD VSS HA_X1
XI1631 cm219_1 cm220_0 ha270_0 ha270_1 VDD VSS HA_X1
XI1632 cm220_1 cm221_0 ha271_0 ha271_1 VDD VSS HA_X1
XI1633 cm221_1 cm222_0 ha272_0 ha272_1 VDD VSS HA_X1
XI1634 cm222_1 cm223_0 ha273_0 ha273_1 VDD VSS HA_X1
XI1635 cm223_1 cm224_0 ha274_0 ha274_1 VDD VSS HA_X1
XI1636 cm224_1 cm225_0 ha275_0 ha275_1 VDD VSS HA_X1
XI1637 cm225_1 cm226_0 ha276_0 ha276_1 VDD VSS HA_X1
XI1638 cm226_1 cm227_0 ha277_0 ha277_1 VDD VSS HA_X1
XI1639 cm227_1 cm228_0 ha278_0 ha278_1 VDD VSS HA_X1
XI1640 cm228_1 cm229_0 ha279_0 ha279_1 VDD VSS HA_X1
XI1641 cm229_1 cm230_0 cm84_2 fa280_0 fa280_1 VDD VSS FA_X1
XI1642 cm230_1 cm231_0 pp15_7 fa281_0 fa281_1 VDD VSS FA_X1
XI1643 cm231_1 cm232_0 ha282_0 ha282_1 VDD VSS HA_X1
XI1644 cm232_1 cm233_0 cm184_2 fa283_0 fa283_1 VDD VSS FA_X1
XI1645 cm233_1 cm234_0 ha284_0 ha284_1 VDD VSS HA_X1
XI1646 cm234_1 cm235_0 cm103_0 fa285_0 fa285_1 VDD VSS FA_X1
XI1647 cm235_1 cm236_0 ha286_0 ha286_1 VDD VSS HA_X1
XI1648 cm236_1 fa237_0 cm236_2 fa287_0 fa287_1 VDD VSS FA_X1
XI1649 fa237_1 cm238_0 ha288_0 ha288_1 VDD VSS HA_X1
XI1650 cm238_1 fa239_0 cm238_2 fa289_0 fa289_1 VDD VSS FA_X1
XI1651 fa239_1 cm240_0 ha290_0 ha290_1 VDD VSS HA_X1
XI1652 cm240_1 fa241_0 cm240_2 fa291_0 fa291_1 VDD VSS FA_X1
XI1653 fa241_1 fa242_0 ha292_0 ha292_1 VDD VSS HA_X1
XI1654 fa242_1 cm198_1 cm199_0 fa293_0 fa293_1 VDD VSS FA_X1
XI1655 cm199_1 cm200_0 ha294_0 ha294_1 VDD VSS HA_X1
XI1656 fa243_1 cm201_1 cm202_0 fa295_0 fa295_1 VDD VSS FA_X1
XI1657 fa244_1 cm203_1 cm204_0 fa296_0 fa296_1 VDD VSS FA_X1
XI1658 fa245_1 fa205_1 fa206_0 fa297_0 fa297_1 VDD VSS FA_X1
XI1659 fa246_1 cm133_1 cm134_0 fa298_0 fa298_1 VDD VSS FA_X1
XI1660_I0 pp0_0 B_1_b3_5 I1660_gn0 VDD VSS NAND2_X1
XI1660_I1 pp0_1 VSS I1660_gn1 VDD VSS NAND2_X1
XI1660_I2 fa1_0 VSS I1660_gn2 VDD VSS NAND2_X1
XI1660_I3 fa137_0 VSS I1660_gn3 VDD VSS NAND2_X1
XI1660_I4 fa209_0 VSS I1660_gn4 VDD VSS NAND2_X1
XI1660_I5 fa249_0 VSS I1660_gn5 VDD VSS NAND2_X1
XI1660_I6 fa249_1 ha250_0 I1660_gn6 VDD VSS NAND2_X1
XI1660_I7 ha250_1 ha251_0 I1660_gn7 VDD VSS NAND2_X1
XI1660_I8 ha251_1 ha252_0 I1660_gn8 VDD VSS NAND2_X1
XI1660_I9 ha252_1 ha253_0 I1660_gn9 VDD VSS NAND2_X1
XI1660_I10 ha253_1 ha254_0 I1660_gn10 VDD VSS NAND2_X1
XI1660_I11 ha254_1 ha255_0 I1660_gn11 VDD VSS NAND2_X1
XI1660_I12 ha255_1 ha256_0 I1660_gn12 VDD VSS NAND2_X1
XI1660_I13 ha256_1 ha257_0 I1660_gn13 VDD VSS NAND2_X1
XI1660_I14 ha257_1 ha258_0 I1660_gn14 VDD VSS NAND2_X1
XI1660_I15 ha258_1 ha259_0 I1660_gn15 VDD VSS NAND2_X1
XI1660_I16 ha259_1 ha260_0 I1660_gn16 VDD VSS NAND2_X1
XI1660_I17 ha260_1 ha261_0 I1660_gn17 VDD VSS NAND2_X1
XI1660_I18 ha261_1 ha262_0 I1660_gn18 VDD VSS NAND2_X1
XI1660_I19 ha262_1 ha263_0 I1660_gn19 VDD VSS NAND2_X1
XI1660_I20 ha263_1 ha264_0 I1660_gn20 VDD VSS NAND2_X1
XI1660_I21 ha264_1 ha265_0 I1660_gn21 VDD VSS NAND2_X1
XI1660_I22 ha265_1 ha266_0 I1660_gn22 VDD VSS NAND2_X1
XI1660_I23 ha266_1 ha267_0 I1660_gn23 VDD VSS NAND2_X1
XI1660_I24 ha267_1 ha268_0 I1660_gn24 VDD VSS NAND2_X1
XI1660_I25 ha268_1 ha269_0 I1660_gn25 VDD VSS NAND2_X1
XI1660_I26 ha269_1 ha270_0 I1660_gn26 VDD VSS NAND2_X1
XI1660_I27 ha270_1 ha271_0 I1660_gn27 VDD VSS NAND2_X1
XI1660_I28 ha271_1 ha272_0 I1660_gn28 VDD VSS NAND2_X1
XI1660_I29 ha272_1 ha273_0 I1660_gn29 VDD VSS NAND2_X1
XI1660_I30 ha273_1 ha274_0 I1660_gn30 VDD VSS NAND2_X1
XI1660_I31 ha274_1 ha275_0 I1660_gn31 VDD VSS NAND2_X1
XI1660_I32 ha275_1 ha276_0 I1660_gn32 VDD VSS NAND2_X1
XI1660_I33 ha276_1 ha277_0 I1660_gn33 VDD VSS NAND2_X1
XI1660_I34 ha277_1 ha278_0 I1660_gn34 VDD VSS NAND2_X1
XI1660_I35 ha278_1 ha279_0 I1660_gn35 VDD VSS NAND2_X1
XI1660_I36 ha279_1 fa280_0 I1660_gn36 VDD VSS NAND2_X1
XI1660_I37 fa280_1 fa281_0 I1660_gn37 VDD VSS NAND2_X1
XI1660_I38 fa281_1 ha282_0 I1660_gn38 VDD VSS NAND2_X1
XI1660_I39 ha282_1 fa283_0 I1660_gn39 VDD VSS NAND2_X1
XI1660_I40 fa283_1 ha284_0 I1660_gn40 VDD VSS NAND2_X1
XI1660_I41 ha284_1 fa285_0 I1660_gn41 VDD VSS NAND2_X1
XI1660_I42 fa285_1 ha286_0 I1660_gn42 VDD VSS NAND2_X1
XI1660_I43 ha286_1 fa287_0 I1660_gn43 VDD VSS NAND2_X1
XI1660_I44 fa287_1 ha288_0 I1660_gn44 VDD VSS NAND2_X1
XI1660_I45 ha288_1 fa289_0 I1660_gn45 VDD VSS NAND2_X1
XI1660_I46 fa289_1 ha290_0 I1660_gn46 VDD VSS NAND2_X1
XI1660_I47 ha290_1 fa291_0 I1660_gn47 VDD VSS NAND2_X1
XI1660_I48 fa291_1 ha292_0 I1660_gn48 VDD VSS NAND2_X1
XI1660_I49 ha292_1 fa293_0 I1660_gn49 VDD VSS NAND2_X1
XI1660_I50 fa293_1 ha294_0 I1660_gn50 VDD VSS NAND2_X1
XI1660_I51 ha294_1 fa243_0 I1660_gn51 VDD VSS NAND2_X1
XI1660_I52 fa295_0 VSS I1660_gn52 VDD VSS NAND2_X1
XI1660_I53 fa295_1 fa244_0 I1660_gn53 VDD VSS NAND2_X1
XI1660_I54 fa296_0 VSS I1660_gn54 VDD VSS NAND2_X1
XI1660_I55 fa296_1 fa245_0 I1660_gn55 VDD VSS NAND2_X1
XI1660_I56 fa297_0 VSS I1660_gn56 VDD VSS NAND2_X1
XI1660_I57 fa297_1 fa246_0 I1660_gn57 VDD VSS NAND2_X1
XI1660_I58 fa298_0 VSS I1660_gn58 VDD VSS NAND2_X1
XI1660_I59 fa298_1 fa207_0 I1660_gn59 VDD VSS NAND2_X1
XI1660_I60 fa247_0 VSS I1660_gn60 VDD VSS NAND2_X1
XI1660_I61 fa247_1 fa208_0 I1660_gn61 VDD VSS NAND2_X1
XI1660_I62 fa248_0 VSS I1660_gn62 VDD VSS NAND2_X1
XI1660_I63 fa248_1 sn15 I1660_gn63 VDD VSS NAND2_X1
XI1660_I64 pp0_0 B_1_b3_5 I1660_pn0 VDD VSS XNOR2_X1
XI1660_I65 pp0_1 VSS I1660_pn1 VDD VSS XNOR2_X1
XI1660_I66 fa1_0 VSS I1660_pn2 VDD VSS XNOR2_X1
XI1660_I67 fa137_0 VSS I1660_pn3 VDD VSS XNOR2_X1
XI1660_I68 fa209_0 VSS I1660_pn4 VDD VSS XNOR2_X1
XI1660_I69 fa249_0 VSS I1660_pn5 VDD VSS XNOR2_X1
XI1660_I70 fa249_1 ha250_0 I1660_pn6 VDD VSS XNOR2_X1
XI1660_I71 ha250_1 ha251_0 I1660_pn7 VDD VSS XNOR2_X1
XI1660_I72 ha251_1 ha252_0 I1660_pn8 VDD VSS XNOR2_X1
XI1660_I73 ha252_1 ha253_0 I1660_pn9 VDD VSS XNOR2_X1
XI1660_I74 ha253_1 ha254_0 I1660_pn10 VDD VSS XNOR2_X1
XI1660_I75 ha254_1 ha255_0 I1660_pn11 VDD VSS XNOR2_X1
XI1660_I76 ha255_1 ha256_0 I1660_pn12 VDD VSS XNOR2_X1
XI1660_I77 ha256_1 ha257_0 I1660_pn13 VDD VSS XNOR2_X1
XI1660_I78 ha257_1 ha258_0 I1660_pn14 VDD VSS XNOR2_X1
XI1660_I79 ha258_1 ha259_0 I1660_pn15 VDD VSS XNOR2_X1
XI1660_I80 ha259_1 ha260_0 I1660_pn16 VDD VSS XNOR2_X1
XI1660_I81 ha260_1 ha261_0 I1660_pn17 VDD VSS XNOR2_X1
XI1660_I82 ha261_1 ha262_0 I1660_pn18 VDD VSS XNOR2_X1
XI1660_I83 ha262_1 ha263_0 I1660_pn19 VDD VSS XNOR2_X1
XI1660_I84 ha263_1 ha264_0 I1660_pn20 VDD VSS XNOR2_X1
XI1660_I85 ha264_1 ha265_0 I1660_pn21 VDD VSS XNOR2_X1
XI1660_I86 ha265_1 ha266_0 I1660_pn22 VDD VSS XNOR2_X1
XI1660_I87 ha266_1 ha267_0 I1660_pn23 VDD VSS XNOR2_X1
XI1660_I88 ha267_1 ha268_0 I1660_pn24 VDD VSS XNOR2_X1
XI1660_I89 ha268_1 ha269_0 I1660_pn25 VDD VSS XNOR2_X1
XI1660_I90 ha269_1 ha270_0 I1660_pn26 VDD VSS XNOR2_X1
XI1660_I91 ha270_1 ha271_0 I1660_pn27 VDD VSS XNOR2_X1
XI1660_I92 ha271_1 ha272_0 I1660_pn28 VDD VSS XNOR2_X1
XI1660_I93 ha272_1 ha273_0 I1660_pn29 VDD VSS XNOR2_X1
XI1660_I94 ha273_1 ha274_0 I1660_pn30 VDD VSS XNOR2_X1
XI1660_I95 ha274_1 ha275_0 I1660_pn31 VDD VSS XNOR2_X1
XI1660_I96 ha275_1 ha276_0 I1660_pn32 VDD VSS XNOR2_X1
XI1660_I97 ha276_1 ha277_0 I1660_pn33 VDD VSS XNOR2_X1
XI1660_I98 ha277_1 ha278_0 I1660_pn34 VDD VSS XNOR2_X1
XI1660_I99 ha278_1 ha279_0 I1660_pn35 VDD VSS XNOR2_X1
XI1660_I100 ha279_1 fa280_0 I1660_pn36 VDD VSS XNOR2_X1
XI1660_I101 fa280_1 fa281_0 I1660_pn37 VDD VSS XNOR2_X1
XI1660_I102 fa281_1 ha282_0 I1660_pn38 VDD VSS XNOR2_X1
XI1660_I103 ha282_1 fa283_0 I1660_pn39 VDD VSS XNOR2_X1
XI1660_I104 fa283_1 ha284_0 I1660_pn40 VDD VSS XNOR2_X1
XI1660_I105 ha284_1 fa285_0 I1660_pn41 VDD VSS XNOR2_X1
XI1660_I106 fa285_1 ha286_0 I1660_pn42 VDD VSS XNOR2_X1
XI1660_I107 ha286_1 fa287_0 I1660_pn43 VDD VSS XNOR2_X1
XI1660_I108 fa287_1 ha288_0 I1660_pn44 VDD VSS XNOR2_X1
XI1660_I109 ha288_1 fa289_0 I1660_pn45 VDD VSS XNOR2_X1
XI1660_I110 fa289_1 ha290_0 I1660_pn46 VDD VSS XNOR2_X1
XI1660_I111 ha290_1 fa291_0 I1660_pn47 VDD VSS XNOR2_X1
XI1660_I112 fa291_1 ha292_0 I1660_pn48 VDD VSS XNOR2_X1
XI1660_I113 ha292_1 fa293_0 I1660_pn49 VDD VSS XNOR2_X1
XI1660_I114 fa293_1 ha294_0 I1660_pn50 VDD VSS XNOR2_X1
XI1660_I115 ha294_1 fa243_0 I1660_pn51 VDD VSS XNOR2_X1
XI1660_I116 fa295_0 VSS I1660_pn52 VDD VSS XNOR2_X1
XI1660_I117 fa295_1 fa244_0 I1660_pn53 VDD VSS XNOR2_X1
XI1660_I118 fa296_0 VSS I1660_pn54 VDD VSS XNOR2_X1
XI1660_I119 fa296_1 fa245_0 I1660_pn55 VDD VSS XNOR2_X1
XI1660_I120 fa297_0 VSS I1660_pn56 VDD VSS XNOR2_X1
XI1660_I121 fa297_1 fa246_0 I1660_pn57 VDD VSS XNOR2_X1
XI1660_I122 fa298_0 VSS I1660_pn58 VDD VSS XNOR2_X1
XI1660_I123 fa298_1 fa207_0 I1660_pn59 VDD VSS XNOR2_X1
XI1660_I124 fa247_0 VSS I1660_pn60 VDD VSS XNOR2_X1
XI1660_I125 fa247_1 fa208_0 I1660_pn61 VDD VSS XNOR2_X1
XI1660_I126 fa248_0 VSS I1660_pn62 VDD VSS XNOR2_X1
XI1660_I127 fa248_1 sn15 I1660_pn63 VDD VSS XNOR2_X1
XI1660_I128 VSS I1660_cinn VDD VSS INV_X1
XI1660_I129_XG I1660_pn0 I1660_cinn I1660_gn0 I1660_G0_0 VDD VSS OAI21_X1
XI1660_I130 I1660_G0_0 I1660_G0_0n VDD VSS INV_X1
XI1660_I131_XG I1660_pn1 I1660_G0_0n I1660_gn1 I1660_G1_0 VDD VSS OAI21_X1
XI1660_I132_XG I1660_pn2 I1660_gn1 I1660_gn2 I1660_G2_1 VDD VSS OAI21_X1
XI1660_I132_XP I1660_pn2 I1660_pn1 I1660_P2_1 VDD VSS NOR2_X1
XI1660_I133_XG I1660_pn3 I1660_gn2 I1660_gn3 I1660_G3_2 VDD VSS OAI21_X1
XI1660_I133_XP I1660_pn3 I1660_pn2 I1660_P3_2 VDD VSS NOR2_X1
XI1660_I134_XG I1660_pn4 I1660_gn3 I1660_gn4 I1660_G4_3 VDD VSS OAI21_X1
XI1660_I134_XP I1660_pn4 I1660_pn3 I1660_P4_3 VDD VSS NOR2_X1
XI1660_I135_XG I1660_pn5 I1660_gn4 I1660_gn5 I1660_G5_4 VDD VSS OAI21_X1
XI1660_I135_XP I1660_pn5 I1660_pn4 I1660_P5_4 VDD VSS NOR2_X1
XI1660_I136_XG I1660_pn6 I1660_gn5 I1660_gn6 I1660_G6_5 VDD VSS OAI21_X1
XI1660_I136_XP I1660_pn6 I1660_pn5 I1660_P6_5 VDD VSS NOR2_X1
XI1660_I137_XG I1660_pn7 I1660_gn6 I1660_gn7 I1660_G7_6 VDD VSS OAI21_X1
XI1660_I137_XP I1660_pn7 I1660_pn6 I1660_P7_6 VDD VSS NOR2_X1
XI1660_I138_XG I1660_pn8 I1660_gn7 I1660_gn8 I1660_G8_7 VDD VSS OAI21_X1
XI1660_I138_XP I1660_pn8 I1660_pn7 I1660_P8_7 VDD VSS NOR2_X1
XI1660_I139_XG I1660_pn9 I1660_gn8 I1660_gn9 I1660_G9_8 VDD VSS OAI21_X1
XI1660_I139_XP I1660_pn9 I1660_pn8 I1660_P9_8 VDD VSS NOR2_X1
XI1660_I140_XG I1660_pn10 I1660_gn9 I1660_gn10 I1660_G10_9 VDD VSS OAI21_X1
XI1660_I140_XP I1660_pn10 I1660_pn9 I1660_P10_9 VDD VSS NOR2_X1
XI1660_I141_XG I1660_pn11 I1660_gn10 I1660_gn11 I1660_G11_10 VDD VSS OAI21_X1
XI1660_I141_XP I1660_pn11 I1660_pn10 I1660_P11_10 VDD VSS NOR2_X1
XI1660_I142_XG I1660_pn12 I1660_gn11 I1660_gn12 I1660_G12_11 VDD VSS OAI21_X1
XI1660_I142_XP I1660_pn12 I1660_pn11 I1660_P12_11 VDD VSS NOR2_X1
XI1660_I143_XG I1660_pn13 I1660_gn12 I1660_gn13 I1660_G13_12 VDD VSS OAI21_X1
XI1660_I143_XP I1660_pn13 I1660_pn12 I1660_P13_12 VDD VSS NOR2_X1
XI1660_I144_XG I1660_pn14 I1660_gn13 I1660_gn14 I1660_G14_13 VDD VSS OAI21_X1
XI1660_I144_XP I1660_pn14 I1660_pn13 I1660_P14_13 VDD VSS NOR2_X1
XI1660_I145_XG I1660_pn15 I1660_gn14 I1660_gn15 I1660_G15_14 VDD VSS OAI21_X1
XI1660_I145_XP I1660_pn15 I1660_pn14 I1660_P15_14 VDD VSS NOR2_X1
XI1660_I146_XG I1660_pn16 I1660_gn15 I1660_gn16 I1660_G16_15 VDD VSS OAI21_X1
XI1660_I146_XP I1660_pn16 I1660_pn15 I1660_P16_15 VDD VSS NOR2_X1
XI1660_I147_XG I1660_pn17 I1660_gn16 I1660_gn17 I1660_G17_16 VDD VSS OAI21_X1
XI1660_I147_XP I1660_pn17 I1660_pn16 I1660_P17_16 VDD VSS NOR2_X1
XI1660_I148_XG I1660_pn18 I1660_gn17 I1660_gn18 I1660_G18_17 VDD VSS OAI21_X1
XI1660_I148_XP I1660_pn18 I1660_pn17 I1660_P18_17 VDD VSS NOR2_X1
XI1660_I149_XG I1660_pn19 I1660_gn18 I1660_gn19 I1660_G19_18 VDD VSS OAI21_X1
XI1660_I149_XP I1660_pn19 I1660_pn18 I1660_P19_18 VDD VSS NOR2_X1
XI1660_I150_XG I1660_pn20 I1660_gn19 I1660_gn20 I1660_G20_19 VDD VSS OAI21_X1
XI1660_I150_XP I1660_pn20 I1660_pn19 I1660_P20_19 VDD VSS NOR2_X1
XI1660_I151_XG I1660_pn21 I1660_gn20 I1660_gn21 I1660_G21_20 VDD VSS OAI21_X1
XI1660_I151_XP I1660_pn21 I1660_pn20 I1660_P21_20 VDD VSS NOR2_X1
XI1660_I152_XG I1660_pn22 I1660_gn21 I1660_gn22 I1660_G22_21 VDD VSS OAI21_X1
XI1660_I152_XP I1660_pn22 I1660_pn21 I1660_P22_21 VDD VSS NOR2_X1
XI1660_I153_XG I1660_pn23 I1660_gn22 I1660_gn23 I1660_G23_22 VDD VSS OAI21_X1
XI1660_I153_XP I1660_pn23 I1660_pn22 I1660_P23_22 VDD VSS NOR2_X1
XI1660_I154_XG I1660_pn24 I1660_gn23 I1660_gn24 I1660_G24_23 VDD VSS OAI21_X1
XI1660_I154_XP I1660_pn24 I1660_pn23 I1660_P24_23 VDD VSS NOR2_X1
XI1660_I155_XG I1660_pn25 I1660_gn24 I1660_gn25 I1660_G25_24 VDD VSS OAI21_X1
XI1660_I155_XP I1660_pn25 I1660_pn24 I1660_P25_24 VDD VSS NOR2_X1
XI1660_I156_XG I1660_pn26 I1660_gn25 I1660_gn26 I1660_G26_25 VDD VSS OAI21_X1
XI1660_I156_XP I1660_pn26 I1660_pn25 I1660_P26_25 VDD VSS NOR2_X1
XI1660_I157_XG I1660_pn27 I1660_gn26 I1660_gn27 I1660_G27_26 VDD VSS OAI21_X1
XI1660_I157_XP I1660_pn27 I1660_pn26 I1660_P27_26 VDD VSS NOR2_X1
XI1660_I158_XG I1660_pn28 I1660_gn27 I1660_gn28 I1660_G28_27 VDD VSS OAI21_X1
XI1660_I158_XP I1660_pn28 I1660_pn27 I1660_P28_27 VDD VSS NOR2_X1
XI1660_I159_XG I1660_pn29 I1660_gn28 I1660_gn29 I1660_G29_28 VDD VSS OAI21_X1
XI1660_I159_XP I1660_pn29 I1660_pn28 I1660_P29_28 VDD VSS NOR2_X1
XI1660_I160_XG I1660_pn30 I1660_gn29 I1660_gn30 I1660_G30_29 VDD VSS OAI21_X1
XI1660_I160_XP I1660_pn30 I1660_pn29 I1660_P30_29 VDD VSS NOR2_X1
XI1660_I161_XG I1660_pn31 I1660_gn30 I1660_gn31 I1660_G31_30 VDD VSS OAI21_X1
XI1660_I161_XP I1660_pn31 I1660_pn30 I1660_P31_30 VDD VSS NOR2_X1
XI1660_I162_XG I1660_pn32 I1660_gn31 I1660_gn32 I1660_G32_31 VDD VSS OAI21_X1
XI1660_I162_XP I1660_pn32 I1660_pn31 I1660_P32_31 VDD VSS NOR2_X1
XI1660_I163_XG I1660_pn33 I1660_gn32 I1660_gn33 I1660_G33_32 VDD VSS OAI21_X1
XI1660_I163_XP I1660_pn33 I1660_pn32 I1660_P33_32 VDD VSS NOR2_X1
XI1660_I164_XG I1660_pn34 I1660_gn33 I1660_gn34 I1660_G34_33 VDD VSS OAI21_X1
XI1660_I164_XP I1660_pn34 I1660_pn33 I1660_P34_33 VDD VSS NOR2_X1
XI1660_I165_XG I1660_pn35 I1660_gn34 I1660_gn35 I1660_G35_34 VDD VSS OAI21_X1
XI1660_I165_XP I1660_pn35 I1660_pn34 I1660_P35_34 VDD VSS NOR2_X1
XI1660_I166_XG I1660_pn36 I1660_gn35 I1660_gn36 I1660_G36_35 VDD VSS OAI21_X1
XI1660_I166_XP I1660_pn36 I1660_pn35 I1660_P36_35 VDD VSS NOR2_X1
XI1660_I167_XG I1660_pn37 I1660_gn36 I1660_gn37 I1660_G37_36 VDD VSS OAI21_X1
XI1660_I167_XP I1660_pn37 I1660_pn36 I1660_P37_36 VDD VSS NOR2_X1
XI1660_I168_XG I1660_pn38 I1660_gn37 I1660_gn38 I1660_G38_37 VDD VSS OAI21_X1
XI1660_I168_XP I1660_pn38 I1660_pn37 I1660_P38_37 VDD VSS NOR2_X1
XI1660_I169_XG I1660_pn39 I1660_gn38 I1660_gn39 I1660_G39_38 VDD VSS OAI21_X1
XI1660_I169_XP I1660_pn39 I1660_pn38 I1660_P39_38 VDD VSS NOR2_X1
XI1660_I170_XG I1660_pn40 I1660_gn39 I1660_gn40 I1660_G40_39 VDD VSS OAI21_X1
XI1660_I170_XP I1660_pn40 I1660_pn39 I1660_P40_39 VDD VSS NOR2_X1
XI1660_I171_XG I1660_pn41 I1660_gn40 I1660_gn41 I1660_G41_40 VDD VSS OAI21_X1
XI1660_I171_XP I1660_pn41 I1660_pn40 I1660_P41_40 VDD VSS NOR2_X1
XI1660_I172_XG I1660_pn42 I1660_gn41 I1660_gn42 I1660_G42_41 VDD VSS OAI21_X1
XI1660_I172_XP I1660_pn42 I1660_pn41 I1660_P42_41 VDD VSS NOR2_X1
XI1660_I173_XG I1660_pn43 I1660_gn42 I1660_gn43 I1660_G43_42 VDD VSS OAI21_X1
XI1660_I173_XP I1660_pn43 I1660_pn42 I1660_P43_42 VDD VSS NOR2_X1
XI1660_I174_XG I1660_pn44 I1660_gn43 I1660_gn44 I1660_G44_43 VDD VSS OAI21_X1
XI1660_I174_XP I1660_pn44 I1660_pn43 I1660_P44_43 VDD VSS NOR2_X1
XI1660_I175_XG I1660_pn45 I1660_gn44 I1660_gn45 I1660_G45_44 VDD VSS OAI21_X1
XI1660_I175_XP I1660_pn45 I1660_pn44 I1660_P45_44 VDD VSS NOR2_X1
XI1660_I176_XG I1660_pn46 I1660_gn45 I1660_gn46 I1660_G46_45 VDD VSS OAI21_X1
XI1660_I176_XP I1660_pn46 I1660_pn45 I1660_P46_45 VDD VSS NOR2_X1
XI1660_I177_XG I1660_pn47 I1660_gn46 I1660_gn47 I1660_G47_46 VDD VSS OAI21_X1
XI1660_I177_XP I1660_pn47 I1660_pn46 I1660_P47_46 VDD VSS NOR2_X1
XI1660_I178_XG I1660_pn48 I1660_gn47 I1660_gn48 I1660_G48_47 VDD VSS OAI21_X1
XI1660_I178_XP I1660_pn48 I1660_pn47 I1660_P48_47 VDD VSS NOR2_X1
XI1660_I179_XG I1660_pn49 I1660_gn48 I1660_gn49 I1660_G49_48 VDD VSS OAI21_X1
XI1660_I179_XP I1660_pn49 I1660_pn48 I1660_P49_48 VDD VSS NOR2_X1
XI1660_I180_XG I1660_pn50 I1660_gn49 I1660_gn50 I1660_G50_49 VDD VSS OAI21_X1
XI1660_I180_XP I1660_pn50 I1660_pn49 I1660_P50_49 VDD VSS NOR2_X1
XI1660_I181_XG I1660_pn51 I1660_gn50 I1660_gn51 I1660_G51_50 VDD VSS OAI21_X1
XI1660_I181_XP I1660_pn51 I1660_pn50 I1660_P51_50 VDD VSS NOR2_X1
XI1660_I182_XG I1660_pn52 I1660_gn51 I1660_gn52 I1660_G52_51 VDD VSS OAI21_X1
XI1660_I182_XP I1660_pn52 I1660_pn51 I1660_P52_51 VDD VSS NOR2_X1
XI1660_I183_XG I1660_pn53 I1660_gn52 I1660_gn53 I1660_G53_52 VDD VSS OAI21_X1
XI1660_I183_XP I1660_pn53 I1660_pn52 I1660_P53_52 VDD VSS NOR2_X1
XI1660_I184_XG I1660_pn54 I1660_gn53 I1660_gn54 I1660_G54_53 VDD VSS OAI21_X1
XI1660_I184_XP I1660_pn54 I1660_pn53 I1660_P54_53 VDD VSS NOR2_X1
XI1660_I185_XG I1660_pn55 I1660_gn54 I1660_gn55 I1660_G55_54 VDD VSS OAI21_X1
XI1660_I185_XP I1660_pn55 I1660_pn54 I1660_P55_54 VDD VSS NOR2_X1
XI1660_I186_XG I1660_pn56 I1660_gn55 I1660_gn56 I1660_G56_55 VDD VSS OAI21_X1
XI1660_I186_XP I1660_pn56 I1660_pn55 I1660_P56_55 VDD VSS NOR2_X1
XI1660_I187_XG I1660_pn57 I1660_gn56 I1660_gn57 I1660_G57_56 VDD VSS OAI21_X1
XI1660_I187_XP I1660_pn57 I1660_pn56 I1660_P57_56 VDD VSS NOR2_X1
XI1660_I188_XG I1660_pn58 I1660_gn57 I1660_gn58 I1660_G58_57 VDD VSS OAI21_X1
XI1660_I188_XP I1660_pn58 I1660_pn57 I1660_P58_57 VDD VSS NOR2_X1
XI1660_I189_XG I1660_pn59 I1660_gn58 I1660_gn59 I1660_G59_58 VDD VSS OAI21_X1
XI1660_I189_XP I1660_pn59 I1660_pn58 I1660_P59_58 VDD VSS NOR2_X1
XI1660_I190_XG I1660_pn60 I1660_gn59 I1660_gn60 I1660_G60_59 VDD VSS OAI21_X1
XI1660_I190_XP I1660_pn60 I1660_pn59 I1660_P60_59 VDD VSS NOR2_X1
XI1660_I191_XG I1660_pn61 I1660_gn60 I1660_gn61 I1660_G61_60 VDD VSS OAI21_X1
XI1660_I191_XP I1660_pn61 I1660_pn60 I1660_P61_60 VDD VSS NOR2_X1
XI1660_I192_XG I1660_pn62 I1660_gn61 I1660_gn62 I1660_G62_61 VDD VSS OAI21_X1
XI1660_I192_XP I1660_pn62 I1660_pn61 I1660_P62_61 VDD VSS NOR2_X1
XI1660_I193_XG I1660_pn63 I1660_gn62 I1660_gn63 I1660_G63_62 VDD VSS OAI21_X1
XI1660_I193_XP I1660_pn63 I1660_pn62 I1660_P63_62 VDD VSS NOR2_X1
XI1660_I194_XG I1660_P2_1 I1660_G0_0 I1660_G2_1 I1660_G2_0n VDD VSS AOI21_X1
XI1660_I195_XG I1660_P3_2 I1660_G1_0 I1660_G3_2 I1660_G3_0n VDD VSS AOI21_X1
XI1660_I196_XG I1660_P4_3 I1660_G2_1 I1660_G4_3 I1660_G4_1n VDD VSS AOI21_X1
XI1660_I196_XP I1660_P4_3 I1660_P2_1 I1660_P4_1n VDD VSS NAND2_X1
XI1660_I197_XG I1660_P5_4 I1660_G3_2 I1660_G5_4 I1660_G5_2n VDD VSS AOI21_X1
XI1660_I197_XP I1660_P5_4 I1660_P3_2 I1660_P5_2n VDD VSS NAND2_X1
XI1660_I198_XG I1660_P6_5 I1660_G4_3 I1660_G6_5 I1660_G6_3n VDD VSS AOI21_X1
XI1660_I198_XP I1660_P6_5 I1660_P4_3 I1660_P6_3n VDD VSS NAND2_X1
XI1660_I199_XG I1660_P7_6 I1660_G5_4 I1660_G7_6 I1660_G7_4n VDD VSS AOI21_X1
XI1660_I199_XP I1660_P7_6 I1660_P5_4 I1660_P7_4n VDD VSS NAND2_X1
XI1660_I200_XG I1660_P8_7 I1660_G6_5 I1660_G8_7 I1660_G8_5n VDD VSS AOI21_X1
XI1660_I200_XP I1660_P8_7 I1660_P6_5 I1660_P8_5n VDD VSS NAND2_X1
XI1660_I201_XG I1660_P9_8 I1660_G7_6 I1660_G9_8 I1660_G9_6n VDD VSS AOI21_X1
XI1660_I201_XP I1660_P9_8 I1660_P7_6 I1660_P9_6n VDD VSS NAND2_X1
XI1660_I202_XG I1660_P10_9 I1660_G8_7 I1660_G10_9 I1660_G10_7n VDD VSS AOI21_X1
XI1660_I202_XP I1660_P10_9 I1660_P8_7 I1660_P10_7n VDD VSS NAND2_X1
XI1660_I203_XG I1660_P11_10 I1660_G9_8 I1660_G11_10 I1660_G11_8n VDD VSS AOI21_X1
XI1660_I203_XP I1660_P11_10 I1660_P9_8 I1660_P11_8n VDD VSS NAND2_X1
XI1660_I204_XG I1660_P12_11 I1660_G10_9 I1660_G12_11 I1660_G12_9n VDD VSS AOI21_X1
XI1660_I204_XP I1660_P12_11 I1660_P10_9 I1660_P12_9n VDD VSS NAND2_X1
XI1660_I205_XG I1660_P13_12 I1660_G11_10 I1660_G13_12 I1660_G13_10n VDD VSS AOI21_X1
XI1660_I205_XP I1660_P13_12 I1660_P11_10 I1660_P13_10n VDD VSS NAND2_X1
XI1660_I206_XG I1660_P14_13 I1660_G12_11 I1660_G14_13 I1660_G14_11n VDD VSS AOI21_X1
XI1660_I206_XP I1660_P14_13 I1660_P12_11 I1660_P14_11n VDD VSS NAND2_X1
XI1660_I207_XG I1660_P15_14 I1660_G13_12 I1660_G15_14 I1660_G15_12n VDD VSS AOI21_X1
XI1660_I207_XP I1660_P15_14 I1660_P13_12 I1660_P15_12n VDD VSS NAND2_X1
XI1660_I208_XG I1660_P16_15 I1660_G14_13 I1660_G16_15 I1660_G16_13n VDD VSS AOI21_X1
XI1660_I208_XP I1660_P16_15 I1660_P14_13 I1660_P16_13n VDD VSS NAND2_X1
XI1660_I209_XG I1660_P17_16 I1660_G15_14 I1660_G17_16 I1660_G17_14n VDD VSS AOI21_X1
XI1660_I209_XP I1660_P17_16 I1660_P15_14 I1660_P17_14n VDD VSS NAND2_X1
XI1660_I210_XG I1660_P18_17 I1660_G16_15 I1660_G18_17 I1660_G18_15n VDD VSS AOI21_X1
XI1660_I210_XP I1660_P18_17 I1660_P16_15 I1660_P18_15n VDD VSS NAND2_X1
XI1660_I211_XG I1660_P19_18 I1660_G17_16 I1660_G19_18 I1660_G19_16n VDD VSS AOI21_X1
XI1660_I211_XP I1660_P19_18 I1660_P17_16 I1660_P19_16n VDD VSS NAND2_X1
XI1660_I212_XG I1660_P20_19 I1660_G18_17 I1660_G20_19 I1660_G20_17n VDD VSS AOI21_X1
XI1660_I212_XP I1660_P20_19 I1660_P18_17 I1660_P20_17n VDD VSS NAND2_X1
XI1660_I213_XG I1660_P21_20 I1660_G19_18 I1660_G21_20 I1660_G21_18n VDD VSS AOI21_X1
XI1660_I213_XP I1660_P21_20 I1660_P19_18 I1660_P21_18n VDD VSS NAND2_X1
XI1660_I214_XG I1660_P22_21 I1660_G20_19 I1660_G22_21 I1660_G22_19n VDD VSS AOI21_X1
XI1660_I214_XP I1660_P22_21 I1660_P20_19 I1660_P22_19n VDD VSS NAND2_X1
XI1660_I215_XG I1660_P23_22 I1660_G21_20 I1660_G23_22 I1660_G23_20n VDD VSS AOI21_X1
XI1660_I215_XP I1660_P23_22 I1660_P21_20 I1660_P23_20n VDD VSS NAND2_X1
XI1660_I216_XG I1660_P24_23 I1660_G22_21 I1660_G24_23 I1660_G24_21n VDD VSS AOI21_X1
XI1660_I216_XP I1660_P24_23 I1660_P22_21 I1660_P24_21n VDD VSS NAND2_X1
XI1660_I217_XG I1660_P25_24 I1660_G23_22 I1660_G25_24 I1660_G25_22n VDD VSS AOI21_X1
XI1660_I217_XP I1660_P25_24 I1660_P23_22 I1660_P25_22n VDD VSS NAND2_X1
XI1660_I218_XG I1660_P26_25 I1660_G24_23 I1660_G26_25 I1660_G26_23n VDD VSS AOI21_X1
XI1660_I218_XP I1660_P26_25 I1660_P24_23 I1660_P26_23n VDD VSS NAND2_X1
XI1660_I219_XG I1660_P27_26 I1660_G25_24 I1660_G27_26 I1660_G27_24n VDD VSS AOI21_X1
XI1660_I219_XP I1660_P27_26 I1660_P25_24 I1660_P27_24n VDD VSS NAND2_X1
XI1660_I220_XG I1660_P28_27 I1660_G26_25 I1660_G28_27 I1660_G28_25n VDD VSS AOI21_X1
XI1660_I220_XP I1660_P28_27 I1660_P26_25 I1660_P28_25n VDD VSS NAND2_X1
XI1660_I221_XG I1660_P29_28 I1660_G27_26 I1660_G29_28 I1660_G29_26n VDD VSS AOI21_X1
XI1660_I221_XP I1660_P29_28 I1660_P27_26 I1660_P29_26n VDD VSS NAND2_X1
XI1660_I222_XG I1660_P30_29 I1660_G28_27 I1660_G30_29 I1660_G30_27n VDD VSS AOI21_X1
XI1660_I222_XP I1660_P30_29 I1660_P28_27 I1660_P30_27n VDD VSS NAND2_X1
XI1660_I223_XG I1660_P31_30 I1660_G29_28 I1660_G31_30 I1660_G31_28n VDD VSS AOI21_X1
XI1660_I223_XP I1660_P31_30 I1660_P29_28 I1660_P31_28n VDD VSS NAND2_X1
XI1660_I224_XG I1660_P32_31 I1660_G30_29 I1660_G32_31 I1660_G32_29n VDD VSS AOI21_X1
XI1660_I224_XP I1660_P32_31 I1660_P30_29 I1660_P32_29n VDD VSS NAND2_X1
XI1660_I225_XG I1660_P33_32 I1660_G31_30 I1660_G33_32 I1660_G33_30n VDD VSS AOI21_X1
XI1660_I225_XP I1660_P33_32 I1660_P31_30 I1660_P33_30n VDD VSS NAND2_X1
XI1660_I226_XG I1660_P34_33 I1660_G32_31 I1660_G34_33 I1660_G34_31n VDD VSS AOI21_X1
XI1660_I226_XP I1660_P34_33 I1660_P32_31 I1660_P34_31n VDD VSS NAND2_X1
XI1660_I227_XG I1660_P35_34 I1660_G33_32 I1660_G35_34 I1660_G35_32n VDD VSS AOI21_X1
XI1660_I227_XP I1660_P35_34 I1660_P33_32 I1660_P35_32n VDD VSS NAND2_X1
XI1660_I228_XG I1660_P36_35 I1660_G34_33 I1660_G36_35 I1660_G36_33n VDD VSS AOI21_X1
XI1660_I228_XP I1660_P36_35 I1660_P34_33 I1660_P36_33n VDD VSS NAND2_X1
XI1660_I229_XG I1660_P37_36 I1660_G35_34 I1660_G37_36 I1660_G37_34n VDD VSS AOI21_X1
XI1660_I229_XP I1660_P37_36 I1660_P35_34 I1660_P37_34n VDD VSS NAND2_X1
XI1660_I230_XG I1660_P38_37 I1660_G36_35 I1660_G38_37 I1660_G38_35n VDD VSS AOI21_X1
XI1660_I230_XP I1660_P38_37 I1660_P36_35 I1660_P38_35n VDD VSS NAND2_X1
XI1660_I231_XG I1660_P39_38 I1660_G37_36 I1660_G39_38 I1660_G39_36n VDD VSS AOI21_X1
XI1660_I231_XP I1660_P39_38 I1660_P37_36 I1660_P39_36n VDD VSS NAND2_X1
XI1660_I232_XG I1660_P40_39 I1660_G38_37 I1660_G40_39 I1660_G40_37n VDD VSS AOI21_X1
XI1660_I232_XP I1660_P40_39 I1660_P38_37 I1660_P40_37n VDD VSS NAND2_X1
XI1660_I233_XG I1660_P41_40 I1660_G39_38 I1660_G41_40 I1660_G41_38n VDD VSS AOI21_X1
XI1660_I233_XP I1660_P41_40 I1660_P39_38 I1660_P41_38n VDD VSS NAND2_X1
XI1660_I234_XG I1660_P42_41 I1660_G40_39 I1660_G42_41 I1660_G42_39n VDD VSS AOI21_X1
XI1660_I234_XP I1660_P42_41 I1660_P40_39 I1660_P42_39n VDD VSS NAND2_X1
XI1660_I235_XG I1660_P43_42 I1660_G41_40 I1660_G43_42 I1660_G43_40n VDD VSS AOI21_X1
XI1660_I235_XP I1660_P43_42 I1660_P41_40 I1660_P43_40n VDD VSS NAND2_X1
XI1660_I236_XG I1660_P44_43 I1660_G42_41 I1660_G44_43 I1660_G44_41n VDD VSS AOI21_X1
XI1660_I236_XP I1660_P44_43 I1660_P42_41 I1660_P44_41n VDD VSS NAND2_X1
XI1660_I237_XG I1660_P45_44 I1660_G43_42 I1660_G45_44 I1660_G45_42n VDD VSS AOI21_X1
XI1660_I237_XP I1660_P45_44 I1660_P43_42 I1660_P45_42n VDD VSS NAND2_X1
XI1660_I238_XG I1660_P46_45 I1660_G44_43 I1660_G46_45 I1660_G46_43n VDD VSS AOI21_X1
XI1660_I238_XP I1660_P46_45 I1660_P44_43 I1660_P46_43n VDD VSS NAND2_X1
XI1660_I239_XG I1660_P47_46 I1660_G45_44 I1660_G47_46 I1660_G47_44n VDD VSS AOI21_X1
XI1660_I239_XP I1660_P47_46 I1660_P45_44 I1660_P47_44n VDD VSS NAND2_X1
XI1660_I240_XG I1660_P48_47 I1660_G46_45 I1660_G48_47 I1660_G48_45n VDD VSS AOI21_X1
XI1660_I240_XP I1660_P48_47 I1660_P46_45 I1660_P48_45n VDD VSS NAND2_X1
XI1660_I241_XG I1660_P49_48 I1660_G47_46 I1660_G49_48 I1660_G49_46n VDD VSS AOI21_X1
XI1660_I241_XP I1660_P49_48 I1660_P47_46 I1660_P49_46n VDD VSS NAND2_X1
XI1660_I242_XG I1660_P50_49 I1660_G48_47 I1660_G50_49 I1660_G50_47n VDD VSS AOI21_X1
XI1660_I242_XP I1660_P50_49 I1660_P48_47 I1660_P50_47n VDD VSS NAND2_X1
XI1660_I243_XG I1660_P51_50 I1660_G49_48 I1660_G51_50 I1660_G51_48n VDD VSS AOI21_X1
XI1660_I243_XP I1660_P51_50 I1660_P49_48 I1660_P51_48n VDD VSS NAND2_X1
XI1660_I244_XG I1660_P52_51 I1660_G50_49 I1660_G52_51 I1660_G52_49n VDD VSS AOI21_X1
XI1660_I244_XP I1660_P52_51 I1660_P50_49 I1660_P52_49n VDD VSS NAND2_X1
XI1660_I245_XG I1660_P53_52 I1660_G51_50 I1660_G53_52 I1660_G53_50n VDD VSS AOI21_X1
XI1660_I245_XP I1660_P53_52 I1660_P51_50 I1660_P53_50n VDD VSS NAND2_X1
XI1660_I246_XG I1660_P54_53 I1660_G52_51 I1660_G54_53 I1660_G54_51n VDD VSS AOI21_X1
XI1660_I246_XP I1660_P54_53 I1660_P52_51 I1660_P54_51n VDD VSS NAND2_X1
XI1660_I247_XG I1660_P55_54 I1660_G53_52 I1660_G55_54 I1660_G55_52n VDD VSS AOI21_X1
XI1660_I247_XP I1660_P55_54 I1660_P53_52 I1660_P55_52n VDD VSS NAND2_X1
XI1660_I248_XG I1660_P56_55 I1660_G54_53 I1660_G56_55 I1660_G56_53n VDD VSS AOI21_X1
XI1660_I248_XP I1660_P56_55 I1660_P54_53 I1660_P56_53n VDD VSS NAND2_X1
XI1660_I249_XG I1660_P57_56 I1660_G55_54 I1660_G57_56 I1660_G57_54n VDD VSS AOI21_X1
XI1660_I249_XP I1660_P57_56 I1660_P55_54 I1660_P57_54n VDD VSS NAND2_X1
XI1660_I250_XG I1660_P58_57 I1660_G56_55 I1660_G58_57 I1660_G58_55n VDD VSS AOI21_X1
XI1660_I250_XP I1660_P58_57 I1660_P56_55 I1660_P58_55n VDD VSS NAND2_X1
XI1660_I251_XG I1660_P59_58 I1660_G57_56 I1660_G59_58 I1660_G59_56n VDD VSS AOI21_X1
XI1660_I251_XP I1660_P59_58 I1660_P57_56 I1660_P59_56n VDD VSS NAND2_X1
XI1660_I252_XG I1660_P60_59 I1660_G58_57 I1660_G60_59 I1660_G60_57n VDD VSS AOI21_X1
XI1660_I252_XP I1660_P60_59 I1660_P58_57 I1660_P60_57n VDD VSS NAND2_X1
XI1660_I253_XG I1660_P61_60 I1660_G59_58 I1660_G61_60 I1660_G61_58n VDD VSS AOI21_X1
XI1660_I253_XP I1660_P61_60 I1660_P59_58 I1660_P61_58n VDD VSS NAND2_X1
XI1660_I254_XG I1660_P62_61 I1660_G60_59 I1660_G62_61 I1660_G62_59n VDD VSS AOI21_X1
XI1660_I254_XP I1660_P62_61 I1660_P60_59 I1660_P62_59n VDD VSS NAND2_X1
XI1660_I255_XG I1660_P63_62 I1660_G61_60 I1660_G63_62 I1660_G63_60n VDD VSS AOI21_X1
XI1660_I255_XP I1660_P63_62 I1660_P61_60 I1660_P63_60n VDD VSS NAND2_X1
XI1660_I256_XG I1660_P4_1n I1660_G0_0n I1660_G4_1n I1660_G4_0 VDD VSS OAI21_X1
XI1660_I257 I1660_G1_0 I1660_G1_0n VDD VSS INV_X1
XI1660_I258_XG I1660_P5_2n I1660_G1_0n I1660_G5_2n I1660_G5_0 VDD VSS OAI21_X1
XI1660_I259_XG I1660_P6_3n I1660_G2_0n I1660_G6_3n I1660_G6_0 VDD VSS OAI21_X1
XI1660_I260_XG I1660_P7_4n I1660_G3_0n I1660_G7_4n I1660_G7_0 VDD VSS OAI21_X1
XI1660_I261_XG I1660_P8_5n I1660_G4_1n I1660_G8_5n I1660_G8_1 VDD VSS OAI21_X1
XI1660_I261_XP I1660_P8_5n I1660_P4_1n I1660_P8_1 VDD VSS NOR2_X1
XI1660_I262_XG I1660_P9_6n I1660_G5_2n I1660_G9_6n I1660_G9_2 VDD VSS OAI21_X1
XI1660_I262_XP I1660_P9_6n I1660_P5_2n I1660_P9_2 VDD VSS NOR2_X1
XI1660_I263_XG I1660_P10_7n I1660_G6_3n I1660_G10_7n I1660_G10_3 VDD VSS OAI21_X1
XI1660_I263_XP I1660_P10_7n I1660_P6_3n I1660_P10_3 VDD VSS NOR2_X1
XI1660_I264_XG I1660_P11_8n I1660_G7_4n I1660_G11_8n I1660_G11_4 VDD VSS OAI21_X1
XI1660_I264_XP I1660_P11_8n I1660_P7_4n I1660_P11_4 VDD VSS NOR2_X1
XI1660_I265_XG I1660_P12_9n I1660_G8_5n I1660_G12_9n I1660_G12_5 VDD VSS OAI21_X1
XI1660_I265_XP I1660_P12_9n I1660_P8_5n I1660_P12_5 VDD VSS NOR2_X1
XI1660_I266_XG I1660_P13_10n I1660_G9_6n I1660_G13_10n I1660_G13_6 VDD VSS OAI21_X1
XI1660_I266_XP I1660_P13_10n I1660_P9_6n I1660_P13_6 VDD VSS NOR2_X1
XI1660_I267_XG I1660_P14_11n I1660_G10_7n I1660_G14_11n I1660_G14_7 VDD VSS OAI21_X1
XI1660_I267_XP I1660_P14_11n I1660_P10_7n I1660_P14_7 VDD VSS NOR2_X1
XI1660_I268_XG I1660_P15_12n I1660_G11_8n I1660_G15_12n I1660_G15_8 VDD VSS OAI21_X1
XI1660_I268_XP I1660_P15_12n I1660_P11_8n I1660_P15_8 VDD VSS NOR2_X1
XI1660_I269_XG I1660_P16_13n I1660_G12_9n I1660_G16_13n I1660_G16_9 VDD VSS OAI21_X1
XI1660_I269_XP I1660_P16_13n I1660_P12_9n I1660_P16_9 VDD VSS NOR2_X1
XI1660_I270_XG I1660_P17_14n I1660_G13_10n I1660_G17_14n I1660_G17_10 VDD VSS OAI21_X1
XI1660_I270_XP I1660_P17_14n I1660_P13_10n I1660_P17_10 VDD VSS NOR2_X1
XI1660_I271_XG I1660_P18_15n I1660_G14_11n I1660_G18_15n I1660_G18_11 VDD VSS OAI21_X1
XI1660_I271_XP I1660_P18_15n I1660_P14_11n I1660_P18_11 VDD VSS NOR2_X1
XI1660_I272_XG I1660_P19_16n I1660_G15_12n I1660_G19_16n I1660_G19_12 VDD VSS OAI21_X1
XI1660_I272_XP I1660_P19_16n I1660_P15_12n I1660_P19_12 VDD VSS NOR2_X1
XI1660_I273_XG I1660_P20_17n I1660_G16_13n I1660_G20_17n I1660_G20_13 VDD VSS OAI21_X1
XI1660_I273_XP I1660_P20_17n I1660_P16_13n I1660_P20_13 VDD VSS NOR2_X1
XI1660_I274_XG I1660_P21_18n I1660_G17_14n I1660_G21_18n I1660_G21_14 VDD VSS OAI21_X1
XI1660_I274_XP I1660_P21_18n I1660_P17_14n I1660_P21_14 VDD VSS NOR2_X1
XI1660_I275_XG I1660_P22_19n I1660_G18_15n I1660_G22_19n I1660_G22_15 VDD VSS OAI21_X1
XI1660_I275_XP I1660_P22_19n I1660_P18_15n I1660_P22_15 VDD VSS NOR2_X1
XI1660_I276_XG I1660_P23_20n I1660_G19_16n I1660_G23_20n I1660_G23_16 VDD VSS OAI21_X1
XI1660_I276_XP I1660_P23_20n I1660_P19_16n I1660_P23_16 VDD VSS NOR2_X1
XI1660_I277_XG I1660_P24_21n I1660_G20_17n I1660_G24_21n I1660_G24_17 VDD VSS OAI21_X1
XI1660_I277_XP I1660_P24_21n I1660_P20_17n I1660_P24_17 VDD VSS NOR2_X1
XI1660_I278_XG I1660_P25_22n I1660_G21_18n I1660_G25_22n I1660_G25_18 VDD VSS OAI21_X1
XI1660_I278_XP I1660_P25_22n I1660_P21_18n I1660_P25_18 VDD VSS NOR2_X1
XI1660_I279_XG I1660_P26_23n I1660_G22_19n I1660_G26_23n I1660_G26_19 VDD VSS OAI21_X1
XI1660_I279_XP I1660_P26_23n I1660_P22_19n I1660_P26_19 VDD VSS NOR2_X1
XI1660_I280_XG I1660_P27_24n I1660_G23_20n I1660_G27_24n I1660_G27_20 VDD VSS OAI21_X1
XI1660_I280_XP I1660_P27_24n I1660_P23_20n I1660_P27_20 VDD VSS NOR2_X1
XI1660_I281_XG I1660_P28_25n I1660_G24_21n I1660_G28_25n I1660_G28_21 VDD VSS OAI21_X1
XI1660_I281_XP I1660_P28_25n I1660_P24_21n I1660_P28_21 VDD VSS NOR2_X1
XI1660_I282_XG I1660_P29_26n I1660_G25_22n I1660_G29_26n I1660_G29_22 VDD VSS OAI21_X1
XI1660_I282_XP I1660_P29_26n I1660_P25_22n I1660_P29_22 VDD VSS NOR2_X1
XI1660_I283_XG I1660_P30_27n I1660_G26_23n I1660_G30_27n I1660_G30_23 VDD VSS OAI21_X1
XI1660_I283_XP I1660_P30_27n I1660_P26_23n I1660_P30_23 VDD VSS NOR2_X1
XI1660_I284_XG I1660_P31_28n I1660_G27_24n I1660_G31_28n I1660_G31_24 VDD VSS OAI21_X1
XI1660_I284_XP I1660_P31_28n I1660_P27_24n I1660_P31_24 VDD VSS NOR2_X1
XI1660_I285_XG I1660_P32_29n I1660_G28_25n I1660_G32_29n I1660_G32_25 VDD VSS OAI21_X1
XI1660_I285_XP I1660_P32_29n I1660_P28_25n I1660_P32_25 VDD VSS NOR2_X1
XI1660_I286_XG I1660_P33_30n I1660_G29_26n I1660_G33_30n I1660_G33_26 VDD VSS OAI21_X1
XI1660_I286_XP I1660_P33_30n I1660_P29_26n I1660_P33_26 VDD VSS NOR2_X1
XI1660_I287_XG I1660_P34_31n I1660_G30_27n I1660_G34_31n I1660_G34_27 VDD VSS OAI21_X1
XI1660_I287_XP I1660_P34_31n I1660_P30_27n I1660_P34_27 VDD VSS NOR2_X1
XI1660_I288_XG I1660_P35_32n I1660_G31_28n I1660_G35_32n I1660_G35_28 VDD VSS OAI21_X1
XI1660_I288_XP I1660_P35_32n I1660_P31_28n I1660_P35_28 VDD VSS NOR2_X1
XI1660_I289_XG I1660_P36_33n I1660_G32_29n I1660_G36_33n I1660_G36_29 VDD VSS OAI21_X1
XI1660_I289_XP I1660_P36_33n I1660_P32_29n I1660_P36_29 VDD VSS NOR2_X1
XI1660_I290_XG I1660_P37_34n I1660_G33_30n I1660_G37_34n I1660_G37_30 VDD VSS OAI21_X1
XI1660_I290_XP I1660_P37_34n I1660_P33_30n I1660_P37_30 VDD VSS NOR2_X1
XI1660_I291_XG I1660_P38_35n I1660_G34_31n I1660_G38_35n I1660_G38_31 VDD VSS OAI21_X1
XI1660_I291_XP I1660_P38_35n I1660_P34_31n I1660_P38_31 VDD VSS NOR2_X1
XI1660_I292_XG I1660_P39_36n I1660_G35_32n I1660_G39_36n I1660_G39_32 VDD VSS OAI21_X1
XI1660_I292_XP I1660_P39_36n I1660_P35_32n I1660_P39_32 VDD VSS NOR2_X1
XI1660_I293_XG I1660_P40_37n I1660_G36_33n I1660_G40_37n I1660_G40_33 VDD VSS OAI21_X1
XI1660_I293_XP I1660_P40_37n I1660_P36_33n I1660_P40_33 VDD VSS NOR2_X1
XI1660_I294_XG I1660_P41_38n I1660_G37_34n I1660_G41_38n I1660_G41_34 VDD VSS OAI21_X1
XI1660_I294_XP I1660_P41_38n I1660_P37_34n I1660_P41_34 VDD VSS NOR2_X1
XI1660_I295_XG I1660_P42_39n I1660_G38_35n I1660_G42_39n I1660_G42_35 VDD VSS OAI21_X1
XI1660_I295_XP I1660_P42_39n I1660_P38_35n I1660_P42_35 VDD VSS NOR2_X1
XI1660_I296_XG I1660_P43_40n I1660_G39_36n I1660_G43_40n I1660_G43_36 VDD VSS OAI21_X1
XI1660_I296_XP I1660_P43_40n I1660_P39_36n I1660_P43_36 VDD VSS NOR2_X1
XI1660_I297_XG I1660_P44_41n I1660_G40_37n I1660_G44_41n I1660_G44_37 VDD VSS OAI21_X1
XI1660_I297_XP I1660_P44_41n I1660_P40_37n I1660_P44_37 VDD VSS NOR2_X1
XI1660_I298_XG I1660_P45_42n I1660_G41_38n I1660_G45_42n I1660_G45_38 VDD VSS OAI21_X1
XI1660_I298_XP I1660_P45_42n I1660_P41_38n I1660_P45_38 VDD VSS NOR2_X1
XI1660_I299_XG I1660_P46_43n I1660_G42_39n I1660_G46_43n I1660_G46_39 VDD VSS OAI21_X1
XI1660_I299_XP I1660_P46_43n I1660_P42_39n I1660_P46_39 VDD VSS NOR2_X1
XI1660_I300_XG I1660_P47_44n I1660_G43_40n I1660_G47_44n I1660_G47_40 VDD VSS OAI21_X1
XI1660_I300_XP I1660_P47_44n I1660_P43_40n I1660_P47_40 VDD VSS NOR2_X1
XI1660_I301_XG I1660_P48_45n I1660_G44_41n I1660_G48_45n I1660_G48_41 VDD VSS OAI21_X1
XI1660_I301_XP I1660_P48_45n I1660_P44_41n I1660_P48_41 VDD VSS NOR2_X1
XI1660_I302_XG I1660_P49_46n I1660_G45_42n I1660_G49_46n I1660_G49_42 VDD VSS OAI21_X1
XI1660_I302_XP I1660_P49_46n I1660_P45_42n I1660_P49_42 VDD VSS NOR2_X1
XI1660_I303_XG I1660_P50_47n I1660_G46_43n I1660_G50_47n I1660_G50_43 VDD VSS OAI21_X1
XI1660_I303_XP I1660_P50_47n I1660_P46_43n I1660_P50_43 VDD VSS NOR2_X1
XI1660_I304_XG I1660_P51_48n I1660_G47_44n I1660_G51_48n I1660_G51_44 VDD VSS OAI21_X1
XI1660_I304_XP I1660_P51_48n I1660_P47_44n I1660_P51_44 VDD VSS NOR2_X1
XI1660_I305_XG I1660_P52_49n I1660_G48_45n I1660_G52_49n I1660_G52_45 VDD VSS OAI21_X1
XI1660_I305_XP I1660_P52_49n I1660_P48_45n I1660_P52_45 VDD VSS NOR2_X1
XI1660_I306_XG I1660_P53_50n I1660_G49_46n I1660_G53_50n I1660_G53_46 VDD VSS OAI21_X1
XI1660_I306_XP I1660_P53_50n I1660_P49_46n I1660_P53_46 VDD VSS NOR2_X1
XI1660_I307_XG I1660_P54_51n I1660_G50_47n I1660_G54_51n I1660_G54_47 VDD VSS OAI21_X1
XI1660_I307_XP I1660_P54_51n I1660_P50_47n I1660_P54_47 VDD VSS NOR2_X1
XI1660_I308_XG I1660_P55_52n I1660_G51_48n I1660_G55_52n I1660_G55_48 VDD VSS OAI21_X1
XI1660_I308_XP I1660_P55_52n I1660_P51_48n I1660_P55_48 VDD VSS NOR2_X1
XI1660_I309_XG I1660_P56_53n I1660_G52_49n I1660_G56_53n I1660_G56_49 VDD VSS OAI21_X1
XI1660_I309_XP I1660_P56_53n I1660_P52_49n I1660_P56_49 VDD VSS NOR2_X1
XI1660_I310_XG I1660_P57_54n I1660_G53_50n I1660_G57_54n I1660_G57_50 VDD VSS OAI21_X1
XI1660_I310_XP I1660_P57_54n I1660_P53_50n I1660_P57_50 VDD VSS NOR2_X1
XI1660_I311_XG I1660_P58_55n I1660_G54_51n I1660_G58_55n I1660_G58_51 VDD VSS OAI21_X1
XI1660_I311_XP I1660_P58_55n I1660_P54_51n I1660_P58_51 VDD VSS NOR2_X1
XI1660_I312_XG I1660_P59_56n I1660_G55_52n I1660_G59_56n I1660_G59_52 VDD VSS OAI21_X1
XI1660_I312_XP I1660_P59_56n I1660_P55_52n I1660_P59_52 VDD VSS NOR2_X1
XI1660_I313_XG I1660_P60_57n I1660_G56_53n I1660_G60_57n I1660_G60_53 VDD VSS OAI21_X1
XI1660_I313_XP I1660_P60_57n I1660_P56_53n I1660_P60_53 VDD VSS NOR2_X1
XI1660_I314_XG I1660_P61_58n I1660_G57_54n I1660_G61_58n I1660_G61_54 VDD VSS OAI21_X1
XI1660_I314_XP I1660_P61_58n I1660_P57_54n I1660_P61_54 VDD VSS NOR2_X1
XI1660_I315_XG I1660_P62_59n I1660_G58_55n I1660_G62_59n I1660_G62_55 VDD VSS OAI21_X1
XI1660_I315_XP I1660_P62_59n I1660_P58_55n I1660_P62_55 VDD VSS NOR2_X1
XI1660_I316_XG I1660_P63_60n I1660_G59_56n I1660_G63_60n I1660_G63_56 VDD VSS OAI21_X1
XI1660_I316_XP I1660_P63_60n I1660_P59_56n I1660_P63_56 VDD VSS NOR2_X1
XI1660_I317_XG I1660_P8_1 I1660_G0_0 I1660_G8_1 I1660_G8_0n VDD VSS AOI21_X1
XI1660_I318_XG I1660_P9_2 I1660_G1_0 I1660_G9_2 I1660_G9_0n VDD VSS AOI21_X1
XI1660_I319 I1660_G2_0n I1660_G2_0np VDD VSS INV_X1
XI1660_I320_XG I1660_P10_3 I1660_G2_0np I1660_G10_3 I1660_G10_0n VDD VSS AOI21_X1
XI1660_I321 I1660_G3_0n I1660_G3_0np VDD VSS INV_X1
XI1660_I322_XG I1660_P11_4 I1660_G3_0np I1660_G11_4 I1660_G11_0n VDD VSS AOI21_X1
XI1660_I323_XG I1660_P12_5 I1660_G4_0 I1660_G12_5 I1660_G12_0n VDD VSS AOI21_X1
XI1660_I324_XG I1660_P13_6 I1660_G5_0 I1660_G13_6 I1660_G13_0n VDD VSS AOI21_X1
XI1660_I325_XG I1660_P14_7 I1660_G6_0 I1660_G14_7 I1660_G14_0n VDD VSS AOI21_X1
XI1660_I326_XG I1660_P15_8 I1660_G7_0 I1660_G15_8 I1660_G15_0n VDD VSS AOI21_X1
XI1660_I327_XG I1660_P16_9 I1660_G8_1 I1660_G16_9 I1660_G16_1n VDD VSS AOI21_X1
XI1660_I327_XP I1660_P16_9 I1660_P8_1 I1660_P16_1n VDD VSS NAND2_X1
XI1660_I328_XG I1660_P17_10 I1660_G9_2 I1660_G17_10 I1660_G17_2n VDD VSS AOI21_X1
XI1660_I328_XP I1660_P17_10 I1660_P9_2 I1660_P17_2n VDD VSS NAND2_X1
XI1660_I329_XG I1660_P18_11 I1660_G10_3 I1660_G18_11 I1660_G18_3n VDD VSS AOI21_X1
XI1660_I329_XP I1660_P18_11 I1660_P10_3 I1660_P18_3n VDD VSS NAND2_X1
XI1660_I330_XG I1660_P19_12 I1660_G11_4 I1660_G19_12 I1660_G19_4n VDD VSS AOI21_X1
XI1660_I330_XP I1660_P19_12 I1660_P11_4 I1660_P19_4n VDD VSS NAND2_X1
XI1660_I331_XG I1660_P20_13 I1660_G12_5 I1660_G20_13 I1660_G20_5n VDD VSS AOI21_X1
XI1660_I331_XP I1660_P20_13 I1660_P12_5 I1660_P20_5n VDD VSS NAND2_X1
XI1660_I332_XG I1660_P21_14 I1660_G13_6 I1660_G21_14 I1660_G21_6n VDD VSS AOI21_X1
XI1660_I332_XP I1660_P21_14 I1660_P13_6 I1660_P21_6n VDD VSS NAND2_X1
XI1660_I333_XG I1660_P22_15 I1660_G14_7 I1660_G22_15 I1660_G22_7n VDD VSS AOI21_X1
XI1660_I333_XP I1660_P22_15 I1660_P14_7 I1660_P22_7n VDD VSS NAND2_X1
XI1660_I334_XG I1660_P23_16 I1660_G15_8 I1660_G23_16 I1660_G23_8n VDD VSS AOI21_X1
XI1660_I334_XP I1660_P23_16 I1660_P15_8 I1660_P23_8n VDD VSS NAND2_X1
XI1660_I335_XG I1660_P24_17 I1660_G16_9 I1660_G24_17 I1660_G24_9n VDD VSS AOI21_X1
XI1660_I335_XP I1660_P24_17 I1660_P16_9 I1660_P24_9n VDD VSS NAND2_X1
XI1660_I336_XG I1660_P25_18 I1660_G17_10 I1660_G25_18 I1660_G25_10n VDD VSS AOI21_X1
XI1660_I336_XP I1660_P25_18 I1660_P17_10 I1660_P25_10n VDD VSS NAND2_X1
XI1660_I337_XG I1660_P26_19 I1660_G18_11 I1660_G26_19 I1660_G26_11n VDD VSS AOI21_X1
XI1660_I337_XP I1660_P26_19 I1660_P18_11 I1660_P26_11n VDD VSS NAND2_X1
XI1660_I338_XG I1660_P27_20 I1660_G19_12 I1660_G27_20 I1660_G27_12n VDD VSS AOI21_X1
XI1660_I338_XP I1660_P27_20 I1660_P19_12 I1660_P27_12n VDD VSS NAND2_X1
XI1660_I339_XG I1660_P28_21 I1660_G20_13 I1660_G28_21 I1660_G28_13n VDD VSS AOI21_X1
XI1660_I339_XP I1660_P28_21 I1660_P20_13 I1660_P28_13n VDD VSS NAND2_X1
XI1660_I340_XG I1660_P29_22 I1660_G21_14 I1660_G29_22 I1660_G29_14n VDD VSS AOI21_X1
XI1660_I340_XP I1660_P29_22 I1660_P21_14 I1660_P29_14n VDD VSS NAND2_X1
XI1660_I341_XG I1660_P30_23 I1660_G22_15 I1660_G30_23 I1660_G30_15n VDD VSS AOI21_X1
XI1660_I341_XP I1660_P30_23 I1660_P22_15 I1660_P30_15n VDD VSS NAND2_X1
XI1660_I342_XG I1660_P31_24 I1660_G23_16 I1660_G31_24 I1660_G31_16n VDD VSS AOI21_X1
XI1660_I342_XP I1660_P31_24 I1660_P23_16 I1660_P31_16n VDD VSS NAND2_X1
XI1660_I343_XG I1660_P32_25 I1660_G24_17 I1660_G32_25 I1660_G32_17n VDD VSS AOI21_X1
XI1660_I343_XP I1660_P32_25 I1660_P24_17 I1660_P32_17n VDD VSS NAND2_X1
XI1660_I344_XG I1660_P33_26 I1660_G25_18 I1660_G33_26 I1660_G33_18n VDD VSS AOI21_X1
XI1660_I344_XP I1660_P33_26 I1660_P25_18 I1660_P33_18n VDD VSS NAND2_X1
XI1660_I345_XG I1660_P34_27 I1660_G26_19 I1660_G34_27 I1660_G34_19n VDD VSS AOI21_X1
XI1660_I345_XP I1660_P34_27 I1660_P26_19 I1660_P34_19n VDD VSS NAND2_X1
XI1660_I346_XG I1660_P35_28 I1660_G27_20 I1660_G35_28 I1660_G35_20n VDD VSS AOI21_X1
XI1660_I346_XP I1660_P35_28 I1660_P27_20 I1660_P35_20n VDD VSS NAND2_X1
XI1660_I347_XG I1660_P36_29 I1660_G28_21 I1660_G36_29 I1660_G36_21n VDD VSS AOI21_X1
XI1660_I347_XP I1660_P36_29 I1660_P28_21 I1660_P36_21n VDD VSS NAND2_X1
XI1660_I348_XG I1660_P37_30 I1660_G29_22 I1660_G37_30 I1660_G37_22n VDD VSS AOI21_X1
XI1660_I348_XP I1660_P37_30 I1660_P29_22 I1660_P37_22n VDD VSS NAND2_X1
XI1660_I349_XG I1660_P38_31 I1660_G30_23 I1660_G38_31 I1660_G38_23n VDD VSS AOI21_X1
XI1660_I349_XP I1660_P38_31 I1660_P30_23 I1660_P38_23n VDD VSS NAND2_X1
XI1660_I350_XG I1660_P39_32 I1660_G31_24 I1660_G39_32 I1660_G39_24n VDD VSS AOI21_X1
XI1660_I350_XP I1660_P39_32 I1660_P31_24 I1660_P39_24n VDD VSS NAND2_X1
XI1660_I351_XG I1660_P40_33 I1660_G32_25 I1660_G40_33 I1660_G40_25n VDD VSS AOI21_X1
XI1660_I351_XP I1660_P40_33 I1660_P32_25 I1660_P40_25n VDD VSS NAND2_X1
XI1660_I352_XG I1660_P41_34 I1660_G33_26 I1660_G41_34 I1660_G41_26n VDD VSS AOI21_X1
XI1660_I352_XP I1660_P41_34 I1660_P33_26 I1660_P41_26n VDD VSS NAND2_X1
XI1660_I353_XG I1660_P42_35 I1660_G34_27 I1660_G42_35 I1660_G42_27n VDD VSS AOI21_X1
XI1660_I353_XP I1660_P42_35 I1660_P34_27 I1660_P42_27n VDD VSS NAND2_X1
XI1660_I354_XG I1660_P43_36 I1660_G35_28 I1660_G43_36 I1660_G43_28n VDD VSS AOI21_X1
XI1660_I354_XP I1660_P43_36 I1660_P35_28 I1660_P43_28n VDD VSS NAND2_X1
XI1660_I355_XG I1660_P44_37 I1660_G36_29 I1660_G44_37 I1660_G44_29n VDD VSS AOI21_X1
XI1660_I355_XP I1660_P44_37 I1660_P36_29 I1660_P44_29n VDD VSS NAND2_X1
XI1660_I356_XG I1660_P45_38 I1660_G37_30 I1660_G45_38 I1660_G45_30n VDD VSS AOI21_X1
XI1660_I356_XP I1660_P45_38 I1660_P37_30 I1660_P45_30n VDD VSS NAND2_X1
XI1660_I357_XG I1660_P46_39 I1660_G38_31 I1660_G46_39 I1660_G46_31n VDD VSS AOI21_X1
XI1660_I357_XP I1660_P46_39 I1660_P38_31 I1660_P46_31n VDD VSS NAND2_X1
XI1660_I358_XG I1660_P47_40 I1660_G39_32 I1660_G47_40 I1660_G47_32n VDD VSS AOI21_X1
XI1660_I358_XP I1660_P47_40 I1660_P39_32 I1660_P47_32n VDD VSS NAND2_X1
XI1660_I359_XG I1660_P48_41 I1660_G40_33 I1660_G48_41 I1660_G48_33n VDD VSS AOI21_X1
XI1660_I359_XP I1660_P48_41 I1660_P40_33 I1660_P48_33n VDD VSS NAND2_X1
XI1660_I360_XG I1660_P49_42 I1660_G41_34 I1660_G49_42 I1660_G49_34n VDD VSS AOI21_X1
XI1660_I360_XP I1660_P49_42 I1660_P41_34 I1660_P49_34n VDD VSS NAND2_X1
XI1660_I361_XG I1660_P50_43 I1660_G42_35 I1660_G50_43 I1660_G50_35n VDD VSS AOI21_X1
XI1660_I361_XP I1660_P50_43 I1660_P42_35 I1660_P50_35n VDD VSS NAND2_X1
XI1660_I362_XG I1660_P51_44 I1660_G43_36 I1660_G51_44 I1660_G51_36n VDD VSS AOI21_X1
XI1660_I362_XP I1660_P51_44 I1660_P43_36 I1660_P51_36n VDD VSS NAND2_X1
XI1660_I363_XG I1660_P52_45 I1660_G44_37 I1660_G52_45 I1660_G52_37n VDD VSS AOI21_X1
XI1660_I363_XP I1660_P52_45 I1660_P44_37 I1660_P52_37n VDD VSS NAND2_X1
XI1660_I364_XG I1660_P53_46 I1660_G45_38 I1660_G53_46 I1660_G53_38n VDD VSS AOI21_X1
XI1660_I364_XP I1660_P53_46 I1660_P45_38 I1660_P53_38n VDD VSS NAND2_X1
XI1660_I365_XG I1660_P54_47 I1660_G46_39 I1660_G54_47 I1660_G54_39n VDD VSS AOI21_X1
XI1660_I365_XP I1660_P54_47 I1660_P46_39 I1660_P54_39n VDD VSS NAND2_X1
XI1660_I366_XG I1660_P55_48 I1660_G47_40 I1660_G55_48 I1660_G55_40n VDD VSS AOI21_X1
XI1660_I366_XP I1660_P55_48 I1660_P47_40 I1660_P55_40n VDD VSS NAND2_X1
XI1660_I367_XG I1660_P56_49 I1660_G48_41 I1660_G56_49 I1660_G56_41n VDD VSS AOI21_X1
XI1660_I367_XP I1660_P56_49 I1660_P48_41 I1660_P56_41n VDD VSS NAND2_X1
XI1660_I368_XG I1660_P57_50 I1660_G49_42 I1660_G57_50 I1660_G57_42n VDD VSS AOI21_X1
XI1660_I368_XP I1660_P57_50 I1660_P49_42 I1660_P57_42n VDD VSS NAND2_X1
XI1660_I369_XG I1660_P58_51 I1660_G50_43 I1660_G58_51 I1660_G58_43n VDD VSS AOI21_X1
XI1660_I369_XP I1660_P58_51 I1660_P50_43 I1660_P58_43n VDD VSS NAND2_X1
XI1660_I370_XG I1660_P59_52 I1660_G51_44 I1660_G59_52 I1660_G59_44n VDD VSS AOI21_X1
XI1660_I370_XP I1660_P59_52 I1660_P51_44 I1660_P59_44n VDD VSS NAND2_X1
XI1660_I371_XG I1660_P60_53 I1660_G52_45 I1660_G60_53 I1660_G60_45n VDD VSS AOI21_X1
XI1660_I371_XP I1660_P60_53 I1660_P52_45 I1660_P60_45n VDD VSS NAND2_X1
XI1660_I372_XG I1660_P61_54 I1660_G53_46 I1660_G61_54 I1660_G61_46n VDD VSS AOI21_X1
XI1660_I372_XP I1660_P61_54 I1660_P53_46 I1660_P61_46n VDD VSS NAND2_X1
XI1660_I373_XG I1660_P62_55 I1660_G54_47 I1660_G62_55 I1660_G62_47n VDD VSS AOI21_X1
XI1660_I373_XP I1660_P62_55 I1660_P54_47 I1660_P62_47n VDD VSS NAND2_X1
XI1660_I374_XG I1660_P63_56 I1660_G55_48 I1660_G63_56 I1660_G63_48n VDD VSS AOI21_X1
XI1660_I374_XP I1660_P63_56 I1660_P55_48 I1660_P63_48n VDD VSS NAND2_X1
XI1660_I375_XG I1660_P16_1n I1660_G0_0n I1660_G16_1n I1660_G16_0 VDD VSS OAI21_X1
XI1660_I376_XG I1660_P17_2n I1660_G1_0n I1660_G17_2n I1660_G17_0 VDD VSS OAI21_X1
XI1660_I377_XG I1660_P18_3n I1660_G2_0n I1660_G18_3n I1660_G18_0 VDD VSS OAI21_X1
XI1660_I378_XG I1660_P19_4n I1660_G3_0n I1660_G19_4n I1660_G19_0 VDD VSS OAI21_X1
XI1660_I379 I1660_G4_0 I1660_G4_0n VDD VSS INV_X1
XI1660_I380_XG I1660_P20_5n I1660_G4_0n I1660_G20_5n I1660_G20_0 VDD VSS OAI21_X1
XI1660_I381 I1660_G5_0 I1660_G5_0n VDD VSS INV_X1
XI1660_I382_XG I1660_P21_6n I1660_G5_0n I1660_G21_6n I1660_G21_0 VDD VSS OAI21_X1
XI1660_I383 I1660_G6_0 I1660_G6_0n VDD VSS INV_X1
XI1660_I384_XG I1660_P22_7n I1660_G6_0n I1660_G22_7n I1660_G22_0 VDD VSS OAI21_X1
XI1660_I385 I1660_G7_0 I1660_G7_0n VDD VSS INV_X1
XI1660_I386_XG I1660_P23_8n I1660_G7_0n I1660_G23_8n I1660_G23_0 VDD VSS OAI21_X1
XI1660_I387_XG I1660_P24_9n I1660_G8_0n I1660_G24_9n I1660_G24_0 VDD VSS OAI21_X1
XI1660_I388_XG I1660_P25_10n I1660_G9_0n I1660_G25_10n I1660_G25_0 VDD VSS OAI21_X1
XI1660_I389_XG I1660_P26_11n I1660_G10_0n I1660_G26_11n I1660_G26_0 VDD VSS OAI21_X1
XI1660_I390_XG I1660_P27_12n I1660_G11_0n I1660_G27_12n I1660_G27_0 VDD VSS OAI21_X1
XI1660_I391_XG I1660_P28_13n I1660_G12_0n I1660_G28_13n I1660_G28_0 VDD VSS OAI21_X1
XI1660_I392_XG I1660_P29_14n I1660_G13_0n I1660_G29_14n I1660_G29_0 VDD VSS OAI21_X1
XI1660_I393_XG I1660_P30_15n I1660_G14_0n I1660_G30_15n I1660_G30_0 VDD VSS OAI21_X1
XI1660_I394_XG I1660_P31_16n I1660_G15_0n I1660_G31_16n I1660_G31_0 VDD VSS OAI21_X1
XI1660_I395_XG I1660_P32_17n I1660_G16_1n I1660_G32_17n I1660_G32_1 VDD VSS OAI21_X1
XI1660_I395_XP I1660_P32_17n I1660_P16_1n I1660_P32_1 VDD VSS NOR2_X1
XI1660_I396_XG I1660_P33_18n I1660_G17_2n I1660_G33_18n I1660_G33_2 VDD VSS OAI21_X1
XI1660_I396_XP I1660_P33_18n I1660_P17_2n I1660_P33_2 VDD VSS NOR2_X1
XI1660_I397_XG I1660_P34_19n I1660_G18_3n I1660_G34_19n I1660_G34_3 VDD VSS OAI21_X1
XI1660_I397_XP I1660_P34_19n I1660_P18_3n I1660_P34_3 VDD VSS NOR2_X1
XI1660_I398_XG I1660_P35_20n I1660_G19_4n I1660_G35_20n I1660_G35_4 VDD VSS OAI21_X1
XI1660_I398_XP I1660_P35_20n I1660_P19_4n I1660_P35_4 VDD VSS NOR2_X1
XI1660_I399_XG I1660_P36_21n I1660_G20_5n I1660_G36_21n I1660_G36_5 VDD VSS OAI21_X1
XI1660_I399_XP I1660_P36_21n I1660_P20_5n I1660_P36_5 VDD VSS NOR2_X1
XI1660_I400_XG I1660_P37_22n I1660_G21_6n I1660_G37_22n I1660_G37_6 VDD VSS OAI21_X1
XI1660_I400_XP I1660_P37_22n I1660_P21_6n I1660_P37_6 VDD VSS NOR2_X1
XI1660_I401_XG I1660_P38_23n I1660_G22_7n I1660_G38_23n I1660_G38_7 VDD VSS OAI21_X1
XI1660_I401_XP I1660_P38_23n I1660_P22_7n I1660_P38_7 VDD VSS NOR2_X1
XI1660_I402_XG I1660_P39_24n I1660_G23_8n I1660_G39_24n I1660_G39_8 VDD VSS OAI21_X1
XI1660_I402_XP I1660_P39_24n I1660_P23_8n I1660_P39_8 VDD VSS NOR2_X1
XI1660_I403_XG I1660_P40_25n I1660_G24_9n I1660_G40_25n I1660_G40_9 VDD VSS OAI21_X1
XI1660_I403_XP I1660_P40_25n I1660_P24_9n I1660_P40_9 VDD VSS NOR2_X1
XI1660_I404_XG I1660_P41_26n I1660_G25_10n I1660_G41_26n I1660_G41_10 VDD VSS OAI21_X1
XI1660_I404_XP I1660_P41_26n I1660_P25_10n I1660_P41_10 VDD VSS NOR2_X1
XI1660_I405_XG I1660_P42_27n I1660_G26_11n I1660_G42_27n I1660_G42_11 VDD VSS OAI21_X1
XI1660_I405_XP I1660_P42_27n I1660_P26_11n I1660_P42_11 VDD VSS NOR2_X1
XI1660_I406_XG I1660_P43_28n I1660_G27_12n I1660_G43_28n I1660_G43_12 VDD VSS OAI21_X1
XI1660_I406_XP I1660_P43_28n I1660_P27_12n I1660_P43_12 VDD VSS NOR2_X1
XI1660_I407_XG I1660_P44_29n I1660_G28_13n I1660_G44_29n I1660_G44_13 VDD VSS OAI21_X1
XI1660_I407_XP I1660_P44_29n I1660_P28_13n I1660_P44_13 VDD VSS NOR2_X1
XI1660_I408_XG I1660_P45_30n I1660_G29_14n I1660_G45_30n I1660_G45_14 VDD VSS OAI21_X1
XI1660_I408_XP I1660_P45_30n I1660_P29_14n I1660_P45_14 VDD VSS NOR2_X1
XI1660_I409_XG I1660_P46_31n I1660_G30_15n I1660_G46_31n I1660_G46_15 VDD VSS OAI21_X1
XI1660_I409_XP I1660_P46_31n I1660_P30_15n I1660_P46_15 VDD VSS NOR2_X1
XI1660_I410_XG I1660_P47_32n I1660_G31_16n I1660_G47_32n I1660_G47_16 VDD VSS OAI21_X1
XI1660_I410_XP I1660_P47_32n I1660_P31_16n I1660_P47_16 VDD VSS NOR2_X1
XI1660_I411_XG I1660_P48_33n I1660_G32_17n I1660_G48_33n I1660_G48_17 VDD VSS OAI21_X1
XI1660_I411_XP I1660_P48_33n I1660_P32_17n I1660_P48_17 VDD VSS NOR2_X1
XI1660_I412_XG I1660_P49_34n I1660_G33_18n I1660_G49_34n I1660_G49_18 VDD VSS OAI21_X1
XI1660_I412_XP I1660_P49_34n I1660_P33_18n I1660_P49_18 VDD VSS NOR2_X1
XI1660_I413_XG I1660_P50_35n I1660_G34_19n I1660_G50_35n I1660_G50_19 VDD VSS OAI21_X1
XI1660_I413_XP I1660_P50_35n I1660_P34_19n I1660_P50_19 VDD VSS NOR2_X1
XI1660_I414_XG I1660_P51_36n I1660_G35_20n I1660_G51_36n I1660_G51_20 VDD VSS OAI21_X1
XI1660_I414_XP I1660_P51_36n I1660_P35_20n I1660_P51_20 VDD VSS NOR2_X1
XI1660_I415_XG I1660_P52_37n I1660_G36_21n I1660_G52_37n I1660_G52_21 VDD VSS OAI21_X1
XI1660_I415_XP I1660_P52_37n I1660_P36_21n I1660_P52_21 VDD VSS NOR2_X1
XI1660_I416_XG I1660_P53_38n I1660_G37_22n I1660_G53_38n I1660_G53_22 VDD VSS OAI21_X1
XI1660_I416_XP I1660_P53_38n I1660_P37_22n I1660_P53_22 VDD VSS NOR2_X1
XI1660_I417_XG I1660_P54_39n I1660_G38_23n I1660_G54_39n I1660_G54_23 VDD VSS OAI21_X1
XI1660_I417_XP I1660_P54_39n I1660_P38_23n I1660_P54_23 VDD VSS NOR2_X1
XI1660_I418_XG I1660_P55_40n I1660_G39_24n I1660_G55_40n I1660_G55_24 VDD VSS OAI21_X1
XI1660_I418_XP I1660_P55_40n I1660_P39_24n I1660_P55_24 VDD VSS NOR2_X1
XI1660_I419_XG I1660_P56_41n I1660_G40_25n I1660_G56_41n I1660_G56_25 VDD VSS OAI21_X1
XI1660_I419_XP I1660_P56_41n I1660_P40_25n I1660_P56_25 VDD VSS NOR2_X1
XI1660_I420_XG I1660_P57_42n I1660_G41_26n I1660_G57_42n I1660_G57_26 VDD VSS OAI21_X1
XI1660_I420_XP I1660_P57_42n I1660_P41_26n I1660_P57_26 VDD VSS NOR2_X1
XI1660_I421_XG I1660_P58_43n I1660_G42_27n I1660_G58_43n I1660_G58_27 VDD VSS OAI21_X1
XI1660_I421_XP I1660_P58_43n I1660_P42_27n I1660_P58_27 VDD VSS NOR2_X1
XI1660_I422_XG I1660_P59_44n I1660_G43_28n I1660_G59_44n I1660_G59_28 VDD VSS OAI21_X1
XI1660_I422_XP I1660_P59_44n I1660_P43_28n I1660_P59_28 VDD VSS NOR2_X1
XI1660_I423_XG I1660_P60_45n I1660_G44_29n I1660_G60_45n I1660_G60_29 VDD VSS OAI21_X1
XI1660_I423_XP I1660_P60_45n I1660_P44_29n I1660_P60_29 VDD VSS NOR2_X1
XI1660_I424_XG I1660_P61_46n I1660_G45_30n I1660_G61_46n I1660_G61_30 VDD VSS OAI21_X1
XI1660_I424_XP I1660_P61_46n I1660_P45_30n I1660_P61_30 VDD VSS NOR2_X1
XI1660_I425_XG I1660_P62_47n I1660_G46_31n I1660_G62_47n I1660_G62_31 VDD VSS OAI21_X1
XI1660_I425_XP I1660_P62_47n I1660_P46_31n I1660_P62_31 VDD VSS NOR2_X1
XI1660_I426_XG I1660_P63_48n I1660_G47_32n I1660_G63_48n I1660_G63_32 VDD VSS OAI21_X1
XI1660_I426_XP I1660_P63_48n I1660_P47_32n I1660_P63_32 VDD VSS NOR2_X1
XI1660_I427_XG I1660_P32_1 I1660_G0_0 I1660_G32_1 I1660_G32_0n VDD VSS AOI21_X1
XI1660_I428_XG I1660_P33_2 I1660_G1_0 I1660_G33_2 I1660_G33_0n VDD VSS AOI21_X1
XI1660_I429_XG I1660_P34_3 I1660_G2_0np I1660_G34_3 I1660_G34_0n VDD VSS AOI21_X1
XI1660_I430_XG I1660_P35_4 I1660_G3_0np I1660_G35_4 I1660_G35_0n VDD VSS AOI21_X1
XI1660_I431_XG I1660_P36_5 I1660_G4_0 I1660_G36_5 I1660_G36_0n VDD VSS AOI21_X1
XI1660_I432_XG I1660_P37_6 I1660_G5_0 I1660_G37_6 I1660_G37_0n VDD VSS AOI21_X1
XI1660_I433_XG I1660_P38_7 I1660_G6_0 I1660_G38_7 I1660_G38_0n VDD VSS AOI21_X1
XI1660_I434_XG I1660_P39_8 I1660_G7_0 I1660_G39_8 I1660_G39_0n VDD VSS AOI21_X1
XI1660_I435 I1660_G8_0n I1660_G8_0np VDD VSS INV_X1
XI1660_I436_XG I1660_P40_9 I1660_G8_0np I1660_G40_9 I1660_G40_0n VDD VSS AOI21_X1
XI1660_I437 I1660_G9_0n I1660_G9_0np VDD VSS INV_X1
XI1660_I438_XG I1660_P41_10 I1660_G9_0np I1660_G41_10 I1660_G41_0n VDD VSS AOI21_X1
XI1660_I439 I1660_G10_0n I1660_G10_0np VDD VSS INV_X1
XI1660_I440_XG I1660_P42_11 I1660_G10_0np I1660_G42_11 I1660_G42_0n VDD VSS AOI21_X1
XI1660_I441 I1660_G11_0n I1660_G11_0np VDD VSS INV_X1
XI1660_I442_XG I1660_P43_12 I1660_G11_0np I1660_G43_12 I1660_G43_0n VDD VSS AOI21_X1
XI1660_I443 I1660_G12_0n I1660_G12_0np VDD VSS INV_X1
XI1660_I444_XG I1660_P44_13 I1660_G12_0np I1660_G44_13 I1660_G44_0n VDD VSS AOI21_X1
XI1660_I445 I1660_G13_0n I1660_G13_0np VDD VSS INV_X1
XI1660_I446_XG I1660_P45_14 I1660_G13_0np I1660_G45_14 I1660_G45_0n VDD VSS AOI21_X1
XI1660_I447 I1660_G14_0n I1660_G14_0np VDD VSS INV_X1
XI1660_I448_XG I1660_P46_15 I1660_G14_0np I1660_G46_15 I1660_G46_0n VDD VSS AOI21_X1
XI1660_I449 I1660_G15_0n I1660_G15_0np VDD VSS INV_X1
XI1660_I450_XG I1660_P47_16 I1660_G15_0np I1660_G47_16 I1660_G47_0n VDD VSS AOI21_X1
XI1660_I451_XG I1660_P48_17 I1660_G16_0 I1660_G48_17 I1660_G48_0n VDD VSS AOI21_X1
XI1660_I452_XG I1660_P49_18 I1660_G17_0 I1660_G49_18 I1660_G49_0n VDD VSS AOI21_X1
XI1660_I453_XG I1660_P50_19 I1660_G18_0 I1660_G50_19 I1660_G50_0n VDD VSS AOI21_X1
XI1660_I454_XG I1660_P51_20 I1660_G19_0 I1660_G51_20 I1660_G51_0n VDD VSS AOI21_X1
XI1660_I455_XG I1660_P52_21 I1660_G20_0 I1660_G52_21 I1660_G52_0n VDD VSS AOI21_X1
XI1660_I456_XG I1660_P53_22 I1660_G21_0 I1660_G53_22 I1660_G53_0n VDD VSS AOI21_X1
XI1660_I457_XG I1660_P54_23 I1660_G22_0 I1660_G54_23 I1660_G54_0n VDD VSS AOI21_X1
XI1660_I458_XG I1660_P55_24 I1660_G23_0 I1660_G55_24 I1660_G55_0n VDD VSS AOI21_X1
XI1660_I459_XG I1660_P56_25 I1660_G24_0 I1660_G56_25 I1660_G56_0n VDD VSS AOI21_X1
XI1660_I460_XG I1660_P57_26 I1660_G25_0 I1660_G57_26 I1660_G57_0n VDD VSS AOI21_X1
XI1660_I461_XG I1660_P58_27 I1660_G26_0 I1660_G58_27 I1660_G58_0n VDD VSS AOI21_X1
XI1660_I462_XG I1660_P59_28 I1660_G27_0 I1660_G59_28 I1660_G59_0n VDD VSS AOI21_X1
XI1660_I463_XG I1660_P60_29 I1660_G28_0 I1660_G60_29 I1660_G60_0n VDD VSS AOI21_X1
XI1660_I464_XG I1660_P61_30 I1660_G29_0 I1660_G61_30 I1660_G61_0n VDD VSS AOI21_X1
XI1660_I465_XG I1660_P62_31 I1660_G30_0 I1660_G62_31 I1660_G62_0n VDD VSS AOI21_X1
XI1660_I466_XG I1660_P63_32 I1660_G31_0 I1660_G63_32 I1660_G63_0n VDD VSS AOI21_X1
XI1660_I467 I1660_pn0 VSS P_0 VDD VSS XNOR2_X1
XI1660_I468 I1660_pn1 I1660_G0_0 P_1 VDD VSS XNOR2_X1
XI1660_I469 I1660_pn2 I1660_G1_0 P_2 VDD VSS XNOR2_X1
XI1660_I470 I1660_pn3 I1660_G2_0n P_3 VDD VSS XOR2_X1
XI1660_I471 I1660_pn4 I1660_G3_0n P_4 VDD VSS XOR2_X1
XI1660_I472 I1660_pn5 I1660_G4_0 P_5 VDD VSS XNOR2_X1
XI1660_I473 I1660_pn6 I1660_G5_0 P_6 VDD VSS XNOR2_X1
XI1660_I474 I1660_pn7 I1660_G6_0 P_7 VDD VSS XNOR2_X1
XI1660_I475 I1660_pn8 I1660_G7_0 P_8 VDD VSS XNOR2_X1
XI1660_I476 I1660_pn9 I1660_G8_0n P_9 VDD VSS XOR2_X1
XI1660_I477 I1660_pn10 I1660_G9_0n P_10 VDD VSS XOR2_X1
XI1660_I478 I1660_pn11 I1660_G10_0n P_11 VDD VSS XOR2_X1
XI1660_I479 I1660_pn12 I1660_G11_0n P_12 VDD VSS XOR2_X1
XI1660_I480 I1660_pn13 I1660_G12_0n P_13 VDD VSS XOR2_X1
XI1660_I481 I1660_pn14 I1660_G13_0n P_14 VDD VSS XOR2_X1
XI1660_I482 I1660_pn15 I1660_G14_0n P_15 VDD VSS XOR2_X1
XI1660_I483 I1660_pn16 I1660_G15_0n P_16 VDD VSS XOR2_X1
XI1660_I484 I1660_pn17 I1660_G16_0 P_17 VDD VSS XNOR2_X1
XI1660_I485 I1660_pn18 I1660_G17_0 P_18 VDD VSS XNOR2_X1
XI1660_I486 I1660_pn19 I1660_G18_0 P_19 VDD VSS XNOR2_X1
XI1660_I487 I1660_pn20 I1660_G19_0 P_20 VDD VSS XNOR2_X1
XI1660_I488 I1660_pn21 I1660_G20_0 P_21 VDD VSS XNOR2_X1
XI1660_I489 I1660_pn22 I1660_G21_0 P_22 VDD VSS XNOR2_X1
XI1660_I490 I1660_pn23 I1660_G22_0 P_23 VDD VSS XNOR2_X1
XI1660_I491 I1660_pn24 I1660_G23_0 P_24 VDD VSS XNOR2_X1
XI1660_I492 I1660_pn25 I1660_G24_0 P_25 VDD VSS XNOR2_X1
XI1660_I493 I1660_pn26 I1660_G25_0 P_26 VDD VSS XNOR2_X1
XI1660_I494 I1660_pn27 I1660_G26_0 P_27 VDD VSS XNOR2_X1
XI1660_I495 I1660_pn28 I1660_G27_0 P_28 VDD VSS XNOR2_X1
XI1660_I496 I1660_pn29 I1660_G28_0 P_29 VDD VSS XNOR2_X1
XI1660_I497 I1660_pn30 I1660_G29_0 P_30 VDD VSS XNOR2_X1
XI1660_I498 I1660_pn31 I1660_G30_0 P_31 VDD VSS XNOR2_X1
XI1660_I499 I1660_pn32 I1660_G31_0 P_32 VDD VSS XNOR2_X1
XI1660_I500 I1660_pn33 I1660_G32_0n P_33 VDD VSS XOR2_X1
XI1660_I501 I1660_pn34 I1660_G33_0n P_34 VDD VSS XOR2_X1
XI1660_I502 I1660_pn35 I1660_G34_0n P_35 VDD VSS XOR2_X1
XI1660_I503 I1660_pn36 I1660_G35_0n P_36 VDD VSS XOR2_X1
XI1660_I504 I1660_pn37 I1660_G36_0n P_37 VDD VSS XOR2_X1
XI1660_I505 I1660_pn38 I1660_G37_0n P_38 VDD VSS XOR2_X1
XI1660_I506 I1660_pn39 I1660_G38_0n P_39 VDD VSS XOR2_X1
XI1660_I507 I1660_pn40 I1660_G39_0n P_40 VDD VSS XOR2_X1
XI1660_I508 I1660_pn41 I1660_G40_0n P_41 VDD VSS XOR2_X1
XI1660_I509 I1660_pn42 I1660_G41_0n P_42 VDD VSS XOR2_X1
XI1660_I510 I1660_pn43 I1660_G42_0n P_43 VDD VSS XOR2_X1
XI1660_I511 I1660_pn44 I1660_G43_0n P_44 VDD VSS XOR2_X1
XI1660_I512 I1660_pn45 I1660_G44_0n P_45 VDD VSS XOR2_X1
XI1660_I513 I1660_pn46 I1660_G45_0n P_46 VDD VSS XOR2_X1
XI1660_I514 I1660_pn47 I1660_G46_0n P_47 VDD VSS XOR2_X1
XI1660_I515 I1660_pn48 I1660_G47_0n P_48 VDD VSS XOR2_X1
XI1660_I516 I1660_pn49 I1660_G48_0n P_49 VDD VSS XOR2_X1
XI1660_I517 I1660_pn50 I1660_G49_0n P_50 VDD VSS XOR2_X1
XI1660_I518 I1660_pn51 I1660_G50_0n P_51 VDD VSS XOR2_X1
XI1660_I519 I1660_pn52 I1660_G51_0n P_52 VDD VSS XOR2_X1
XI1660_I520 I1660_pn53 I1660_G52_0n P_53 VDD VSS XOR2_X1
XI1660_I521 I1660_pn54 I1660_G53_0n P_54 VDD VSS XOR2_X1
XI1660_I522 I1660_pn55 I1660_G54_0n P_55 VDD VSS XOR2_X1
XI1660_I523 I1660_pn56 I1660_G55_0n P_56 VDD VSS XOR2_X1
XI1660_I524 I1660_pn57 I1660_G56_0n P_57 VDD VSS XOR2_X1
XI1660_I525 I1660_pn58 I1660_G57_0n P_58 VDD VSS XOR2_X1
XI1660_I526 I1660_pn59 I1660_G58_0n P_59 VDD VSS XOR2_X1
XI1660_I527 I1660_pn60 I1660_G59_0n P_60 VDD VSS XOR2_X1
XI1660_I528 I1660_pn61 I1660_G60_0n P_61 VDD VSS XOR2_X1
XI1660_I529 I1660_pn62 I1660_G61_0n P_62 VDD VSS XOR2_X1
XI1660_I530 I1660_pn63 I1660_G62_0n P_63 VDD VSS XOR2_X1
XI1660_I531 I1660_G62_0n kcm VDD VSS INV_X1
XI1660_I532 I1660_G63_0n kco VDD VSS INV_X1
.ENDS MUL32
