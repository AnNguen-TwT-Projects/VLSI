* HA_X1: generated by layout/scs2cdl.py from cells/ -- do not edit

.SUBCKT HA_X1 A B S CO VDD VSS
MN1 xan A VSS VSS nmos1v w=0.12u l=0.1u
MP2 xan A VDD VDD pmos1v w=0.24u l=0.1u
MN3 xbn B VSS VSS nmos1v w=0.12u l=0.1u
MP4 xbn B VDD VDD pmos1v w=0.24u l=0.1u
MN5 S A xn1 VSS nmos1v w=0.24u l=0.1u
MN6 xn1 B VSS VSS nmos1v w=0.24u l=0.1u
MN7 S xan xn2 VSS nmos1v w=0.24u l=0.1u
MN8 xn2 xbn VSS VSS nmos1v w=0.24u l=0.1u
MP9 xp1 A VDD VDD pmos1v w=0.48u l=0.1u
MP10 xp1 B VDD VDD pmos1v w=0.48u l=0.1u
MP11 S xan xp1 VDD pmos1v w=0.48u l=0.1u
MP12 S xbn xp1 VDD pmos1v w=0.48u l=0.1u
MN13 con A an VSS nmos1v w=0.24u l=0.1u
MN14 an B VSS VSS nmos1v w=0.24u l=0.1u
MP15 con A VDD VDD pmos1v w=0.24u l=0.1u
MP16 con B VDD VDD pmos1v w=0.24u l=0.1u
MN17 CO con VSS VSS nmos1v w=0.12u l=0.1u
MP18 CO con VDD VDD pmos1v w=0.24u l=0.1u
.ENDS HA_X1
