* DIV8 phang xuong cell la: sinh boi layout/pnr/prep.py

.SUBCKT AOI21_X1 A1 A2 B Y VDD VSS
MN0 Y A1 n1 VSS nmos1v w=0.24u l=0.1u
MN1 n1 A2 VSS VSS nmos1v w=0.24u l=0.1u
MN2 Y B VSS VSS nmos1v w=0.12u l=0.1u
MP0 p1 A1 VDD VDD pmos1v w=0.48u l=0.1u
MP1 p1 A2 VDD VDD pmos1v w=0.48u l=0.1u
MP2 Y B p1 VDD pmos1v w=0.48u l=0.1u
.ENDS AOI21_X1

.SUBCKT XOR2_X1 A B Y VDD VSS
MN0 An A VSS VSS nmos1v w=0.12u l=0.1u
MP0 An A VDD VDD pmos1v w=0.24u l=0.1u
MN1 Bn B VSS VSS nmos1v w=0.12u l=0.1u
MP1 Bn B VDD VDD pmos1v w=0.24u l=0.1u
MN2 Y A n1 VSS nmos1v w=0.24u l=0.1u
MN3 n1 B VSS VSS nmos1v w=0.24u l=0.1u
MN4 Y An n2 VSS nmos1v w=0.24u l=0.1u
MN5 n2 Bn VSS VSS nmos1v w=0.24u l=0.1u
MP2 p1 A VDD VDD pmos1v w=0.48u l=0.1u
MP3 p1 B VDD VDD pmos1v w=0.48u l=0.1u
MP4 Y An p1 VDD pmos1v w=0.48u l=0.1u
MP5 Y Bn p1 VDD pmos1v w=0.48u l=0.1u
.ENDS XOR2_X1

.SUBCKT NAND2_X1 A B Y VDD VSS
MN0 Y A n1 VSS nmos1v w=0.24u l=0.1u
MN1 n1 B VSS VSS nmos1v w=0.24u l=0.1u
MP0 Y A VDD VDD pmos1v w=0.24u l=0.1u
MP1 Y B VDD VDD pmos1v w=0.24u l=0.1u
.ENDS NAND2_X1

.SUBCKT CAS_X1 X D T CI S CO VDD VSS
XI0 D T b VDD VSS XOR2_X1
XI1 X b p VDD VSS XOR2_X1
XI2 p CI S VDD VSS XOR2_X1
XI3 X b g_n VDD VSS NAND2_X1
XI4 p CI pc_n VDD VSS NAND2_X1
XI5 g_n pc_n CO VDD VSS NAND2_X1
.ENDS CAS_X1

.SUBCKT INV_X1 A Y VDD VSS
MN0 Y A VSS VSS nmos1v w=0.12u l=0.1u
MP0 Y A VDD VDD pmos1v w=0.24u l=0.1u
.ENDS INV_X1

.SUBCKT INV_X4 A Y VDD VSS
MN1 Y A VSS VSS nmos1v w=0.48u l=0.1u
MP2 Y A VDD VDD pmos1v w=0.96u l=0.1u
.ENDS INV_X4

.SUBCKT NOR2_X1 A B Y VDD VSS
MN0 Y A VSS VSS nmos1v w=0.12u l=0.1u
MN1 Y B VSS VSS nmos1v w=0.12u l=0.1u
MP0 p1 A VDD VDD pmos1v w=0.48u l=0.1u
MP1 Y B p1 VDD pmos1v w=0.48u l=0.1u
.ENDS NOR2_X1

.SUBCKT XNOR2_X1 A B Y VDD VSS
MN0 An A VSS VSS nmos1v w=0.12u l=0.1u
MP0 An A VDD VDD pmos1v w=0.24u l=0.1u
MN1 Bn B VSS VSS nmos1v w=0.12u l=0.1u
MP1 Bn B VDD VDD pmos1v w=0.24u l=0.1u
MN2 Y A n1 VSS nmos1v w=0.24u l=0.1u
MN3 n1 Bn VSS VSS nmos1v w=0.24u l=0.1u
MN4 Y An n2 VSS nmos1v w=0.24u l=0.1u
MN5 n2 B VSS VSS nmos1v w=0.24u l=0.1u
MP2 p1 A VDD VDD pmos1v w=0.48u l=0.1u
MP3 p1 Bn VDD VDD pmos1v w=0.48u l=0.1u
MP4 Y An p1 VDD pmos1v w=0.48u l=0.1u
MP5 Y B p1 VDD pmos1v w=0.48u l=0.1u
.ENDS XNOR2_X1

.SUBCKT DIV8 A_0 A_1 A_2 A_3 A_4 A_5 A_6 A_7 B_0 B_1 B_2 B_3 B_4 B_5 B_6 B_7 Q_0 Q_1 Q_2 Q_3 Q_4 Q_5 Q_6 Q_7 R_0 R_1 R_2 R_3 R_4 R_5 R_6 R_7 V DZ VDD VSS
XI0 A_7 A_0 nakn1 VDD VSS NAND2_X1
XI1 A_1 nakn1 aa1 VDD VSS XNOR2_X1
XI2 nakn1 nak1 VDD VSS INV_X1
XI3 A_7 A_1 nak1 nakn2 VDD VSS AOI21_X1
XI4 A_2 nakn2 aa2 VDD VSS XNOR2_X1
XI5 nakn2 nak2 VDD VSS INV_X1
XI6 A_7 A_2 nak2 nakn3 VDD VSS AOI21_X1
XI7 A_3 nakn3 aa3 VDD VSS XNOR2_X1
XI8 nakn3 nak3 VDD VSS INV_X1
XI9 A_7 A_3 nak3 nakn4 VDD VSS AOI21_X1
XI10 A_4 nakn4 aa4 VDD VSS XNOR2_X1
XI11 nakn4 nak4 VDD VSS INV_X1
XI12 A_7 A_4 nak4 nakn5 VDD VSS AOI21_X1
XI13 A_5 nakn5 aa5 VDD VSS XNOR2_X1
XI14 nakn5 nak5 VDD VSS INV_X1
XI15 A_7 A_5 nak5 nakn6 VDD VSS AOI21_X1
XI16 A_6 nakn6 aa6 VDD VSS XNOR2_X1
XI17 nakn6 nak6 VDD VSS INV_X1
XI18 A_7 A_6 nak6 nakn7 VDD VSS AOI21_X1
XI19 A_7 nakn7 aa7 VDD VSS XNOR2_X1
XI20 B_7 B_0 nbkn1 VDD VSS NAND2_X1
XI21 B_1 nbkn1 dd1 VDD VSS XNOR2_X1
XI22 nbkn1 nbk1 VDD VSS INV_X1
XI23 B_7 B_1 nbk1 nbkn2 VDD VSS AOI21_X1
XI24 B_2 nbkn2 dd2 VDD VSS XNOR2_X1
XI25 nbkn2 nbk2 VDD VSS INV_X1
XI26 B_7 B_2 nbk2 nbkn3 VDD VSS AOI21_X1
XI27 B_3 nbkn3 dd3 VDD VSS XNOR2_X1
XI28 nbkn3 nbk3 VDD VSS INV_X1
XI29 B_7 B_3 nbk3 nbkn4 VDD VSS AOI21_X1
XI30 B_4 nbkn4 dd4 VDD VSS XNOR2_X1
XI31 nbkn4 nbk4 VDD VSS INV_X1
XI32 B_7 B_4 nbk4 nbkn5 VDD VSS AOI21_X1
XI33 B_5 nbkn5 dd5 VDD VSS XNOR2_X1
XI34 nbkn5 nbk5 VDD VSS INV_X1
XI35 B_7 B_5 nbk5 nbkn6 VDD VSS AOI21_X1
XI36 B_6 nbkn6 dd6 VDD VSS XNOR2_X1
XI37 nbkn6 nbk6 VDD VSS INV_X1
XI38 B_7 B_6 nbk6 nbkn7 VDD VSS AOI21_X1
XI39 B_7 nbkn7 dd7 VDD VSS XNOR2_X1
XI40 aa7 B_0 VDD VDD p0_0 c0_0 VDD VSS CAS_X1
XI41 VSS dd1 VDD c0_0 p0_1 c0_1 VDD VSS CAS_X1
XI42 VSS dd2 VDD c0_1 p0_2 c0_2 VDD VSS CAS_X1
XI43 VSS dd3 VDD c0_2 p0_3 c0_3 VDD VSS CAS_X1
XI44 VSS dd4 VDD c0_3 p0_4 c0_4 VDD VSS CAS_X1
XI45 VSS dd5 VDD c0_4 p0_5 c0_5 VDD VSS CAS_X1
XI46 VSS dd6 VDD c0_5 p0_6 c0_6 VDD VSS CAS_X1
XI47 VSS dd7 VDD c0_6 p0_7 c0_7 VDD VSS CAS_X1
XI48 VSS VSS VDD c0_7 p0_8 c0_8 VDD VSS CAS_X1
XI49 p0_8 qu7 VDD VSS INV_X4
XI50 aa6 B_0 qu7 qu7 p1_0 c1_0 VDD VSS CAS_X1
XI51 p0_0 dd1 qu7 c1_0 p1_1 c1_1 VDD VSS CAS_X1
XI52 p0_1 dd2 qu7 c1_1 p1_2 c1_2 VDD VSS CAS_X1
XI53 p0_2 dd3 qu7 c1_2 p1_3 c1_3 VDD VSS CAS_X1
XI54 p0_3 dd4 qu7 c1_3 p1_4 c1_4 VDD VSS CAS_X1
XI55 p0_4 dd5 qu7 c1_4 p1_5 c1_5 VDD VSS CAS_X1
XI56 p0_5 dd6 qu7 c1_5 p1_6 c1_6 VDD VSS CAS_X1
XI57 p0_6 dd7 qu7 c1_6 p1_7 c1_7 VDD VSS CAS_X1
XI58 p0_7 VSS qu7 c1_7 p1_8 c1_8 VDD VSS CAS_X1
XI59 p1_8 qu6 VDD VSS INV_X4
XI60 aa5 B_0 qu6 qu6 p2_0 c2_0 VDD VSS CAS_X1
XI61 p1_0 dd1 qu6 c2_0 p2_1 c2_1 VDD VSS CAS_X1
XI62 p1_1 dd2 qu6 c2_1 p2_2 c2_2 VDD VSS CAS_X1
XI63 p1_2 dd3 qu6 c2_2 p2_3 c2_3 VDD VSS CAS_X1
XI64 p1_3 dd4 qu6 c2_3 p2_4 c2_4 VDD VSS CAS_X1
XI65 p1_4 dd5 qu6 c2_4 p2_5 c2_5 VDD VSS CAS_X1
XI66 p1_5 dd6 qu6 c2_5 p2_6 c2_6 VDD VSS CAS_X1
XI67 p1_6 dd7 qu6 c2_6 p2_7 c2_7 VDD VSS CAS_X1
XI68 p1_7 VSS qu6 c2_7 p2_8 c2_8 VDD VSS CAS_X1
XI69 p2_8 qu5 VDD VSS INV_X4
XI70 aa4 B_0 qu5 qu5 p3_0 c3_0 VDD VSS CAS_X1
XI71 p2_0 dd1 qu5 c3_0 p3_1 c3_1 VDD VSS CAS_X1
XI72 p2_1 dd2 qu5 c3_1 p3_2 c3_2 VDD VSS CAS_X1
XI73 p2_2 dd3 qu5 c3_2 p3_3 c3_3 VDD VSS CAS_X1
XI74 p2_3 dd4 qu5 c3_3 p3_4 c3_4 VDD VSS CAS_X1
XI75 p2_4 dd5 qu5 c3_4 p3_5 c3_5 VDD VSS CAS_X1
XI76 p2_5 dd6 qu5 c3_5 p3_6 c3_6 VDD VSS CAS_X1
XI77 p2_6 dd7 qu5 c3_6 p3_7 c3_7 VDD VSS CAS_X1
XI78 p2_7 VSS qu5 c3_7 p3_8 c3_8 VDD VSS CAS_X1
XI79 p3_8 qu4 VDD VSS INV_X4
XI80 aa3 B_0 qu4 qu4 p4_0 c4_0 VDD VSS CAS_X1
XI81 p3_0 dd1 qu4 c4_0 p4_1 c4_1 VDD VSS CAS_X1
XI82 p3_1 dd2 qu4 c4_1 p4_2 c4_2 VDD VSS CAS_X1
XI83 p3_2 dd3 qu4 c4_2 p4_3 c4_3 VDD VSS CAS_X1
XI84 p3_3 dd4 qu4 c4_3 p4_4 c4_4 VDD VSS CAS_X1
XI85 p3_4 dd5 qu4 c4_4 p4_5 c4_5 VDD VSS CAS_X1
XI86 p3_5 dd6 qu4 c4_5 p4_6 c4_6 VDD VSS CAS_X1
XI87 p3_6 dd7 qu4 c4_6 p4_7 c4_7 VDD VSS CAS_X1
XI88 p3_7 VSS qu4 c4_7 p4_8 c4_8 VDD VSS CAS_X1
XI89 p4_8 qu3 VDD VSS INV_X4
XI90 aa2 B_0 qu3 qu3 p5_0 c5_0 VDD VSS CAS_X1
XI91 p4_0 dd1 qu3 c5_0 p5_1 c5_1 VDD VSS CAS_X1
XI92 p4_1 dd2 qu3 c5_1 p5_2 c5_2 VDD VSS CAS_X1
XI93 p4_2 dd3 qu3 c5_2 p5_3 c5_3 VDD VSS CAS_X1
XI94 p4_3 dd4 qu3 c5_3 p5_4 c5_4 VDD VSS CAS_X1
XI95 p4_4 dd5 qu3 c5_4 p5_5 c5_5 VDD VSS CAS_X1
XI96 p4_5 dd6 qu3 c5_5 p5_6 c5_6 VDD VSS CAS_X1
XI97 p4_6 dd7 qu3 c5_6 p5_7 c5_7 VDD VSS CAS_X1
XI98 p4_7 VSS qu3 c5_7 p5_8 c5_8 VDD VSS CAS_X1
XI99 p5_8 qu2 VDD VSS INV_X4
XI100 aa1 B_0 qu2 qu2 p6_0 c6_0 VDD VSS CAS_X1
XI101 p5_0 dd1 qu2 c6_0 p6_1 c6_1 VDD VSS CAS_X1
XI102 p5_1 dd2 qu2 c6_1 p6_2 c6_2 VDD VSS CAS_X1
XI103 p5_2 dd3 qu2 c6_2 p6_3 c6_3 VDD VSS CAS_X1
XI104 p5_3 dd4 qu2 c6_3 p6_4 c6_4 VDD VSS CAS_X1
XI105 p5_4 dd5 qu2 c6_4 p6_5 c6_5 VDD VSS CAS_X1
XI106 p5_5 dd6 qu2 c6_5 p6_6 c6_6 VDD VSS CAS_X1
XI107 p5_6 dd7 qu2 c6_6 p6_7 c6_7 VDD VSS CAS_X1
XI108 p5_7 VSS qu2 c6_7 p6_8 c6_8 VDD VSS CAS_X1
XI109 p6_8 qu1 VDD VSS INV_X4
XI110 A_0 B_0 qu1 qu1 p7_0 c7_0 VDD VSS CAS_X1
XI111 p6_0 dd1 qu1 c7_0 p7_1 c7_1 VDD VSS CAS_X1
XI112 p6_1 dd2 qu1 c7_1 p7_2 c7_2 VDD VSS CAS_X1
XI113 p6_2 dd3 qu1 c7_2 p7_3 c7_3 VDD VSS CAS_X1
XI114 p6_3 dd4 qu1 c7_3 p7_4 c7_4 VDD VSS CAS_X1
XI115 p6_4 dd5 qu1 c7_4 p7_5 c7_5 VDD VSS CAS_X1
XI116 p6_5 dd6 qu1 c7_5 p7_6 c7_6 VDD VSS CAS_X1
XI117 p6_6 dd7 qu1 c7_6 p7_7 c7_7 VDD VSS CAS_X1
XI118 p6_7 VSS qu1 c7_7 p7_8 c7_8 VDD VSS CAS_X1
XI119 p7_8 Q_0 VDD VSS INV_X1
XI120 B_0 p7_8 dmn0 VDD VSS NAND2_X1
XI121 dmn0 dm0 VDD VSS INV_X1
XI122 p7_0 dm0 VSS VSS R_0 rc0 VDD VSS CAS_X1
XI123 dd1 p7_8 dmn1 VDD VSS NAND2_X1
XI124 dmn1 dm1 VDD VSS INV_X1
XI125 p7_1 dm1 VSS rc0 ru1 rc1 VDD VSS CAS_X1
XI126 dd2 p7_8 dmn2 VDD VSS NAND2_X1
XI127 dmn2 dm2 VDD VSS INV_X1
XI128 p7_2 dm2 VSS rc1 ru2 rc2 VDD VSS CAS_X1
XI129 dd3 p7_8 dmn3 VDD VSS NAND2_X1
XI130 dmn3 dm3 VDD VSS INV_X1
XI131 p7_3 dm3 VSS rc2 ru3 rc3 VDD VSS CAS_X1
XI132 dd4 p7_8 dmn4 VDD VSS NAND2_X1
XI133 dmn4 dm4 VDD VSS INV_X1
XI134 p7_4 dm4 VSS rc3 ru4 rc4 VDD VSS CAS_X1
XI135 dd5 p7_8 dmn5 VDD VSS NAND2_X1
XI136 dmn5 dm5 VDD VSS INV_X1
XI137 p7_5 dm5 VSS rc4 ru5 rc5 VDD VSS CAS_X1
XI138 dd6 p7_8 dmn6 VDD VSS NAND2_X1
XI139 dmn6 dm6 VDD VSS INV_X1
XI140 p7_6 dm6 VSS rc5 ru6 rc6 VDD VSS CAS_X1
XI141 dd7 p7_8 dmn7 VDD VSS NAND2_X1
XI142 dmn7 dm7 VDD VSS INV_X1
XI143 p7_7 dm7 VSS rc6 ru7 rc7 VDD VSS CAS_X1
XI144 A_7 B_7 sq VDD VSS XOR2_X1
XI145 sq Q_0 nqkn1 VDD VSS NAND2_X1
XI146 qu1 nqkn1 Q_1 VDD VSS XNOR2_X1
XI147 nqkn1 nqk1 VDD VSS INV_X1
XI148 sq qu1 nqk1 nqkn2 VDD VSS AOI21_X1
XI149 qu2 nqkn2 Q_2 VDD VSS XNOR2_X1
XI150 nqkn2 nqk2 VDD VSS INV_X1
XI151 sq qu2 nqk2 nqkn3 VDD VSS AOI21_X1
XI152 qu3 nqkn3 Q_3 VDD VSS XNOR2_X1
XI153 nqkn3 nqk3 VDD VSS INV_X1
XI154 sq qu3 nqk3 nqkn4 VDD VSS AOI21_X1
XI155 qu4 nqkn4 Q_4 VDD VSS XNOR2_X1
XI156 nqkn4 nqk4 VDD VSS INV_X1
XI157 sq qu4 nqk4 nqkn5 VDD VSS AOI21_X1
XI158 qu5 nqkn5 Q_5 VDD VSS XNOR2_X1
XI159 nqkn5 nqk5 VDD VSS INV_X1
XI160 sq qu5 nqk5 nqkn6 VDD VSS AOI21_X1
XI161 qu6 nqkn6 Q_6 VDD VSS XNOR2_X1
XI162 nqkn6 nqk6 VDD VSS INV_X1
XI163 sq qu6 nqk6 nqkn7 VDD VSS AOI21_X1
XI164 qu7 nqkn7 Q_7 VDD VSS XNOR2_X1
XI165 A_7 R_0 nrkn1 VDD VSS NAND2_X1
XI166 ru1 nrkn1 R_1 VDD VSS XNOR2_X1
XI167 nrkn1 nrk1 VDD VSS INV_X1
XI168 A_7 ru1 nrk1 nrkn2 VDD VSS AOI21_X1
XI169 ru2 nrkn2 R_2 VDD VSS XNOR2_X1
XI170 nrkn2 nrk2 VDD VSS INV_X1
XI171 A_7 ru2 nrk2 nrkn3 VDD VSS AOI21_X1
XI172 ru3 nrkn3 R_3 VDD VSS XNOR2_X1
XI173 nrkn3 nrk3 VDD VSS INV_X1
XI174 A_7 ru3 nrk3 nrkn4 VDD VSS AOI21_X1
XI175 ru4 nrkn4 R_4 VDD VSS XNOR2_X1
XI176 nrkn4 nrk4 VDD VSS INV_X1
XI177 A_7 ru4 nrk4 nrkn5 VDD VSS AOI21_X1
XI178 ru5 nrkn5 R_5 VDD VSS XNOR2_X1
XI179 nrkn5 nrk5 VDD VSS INV_X1
XI180 A_7 ru5 nrk5 nrkn6 VDD VSS AOI21_X1
XI181 ru6 nrkn6 R_6 VDD VSS XNOR2_X1
XI182 nrkn6 nrk6 VDD VSS INV_X1
XI183 A_7 ru6 nrk6 nrkn7 VDD VSS AOI21_X1
XI184 ru7 nrkn7 R_7 VDD VSS XNOR2_X1
XI185 B_0 B_1 z1_0 VDD VSS NOR2_X1
XI186 B_2 B_3 z1_1 VDD VSS NOR2_X1
XI187 B_4 B_5 z1_2 VDD VSS NOR2_X1
XI188 B_6 B_7 z1_3 VDD VSS NOR2_X1
XI189 z1_0 z1_1 z2_0 VDD VSS NAND2_X1
XI190 z1_2 z1_3 z2_1 VDD VSS NAND2_X1
XI191 z2_0 z2_1 DZ VDD VSS NOR2_X1
XI192 sq sqn VDD VSS INV_X1
XI193 Q_7 sqn vn VDD VSS NAND2_X1
XI194 vn DZ V VDD VSS NOR2_X1
.ENDS DIV8
