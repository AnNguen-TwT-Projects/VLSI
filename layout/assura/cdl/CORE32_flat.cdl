* CORE32 phang xuong cell la: sinh boi layout/pnr/prep.py

.SUBCKT AOI21_X1 A1 A2 B Y VDD VSS
MN0 Y A1 n1 VSS nmos1v w=0.24u l=0.1u
MN1 n1 A2 VSS VSS nmos1v w=0.24u l=0.1u
MN2 Y B VSS VSS nmos1v w=0.12u l=0.1u
MP0 p1 A1 VDD VDD pmos1v w=0.48u l=0.1u
MP1 p1 A2 VDD VDD pmos1v w=0.48u l=0.1u
MP2 Y B p1 VDD pmos1v w=0.48u l=0.1u
.ENDS AOI21_X1

.SUBCKT INV_X1 A Y VDD VSS
MN0 Y A VSS VSS nmos1v w=0.12u l=0.1u
MP0 Y A VDD VDD pmos1v w=0.24u l=0.1u
.ENDS INV_X1

.SUBCKT INV_X4 A Y VDD VSS
MN1 Y A VSS VSS nmos1v w=0.48u l=0.1u
MP2 Y A VDD VDD pmos1v w=0.96u l=0.1u
.ENDS INV_X4

.SUBCKT NAND2_X1 A B Y VDD VSS
MN0 Y A n1 VSS nmos1v w=0.24u l=0.1u
MN1 n1 B VSS VSS nmos1v w=0.24u l=0.1u
MP0 Y A VDD VDD pmos1v w=0.24u l=0.1u
MP1 Y B VDD VDD pmos1v w=0.24u l=0.1u
.ENDS NAND2_X1

.SUBCKT NOR2_X1 A B Y VDD VSS
MN0 Y A VSS VSS nmos1v w=0.12u l=0.1u
MN1 Y B VSS VSS nmos1v w=0.12u l=0.1u
MP0 p1 A VDD VDD pmos1v w=0.48u l=0.1u
MP1 Y B p1 VDD pmos1v w=0.48u l=0.1u
.ENDS NOR2_X1

.SUBCKT OAI21_X1 A1 A2 B Y VDD VSS
MN0 Y A1 n1 VSS nmos1v w=0.24u l=0.1u
MN1 Y A2 n1 VSS nmos1v w=0.24u l=0.1u
MN2 n1 B VSS VSS nmos1v w=0.24u l=0.1u
MP0 p1 A1 VDD VDD pmos1v w=0.48u l=0.1u
MP1 Y A2 p1 VDD pmos1v w=0.48u l=0.1u
MP2 Y B VDD VDD pmos1v w=0.24u l=0.1u
.ENDS OAI21_X1

.SUBCKT XNOR2_X1 A B Y VDD VSS
MN0 An A VSS VSS nmos1v w=0.12u l=0.1u
MP0 An A VDD VDD pmos1v w=0.24u l=0.1u
MN1 Bn B VSS VSS nmos1v w=0.12u l=0.1u
MP1 Bn B VDD VDD pmos1v w=0.24u l=0.1u
MN2 Y A n1 VSS nmos1v w=0.24u l=0.1u
MN3 n1 Bn VSS VSS nmos1v w=0.24u l=0.1u
MN4 Y An n2 VSS nmos1v w=0.24u l=0.1u
MN5 n2 B VSS VSS nmos1v w=0.24u l=0.1u
MP2 p1 A VDD VDD pmos1v w=0.48u l=0.1u
MP3 p1 Bn VDD VDD pmos1v w=0.48u l=0.1u
MP4 Y An p1 VDD pmos1v w=0.48u l=0.1u
MP5 Y B p1 VDD pmos1v w=0.48u l=0.1u
.ENDS XNOR2_X1

.SUBCKT XOR2_X1 A B Y VDD VSS
MN0 An A VSS VSS nmos1v w=0.12u l=0.1u
MP0 An A VDD VDD pmos1v w=0.24u l=0.1u
MN1 Bn B VSS VSS nmos1v w=0.12u l=0.1u
MP1 Bn B VDD VDD pmos1v w=0.24u l=0.1u
MN2 Y A n1 VSS nmos1v w=0.24u l=0.1u
MN3 n1 B VSS VSS nmos1v w=0.24u l=0.1u
MN4 Y An n2 VSS nmos1v w=0.24u l=0.1u
MN5 n2 Bn VSS VSS nmos1v w=0.24u l=0.1u
MP2 p1 A VDD VDD pmos1v w=0.48u l=0.1u
MP3 p1 B VDD VDD pmos1v w=0.48u l=0.1u
MP4 Y An p1 VDD pmos1v w=0.48u l=0.1u
MP5 Y Bn p1 VDD pmos1v w=0.48u l=0.1u
.ENDS XOR2_X1

.SUBCKT CORE32 A_0 A_1 A_2 A_3 A_4 A_5 A_6 A_7 A_8 A_9 A_10 A_11 A_12 A_13 A_14 A_15 A_16 A_17 A_18 A_19 A_20 A_21 A_22 A_23 A_24 A_25 A_26 A_27 A_28 A_29 A_30 A_31 B_0 B_1 B_2 B_3 B_4 B_5 B_6 B_7 B_8 B_9 B_10 B_11 B_12 B_13 B_14 B_15 B_16 B_17 B_18 B_19 B_20 B_21 B_22 B_23 B_24 B_25 B_26 B_27 B_28 B_29 B_30 B_31 OP_0 OP_1 OP_2 OP_3 MULP_0 MULP_1 MULP_2 MULP_3 MULP_4 MULP_5 MULP_6 MULP_7 MULP_8 MULP_9 MULP_10 MULP_11 MULP_12 MULP_13 MULP_14 MULP_15 MULP_16 MULP_17 MULP_18 MULP_19 MULP_20 MULP_21 MULP_22 MULP_23 MULP_24 MULP_25 MULP_26 MULP_27 MULP_28 MULP_29 MULP_30 MULP_31 MULP_32 MULP_33 MULP_34 MULP_35 MULP_36 MULP_37 MULP_38 MULP_39 MULP_40 MULP_41 MULP_42 MULP_43 MULP_44 MULP_45 MULP_46 MULP_47 MULP_48 MULP_49 MULP_50 MULP_51 MULP_52 MULP_53 MULP_54 MULP_55 MULP_56 MULP_57 MULP_58 MULP_59 MULP_60 MULP_61 MULP_62 MULP_63 DIVQ_0 DIVQ_1 DIVQ_2 DIVQ_3 DIVQ_4 DIVQ_5 DIVQ_6 DIVQ_7 DIVQ_8 DIVQ_9 DIVQ_10 DIVQ_11 DIVQ_12 DIVQ_13 DIVQ_14 DIVQ_15 DIVQ_16 DIVQ_17 DIVQ_18 DIVQ_19 DIVQ_20 DIVQ_21 DIVQ_22 DIVQ_23 DIVQ_24 DIVQ_25 DIVQ_26 DIVQ_27 DIVQ_28 DIVQ_29 DIVQ_30 DIVQ_31 DIVR_0 DIVR_1 DIVR_2 DIVR_3 DIVR_4 DIVR_5 DIVR_6 DIVR_7 DIVR_8 DIVR_9 DIVR_10 DIVR_11 DIVR_12 DIVR_13 DIVR_14 DIVR_15 DIVR_16 DIVR_17 DIVR_18 DIVR_19 DIVR_20 DIVR_21 DIVR_22 DIVR_23 DIVR_24 DIVR_25 DIVR_26 DIVR_27 DIVR_28 DIVR_29 DIVR_30 DIVR_31 DIVV DIVDZ Y_0 Y_1 Y_2 Y_3 Y_4 Y_5 Y_6 Y_7 Y_8 Y_9 Y_10 Y_11 Y_12 Y_13 Y_14 Y_15 Y_16 Y_17 Y_18 Y_19 Y_20 Y_21 Y_22 Y_23 Y_24 Y_25 Y_26 Y_27 Y_28 Y_29 Y_30 Y_31 Y_32 Y_33 Y_34 Y_35 Y_36 Y_37 Y_38 Y_39 Y_40 Y_41 Y_42 Y_43 Y_44 Y_45 Y_46 Y_47 Y_48 Y_49 Y_50 Y_51 Y_52 Y_53 Y_54 Y_55 Y_56 Y_57 Y_58 Y_59 Y_60 Y_61 Y_62 Y_63 Z C V DZ VDD VSS
XI0_I0 OP_0 I0_opn0 VDD VSS INV_X1
XI0_I1 OP_1 I0_opn1 VDD VSS INV_X1
XI0_I2 OP_2 I0_opn2 VDD VSS INV_X1
XI0_I3 OP_3 I0_opn3 VDD VSS INV_X1
XI0_I4 I0_opn3 I0_opn2 I0_h00 VDD VSS NAND2_X1
XI0_I5 I0_opn3 OP_2 I0_h01 VDD VSS NAND2_X1
XI0_I6 OP_3 I0_opn2 I0_h10 VDD VSS NAND2_X1
XI0_I7 I0_opn1 I0_opn0 I0_l00 VDD VSS NAND2_X1
XI0_I8 I0_opn1 OP_0 I0_l01 VDD VSS NAND2_X1
XI0_I9 OP_1 I0_opn0 I0_l10 VDD VSS NAND2_X1
XI0_I10 OP_1 OP_0 I0_l11 VDD VSS NAND2_X1
XI0_I11 I0_h00 OP_1 SEL_AS VDD VSS NOR2_X1
XI0_I12 I0_h00 I0_l10 SEL_AND VDD VSS NOR2_X1
XI0_I13 I0_h00 I0_l11 SEL_OR VDD VSS NOR2_X1
XI0_I14 I0_h01 I0_l00 SEL_XOR VDD VSS NOR2_X1
XI0_I15 I0_h01 I0_l01 SEL_NOT VDD VSS NOR2_X1
XI0_I16 I0_h10 I0_l01 SEL_MUL VDD VSS NOR2_X1
XI0_I17 I0_h10 I0_l11 SEL_DIV VDD VSS NOR2_X1
XI1_I0 OP_0 I1_SUB_b0 VDD VSS INV_X1
XI1_I1 I1_SUB_b0 I1_SUB_b1_0 VDD VSS INV_X4
XI1_I2 I1_SUB_b1_0 I1_SUB_b2_0 VDD VSS INV_X4
XI1_I3 I1_SUB_b1_0 I1_SUB_b2_1 VDD VSS INV_X4
XI1_I4 I1_SUB_b2_0 I1_SUB_b3_0 VDD VSS INV_X4
XI1_I5 I1_SUB_b2_0 I1_SUB_b3_1 VDD VSS INV_X4
XI1_I6 I1_SUB_b2_0 I1_SUB_b3_2 VDD VSS INV_X4
XI1_I7 I1_SUB_b2_1 I1_SUB_b3_3 VDD VSS INV_X4
XI1_I8 I1_SUB_b2_1 I1_SUB_b3_4 VDD VSS INV_X4
XI1_I9 I1_SUB_b2_1 I1_SUB_b3_5 VDD VSS INV_X4
XI1_I10 B_0 I1_SUB_b3_0 I1_bx0 VDD VSS XOR2_X1
XI1_I11 B_1 I1_SUB_b3_0 I1_bx1 VDD VSS XOR2_X1
XI1_I12 B_2 I1_SUB_b3_0 I1_bx2 VDD VSS XOR2_X1
XI1_I13 B_3 I1_SUB_b3_0 I1_bx3 VDD VSS XOR2_X1
XI1_I14 B_4 I1_SUB_b3_0 I1_bx4 VDD VSS XOR2_X1
XI1_I15 B_5 I1_SUB_b3_0 I1_bx5 VDD VSS XOR2_X1
XI1_I16 B_6 I1_SUB_b3_1 I1_bx6 VDD VSS XOR2_X1
XI1_I17 B_7 I1_SUB_b3_1 I1_bx7 VDD VSS XOR2_X1
XI1_I18 B_8 I1_SUB_b3_1 I1_bx8 VDD VSS XOR2_X1
XI1_I19 B_9 I1_SUB_b3_1 I1_bx9 VDD VSS XOR2_X1
XI1_I20 B_10 I1_SUB_b3_1 I1_bx10 VDD VSS XOR2_X1
XI1_I21 B_11 I1_SUB_b3_2 I1_bx11 VDD VSS XOR2_X1
XI1_I22 B_12 I1_SUB_b3_2 I1_bx12 VDD VSS XOR2_X1
XI1_I23 B_13 I1_SUB_b3_2 I1_bx13 VDD VSS XOR2_X1
XI1_I24 B_14 I1_SUB_b3_2 I1_bx14 VDD VSS XOR2_X1
XI1_I25 B_15 I1_SUB_b3_2 I1_bx15 VDD VSS XOR2_X1
XI1_I26 B_16 I1_SUB_b3_2 I1_bx16 VDD VSS XOR2_X1
XI1_I27 B_17 I1_SUB_b3_3 I1_bx17 VDD VSS XOR2_X1
XI1_I28 B_18 I1_SUB_b3_3 I1_bx18 VDD VSS XOR2_X1
XI1_I29 B_19 I1_SUB_b3_3 I1_bx19 VDD VSS XOR2_X1
XI1_I30 B_20 I1_SUB_b3_3 I1_bx20 VDD VSS XOR2_X1
XI1_I31 B_21 I1_SUB_b3_3 I1_bx21 VDD VSS XOR2_X1
XI1_I32 B_22 I1_SUB_b3_4 I1_bx22 VDD VSS XOR2_X1
XI1_I33 B_23 I1_SUB_b3_4 I1_bx23 VDD VSS XOR2_X1
XI1_I34 B_24 I1_SUB_b3_4 I1_bx24 VDD VSS XOR2_X1
XI1_I35 B_25 I1_SUB_b3_4 I1_bx25 VDD VSS XOR2_X1
XI1_I36 B_26 I1_SUB_b3_4 I1_bx26 VDD VSS XOR2_X1
XI1_I37 B_27 I1_SUB_b3_4 I1_bx27 VDD VSS XOR2_X1
XI1_I38 B_28 I1_SUB_b3_5 I1_bx28 VDD VSS XOR2_X1
XI1_I39 B_29 I1_SUB_b3_5 I1_bx29 VDD VSS XOR2_X1
XI1_I40 B_30 I1_SUB_b3_5 I1_bx30 VDD VSS XOR2_X1
XI1_I41 B_31 I1_SUB_b3_5 I1_bx31 VDD VSS XOR2_X1
XI1_I42_I0 A_0 I1_bx0 I1_I42_gn0 VDD VSS NAND2_X1
XI1_I42_I1 A_1 I1_bx1 I1_I42_gn1 VDD VSS NAND2_X1
XI1_I42_I2 A_2 I1_bx2 I1_I42_gn2 VDD VSS NAND2_X1
XI1_I42_I3 A_3 I1_bx3 I1_I42_gn3 VDD VSS NAND2_X1
XI1_I42_I4 A_4 I1_bx4 I1_I42_gn4 VDD VSS NAND2_X1
XI1_I42_I5 A_5 I1_bx5 I1_I42_gn5 VDD VSS NAND2_X1
XI1_I42_I6 A_6 I1_bx6 I1_I42_gn6 VDD VSS NAND2_X1
XI1_I42_I7 A_7 I1_bx7 I1_I42_gn7 VDD VSS NAND2_X1
XI1_I42_I8 A_8 I1_bx8 I1_I42_gn8 VDD VSS NAND2_X1
XI1_I42_I9 A_9 I1_bx9 I1_I42_gn9 VDD VSS NAND2_X1
XI1_I42_I10 A_10 I1_bx10 I1_I42_gn10 VDD VSS NAND2_X1
XI1_I42_I11 A_11 I1_bx11 I1_I42_gn11 VDD VSS NAND2_X1
XI1_I42_I12 A_12 I1_bx12 I1_I42_gn12 VDD VSS NAND2_X1
XI1_I42_I13 A_13 I1_bx13 I1_I42_gn13 VDD VSS NAND2_X1
XI1_I42_I14 A_14 I1_bx14 I1_I42_gn14 VDD VSS NAND2_X1
XI1_I42_I15 A_15 I1_bx15 I1_I42_gn15 VDD VSS NAND2_X1
XI1_I42_I16 A_16 I1_bx16 I1_I42_gn16 VDD VSS NAND2_X1
XI1_I42_I17 A_17 I1_bx17 I1_I42_gn17 VDD VSS NAND2_X1
XI1_I42_I18 A_18 I1_bx18 I1_I42_gn18 VDD VSS NAND2_X1
XI1_I42_I19 A_19 I1_bx19 I1_I42_gn19 VDD VSS NAND2_X1
XI1_I42_I20 A_20 I1_bx20 I1_I42_gn20 VDD VSS NAND2_X1
XI1_I42_I21 A_21 I1_bx21 I1_I42_gn21 VDD VSS NAND2_X1
XI1_I42_I22 A_22 I1_bx22 I1_I42_gn22 VDD VSS NAND2_X1
XI1_I42_I23 A_23 I1_bx23 I1_I42_gn23 VDD VSS NAND2_X1
XI1_I42_I24 A_24 I1_bx24 I1_I42_gn24 VDD VSS NAND2_X1
XI1_I42_I25 A_25 I1_bx25 I1_I42_gn25 VDD VSS NAND2_X1
XI1_I42_I26 A_26 I1_bx26 I1_I42_gn26 VDD VSS NAND2_X1
XI1_I42_I27 A_27 I1_bx27 I1_I42_gn27 VDD VSS NAND2_X1
XI1_I42_I28 A_28 I1_bx28 I1_I42_gn28 VDD VSS NAND2_X1
XI1_I42_I29 A_29 I1_bx29 I1_I42_gn29 VDD VSS NAND2_X1
XI1_I42_I30 A_30 I1_bx30 I1_I42_gn30 VDD VSS NAND2_X1
XI1_I42_I31 A_31 I1_bx31 I1_I42_gn31 VDD VSS NAND2_X1
XI1_I42_I32 A_0 I1_bx0 I1_I42_pn0 VDD VSS XNOR2_X1
XI1_I42_I33 A_1 I1_bx1 I1_I42_pn1 VDD VSS XNOR2_X1
XI1_I42_I34 A_2 I1_bx2 I1_I42_pn2 VDD VSS XNOR2_X1
XI1_I42_I35 A_3 I1_bx3 I1_I42_pn3 VDD VSS XNOR2_X1
XI1_I42_I36 A_4 I1_bx4 I1_I42_pn4 VDD VSS XNOR2_X1
XI1_I42_I37 A_5 I1_bx5 I1_I42_pn5 VDD VSS XNOR2_X1
XI1_I42_I38 A_6 I1_bx6 I1_I42_pn6 VDD VSS XNOR2_X1
XI1_I42_I39 A_7 I1_bx7 I1_I42_pn7 VDD VSS XNOR2_X1
XI1_I42_I40 A_8 I1_bx8 I1_I42_pn8 VDD VSS XNOR2_X1
XI1_I42_I41 A_9 I1_bx9 I1_I42_pn9 VDD VSS XNOR2_X1
XI1_I42_I42 A_10 I1_bx10 I1_I42_pn10 VDD VSS XNOR2_X1
XI1_I42_I43 A_11 I1_bx11 I1_I42_pn11 VDD VSS XNOR2_X1
XI1_I42_I44 A_12 I1_bx12 I1_I42_pn12 VDD VSS XNOR2_X1
XI1_I42_I45 A_13 I1_bx13 I1_I42_pn13 VDD VSS XNOR2_X1
XI1_I42_I46 A_14 I1_bx14 I1_I42_pn14 VDD VSS XNOR2_X1
XI1_I42_I47 A_15 I1_bx15 I1_I42_pn15 VDD VSS XNOR2_X1
XI1_I42_I48 A_16 I1_bx16 I1_I42_pn16 VDD VSS XNOR2_X1
XI1_I42_I49 A_17 I1_bx17 I1_I42_pn17 VDD VSS XNOR2_X1
XI1_I42_I50 A_18 I1_bx18 I1_I42_pn18 VDD VSS XNOR2_X1
XI1_I42_I51 A_19 I1_bx19 I1_I42_pn19 VDD VSS XNOR2_X1
XI1_I42_I52 A_20 I1_bx20 I1_I42_pn20 VDD VSS XNOR2_X1
XI1_I42_I53 A_21 I1_bx21 I1_I42_pn21 VDD VSS XNOR2_X1
XI1_I42_I54 A_22 I1_bx22 I1_I42_pn22 VDD VSS XNOR2_X1
XI1_I42_I55 A_23 I1_bx23 I1_I42_pn23 VDD VSS XNOR2_X1
XI1_I42_I56 A_24 I1_bx24 I1_I42_pn24 VDD VSS XNOR2_X1
XI1_I42_I57 A_25 I1_bx25 I1_I42_pn25 VDD VSS XNOR2_X1
XI1_I42_I58 A_26 I1_bx26 I1_I42_pn26 VDD VSS XNOR2_X1
XI1_I42_I59 A_27 I1_bx27 I1_I42_pn27 VDD VSS XNOR2_X1
XI1_I42_I60 A_28 I1_bx28 I1_I42_pn28 VDD VSS XNOR2_X1
XI1_I42_I61 A_29 I1_bx29 I1_I42_pn29 VDD VSS XNOR2_X1
XI1_I42_I62 A_30 I1_bx30 I1_I42_pn30 VDD VSS XNOR2_X1
XI1_I42_I63 A_31 I1_bx31 I1_I42_pn31 VDD VSS XNOR2_X1
XI1_I42_I64 I1_SUB_b3_5 I1_I42_cinn VDD VSS INV_X1
XI1_I42_I65_XG I1_I42_pn0 I1_I42_cinn I1_I42_gn0 I1_I42_G0_0 VDD VSS OAI21_X1
XI1_I42_I66 I1_I42_G0_0 I1_I42_G0_0n VDD VSS INV_X1
XI1_I42_I67_XG I1_I42_pn1 I1_I42_G0_0n I1_I42_gn1 I1_I42_G1_0 VDD VSS OAI21_X1
XI1_I42_I68_XG I1_I42_pn2 I1_I42_gn1 I1_I42_gn2 I1_I42_G2_1 VDD VSS OAI21_X1
XI1_I42_I68_XP I1_I42_pn2 I1_I42_pn1 I1_I42_P2_1 VDD VSS NOR2_X1
XI1_I42_I69_XG I1_I42_pn3 I1_I42_gn2 I1_I42_gn3 I1_I42_G3_2 VDD VSS OAI21_X1
XI1_I42_I69_XP I1_I42_pn3 I1_I42_pn2 I1_I42_P3_2 VDD VSS NOR2_X1
XI1_I42_I70_XG I1_I42_pn4 I1_I42_gn3 I1_I42_gn4 I1_I42_G4_3 VDD VSS OAI21_X1
XI1_I42_I70_XP I1_I42_pn4 I1_I42_pn3 I1_I42_P4_3 VDD VSS NOR2_X1
XI1_I42_I71_XG I1_I42_pn5 I1_I42_gn4 I1_I42_gn5 I1_I42_G5_4 VDD VSS OAI21_X1
XI1_I42_I71_XP I1_I42_pn5 I1_I42_pn4 I1_I42_P5_4 VDD VSS NOR2_X1
XI1_I42_I72_XG I1_I42_pn6 I1_I42_gn5 I1_I42_gn6 I1_I42_G6_5 VDD VSS OAI21_X1
XI1_I42_I72_XP I1_I42_pn6 I1_I42_pn5 I1_I42_P6_5 VDD VSS NOR2_X1
XI1_I42_I73_XG I1_I42_pn7 I1_I42_gn6 I1_I42_gn7 I1_I42_G7_6 VDD VSS OAI21_X1
XI1_I42_I73_XP I1_I42_pn7 I1_I42_pn6 I1_I42_P7_6 VDD VSS NOR2_X1
XI1_I42_I74_XG I1_I42_pn8 I1_I42_gn7 I1_I42_gn8 I1_I42_G8_7 VDD VSS OAI21_X1
XI1_I42_I74_XP I1_I42_pn8 I1_I42_pn7 I1_I42_P8_7 VDD VSS NOR2_X1
XI1_I42_I75_XG I1_I42_pn9 I1_I42_gn8 I1_I42_gn9 I1_I42_G9_8 VDD VSS OAI21_X1
XI1_I42_I75_XP I1_I42_pn9 I1_I42_pn8 I1_I42_P9_8 VDD VSS NOR2_X1
XI1_I42_I76_XG I1_I42_pn10 I1_I42_gn9 I1_I42_gn10 I1_I42_G10_9 VDD VSS OAI21_X1
XI1_I42_I76_XP I1_I42_pn10 I1_I42_pn9 I1_I42_P10_9 VDD VSS NOR2_X1
XI1_I42_I77_XG I1_I42_pn11 I1_I42_gn10 I1_I42_gn11 I1_I42_G11_10 VDD VSS OAI21_X1
XI1_I42_I77_XP I1_I42_pn11 I1_I42_pn10 I1_I42_P11_10 VDD VSS NOR2_X1
XI1_I42_I78_XG I1_I42_pn12 I1_I42_gn11 I1_I42_gn12 I1_I42_G12_11 VDD VSS OAI21_X1
XI1_I42_I78_XP I1_I42_pn12 I1_I42_pn11 I1_I42_P12_11 VDD VSS NOR2_X1
XI1_I42_I79_XG I1_I42_pn13 I1_I42_gn12 I1_I42_gn13 I1_I42_G13_12 VDD VSS OAI21_X1
XI1_I42_I79_XP I1_I42_pn13 I1_I42_pn12 I1_I42_P13_12 VDD VSS NOR2_X1
XI1_I42_I80_XG I1_I42_pn14 I1_I42_gn13 I1_I42_gn14 I1_I42_G14_13 VDD VSS OAI21_X1
XI1_I42_I80_XP I1_I42_pn14 I1_I42_pn13 I1_I42_P14_13 VDD VSS NOR2_X1
XI1_I42_I81_XG I1_I42_pn15 I1_I42_gn14 I1_I42_gn15 I1_I42_G15_14 VDD VSS OAI21_X1
XI1_I42_I81_XP I1_I42_pn15 I1_I42_pn14 I1_I42_P15_14 VDD VSS NOR2_X1
XI1_I42_I82_XG I1_I42_pn16 I1_I42_gn15 I1_I42_gn16 I1_I42_G16_15 VDD VSS OAI21_X1
XI1_I42_I82_XP I1_I42_pn16 I1_I42_pn15 I1_I42_P16_15 VDD VSS NOR2_X1
XI1_I42_I83_XG I1_I42_pn17 I1_I42_gn16 I1_I42_gn17 I1_I42_G17_16 VDD VSS OAI21_X1
XI1_I42_I83_XP I1_I42_pn17 I1_I42_pn16 I1_I42_P17_16 VDD VSS NOR2_X1
XI1_I42_I84_XG I1_I42_pn18 I1_I42_gn17 I1_I42_gn18 I1_I42_G18_17 VDD VSS OAI21_X1
XI1_I42_I84_XP I1_I42_pn18 I1_I42_pn17 I1_I42_P18_17 VDD VSS NOR2_X1
XI1_I42_I85_XG I1_I42_pn19 I1_I42_gn18 I1_I42_gn19 I1_I42_G19_18 VDD VSS OAI21_X1
XI1_I42_I85_XP I1_I42_pn19 I1_I42_pn18 I1_I42_P19_18 VDD VSS NOR2_X1
XI1_I42_I86_XG I1_I42_pn20 I1_I42_gn19 I1_I42_gn20 I1_I42_G20_19 VDD VSS OAI21_X1
XI1_I42_I86_XP I1_I42_pn20 I1_I42_pn19 I1_I42_P20_19 VDD VSS NOR2_X1
XI1_I42_I87_XG I1_I42_pn21 I1_I42_gn20 I1_I42_gn21 I1_I42_G21_20 VDD VSS OAI21_X1
XI1_I42_I87_XP I1_I42_pn21 I1_I42_pn20 I1_I42_P21_20 VDD VSS NOR2_X1
XI1_I42_I88_XG I1_I42_pn22 I1_I42_gn21 I1_I42_gn22 I1_I42_G22_21 VDD VSS OAI21_X1
XI1_I42_I88_XP I1_I42_pn22 I1_I42_pn21 I1_I42_P22_21 VDD VSS NOR2_X1
XI1_I42_I89_XG I1_I42_pn23 I1_I42_gn22 I1_I42_gn23 I1_I42_G23_22 VDD VSS OAI21_X1
XI1_I42_I89_XP I1_I42_pn23 I1_I42_pn22 I1_I42_P23_22 VDD VSS NOR2_X1
XI1_I42_I90_XG I1_I42_pn24 I1_I42_gn23 I1_I42_gn24 I1_I42_G24_23 VDD VSS OAI21_X1
XI1_I42_I90_XP I1_I42_pn24 I1_I42_pn23 I1_I42_P24_23 VDD VSS NOR2_X1
XI1_I42_I91_XG I1_I42_pn25 I1_I42_gn24 I1_I42_gn25 I1_I42_G25_24 VDD VSS OAI21_X1
XI1_I42_I91_XP I1_I42_pn25 I1_I42_pn24 I1_I42_P25_24 VDD VSS NOR2_X1
XI1_I42_I92_XG I1_I42_pn26 I1_I42_gn25 I1_I42_gn26 I1_I42_G26_25 VDD VSS OAI21_X1
XI1_I42_I92_XP I1_I42_pn26 I1_I42_pn25 I1_I42_P26_25 VDD VSS NOR2_X1
XI1_I42_I93_XG I1_I42_pn27 I1_I42_gn26 I1_I42_gn27 I1_I42_G27_26 VDD VSS OAI21_X1
XI1_I42_I93_XP I1_I42_pn27 I1_I42_pn26 I1_I42_P27_26 VDD VSS NOR2_X1
XI1_I42_I94_XG I1_I42_pn28 I1_I42_gn27 I1_I42_gn28 I1_I42_G28_27 VDD VSS OAI21_X1
XI1_I42_I94_XP I1_I42_pn28 I1_I42_pn27 I1_I42_P28_27 VDD VSS NOR2_X1
XI1_I42_I95_XG I1_I42_pn29 I1_I42_gn28 I1_I42_gn29 I1_I42_G29_28 VDD VSS OAI21_X1
XI1_I42_I95_XP I1_I42_pn29 I1_I42_pn28 I1_I42_P29_28 VDD VSS NOR2_X1
XI1_I42_I96_XG I1_I42_pn30 I1_I42_gn29 I1_I42_gn30 I1_I42_G30_29 VDD VSS OAI21_X1
XI1_I42_I96_XP I1_I42_pn30 I1_I42_pn29 I1_I42_P30_29 VDD VSS NOR2_X1
XI1_I42_I97_XG I1_I42_pn31 I1_I42_gn30 I1_I42_gn31 I1_I42_G31_30 VDD VSS OAI21_X1
XI1_I42_I97_XP I1_I42_pn31 I1_I42_pn30 I1_I42_P31_30 VDD VSS NOR2_X1
XI1_I42_I98_XG I1_I42_P2_1 I1_I42_G0_0 I1_I42_G2_1 I1_I42_G2_0n VDD VSS AOI21_X1
XI1_I42_I99_XG I1_I42_P3_2 I1_I42_G1_0 I1_I42_G3_2 I1_I42_G3_0n VDD VSS AOI21_X1
XI1_I42_I100_XG I1_I42_P4_3 I1_I42_G2_1 I1_I42_G4_3 I1_I42_G4_1n VDD VSS AOI21_X1
XI1_I42_I100_XP I1_I42_P4_3 I1_I42_P2_1 I1_I42_P4_1n VDD VSS NAND2_X1
XI1_I42_I101_XG I1_I42_P5_4 I1_I42_G3_2 I1_I42_G5_4 I1_I42_G5_2n VDD VSS AOI21_X1
XI1_I42_I101_XP I1_I42_P5_4 I1_I42_P3_2 I1_I42_P5_2n VDD VSS NAND2_X1
XI1_I42_I102_XG I1_I42_P6_5 I1_I42_G4_3 I1_I42_G6_5 I1_I42_G6_3n VDD VSS AOI21_X1
XI1_I42_I102_XP I1_I42_P6_5 I1_I42_P4_3 I1_I42_P6_3n VDD VSS NAND2_X1
XI1_I42_I103_XG I1_I42_P7_6 I1_I42_G5_4 I1_I42_G7_6 I1_I42_G7_4n VDD VSS AOI21_X1
XI1_I42_I103_XP I1_I42_P7_6 I1_I42_P5_4 I1_I42_P7_4n VDD VSS NAND2_X1
XI1_I42_I104_XG I1_I42_P8_7 I1_I42_G6_5 I1_I42_G8_7 I1_I42_G8_5n VDD VSS AOI21_X1
XI1_I42_I104_XP I1_I42_P8_7 I1_I42_P6_5 I1_I42_P8_5n VDD VSS NAND2_X1
XI1_I42_I105_XG I1_I42_P9_8 I1_I42_G7_6 I1_I42_G9_8 I1_I42_G9_6n VDD VSS AOI21_X1
XI1_I42_I105_XP I1_I42_P9_8 I1_I42_P7_6 I1_I42_P9_6n VDD VSS NAND2_X1
XI1_I42_I106_XG I1_I42_P10_9 I1_I42_G8_7 I1_I42_G10_9 I1_I42_G10_7n VDD VSS AOI21_X1
XI1_I42_I106_XP I1_I42_P10_9 I1_I42_P8_7 I1_I42_P10_7n VDD VSS NAND2_X1
XI1_I42_I107_XG I1_I42_P11_10 I1_I42_G9_8 I1_I42_G11_10 I1_I42_G11_8n VDD VSS AOI21_X1
XI1_I42_I107_XP I1_I42_P11_10 I1_I42_P9_8 I1_I42_P11_8n VDD VSS NAND2_X1
XI1_I42_I108_XG I1_I42_P12_11 I1_I42_G10_9 I1_I42_G12_11 I1_I42_G12_9n VDD VSS AOI21_X1
XI1_I42_I108_XP I1_I42_P12_11 I1_I42_P10_9 I1_I42_P12_9n VDD VSS NAND2_X1
XI1_I42_I109_XG I1_I42_P13_12 I1_I42_G11_10 I1_I42_G13_12 I1_I42_G13_10n VDD VSS AOI21_X1
XI1_I42_I109_XP I1_I42_P13_12 I1_I42_P11_10 I1_I42_P13_10n VDD VSS NAND2_X1
XI1_I42_I110_XG I1_I42_P14_13 I1_I42_G12_11 I1_I42_G14_13 I1_I42_G14_11n VDD VSS AOI21_X1
XI1_I42_I110_XP I1_I42_P14_13 I1_I42_P12_11 I1_I42_P14_11n VDD VSS NAND2_X1
XI1_I42_I111_XG I1_I42_P15_14 I1_I42_G13_12 I1_I42_G15_14 I1_I42_G15_12n VDD VSS AOI21_X1
XI1_I42_I111_XP I1_I42_P15_14 I1_I42_P13_12 I1_I42_P15_12n VDD VSS NAND2_X1
XI1_I42_I112_XG I1_I42_P16_15 I1_I42_G14_13 I1_I42_G16_15 I1_I42_G16_13n VDD VSS AOI21_X1
XI1_I42_I112_XP I1_I42_P16_15 I1_I42_P14_13 I1_I42_P16_13n VDD VSS NAND2_X1
XI1_I42_I113_XG I1_I42_P17_16 I1_I42_G15_14 I1_I42_G17_16 I1_I42_G17_14n VDD VSS AOI21_X1
XI1_I42_I113_XP I1_I42_P17_16 I1_I42_P15_14 I1_I42_P17_14n VDD VSS NAND2_X1
XI1_I42_I114_XG I1_I42_P18_17 I1_I42_G16_15 I1_I42_G18_17 I1_I42_G18_15n VDD VSS AOI21_X1
XI1_I42_I114_XP I1_I42_P18_17 I1_I42_P16_15 I1_I42_P18_15n VDD VSS NAND2_X1
XI1_I42_I115_XG I1_I42_P19_18 I1_I42_G17_16 I1_I42_G19_18 I1_I42_G19_16n VDD VSS AOI21_X1
XI1_I42_I115_XP I1_I42_P19_18 I1_I42_P17_16 I1_I42_P19_16n VDD VSS NAND2_X1
XI1_I42_I116_XG I1_I42_P20_19 I1_I42_G18_17 I1_I42_G20_19 I1_I42_G20_17n VDD VSS AOI21_X1
XI1_I42_I116_XP I1_I42_P20_19 I1_I42_P18_17 I1_I42_P20_17n VDD VSS NAND2_X1
XI1_I42_I117_XG I1_I42_P21_20 I1_I42_G19_18 I1_I42_G21_20 I1_I42_G21_18n VDD VSS AOI21_X1
XI1_I42_I117_XP I1_I42_P21_20 I1_I42_P19_18 I1_I42_P21_18n VDD VSS NAND2_X1
XI1_I42_I118_XG I1_I42_P22_21 I1_I42_G20_19 I1_I42_G22_21 I1_I42_G22_19n VDD VSS AOI21_X1
XI1_I42_I118_XP I1_I42_P22_21 I1_I42_P20_19 I1_I42_P22_19n VDD VSS NAND2_X1
XI1_I42_I119_XG I1_I42_P23_22 I1_I42_G21_20 I1_I42_G23_22 I1_I42_G23_20n VDD VSS AOI21_X1
XI1_I42_I119_XP I1_I42_P23_22 I1_I42_P21_20 I1_I42_P23_20n VDD VSS NAND2_X1
XI1_I42_I120_XG I1_I42_P24_23 I1_I42_G22_21 I1_I42_G24_23 I1_I42_G24_21n VDD VSS AOI21_X1
XI1_I42_I120_XP I1_I42_P24_23 I1_I42_P22_21 I1_I42_P24_21n VDD VSS NAND2_X1
XI1_I42_I121_XG I1_I42_P25_24 I1_I42_G23_22 I1_I42_G25_24 I1_I42_G25_22n VDD VSS AOI21_X1
XI1_I42_I121_XP I1_I42_P25_24 I1_I42_P23_22 I1_I42_P25_22n VDD VSS NAND2_X1
XI1_I42_I122_XG I1_I42_P26_25 I1_I42_G24_23 I1_I42_G26_25 I1_I42_G26_23n VDD VSS AOI21_X1
XI1_I42_I122_XP I1_I42_P26_25 I1_I42_P24_23 I1_I42_P26_23n VDD VSS NAND2_X1
XI1_I42_I123_XG I1_I42_P27_26 I1_I42_G25_24 I1_I42_G27_26 I1_I42_G27_24n VDD VSS AOI21_X1
XI1_I42_I123_XP I1_I42_P27_26 I1_I42_P25_24 I1_I42_P27_24n VDD VSS NAND2_X1
XI1_I42_I124_XG I1_I42_P28_27 I1_I42_G26_25 I1_I42_G28_27 I1_I42_G28_25n VDD VSS AOI21_X1
XI1_I42_I124_XP I1_I42_P28_27 I1_I42_P26_25 I1_I42_P28_25n VDD VSS NAND2_X1
XI1_I42_I125_XG I1_I42_P29_28 I1_I42_G27_26 I1_I42_G29_28 I1_I42_G29_26n VDD VSS AOI21_X1
XI1_I42_I125_XP I1_I42_P29_28 I1_I42_P27_26 I1_I42_P29_26n VDD VSS NAND2_X1
XI1_I42_I126_XG I1_I42_P30_29 I1_I42_G28_27 I1_I42_G30_29 I1_I42_G30_27n VDD VSS AOI21_X1
XI1_I42_I126_XP I1_I42_P30_29 I1_I42_P28_27 I1_I42_P30_27n VDD VSS NAND2_X1
XI1_I42_I127_XG I1_I42_P31_30 I1_I42_G29_28 I1_I42_G31_30 I1_I42_G31_28n VDD VSS AOI21_X1
XI1_I42_I127_XP I1_I42_P31_30 I1_I42_P29_28 I1_I42_P31_28n VDD VSS NAND2_X1
XI1_I42_I128_XG I1_I42_P4_1n I1_I42_G0_0n I1_I42_G4_1n I1_I42_G4_0 VDD VSS OAI21_X1
XI1_I42_I129 I1_I42_G1_0 I1_I42_G1_0n VDD VSS INV_X1
XI1_I42_I130_XG I1_I42_P5_2n I1_I42_G1_0n I1_I42_G5_2n I1_I42_G5_0 VDD VSS OAI21_X1
XI1_I42_I131_XG I1_I42_P6_3n I1_I42_G2_0n I1_I42_G6_3n I1_I42_G6_0 VDD VSS OAI21_X1
XI1_I42_I132_XG I1_I42_P7_4n I1_I42_G3_0n I1_I42_G7_4n I1_I42_G7_0 VDD VSS OAI21_X1
XI1_I42_I133_XG I1_I42_P8_5n I1_I42_G4_1n I1_I42_G8_5n I1_I42_G8_1 VDD VSS OAI21_X1
XI1_I42_I133_XP I1_I42_P8_5n I1_I42_P4_1n I1_I42_P8_1 VDD VSS NOR2_X1
XI1_I42_I134_XG I1_I42_P9_6n I1_I42_G5_2n I1_I42_G9_6n I1_I42_G9_2 VDD VSS OAI21_X1
XI1_I42_I134_XP I1_I42_P9_6n I1_I42_P5_2n I1_I42_P9_2 VDD VSS NOR2_X1
XI1_I42_I135_XG I1_I42_P10_7n I1_I42_G6_3n I1_I42_G10_7n I1_I42_G10_3 VDD VSS OAI21_X1
XI1_I42_I135_XP I1_I42_P10_7n I1_I42_P6_3n I1_I42_P10_3 VDD VSS NOR2_X1
XI1_I42_I136_XG I1_I42_P11_8n I1_I42_G7_4n I1_I42_G11_8n I1_I42_G11_4 VDD VSS OAI21_X1
XI1_I42_I136_XP I1_I42_P11_8n I1_I42_P7_4n I1_I42_P11_4 VDD VSS NOR2_X1
XI1_I42_I137_XG I1_I42_P12_9n I1_I42_G8_5n I1_I42_G12_9n I1_I42_G12_5 VDD VSS OAI21_X1
XI1_I42_I137_XP I1_I42_P12_9n I1_I42_P8_5n I1_I42_P12_5 VDD VSS NOR2_X1
XI1_I42_I138_XG I1_I42_P13_10n I1_I42_G9_6n I1_I42_G13_10n I1_I42_G13_6 VDD VSS OAI21_X1
XI1_I42_I138_XP I1_I42_P13_10n I1_I42_P9_6n I1_I42_P13_6 VDD VSS NOR2_X1
XI1_I42_I139_XG I1_I42_P14_11n I1_I42_G10_7n I1_I42_G14_11n I1_I42_G14_7 VDD VSS OAI21_X1
XI1_I42_I139_XP I1_I42_P14_11n I1_I42_P10_7n I1_I42_P14_7 VDD VSS NOR2_X1
XI1_I42_I140_XG I1_I42_P15_12n I1_I42_G11_8n I1_I42_G15_12n I1_I42_G15_8 VDD VSS OAI21_X1
XI1_I42_I140_XP I1_I42_P15_12n I1_I42_P11_8n I1_I42_P15_8 VDD VSS NOR2_X1
XI1_I42_I141_XG I1_I42_P16_13n I1_I42_G12_9n I1_I42_G16_13n I1_I42_G16_9 VDD VSS OAI21_X1
XI1_I42_I141_XP I1_I42_P16_13n I1_I42_P12_9n I1_I42_P16_9 VDD VSS NOR2_X1
XI1_I42_I142_XG I1_I42_P17_14n I1_I42_G13_10n I1_I42_G17_14n I1_I42_G17_10 VDD VSS OAI21_X1
XI1_I42_I142_XP I1_I42_P17_14n I1_I42_P13_10n I1_I42_P17_10 VDD VSS NOR2_X1
XI1_I42_I143_XG I1_I42_P18_15n I1_I42_G14_11n I1_I42_G18_15n I1_I42_G18_11 VDD VSS OAI21_X1
XI1_I42_I143_XP I1_I42_P18_15n I1_I42_P14_11n I1_I42_P18_11 VDD VSS NOR2_X1
XI1_I42_I144_XG I1_I42_P19_16n I1_I42_G15_12n I1_I42_G19_16n I1_I42_G19_12 VDD VSS OAI21_X1
XI1_I42_I144_XP I1_I42_P19_16n I1_I42_P15_12n I1_I42_P19_12 VDD VSS NOR2_X1
XI1_I42_I145_XG I1_I42_P20_17n I1_I42_G16_13n I1_I42_G20_17n I1_I42_G20_13 VDD VSS OAI21_X1
XI1_I42_I145_XP I1_I42_P20_17n I1_I42_P16_13n I1_I42_P20_13 VDD VSS NOR2_X1
XI1_I42_I146_XG I1_I42_P21_18n I1_I42_G17_14n I1_I42_G21_18n I1_I42_G21_14 VDD VSS OAI21_X1
XI1_I42_I146_XP I1_I42_P21_18n I1_I42_P17_14n I1_I42_P21_14 VDD VSS NOR2_X1
XI1_I42_I147_XG I1_I42_P22_19n I1_I42_G18_15n I1_I42_G22_19n I1_I42_G22_15 VDD VSS OAI21_X1
XI1_I42_I147_XP I1_I42_P22_19n I1_I42_P18_15n I1_I42_P22_15 VDD VSS NOR2_X1
XI1_I42_I148_XG I1_I42_P23_20n I1_I42_G19_16n I1_I42_G23_20n I1_I42_G23_16 VDD VSS OAI21_X1
XI1_I42_I148_XP I1_I42_P23_20n I1_I42_P19_16n I1_I42_P23_16 VDD VSS NOR2_X1
XI1_I42_I149_XG I1_I42_P24_21n I1_I42_G20_17n I1_I42_G24_21n I1_I42_G24_17 VDD VSS OAI21_X1
XI1_I42_I149_XP I1_I42_P24_21n I1_I42_P20_17n I1_I42_P24_17 VDD VSS NOR2_X1
XI1_I42_I150_XG I1_I42_P25_22n I1_I42_G21_18n I1_I42_G25_22n I1_I42_G25_18 VDD VSS OAI21_X1
XI1_I42_I150_XP I1_I42_P25_22n I1_I42_P21_18n I1_I42_P25_18 VDD VSS NOR2_X1
XI1_I42_I151_XG I1_I42_P26_23n I1_I42_G22_19n I1_I42_G26_23n I1_I42_G26_19 VDD VSS OAI21_X1
XI1_I42_I151_XP I1_I42_P26_23n I1_I42_P22_19n I1_I42_P26_19 VDD VSS NOR2_X1
XI1_I42_I152_XG I1_I42_P27_24n I1_I42_G23_20n I1_I42_G27_24n I1_I42_G27_20 VDD VSS OAI21_X1
XI1_I42_I152_XP I1_I42_P27_24n I1_I42_P23_20n I1_I42_P27_20 VDD VSS NOR2_X1
XI1_I42_I153_XG I1_I42_P28_25n I1_I42_G24_21n I1_I42_G28_25n I1_I42_G28_21 VDD VSS OAI21_X1
XI1_I42_I153_XP I1_I42_P28_25n I1_I42_P24_21n I1_I42_P28_21 VDD VSS NOR2_X1
XI1_I42_I154_XG I1_I42_P29_26n I1_I42_G25_22n I1_I42_G29_26n I1_I42_G29_22 VDD VSS OAI21_X1
XI1_I42_I154_XP I1_I42_P29_26n I1_I42_P25_22n I1_I42_P29_22 VDD VSS NOR2_X1
XI1_I42_I155_XG I1_I42_P30_27n I1_I42_G26_23n I1_I42_G30_27n I1_I42_G30_23 VDD VSS OAI21_X1
XI1_I42_I155_XP I1_I42_P30_27n I1_I42_P26_23n I1_I42_P30_23 VDD VSS NOR2_X1
XI1_I42_I156_XG I1_I42_P31_28n I1_I42_G27_24n I1_I42_G31_28n I1_I42_G31_24 VDD VSS OAI21_X1
XI1_I42_I156_XP I1_I42_P31_28n I1_I42_P27_24n I1_I42_P31_24 VDD VSS NOR2_X1
XI1_I42_I157_XG I1_I42_P8_1 I1_I42_G0_0 I1_I42_G8_1 I1_I42_G8_0n VDD VSS AOI21_X1
XI1_I42_I158_XG I1_I42_P9_2 I1_I42_G1_0 I1_I42_G9_2 I1_I42_G9_0n VDD VSS AOI21_X1
XI1_I42_I159 I1_I42_G2_0n I1_I42_G2_0np VDD VSS INV_X1
XI1_I42_I160_XG I1_I42_P10_3 I1_I42_G2_0np I1_I42_G10_3 I1_I42_G10_0n VDD VSS AOI21_X1
XI1_I42_I161 I1_I42_G3_0n I1_I42_G3_0np VDD VSS INV_X1
XI1_I42_I162_XG I1_I42_P11_4 I1_I42_G3_0np I1_I42_G11_4 I1_I42_G11_0n VDD VSS AOI21_X1
XI1_I42_I163_XG I1_I42_P12_5 I1_I42_G4_0 I1_I42_G12_5 I1_I42_G12_0n VDD VSS AOI21_X1
XI1_I42_I164_XG I1_I42_P13_6 I1_I42_G5_0 I1_I42_G13_6 I1_I42_G13_0n VDD VSS AOI21_X1
XI1_I42_I165_XG I1_I42_P14_7 I1_I42_G6_0 I1_I42_G14_7 I1_I42_G14_0n VDD VSS AOI21_X1
XI1_I42_I166_XG I1_I42_P15_8 I1_I42_G7_0 I1_I42_G15_8 I1_I42_G15_0n VDD VSS AOI21_X1
XI1_I42_I167_XG I1_I42_P16_9 I1_I42_G8_1 I1_I42_G16_9 I1_I42_G16_1n VDD VSS AOI21_X1
XI1_I42_I167_XP I1_I42_P16_9 I1_I42_P8_1 I1_I42_P16_1n VDD VSS NAND2_X1
XI1_I42_I168_XG I1_I42_P17_10 I1_I42_G9_2 I1_I42_G17_10 I1_I42_G17_2n VDD VSS AOI21_X1
XI1_I42_I168_XP I1_I42_P17_10 I1_I42_P9_2 I1_I42_P17_2n VDD VSS NAND2_X1
XI1_I42_I169_XG I1_I42_P18_11 I1_I42_G10_3 I1_I42_G18_11 I1_I42_G18_3n VDD VSS AOI21_X1
XI1_I42_I169_XP I1_I42_P18_11 I1_I42_P10_3 I1_I42_P18_3n VDD VSS NAND2_X1
XI1_I42_I170_XG I1_I42_P19_12 I1_I42_G11_4 I1_I42_G19_12 I1_I42_G19_4n VDD VSS AOI21_X1
XI1_I42_I170_XP I1_I42_P19_12 I1_I42_P11_4 I1_I42_P19_4n VDD VSS NAND2_X1
XI1_I42_I171_XG I1_I42_P20_13 I1_I42_G12_5 I1_I42_G20_13 I1_I42_G20_5n VDD VSS AOI21_X1
XI1_I42_I171_XP I1_I42_P20_13 I1_I42_P12_5 I1_I42_P20_5n VDD VSS NAND2_X1
XI1_I42_I172_XG I1_I42_P21_14 I1_I42_G13_6 I1_I42_G21_14 I1_I42_G21_6n VDD VSS AOI21_X1
XI1_I42_I172_XP I1_I42_P21_14 I1_I42_P13_6 I1_I42_P21_6n VDD VSS NAND2_X1
XI1_I42_I173_XG I1_I42_P22_15 I1_I42_G14_7 I1_I42_G22_15 I1_I42_G22_7n VDD VSS AOI21_X1
XI1_I42_I173_XP I1_I42_P22_15 I1_I42_P14_7 I1_I42_P22_7n VDD VSS NAND2_X1
XI1_I42_I174_XG I1_I42_P23_16 I1_I42_G15_8 I1_I42_G23_16 I1_I42_G23_8n VDD VSS AOI21_X1
XI1_I42_I174_XP I1_I42_P23_16 I1_I42_P15_8 I1_I42_P23_8n VDD VSS NAND2_X1
XI1_I42_I175_XG I1_I42_P24_17 I1_I42_G16_9 I1_I42_G24_17 I1_I42_G24_9n VDD VSS AOI21_X1
XI1_I42_I175_XP I1_I42_P24_17 I1_I42_P16_9 I1_I42_P24_9n VDD VSS NAND2_X1
XI1_I42_I176_XG I1_I42_P25_18 I1_I42_G17_10 I1_I42_G25_18 I1_I42_G25_10n VDD VSS AOI21_X1
XI1_I42_I176_XP I1_I42_P25_18 I1_I42_P17_10 I1_I42_P25_10n VDD VSS NAND2_X1
XI1_I42_I177_XG I1_I42_P26_19 I1_I42_G18_11 I1_I42_G26_19 I1_I42_G26_11n VDD VSS AOI21_X1
XI1_I42_I177_XP I1_I42_P26_19 I1_I42_P18_11 I1_I42_P26_11n VDD VSS NAND2_X1
XI1_I42_I178_XG I1_I42_P27_20 I1_I42_G19_12 I1_I42_G27_20 I1_I42_G27_12n VDD VSS AOI21_X1
XI1_I42_I178_XP I1_I42_P27_20 I1_I42_P19_12 I1_I42_P27_12n VDD VSS NAND2_X1
XI1_I42_I179_XG I1_I42_P28_21 I1_I42_G20_13 I1_I42_G28_21 I1_I42_G28_13n VDD VSS AOI21_X1
XI1_I42_I179_XP I1_I42_P28_21 I1_I42_P20_13 I1_I42_P28_13n VDD VSS NAND2_X1
XI1_I42_I180_XG I1_I42_P29_22 I1_I42_G21_14 I1_I42_G29_22 I1_I42_G29_14n VDD VSS AOI21_X1
XI1_I42_I180_XP I1_I42_P29_22 I1_I42_P21_14 I1_I42_P29_14n VDD VSS NAND2_X1
XI1_I42_I181_XG I1_I42_P30_23 I1_I42_G22_15 I1_I42_G30_23 I1_I42_G30_15n VDD VSS AOI21_X1
XI1_I42_I181_XP I1_I42_P30_23 I1_I42_P22_15 I1_I42_P30_15n VDD VSS NAND2_X1
XI1_I42_I182_XG I1_I42_P31_24 I1_I42_G23_16 I1_I42_G31_24 I1_I42_G31_16n VDD VSS AOI21_X1
XI1_I42_I182_XP I1_I42_P31_24 I1_I42_P23_16 I1_I42_P31_16n VDD VSS NAND2_X1
XI1_I42_I183_XG I1_I42_P16_1n I1_I42_G0_0n I1_I42_G16_1n I1_I42_G16_0 VDD VSS OAI21_X1
XI1_I42_I184_XG I1_I42_P17_2n I1_I42_G1_0n I1_I42_G17_2n I1_I42_G17_0 VDD VSS OAI21_X1
XI1_I42_I185_XG I1_I42_P18_3n I1_I42_G2_0n I1_I42_G18_3n I1_I42_G18_0 VDD VSS OAI21_X1
XI1_I42_I186_XG I1_I42_P19_4n I1_I42_G3_0n I1_I42_G19_4n I1_I42_G19_0 VDD VSS OAI21_X1
XI1_I42_I187 I1_I42_G4_0 I1_I42_G4_0n VDD VSS INV_X1
XI1_I42_I188_XG I1_I42_P20_5n I1_I42_G4_0n I1_I42_G20_5n I1_I42_G20_0 VDD VSS OAI21_X1
XI1_I42_I189 I1_I42_G5_0 I1_I42_G5_0n VDD VSS INV_X1
XI1_I42_I190_XG I1_I42_P21_6n I1_I42_G5_0n I1_I42_G21_6n I1_I42_G21_0 VDD VSS OAI21_X1
XI1_I42_I191 I1_I42_G6_0 I1_I42_G6_0n VDD VSS INV_X1
XI1_I42_I192_XG I1_I42_P22_7n I1_I42_G6_0n I1_I42_G22_7n I1_I42_G22_0 VDD VSS OAI21_X1
XI1_I42_I193 I1_I42_G7_0 I1_I42_G7_0n VDD VSS INV_X1
XI1_I42_I194_XG I1_I42_P23_8n I1_I42_G7_0n I1_I42_G23_8n I1_I42_G23_0 VDD VSS OAI21_X1
XI1_I42_I195_XG I1_I42_P24_9n I1_I42_G8_0n I1_I42_G24_9n I1_I42_G24_0 VDD VSS OAI21_X1
XI1_I42_I196_XG I1_I42_P25_10n I1_I42_G9_0n I1_I42_G25_10n I1_I42_G25_0 VDD VSS OAI21_X1
XI1_I42_I197_XG I1_I42_P26_11n I1_I42_G10_0n I1_I42_G26_11n I1_I42_G26_0 VDD VSS OAI21_X1
XI1_I42_I198_XG I1_I42_P27_12n I1_I42_G11_0n I1_I42_G27_12n I1_I42_G27_0 VDD VSS OAI21_X1
XI1_I42_I199_XG I1_I42_P28_13n I1_I42_G12_0n I1_I42_G28_13n I1_I42_G28_0 VDD VSS OAI21_X1
XI1_I42_I200_XG I1_I42_P29_14n I1_I42_G13_0n I1_I42_G29_14n I1_I42_G29_0 VDD VSS OAI21_X1
XI1_I42_I201_XG I1_I42_P30_15n I1_I42_G14_0n I1_I42_G30_15n CM VDD VSS OAI21_X1
XI1_I42_I202_XG I1_I42_P31_16n I1_I42_G15_0n I1_I42_G31_16n CO VDD VSS OAI21_X1
XI1_I42_I203 I1_I42_pn0 I1_SUB_b3_5 S_0 VDD VSS XNOR2_X1
XI1_I42_I204 I1_I42_pn1 I1_I42_G0_0 S_1 VDD VSS XNOR2_X1
XI1_I42_I205 I1_I42_pn2 I1_I42_G1_0 S_2 VDD VSS XNOR2_X1
XI1_I42_I206 I1_I42_pn3 I1_I42_G2_0n S_3 VDD VSS XOR2_X1
XI1_I42_I207 I1_I42_pn4 I1_I42_G3_0n S_4 VDD VSS XOR2_X1
XI1_I42_I208 I1_I42_pn5 I1_I42_G4_0 S_5 VDD VSS XNOR2_X1
XI1_I42_I209 I1_I42_pn6 I1_I42_G5_0 S_6 VDD VSS XNOR2_X1
XI1_I42_I210 I1_I42_pn7 I1_I42_G6_0 S_7 VDD VSS XNOR2_X1
XI1_I42_I211 I1_I42_pn8 I1_I42_G7_0 S_8 VDD VSS XNOR2_X1
XI1_I42_I212 I1_I42_pn9 I1_I42_G8_0n S_9 VDD VSS XOR2_X1
XI1_I42_I213 I1_I42_pn10 I1_I42_G9_0n S_10 VDD VSS XOR2_X1
XI1_I42_I214 I1_I42_pn11 I1_I42_G10_0n S_11 VDD VSS XOR2_X1
XI1_I42_I215 I1_I42_pn12 I1_I42_G11_0n S_12 VDD VSS XOR2_X1
XI1_I42_I216 I1_I42_pn13 I1_I42_G12_0n S_13 VDD VSS XOR2_X1
XI1_I42_I217 I1_I42_pn14 I1_I42_G13_0n S_14 VDD VSS XOR2_X1
XI1_I42_I218 I1_I42_pn15 I1_I42_G14_0n S_15 VDD VSS XOR2_X1
XI1_I42_I219 I1_I42_pn16 I1_I42_G15_0n S_16 VDD VSS XOR2_X1
XI1_I42_I220 I1_I42_pn17 I1_I42_G16_0 S_17 VDD VSS XNOR2_X1
XI1_I42_I221 I1_I42_pn18 I1_I42_G17_0 S_18 VDD VSS XNOR2_X1
XI1_I42_I222 I1_I42_pn19 I1_I42_G18_0 S_19 VDD VSS XNOR2_X1
XI1_I42_I223 I1_I42_pn20 I1_I42_G19_0 S_20 VDD VSS XNOR2_X1
XI1_I42_I224 I1_I42_pn21 I1_I42_G20_0 S_21 VDD VSS XNOR2_X1
XI1_I42_I225 I1_I42_pn22 I1_I42_G21_0 S_22 VDD VSS XNOR2_X1
XI1_I42_I226 I1_I42_pn23 I1_I42_G22_0 S_23 VDD VSS XNOR2_X1
XI1_I42_I227 I1_I42_pn24 I1_I42_G23_0 S_24 VDD VSS XNOR2_X1
XI1_I42_I228 I1_I42_pn25 I1_I42_G24_0 S_25 VDD VSS XNOR2_X1
XI1_I42_I229 I1_I42_pn26 I1_I42_G25_0 S_26 VDD VSS XNOR2_X1
XI1_I42_I230 I1_I42_pn27 I1_I42_G26_0 S_27 VDD VSS XNOR2_X1
XI1_I42_I231 I1_I42_pn28 I1_I42_G27_0 S_28 VDD VSS XNOR2_X1
XI1_I42_I232 I1_I42_pn29 I1_I42_G28_0 S_29 VDD VSS XNOR2_X1
XI1_I42_I233 I1_I42_pn30 I1_I42_G29_0 S_30 VDD VSS XNOR2_X1
XI1_I42_I234 I1_I42_pn31 CM S_31 VDD VSS XNOR2_X1
XI2_I0 A_0 B_0 I2_nand0 VDD VSS NAND2_X1
XI2_I1 I2_nand0 AND_0 VDD VSS INV_X1
XI2_I2 A_0 B_0 I2_nor0 VDD VSS NOR2_X1
XI2_I3 I2_nor0 OR_0 VDD VSS INV_X1
XI2_I4 A_0 B_0 XOR_0 VDD VSS XOR2_X1
XI2_I5 A_0 NOT_0 VDD VSS INV_X1
XI2_I6 A_1 B_1 I2_nand1 VDD VSS NAND2_X1
XI2_I7 I2_nand1 AND_1 VDD VSS INV_X1
XI2_I8 A_1 B_1 I2_nor1 VDD VSS NOR2_X1
XI2_I9 I2_nor1 OR_1 VDD VSS INV_X1
XI2_I10 A_1 B_1 XOR_1 VDD VSS XOR2_X1
XI2_I11 A_1 NOT_1 VDD VSS INV_X1
XI2_I12 A_2 B_2 I2_nand2 VDD VSS NAND2_X1
XI2_I13 I2_nand2 AND_2 VDD VSS INV_X1
XI2_I14 A_2 B_2 I2_nor2 VDD VSS NOR2_X1
XI2_I15 I2_nor2 OR_2 VDD VSS INV_X1
XI2_I16 A_2 B_2 XOR_2 VDD VSS XOR2_X1
XI2_I17 A_2 NOT_2 VDD VSS INV_X1
XI2_I18 A_3 B_3 I2_nand3 VDD VSS NAND2_X1
XI2_I19 I2_nand3 AND_3 VDD VSS INV_X1
XI2_I20 A_3 B_3 I2_nor3 VDD VSS NOR2_X1
XI2_I21 I2_nor3 OR_3 VDD VSS INV_X1
XI2_I22 A_3 B_3 XOR_3 VDD VSS XOR2_X1
XI2_I23 A_3 NOT_3 VDD VSS INV_X1
XI2_I24 A_4 B_4 I2_nand4 VDD VSS NAND2_X1
XI2_I25 I2_nand4 AND_4 VDD VSS INV_X1
XI2_I26 A_4 B_4 I2_nor4 VDD VSS NOR2_X1
XI2_I27 I2_nor4 OR_4 VDD VSS INV_X1
XI2_I28 A_4 B_4 XOR_4 VDD VSS XOR2_X1
XI2_I29 A_4 NOT_4 VDD VSS INV_X1
XI2_I30 A_5 B_5 I2_nand5 VDD VSS NAND2_X1
XI2_I31 I2_nand5 AND_5 VDD VSS INV_X1
XI2_I32 A_5 B_5 I2_nor5 VDD VSS NOR2_X1
XI2_I33 I2_nor5 OR_5 VDD VSS INV_X1
XI2_I34 A_5 B_5 XOR_5 VDD VSS XOR2_X1
XI2_I35 A_5 NOT_5 VDD VSS INV_X1
XI2_I36 A_6 B_6 I2_nand6 VDD VSS NAND2_X1
XI2_I37 I2_nand6 AND_6 VDD VSS INV_X1
XI2_I38 A_6 B_6 I2_nor6 VDD VSS NOR2_X1
XI2_I39 I2_nor6 OR_6 VDD VSS INV_X1
XI2_I40 A_6 B_6 XOR_6 VDD VSS XOR2_X1
XI2_I41 A_6 NOT_6 VDD VSS INV_X1
XI2_I42 A_7 B_7 I2_nand7 VDD VSS NAND2_X1
XI2_I43 I2_nand7 AND_7 VDD VSS INV_X1
XI2_I44 A_7 B_7 I2_nor7 VDD VSS NOR2_X1
XI2_I45 I2_nor7 OR_7 VDD VSS INV_X1
XI2_I46 A_7 B_7 XOR_7 VDD VSS XOR2_X1
XI2_I47 A_7 NOT_7 VDD VSS INV_X1
XI2_I48 A_8 B_8 I2_nand8 VDD VSS NAND2_X1
XI2_I49 I2_nand8 AND_8 VDD VSS INV_X1
XI2_I50 A_8 B_8 I2_nor8 VDD VSS NOR2_X1
XI2_I51 I2_nor8 OR_8 VDD VSS INV_X1
XI2_I52 A_8 B_8 XOR_8 VDD VSS XOR2_X1
XI2_I53 A_8 NOT_8 VDD VSS INV_X1
XI2_I54 A_9 B_9 I2_nand9 VDD VSS NAND2_X1
XI2_I55 I2_nand9 AND_9 VDD VSS INV_X1
XI2_I56 A_9 B_9 I2_nor9 VDD VSS NOR2_X1
XI2_I57 I2_nor9 OR_9 VDD VSS INV_X1
XI2_I58 A_9 B_9 XOR_9 VDD VSS XOR2_X1
XI2_I59 A_9 NOT_9 VDD VSS INV_X1
XI2_I60 A_10 B_10 I2_nand10 VDD VSS NAND2_X1
XI2_I61 I2_nand10 AND_10 VDD VSS INV_X1
XI2_I62 A_10 B_10 I2_nor10 VDD VSS NOR2_X1
XI2_I63 I2_nor10 OR_10 VDD VSS INV_X1
XI2_I64 A_10 B_10 XOR_10 VDD VSS XOR2_X1
XI2_I65 A_10 NOT_10 VDD VSS INV_X1
XI2_I66 A_11 B_11 I2_nand11 VDD VSS NAND2_X1
XI2_I67 I2_nand11 AND_11 VDD VSS INV_X1
XI2_I68 A_11 B_11 I2_nor11 VDD VSS NOR2_X1
XI2_I69 I2_nor11 OR_11 VDD VSS INV_X1
XI2_I70 A_11 B_11 XOR_11 VDD VSS XOR2_X1
XI2_I71 A_11 NOT_11 VDD VSS INV_X1
XI2_I72 A_12 B_12 I2_nand12 VDD VSS NAND2_X1
XI2_I73 I2_nand12 AND_12 VDD VSS INV_X1
XI2_I74 A_12 B_12 I2_nor12 VDD VSS NOR2_X1
XI2_I75 I2_nor12 OR_12 VDD VSS INV_X1
XI2_I76 A_12 B_12 XOR_12 VDD VSS XOR2_X1
XI2_I77 A_12 NOT_12 VDD VSS INV_X1
XI2_I78 A_13 B_13 I2_nand13 VDD VSS NAND2_X1
XI2_I79 I2_nand13 AND_13 VDD VSS INV_X1
XI2_I80 A_13 B_13 I2_nor13 VDD VSS NOR2_X1
XI2_I81 I2_nor13 OR_13 VDD VSS INV_X1
XI2_I82 A_13 B_13 XOR_13 VDD VSS XOR2_X1
XI2_I83 A_13 NOT_13 VDD VSS INV_X1
XI2_I84 A_14 B_14 I2_nand14 VDD VSS NAND2_X1
XI2_I85 I2_nand14 AND_14 VDD VSS INV_X1
XI2_I86 A_14 B_14 I2_nor14 VDD VSS NOR2_X1
XI2_I87 I2_nor14 OR_14 VDD VSS INV_X1
XI2_I88 A_14 B_14 XOR_14 VDD VSS XOR2_X1
XI2_I89 A_14 NOT_14 VDD VSS INV_X1
XI2_I90 A_15 B_15 I2_nand15 VDD VSS NAND2_X1
XI2_I91 I2_nand15 AND_15 VDD VSS INV_X1
XI2_I92 A_15 B_15 I2_nor15 VDD VSS NOR2_X1
XI2_I93 I2_nor15 OR_15 VDD VSS INV_X1
XI2_I94 A_15 B_15 XOR_15 VDD VSS XOR2_X1
XI2_I95 A_15 NOT_15 VDD VSS INV_X1
XI2_I96 A_16 B_16 I2_nand16 VDD VSS NAND2_X1
XI2_I97 I2_nand16 AND_16 VDD VSS INV_X1
XI2_I98 A_16 B_16 I2_nor16 VDD VSS NOR2_X1
XI2_I99 I2_nor16 OR_16 VDD VSS INV_X1
XI2_I100 A_16 B_16 XOR_16 VDD VSS XOR2_X1
XI2_I101 A_16 NOT_16 VDD VSS INV_X1
XI2_I102 A_17 B_17 I2_nand17 VDD VSS NAND2_X1
XI2_I103 I2_nand17 AND_17 VDD VSS INV_X1
XI2_I104 A_17 B_17 I2_nor17 VDD VSS NOR2_X1
XI2_I105 I2_nor17 OR_17 VDD VSS INV_X1
XI2_I106 A_17 B_17 XOR_17 VDD VSS XOR2_X1
XI2_I107 A_17 NOT_17 VDD VSS INV_X1
XI2_I108 A_18 B_18 I2_nand18 VDD VSS NAND2_X1
XI2_I109 I2_nand18 AND_18 VDD VSS INV_X1
XI2_I110 A_18 B_18 I2_nor18 VDD VSS NOR2_X1
XI2_I111 I2_nor18 OR_18 VDD VSS INV_X1
XI2_I112 A_18 B_18 XOR_18 VDD VSS XOR2_X1
XI2_I113 A_18 NOT_18 VDD VSS INV_X1
XI2_I114 A_19 B_19 I2_nand19 VDD VSS NAND2_X1
XI2_I115 I2_nand19 AND_19 VDD VSS INV_X1
XI2_I116 A_19 B_19 I2_nor19 VDD VSS NOR2_X1
XI2_I117 I2_nor19 OR_19 VDD VSS INV_X1
XI2_I118 A_19 B_19 XOR_19 VDD VSS XOR2_X1
XI2_I119 A_19 NOT_19 VDD VSS INV_X1
XI2_I120 A_20 B_20 I2_nand20 VDD VSS NAND2_X1
XI2_I121 I2_nand20 AND_20 VDD VSS INV_X1
XI2_I122 A_20 B_20 I2_nor20 VDD VSS NOR2_X1
XI2_I123 I2_nor20 OR_20 VDD VSS INV_X1
XI2_I124 A_20 B_20 XOR_20 VDD VSS XOR2_X1
XI2_I125 A_20 NOT_20 VDD VSS INV_X1
XI2_I126 A_21 B_21 I2_nand21 VDD VSS NAND2_X1
XI2_I127 I2_nand21 AND_21 VDD VSS INV_X1
XI2_I128 A_21 B_21 I2_nor21 VDD VSS NOR2_X1
XI2_I129 I2_nor21 OR_21 VDD VSS INV_X1
XI2_I130 A_21 B_21 XOR_21 VDD VSS XOR2_X1
XI2_I131 A_21 NOT_21 VDD VSS INV_X1
XI2_I132 A_22 B_22 I2_nand22 VDD VSS NAND2_X1
XI2_I133 I2_nand22 AND_22 VDD VSS INV_X1
XI2_I134 A_22 B_22 I2_nor22 VDD VSS NOR2_X1
XI2_I135 I2_nor22 OR_22 VDD VSS INV_X1
XI2_I136 A_22 B_22 XOR_22 VDD VSS XOR2_X1
XI2_I137 A_22 NOT_22 VDD VSS INV_X1
XI2_I138 A_23 B_23 I2_nand23 VDD VSS NAND2_X1
XI2_I139 I2_nand23 AND_23 VDD VSS INV_X1
XI2_I140 A_23 B_23 I2_nor23 VDD VSS NOR2_X1
XI2_I141 I2_nor23 OR_23 VDD VSS INV_X1
XI2_I142 A_23 B_23 XOR_23 VDD VSS XOR2_X1
XI2_I143 A_23 NOT_23 VDD VSS INV_X1
XI2_I144 A_24 B_24 I2_nand24 VDD VSS NAND2_X1
XI2_I145 I2_nand24 AND_24 VDD VSS INV_X1
XI2_I146 A_24 B_24 I2_nor24 VDD VSS NOR2_X1
XI2_I147 I2_nor24 OR_24 VDD VSS INV_X1
XI2_I148 A_24 B_24 XOR_24 VDD VSS XOR2_X1
XI2_I149 A_24 NOT_24 VDD VSS INV_X1
XI2_I150 A_25 B_25 I2_nand25 VDD VSS NAND2_X1
XI2_I151 I2_nand25 AND_25 VDD VSS INV_X1
XI2_I152 A_25 B_25 I2_nor25 VDD VSS NOR2_X1
XI2_I153 I2_nor25 OR_25 VDD VSS INV_X1
XI2_I154 A_25 B_25 XOR_25 VDD VSS XOR2_X1
XI2_I155 A_25 NOT_25 VDD VSS INV_X1
XI2_I156 A_26 B_26 I2_nand26 VDD VSS NAND2_X1
XI2_I157 I2_nand26 AND_26 VDD VSS INV_X1
XI2_I158 A_26 B_26 I2_nor26 VDD VSS NOR2_X1
XI2_I159 I2_nor26 OR_26 VDD VSS INV_X1
XI2_I160 A_26 B_26 XOR_26 VDD VSS XOR2_X1
XI2_I161 A_26 NOT_26 VDD VSS INV_X1
XI2_I162 A_27 B_27 I2_nand27 VDD VSS NAND2_X1
XI2_I163 I2_nand27 AND_27 VDD VSS INV_X1
XI2_I164 A_27 B_27 I2_nor27 VDD VSS NOR2_X1
XI2_I165 I2_nor27 OR_27 VDD VSS INV_X1
XI2_I166 A_27 B_27 XOR_27 VDD VSS XOR2_X1
XI2_I167 A_27 NOT_27 VDD VSS INV_X1
XI2_I168 A_28 B_28 I2_nand28 VDD VSS NAND2_X1
XI2_I169 I2_nand28 AND_28 VDD VSS INV_X1
XI2_I170 A_28 B_28 I2_nor28 VDD VSS NOR2_X1
XI2_I171 I2_nor28 OR_28 VDD VSS INV_X1
XI2_I172 A_28 B_28 XOR_28 VDD VSS XOR2_X1
XI2_I173 A_28 NOT_28 VDD VSS INV_X1
XI2_I174 A_29 B_29 I2_nand29 VDD VSS NAND2_X1
XI2_I175 I2_nand29 AND_29 VDD VSS INV_X1
XI2_I176 A_29 B_29 I2_nor29 VDD VSS NOR2_X1
XI2_I177 I2_nor29 OR_29 VDD VSS INV_X1
XI2_I178 A_29 B_29 XOR_29 VDD VSS XOR2_X1
XI2_I179 A_29 NOT_29 VDD VSS INV_X1
XI2_I180 A_30 B_30 I2_nand30 VDD VSS NAND2_X1
XI2_I181 I2_nand30 AND_30 VDD VSS INV_X1
XI2_I182 A_30 B_30 I2_nor30 VDD VSS NOR2_X1
XI2_I183 I2_nor30 OR_30 VDD VSS INV_X1
XI2_I184 A_30 B_30 XOR_30 VDD VSS XOR2_X1
XI2_I185 A_30 NOT_30 VDD VSS INV_X1
XI2_I186 A_31 B_31 I2_nand31 VDD VSS NAND2_X1
XI2_I187 I2_nand31 AND_31 VDD VSS INV_X1
XI2_I188 A_31 B_31 I2_nor31 VDD VSS NOR2_X1
XI2_I189 I2_nor31 OR_31 VDD VSS INV_X1
XI2_I190 A_31 B_31 XOR_31 VDD VSS XOR2_X1
XI2_I191 A_31 NOT_31 VDD VSS INV_X1
XI3_I0 SEL_AND I3_SEL_AND_b0 VDD VSS INV_X1
XI3_I1 I3_SEL_AND_b0 I3_SEL_AND_b1_0 VDD VSS INV_X4
XI3_I2 I3_SEL_AND_b1_0 I3_SEL_AND_b2_0 VDD VSS INV_X4
XI3_I3 I3_SEL_AND_b1_0 I3_SEL_AND_b2_1 VDD VSS INV_X4
XI3_I4 I3_SEL_AND_b2_0 I3_SEL_AND_b3_0 VDD VSS INV_X4
XI3_I5 I3_SEL_AND_b2_0 I3_SEL_AND_b3_1 VDD VSS INV_X4
XI3_I6 I3_SEL_AND_b2_0 I3_SEL_AND_b3_2 VDD VSS INV_X4
XI3_I7 I3_SEL_AND_b2_1 I3_SEL_AND_b3_3 VDD VSS INV_X4
XI3_I8 I3_SEL_AND_b2_1 I3_SEL_AND_b3_4 VDD VSS INV_X4
XI3_I9 I3_SEL_AND_b2_1 I3_SEL_AND_b3_5 VDD VSS INV_X4
XI3_I10 SEL_OR I3_SEL_OR_b0 VDD VSS INV_X1
XI3_I11 I3_SEL_OR_b0 I3_SEL_OR_b1_0 VDD VSS INV_X4
XI3_I12 I3_SEL_OR_b1_0 I3_SEL_OR_b2_0 VDD VSS INV_X4
XI3_I13 I3_SEL_OR_b1_0 I3_SEL_OR_b2_1 VDD VSS INV_X4
XI3_I14 I3_SEL_OR_b2_0 I3_SEL_OR_b3_0 VDD VSS INV_X4
XI3_I15 I3_SEL_OR_b2_0 I3_SEL_OR_b3_1 VDD VSS INV_X4
XI3_I16 I3_SEL_OR_b2_0 I3_SEL_OR_b3_2 VDD VSS INV_X4
XI3_I17 I3_SEL_OR_b2_1 I3_SEL_OR_b3_3 VDD VSS INV_X4
XI3_I18 I3_SEL_OR_b2_1 I3_SEL_OR_b3_4 VDD VSS INV_X4
XI3_I19 I3_SEL_OR_b2_1 I3_SEL_OR_b3_5 VDD VSS INV_X4
XI3_I20 SEL_XOR I3_SEL_XOR_b0 VDD VSS INV_X1
XI3_I21 I3_SEL_XOR_b0 I3_SEL_XOR_b1_0 VDD VSS INV_X4
XI3_I22 I3_SEL_XOR_b1_0 I3_SEL_XOR_b2_0 VDD VSS INV_X4
XI3_I23 I3_SEL_XOR_b1_0 I3_SEL_XOR_b2_1 VDD VSS INV_X4
XI3_I24 I3_SEL_XOR_b2_0 I3_SEL_XOR_b3_0 VDD VSS INV_X4
XI3_I25 I3_SEL_XOR_b2_0 I3_SEL_XOR_b3_1 VDD VSS INV_X4
XI3_I26 I3_SEL_XOR_b2_0 I3_SEL_XOR_b3_2 VDD VSS INV_X4
XI3_I27 I3_SEL_XOR_b2_1 I3_SEL_XOR_b3_3 VDD VSS INV_X4
XI3_I28 I3_SEL_XOR_b2_1 I3_SEL_XOR_b3_4 VDD VSS INV_X4
XI3_I29 I3_SEL_XOR_b2_1 I3_SEL_XOR_b3_5 VDD VSS INV_X4
XI3_I30 SEL_NOT I3_SEL_NOT_b0 VDD VSS INV_X1
XI3_I31 I3_SEL_NOT_b0 I3_SEL_NOT_b1_0 VDD VSS INV_X4
XI3_I32 I3_SEL_NOT_b1_0 I3_SEL_NOT_b2_0 VDD VSS INV_X4
XI3_I33 I3_SEL_NOT_b1_0 I3_SEL_NOT_b2_1 VDD VSS INV_X4
XI3_I34 I3_SEL_NOT_b2_0 I3_SEL_NOT_b3_0 VDD VSS INV_X4
XI3_I35 I3_SEL_NOT_b2_0 I3_SEL_NOT_b3_1 VDD VSS INV_X4
XI3_I36 I3_SEL_NOT_b2_0 I3_SEL_NOT_b3_2 VDD VSS INV_X4
XI3_I37 I3_SEL_NOT_b2_1 I3_SEL_NOT_b3_3 VDD VSS INV_X4
XI3_I38 I3_SEL_NOT_b2_1 I3_SEL_NOT_b3_4 VDD VSS INV_X4
XI3_I39 I3_SEL_NOT_b2_1 I3_SEL_NOT_b3_5 VDD VSS INV_X4
XI3_I40 SEL_MUL I3_SEL_MUL_b0 VDD VSS INV_X1
XI3_I41 I3_SEL_MUL_b0 I3_SEL_MUL_b1_0 VDD VSS INV_X4
XI3_I42 I3_SEL_MUL_b1_0 I3_SEL_MUL_b2_0 VDD VSS INV_X4
XI3_I43 I3_SEL_MUL_b1_0 I3_SEL_MUL_b2_1 VDD VSS INV_X4
XI3_I44 I3_SEL_MUL_b1_0 I3_SEL_MUL_b2_2 VDD VSS INV_X4
XI3_I45 I3_SEL_MUL_b2_0 I3_SEL_MUL_b3_0 VDD VSS INV_X4
XI3_I46 I3_SEL_MUL_b2_0 I3_SEL_MUL_b3_1 VDD VSS INV_X4
XI3_I47 I3_SEL_MUL_b2_0 I3_SEL_MUL_b3_2 VDD VSS INV_X4
XI3_I48 I3_SEL_MUL_b2_0 I3_SEL_MUL_b3_3 VDD VSS INV_X4
XI3_I49 I3_SEL_MUL_b2_1 I3_SEL_MUL_b3_4 VDD VSS INV_X4
XI3_I50 I3_SEL_MUL_b2_1 I3_SEL_MUL_b3_5 VDD VSS INV_X4
XI3_I51 I3_SEL_MUL_b2_1 I3_SEL_MUL_b3_6 VDD VSS INV_X4
XI3_I52 I3_SEL_MUL_b2_1 I3_SEL_MUL_b3_7 VDD VSS INV_X4
XI3_I53 I3_SEL_MUL_b2_2 I3_SEL_MUL_b3_8 VDD VSS INV_X4
XI3_I54 I3_SEL_MUL_b2_2 I3_SEL_MUL_b3_9 VDD VSS INV_X4
XI3_I55 I3_SEL_MUL_b2_2 I3_SEL_MUL_b3_10 VDD VSS INV_X4
XI3_I56 SEL_DIV I3_SEL_DIV_b0 VDD VSS INV_X1
XI3_I57 I3_SEL_DIV_b0 I3_SEL_DIV_b1_0 VDD VSS INV_X4
XI3_I58 I3_SEL_DIV_b1_0 I3_SEL_DIV_b2_0 VDD VSS INV_X4
XI3_I59 I3_SEL_DIV_b1_0 I3_SEL_DIV_b2_1 VDD VSS INV_X4
XI3_I60 I3_SEL_DIV_b1_0 I3_SEL_DIV_b2_2 VDD VSS INV_X4
XI3_I61 I3_SEL_DIV_b2_0 I3_SEL_DIV_b3_0 VDD VSS INV_X4
XI3_I62 I3_SEL_DIV_b2_0 I3_SEL_DIV_b3_1 VDD VSS INV_X4
XI3_I63 I3_SEL_DIV_b2_0 I3_SEL_DIV_b3_2 VDD VSS INV_X4
XI3_I64 I3_SEL_DIV_b2_0 I3_SEL_DIV_b3_3 VDD VSS INV_X4
XI3_I65 I3_SEL_DIV_b2_1 I3_SEL_DIV_b3_4 VDD VSS INV_X4
XI3_I66 I3_SEL_DIV_b2_1 I3_SEL_DIV_b3_5 VDD VSS INV_X4
XI3_I67 I3_SEL_DIV_b2_1 I3_SEL_DIV_b3_6 VDD VSS INV_X4
XI3_I68 I3_SEL_DIV_b2_1 I3_SEL_DIV_b3_7 VDD VSS INV_X4
XI3_I69 I3_SEL_DIV_b2_2 I3_SEL_DIV_b3_8 VDD VSS INV_X4
XI3_I70 I3_SEL_DIV_b2_2 I3_SEL_DIV_b3_9 VDD VSS INV_X4
XI3_I71 I3_SEL_DIV_b2_2 I3_SEL_DIV_b3_10 VDD VSS INV_X4
XI3_I72 SEL_AS I3_SEL_AS_b0 VDD VSS INV_X1
XI3_I73 I3_SEL_AS_b0 I3_SEL_AS_b1_0 VDD VSS INV_X4
XI3_I74 I3_SEL_AS_b1_0 I3_SEL_AS_b2_0 VDD VSS INV_X4
XI3_I75 I3_SEL_AS_b1_0 I3_SEL_AS_b2_1 VDD VSS INV_X4
XI3_I76 I3_SEL_AS_b2_0 I3_SEL_AS_b3_0 VDD VSS INV_X4
XI3_I77 I3_SEL_AS_b2_0 I3_SEL_AS_b3_1 VDD VSS INV_X4
XI3_I78 I3_SEL_AS_b2_0 I3_SEL_AS_b3_2 VDD VSS INV_X4
XI3_I79 I3_SEL_AS_b2_1 I3_SEL_AS_b3_3 VDD VSS INV_X4
XI3_I80 I3_SEL_AS_b2_1 I3_SEL_AS_b3_4 VDD VSS INV_X4
XI3_I81 I3_SEL_AS_b2_1 I3_SEL_AS_b3_5 VDD VSS INV_X4
XI3_I82 I3_SEL_AND_b3_0 AND_0 I3_n0_0 VDD VSS NAND2_X1
XI3_I83 I3_SEL_OR_b3_0 OR_0 I3_n0_1 VDD VSS NAND2_X1
XI3_I84 I3_SEL_XOR_b3_0 XOR_0 I3_n0_2 VDD VSS NAND2_X1
XI3_I85 I3_SEL_NOT_b3_0 NOT_0 I3_n0_3 VDD VSS NAND2_X1
XI3_I86 I3_SEL_MUL_b3_0 MULP_0 I3_n0_4 VDD VSS NAND2_X1
XI3_I87 I3_SEL_DIV_b3_0 DIVQ_0 I3_n0_5 VDD VSS NAND2_X1
XI3_I88 I3_n0_0 I3_n0_1 I3_o0_0 VDD VSS NAND2_X1
XI3_I89 I3_n0_2 I3_n0_3 I3_o0_1 VDD VSS NAND2_X1
XI3_I90 I3_n0_4 I3_n0_5 I3_o0_2 VDD VSS NAND2_X1
XI3_I91 I3_o0_0 I3_o0_1 I3_q0_1 VDD VSS NOR2_X1
XI3_I92 I3_SEL_AS_b3_0 S_0 I3_o0_2 I3_q0_2 VDD VSS AOI21_X1
XI3_I93 I3_q0_1 I3_q0_2 Y_0 VDD VSS NAND2_X1
XI3_I94 I3_SEL_AND_b3_0 AND_1 I3_n1_0 VDD VSS NAND2_X1
XI3_I95 I3_SEL_OR_b3_0 OR_1 I3_n1_1 VDD VSS NAND2_X1
XI3_I96 I3_SEL_XOR_b3_0 XOR_1 I3_n1_2 VDD VSS NAND2_X1
XI3_I97 I3_SEL_NOT_b3_0 NOT_1 I3_n1_3 VDD VSS NAND2_X1
XI3_I98 I3_SEL_MUL_b3_0 MULP_1 I3_n1_4 VDD VSS NAND2_X1
XI3_I99 I3_SEL_DIV_b3_0 DIVQ_1 I3_n1_5 VDD VSS NAND2_X1
XI3_I100 I3_n1_0 I3_n1_1 I3_o1_0 VDD VSS NAND2_X1
XI3_I101 I3_n1_2 I3_n1_3 I3_o1_1 VDD VSS NAND2_X1
XI3_I102 I3_n1_4 I3_n1_5 I3_o1_2 VDD VSS NAND2_X1
XI3_I103 I3_o1_0 I3_o1_1 I3_q1_1 VDD VSS NOR2_X1
XI3_I104 I3_SEL_AS_b3_0 S_1 I3_o1_2 I3_q1_2 VDD VSS AOI21_X1
XI3_I105 I3_q1_1 I3_q1_2 Y_1 VDD VSS NAND2_X1
XI3_I106 I3_SEL_AND_b3_0 AND_2 I3_n2_0 VDD VSS NAND2_X1
XI3_I107 I3_SEL_OR_b3_0 OR_2 I3_n2_1 VDD VSS NAND2_X1
XI3_I108 I3_SEL_XOR_b3_0 XOR_2 I3_n2_2 VDD VSS NAND2_X1
XI3_I109 I3_SEL_NOT_b3_0 NOT_2 I3_n2_3 VDD VSS NAND2_X1
XI3_I110 I3_SEL_MUL_b3_0 MULP_2 I3_n2_4 VDD VSS NAND2_X1
XI3_I111 I3_SEL_DIV_b3_0 DIVQ_2 I3_n2_5 VDD VSS NAND2_X1
XI3_I112 I3_n2_0 I3_n2_1 I3_o2_0 VDD VSS NAND2_X1
XI3_I113 I3_n2_2 I3_n2_3 I3_o2_1 VDD VSS NAND2_X1
XI3_I114 I3_n2_4 I3_n2_5 I3_o2_2 VDD VSS NAND2_X1
XI3_I115 I3_o2_0 I3_o2_1 I3_q2_1 VDD VSS NOR2_X1
XI3_I116 I3_SEL_AS_b3_0 S_2 I3_o2_2 I3_q2_2 VDD VSS AOI21_X1
XI3_I117 I3_q2_1 I3_q2_2 Y_2 VDD VSS NAND2_X1
XI3_I118 I3_SEL_AND_b3_0 AND_3 I3_n3_0 VDD VSS NAND2_X1
XI3_I119 I3_SEL_OR_b3_0 OR_3 I3_n3_1 VDD VSS NAND2_X1
XI3_I120 I3_SEL_XOR_b3_0 XOR_3 I3_n3_2 VDD VSS NAND2_X1
XI3_I121 I3_SEL_NOT_b3_0 NOT_3 I3_n3_3 VDD VSS NAND2_X1
XI3_I122 I3_SEL_MUL_b3_0 MULP_3 I3_n3_4 VDD VSS NAND2_X1
XI3_I123 I3_SEL_DIV_b3_0 DIVQ_3 I3_n3_5 VDD VSS NAND2_X1
XI3_I124 I3_n3_0 I3_n3_1 I3_o3_0 VDD VSS NAND2_X1
XI3_I125 I3_n3_2 I3_n3_3 I3_o3_1 VDD VSS NAND2_X1
XI3_I126 I3_n3_4 I3_n3_5 I3_o3_2 VDD VSS NAND2_X1
XI3_I127 I3_o3_0 I3_o3_1 I3_q3_1 VDD VSS NOR2_X1
XI3_I128 I3_SEL_AS_b3_0 S_3 I3_o3_2 I3_q3_2 VDD VSS AOI21_X1
XI3_I129 I3_q3_1 I3_q3_2 Y_3 VDD VSS NAND2_X1
XI3_I130 I3_SEL_AND_b3_0 AND_4 I3_n4_0 VDD VSS NAND2_X1
XI3_I131 I3_SEL_OR_b3_0 OR_4 I3_n4_1 VDD VSS NAND2_X1
XI3_I132 I3_SEL_XOR_b3_0 XOR_4 I3_n4_2 VDD VSS NAND2_X1
XI3_I133 I3_SEL_NOT_b3_0 NOT_4 I3_n4_3 VDD VSS NAND2_X1
XI3_I134 I3_SEL_MUL_b3_0 MULP_4 I3_n4_4 VDD VSS NAND2_X1
XI3_I135 I3_SEL_DIV_b3_0 DIVQ_4 I3_n4_5 VDD VSS NAND2_X1
XI3_I136 I3_n4_0 I3_n4_1 I3_o4_0 VDD VSS NAND2_X1
XI3_I137 I3_n4_2 I3_n4_3 I3_o4_1 VDD VSS NAND2_X1
XI3_I138 I3_n4_4 I3_n4_5 I3_o4_2 VDD VSS NAND2_X1
XI3_I139 I3_o4_0 I3_o4_1 I3_q4_1 VDD VSS NOR2_X1
XI3_I140 I3_SEL_AS_b3_0 S_4 I3_o4_2 I3_q4_2 VDD VSS AOI21_X1
XI3_I141 I3_q4_1 I3_q4_2 Y_4 VDD VSS NAND2_X1
XI3_I142 I3_SEL_AND_b3_0 AND_5 I3_n5_0 VDD VSS NAND2_X1
XI3_I143 I3_SEL_OR_b3_0 OR_5 I3_n5_1 VDD VSS NAND2_X1
XI3_I144 I3_SEL_XOR_b3_0 XOR_5 I3_n5_2 VDD VSS NAND2_X1
XI3_I145 I3_SEL_NOT_b3_0 NOT_5 I3_n5_3 VDD VSS NAND2_X1
XI3_I146 I3_SEL_MUL_b3_0 MULP_5 I3_n5_4 VDD VSS NAND2_X1
XI3_I147 I3_SEL_DIV_b3_0 DIVQ_5 I3_n5_5 VDD VSS NAND2_X1
XI3_I148 I3_n5_0 I3_n5_1 I3_o5_0 VDD VSS NAND2_X1
XI3_I149 I3_n5_2 I3_n5_3 I3_o5_1 VDD VSS NAND2_X1
XI3_I150 I3_n5_4 I3_n5_5 I3_o5_2 VDD VSS NAND2_X1
XI3_I151 I3_o5_0 I3_o5_1 I3_q5_1 VDD VSS NOR2_X1
XI3_I152 I3_SEL_AS_b3_0 S_5 I3_o5_2 I3_q5_2 VDD VSS AOI21_X1
XI3_I153 I3_q5_1 I3_q5_2 Y_5 VDD VSS NAND2_X1
XI3_I154 I3_SEL_AND_b3_1 AND_6 I3_n6_0 VDD VSS NAND2_X1
XI3_I155 I3_SEL_OR_b3_1 OR_6 I3_n6_1 VDD VSS NAND2_X1
XI3_I156 I3_SEL_XOR_b3_1 XOR_6 I3_n6_2 VDD VSS NAND2_X1
XI3_I157 I3_SEL_NOT_b3_1 NOT_6 I3_n6_3 VDD VSS NAND2_X1
XI3_I158 I3_SEL_MUL_b3_1 MULP_6 I3_n6_4 VDD VSS NAND2_X1
XI3_I159 I3_SEL_DIV_b3_1 DIVQ_6 I3_n6_5 VDD VSS NAND2_X1
XI3_I160 I3_n6_0 I3_n6_1 I3_o6_0 VDD VSS NAND2_X1
XI3_I161 I3_n6_2 I3_n6_3 I3_o6_1 VDD VSS NAND2_X1
XI3_I162 I3_n6_4 I3_n6_5 I3_o6_2 VDD VSS NAND2_X1
XI3_I163 I3_o6_0 I3_o6_1 I3_q6_1 VDD VSS NOR2_X1
XI3_I164 I3_SEL_AS_b3_1 S_6 I3_o6_2 I3_q6_2 VDD VSS AOI21_X1
XI3_I165 I3_q6_1 I3_q6_2 Y_6 VDD VSS NAND2_X1
XI3_I166 I3_SEL_AND_b3_1 AND_7 I3_n7_0 VDD VSS NAND2_X1
XI3_I167 I3_SEL_OR_b3_1 OR_7 I3_n7_1 VDD VSS NAND2_X1
XI3_I168 I3_SEL_XOR_b3_1 XOR_7 I3_n7_2 VDD VSS NAND2_X1
XI3_I169 I3_SEL_NOT_b3_1 NOT_7 I3_n7_3 VDD VSS NAND2_X1
XI3_I170 I3_SEL_MUL_b3_1 MULP_7 I3_n7_4 VDD VSS NAND2_X1
XI3_I171 I3_SEL_DIV_b3_1 DIVQ_7 I3_n7_5 VDD VSS NAND2_X1
XI3_I172 I3_n7_0 I3_n7_1 I3_o7_0 VDD VSS NAND2_X1
XI3_I173 I3_n7_2 I3_n7_3 I3_o7_1 VDD VSS NAND2_X1
XI3_I174 I3_n7_4 I3_n7_5 I3_o7_2 VDD VSS NAND2_X1
XI3_I175 I3_o7_0 I3_o7_1 I3_q7_1 VDD VSS NOR2_X1
XI3_I176 I3_SEL_AS_b3_1 S_7 I3_o7_2 I3_q7_2 VDD VSS AOI21_X1
XI3_I177 I3_q7_1 I3_q7_2 Y_7 VDD VSS NAND2_X1
XI3_I178 I3_SEL_AND_b3_1 AND_8 I3_n8_0 VDD VSS NAND2_X1
XI3_I179 I3_SEL_OR_b3_1 OR_8 I3_n8_1 VDD VSS NAND2_X1
XI3_I180 I3_SEL_XOR_b3_1 XOR_8 I3_n8_2 VDD VSS NAND2_X1
XI3_I181 I3_SEL_NOT_b3_1 NOT_8 I3_n8_3 VDD VSS NAND2_X1
XI3_I182 I3_SEL_MUL_b3_1 MULP_8 I3_n8_4 VDD VSS NAND2_X1
XI3_I183 I3_SEL_DIV_b3_1 DIVQ_8 I3_n8_5 VDD VSS NAND2_X1
XI3_I184 I3_n8_0 I3_n8_1 I3_o8_0 VDD VSS NAND2_X1
XI3_I185 I3_n8_2 I3_n8_3 I3_o8_1 VDD VSS NAND2_X1
XI3_I186 I3_n8_4 I3_n8_5 I3_o8_2 VDD VSS NAND2_X1
XI3_I187 I3_o8_0 I3_o8_1 I3_q8_1 VDD VSS NOR2_X1
XI3_I188 I3_SEL_AS_b3_1 S_8 I3_o8_2 I3_q8_2 VDD VSS AOI21_X1
XI3_I189 I3_q8_1 I3_q8_2 Y_8 VDD VSS NAND2_X1
XI3_I190 I3_SEL_AND_b3_1 AND_9 I3_n9_0 VDD VSS NAND2_X1
XI3_I191 I3_SEL_OR_b3_1 OR_9 I3_n9_1 VDD VSS NAND2_X1
XI3_I192 I3_SEL_XOR_b3_1 XOR_9 I3_n9_2 VDD VSS NAND2_X1
XI3_I193 I3_SEL_NOT_b3_1 NOT_9 I3_n9_3 VDD VSS NAND2_X1
XI3_I194 I3_SEL_MUL_b3_1 MULP_9 I3_n9_4 VDD VSS NAND2_X1
XI3_I195 I3_SEL_DIV_b3_1 DIVQ_9 I3_n9_5 VDD VSS NAND2_X1
XI3_I196 I3_n9_0 I3_n9_1 I3_o9_0 VDD VSS NAND2_X1
XI3_I197 I3_n9_2 I3_n9_3 I3_o9_1 VDD VSS NAND2_X1
XI3_I198 I3_n9_4 I3_n9_5 I3_o9_2 VDD VSS NAND2_X1
XI3_I199 I3_o9_0 I3_o9_1 I3_q9_1 VDD VSS NOR2_X1
XI3_I200 I3_SEL_AS_b3_1 S_9 I3_o9_2 I3_q9_2 VDD VSS AOI21_X1
XI3_I201 I3_q9_1 I3_q9_2 Y_9 VDD VSS NAND2_X1
XI3_I202 I3_SEL_AND_b3_1 AND_10 I3_n10_0 VDD VSS NAND2_X1
XI3_I203 I3_SEL_OR_b3_1 OR_10 I3_n10_1 VDD VSS NAND2_X1
XI3_I204 I3_SEL_XOR_b3_1 XOR_10 I3_n10_2 VDD VSS NAND2_X1
XI3_I205 I3_SEL_NOT_b3_1 NOT_10 I3_n10_3 VDD VSS NAND2_X1
XI3_I206 I3_SEL_MUL_b3_1 MULP_10 I3_n10_4 VDD VSS NAND2_X1
XI3_I207 I3_SEL_DIV_b3_1 DIVQ_10 I3_n10_5 VDD VSS NAND2_X1
XI3_I208 I3_n10_0 I3_n10_1 I3_o10_0 VDD VSS NAND2_X1
XI3_I209 I3_n10_2 I3_n10_3 I3_o10_1 VDD VSS NAND2_X1
XI3_I210 I3_n10_4 I3_n10_5 I3_o10_2 VDD VSS NAND2_X1
XI3_I211 I3_o10_0 I3_o10_1 I3_q10_1 VDD VSS NOR2_X1
XI3_I212 I3_SEL_AS_b3_1 S_10 I3_o10_2 I3_q10_2 VDD VSS AOI21_X1
XI3_I213 I3_q10_1 I3_q10_2 Y_10 VDD VSS NAND2_X1
XI3_I214 I3_SEL_AND_b3_2 AND_11 I3_n11_0 VDD VSS NAND2_X1
XI3_I215 I3_SEL_OR_b3_2 OR_11 I3_n11_1 VDD VSS NAND2_X1
XI3_I216 I3_SEL_XOR_b3_2 XOR_11 I3_n11_2 VDD VSS NAND2_X1
XI3_I217 I3_SEL_NOT_b3_2 NOT_11 I3_n11_3 VDD VSS NAND2_X1
XI3_I218 I3_SEL_MUL_b3_1 MULP_11 I3_n11_4 VDD VSS NAND2_X1
XI3_I219 I3_SEL_DIV_b3_1 DIVQ_11 I3_n11_5 VDD VSS NAND2_X1
XI3_I220 I3_n11_0 I3_n11_1 I3_o11_0 VDD VSS NAND2_X1
XI3_I221 I3_n11_2 I3_n11_3 I3_o11_1 VDD VSS NAND2_X1
XI3_I222 I3_n11_4 I3_n11_5 I3_o11_2 VDD VSS NAND2_X1
XI3_I223 I3_o11_0 I3_o11_1 I3_q11_1 VDD VSS NOR2_X1
XI3_I224 I3_SEL_AS_b3_2 S_11 I3_o11_2 I3_q11_2 VDD VSS AOI21_X1
XI3_I225 I3_q11_1 I3_q11_2 Y_11 VDD VSS NAND2_X1
XI3_I226 I3_SEL_AND_b3_2 AND_12 I3_n12_0 VDD VSS NAND2_X1
XI3_I227 I3_SEL_OR_b3_2 OR_12 I3_n12_1 VDD VSS NAND2_X1
XI3_I228 I3_SEL_XOR_b3_2 XOR_12 I3_n12_2 VDD VSS NAND2_X1
XI3_I229 I3_SEL_NOT_b3_2 NOT_12 I3_n12_3 VDD VSS NAND2_X1
XI3_I230 I3_SEL_MUL_b3_2 MULP_12 I3_n12_4 VDD VSS NAND2_X1
XI3_I231 I3_SEL_DIV_b3_2 DIVQ_12 I3_n12_5 VDD VSS NAND2_X1
XI3_I232 I3_n12_0 I3_n12_1 I3_o12_0 VDD VSS NAND2_X1
XI3_I233 I3_n12_2 I3_n12_3 I3_o12_1 VDD VSS NAND2_X1
XI3_I234 I3_n12_4 I3_n12_5 I3_o12_2 VDD VSS NAND2_X1
XI3_I235 I3_o12_0 I3_o12_1 I3_q12_1 VDD VSS NOR2_X1
XI3_I236 I3_SEL_AS_b3_2 S_12 I3_o12_2 I3_q12_2 VDD VSS AOI21_X1
XI3_I237 I3_q12_1 I3_q12_2 Y_12 VDD VSS NAND2_X1
XI3_I238 I3_SEL_AND_b3_2 AND_13 I3_n13_0 VDD VSS NAND2_X1
XI3_I239 I3_SEL_OR_b3_2 OR_13 I3_n13_1 VDD VSS NAND2_X1
XI3_I240 I3_SEL_XOR_b3_2 XOR_13 I3_n13_2 VDD VSS NAND2_X1
XI3_I241 I3_SEL_NOT_b3_2 NOT_13 I3_n13_3 VDD VSS NAND2_X1
XI3_I242 I3_SEL_MUL_b3_2 MULP_13 I3_n13_4 VDD VSS NAND2_X1
XI3_I243 I3_SEL_DIV_b3_2 DIVQ_13 I3_n13_5 VDD VSS NAND2_X1
XI3_I244 I3_n13_0 I3_n13_1 I3_o13_0 VDD VSS NAND2_X1
XI3_I245 I3_n13_2 I3_n13_3 I3_o13_1 VDD VSS NAND2_X1
XI3_I246 I3_n13_4 I3_n13_5 I3_o13_2 VDD VSS NAND2_X1
XI3_I247 I3_o13_0 I3_o13_1 I3_q13_1 VDD VSS NOR2_X1
XI3_I248 I3_SEL_AS_b3_2 S_13 I3_o13_2 I3_q13_2 VDD VSS AOI21_X1
XI3_I249 I3_q13_1 I3_q13_2 Y_13 VDD VSS NAND2_X1
XI3_I250 I3_SEL_AND_b3_2 AND_14 I3_n14_0 VDD VSS NAND2_X1
XI3_I251 I3_SEL_OR_b3_2 OR_14 I3_n14_1 VDD VSS NAND2_X1
XI3_I252 I3_SEL_XOR_b3_2 XOR_14 I3_n14_2 VDD VSS NAND2_X1
XI3_I253 I3_SEL_NOT_b3_2 NOT_14 I3_n14_3 VDD VSS NAND2_X1
XI3_I254 I3_SEL_MUL_b3_2 MULP_14 I3_n14_4 VDD VSS NAND2_X1
XI3_I255 I3_SEL_DIV_b3_2 DIVQ_14 I3_n14_5 VDD VSS NAND2_X1
XI3_I256 I3_n14_0 I3_n14_1 I3_o14_0 VDD VSS NAND2_X1
XI3_I257 I3_n14_2 I3_n14_3 I3_o14_1 VDD VSS NAND2_X1
XI3_I258 I3_n14_4 I3_n14_5 I3_o14_2 VDD VSS NAND2_X1
XI3_I259 I3_o14_0 I3_o14_1 I3_q14_1 VDD VSS NOR2_X1
XI3_I260 I3_SEL_AS_b3_2 S_14 I3_o14_2 I3_q14_2 VDD VSS AOI21_X1
XI3_I261 I3_q14_1 I3_q14_2 Y_14 VDD VSS NAND2_X1
XI3_I262 I3_SEL_AND_b3_2 AND_15 I3_n15_0 VDD VSS NAND2_X1
XI3_I263 I3_SEL_OR_b3_2 OR_15 I3_n15_1 VDD VSS NAND2_X1
XI3_I264 I3_SEL_XOR_b3_2 XOR_15 I3_n15_2 VDD VSS NAND2_X1
XI3_I265 I3_SEL_NOT_b3_2 NOT_15 I3_n15_3 VDD VSS NAND2_X1
XI3_I266 I3_SEL_MUL_b3_2 MULP_15 I3_n15_4 VDD VSS NAND2_X1
XI3_I267 I3_SEL_DIV_b3_2 DIVQ_15 I3_n15_5 VDD VSS NAND2_X1
XI3_I268 I3_n15_0 I3_n15_1 I3_o15_0 VDD VSS NAND2_X1
XI3_I269 I3_n15_2 I3_n15_3 I3_o15_1 VDD VSS NAND2_X1
XI3_I270 I3_n15_4 I3_n15_5 I3_o15_2 VDD VSS NAND2_X1
XI3_I271 I3_o15_0 I3_o15_1 I3_q15_1 VDD VSS NOR2_X1
XI3_I272 I3_SEL_AS_b3_2 S_15 I3_o15_2 I3_q15_2 VDD VSS AOI21_X1
XI3_I273 I3_q15_1 I3_q15_2 Y_15 VDD VSS NAND2_X1
XI3_I274 I3_SEL_AND_b3_3 AND_16 I3_n16_0 VDD VSS NAND2_X1
XI3_I275 I3_SEL_OR_b3_3 OR_16 I3_n16_1 VDD VSS NAND2_X1
XI3_I276 I3_SEL_XOR_b3_3 XOR_16 I3_n16_2 VDD VSS NAND2_X1
XI3_I277 I3_SEL_NOT_b3_3 NOT_16 I3_n16_3 VDD VSS NAND2_X1
XI3_I278 I3_SEL_MUL_b3_2 MULP_16 I3_n16_4 VDD VSS NAND2_X1
XI3_I279 I3_SEL_DIV_b3_2 DIVQ_16 I3_n16_5 VDD VSS NAND2_X1
XI3_I280 I3_n16_0 I3_n16_1 I3_o16_0 VDD VSS NAND2_X1
XI3_I281 I3_n16_2 I3_n16_3 I3_o16_1 VDD VSS NAND2_X1
XI3_I282 I3_n16_4 I3_n16_5 I3_o16_2 VDD VSS NAND2_X1
XI3_I283 I3_o16_0 I3_o16_1 I3_q16_1 VDD VSS NOR2_X1
XI3_I284 I3_SEL_AS_b3_3 S_16 I3_o16_2 I3_q16_2 VDD VSS AOI21_X1
XI3_I285 I3_q16_1 I3_q16_2 Y_16 VDD VSS NAND2_X1
XI3_I286 I3_SEL_AND_b3_3 AND_17 I3_n17_0 VDD VSS NAND2_X1
XI3_I287 I3_SEL_OR_b3_3 OR_17 I3_n17_1 VDD VSS NAND2_X1
XI3_I288 I3_SEL_XOR_b3_3 XOR_17 I3_n17_2 VDD VSS NAND2_X1
XI3_I289 I3_SEL_NOT_b3_3 NOT_17 I3_n17_3 VDD VSS NAND2_X1
XI3_I290 I3_SEL_MUL_b3_2 MULP_17 I3_n17_4 VDD VSS NAND2_X1
XI3_I291 I3_SEL_DIV_b3_2 DIVQ_17 I3_n17_5 VDD VSS NAND2_X1
XI3_I292 I3_n17_0 I3_n17_1 I3_o17_0 VDD VSS NAND2_X1
XI3_I293 I3_n17_2 I3_n17_3 I3_o17_1 VDD VSS NAND2_X1
XI3_I294 I3_n17_4 I3_n17_5 I3_o17_2 VDD VSS NAND2_X1
XI3_I295 I3_o17_0 I3_o17_1 I3_q17_1 VDD VSS NOR2_X1
XI3_I296 I3_SEL_AS_b3_3 S_17 I3_o17_2 I3_q17_2 VDD VSS AOI21_X1
XI3_I297 I3_q17_1 I3_q17_2 Y_17 VDD VSS NAND2_X1
XI3_I298 I3_SEL_AND_b3_3 AND_18 I3_n18_0 VDD VSS NAND2_X1
XI3_I299 I3_SEL_OR_b3_3 OR_18 I3_n18_1 VDD VSS NAND2_X1
XI3_I300 I3_SEL_XOR_b3_3 XOR_18 I3_n18_2 VDD VSS NAND2_X1
XI3_I301 I3_SEL_NOT_b3_3 NOT_18 I3_n18_3 VDD VSS NAND2_X1
XI3_I302 I3_SEL_MUL_b3_3 MULP_18 I3_n18_4 VDD VSS NAND2_X1
XI3_I303 I3_SEL_DIV_b3_3 DIVQ_18 I3_n18_5 VDD VSS NAND2_X1
XI3_I304 I3_n18_0 I3_n18_1 I3_o18_0 VDD VSS NAND2_X1
XI3_I305 I3_n18_2 I3_n18_3 I3_o18_1 VDD VSS NAND2_X1
XI3_I306 I3_n18_4 I3_n18_5 I3_o18_2 VDD VSS NAND2_X1
XI3_I307 I3_o18_0 I3_o18_1 I3_q18_1 VDD VSS NOR2_X1
XI3_I308 I3_SEL_AS_b3_3 S_18 I3_o18_2 I3_q18_2 VDD VSS AOI21_X1
XI3_I309 I3_q18_1 I3_q18_2 Y_18 VDD VSS NAND2_X1
XI3_I310 I3_SEL_AND_b3_3 AND_19 I3_n19_0 VDD VSS NAND2_X1
XI3_I311 I3_SEL_OR_b3_3 OR_19 I3_n19_1 VDD VSS NAND2_X1
XI3_I312 I3_SEL_XOR_b3_3 XOR_19 I3_n19_2 VDD VSS NAND2_X1
XI3_I313 I3_SEL_NOT_b3_3 NOT_19 I3_n19_3 VDD VSS NAND2_X1
XI3_I314 I3_SEL_MUL_b3_3 MULP_19 I3_n19_4 VDD VSS NAND2_X1
XI3_I315 I3_SEL_DIV_b3_3 DIVQ_19 I3_n19_5 VDD VSS NAND2_X1
XI3_I316 I3_n19_0 I3_n19_1 I3_o19_0 VDD VSS NAND2_X1
XI3_I317 I3_n19_2 I3_n19_3 I3_o19_1 VDD VSS NAND2_X1
XI3_I318 I3_n19_4 I3_n19_5 I3_o19_2 VDD VSS NAND2_X1
XI3_I319 I3_o19_0 I3_o19_1 I3_q19_1 VDD VSS NOR2_X1
XI3_I320 I3_SEL_AS_b3_3 S_19 I3_o19_2 I3_q19_2 VDD VSS AOI21_X1
XI3_I321 I3_q19_1 I3_q19_2 Y_19 VDD VSS NAND2_X1
XI3_I322 I3_SEL_AND_b3_3 AND_20 I3_n20_0 VDD VSS NAND2_X1
XI3_I323 I3_SEL_OR_b3_3 OR_20 I3_n20_1 VDD VSS NAND2_X1
XI3_I324 I3_SEL_XOR_b3_3 XOR_20 I3_n20_2 VDD VSS NAND2_X1
XI3_I325 I3_SEL_NOT_b3_3 NOT_20 I3_n20_3 VDD VSS NAND2_X1
XI3_I326 I3_SEL_MUL_b3_3 MULP_20 I3_n20_4 VDD VSS NAND2_X1
XI3_I327 I3_SEL_DIV_b3_3 DIVQ_20 I3_n20_5 VDD VSS NAND2_X1
XI3_I328 I3_n20_0 I3_n20_1 I3_o20_0 VDD VSS NAND2_X1
XI3_I329 I3_n20_2 I3_n20_3 I3_o20_1 VDD VSS NAND2_X1
XI3_I330 I3_n20_4 I3_n20_5 I3_o20_2 VDD VSS NAND2_X1
XI3_I331 I3_o20_0 I3_o20_1 I3_q20_1 VDD VSS NOR2_X1
XI3_I332 I3_SEL_AS_b3_3 S_20 I3_o20_2 I3_q20_2 VDD VSS AOI21_X1
XI3_I333 I3_q20_1 I3_q20_2 Y_20 VDD VSS NAND2_X1
XI3_I334 I3_SEL_AND_b3_3 AND_21 I3_n21_0 VDD VSS NAND2_X1
XI3_I335 I3_SEL_OR_b3_3 OR_21 I3_n21_1 VDD VSS NAND2_X1
XI3_I336 I3_SEL_XOR_b3_3 XOR_21 I3_n21_2 VDD VSS NAND2_X1
XI3_I337 I3_SEL_NOT_b3_3 NOT_21 I3_n21_3 VDD VSS NAND2_X1
XI3_I338 I3_SEL_MUL_b3_3 MULP_21 I3_n21_4 VDD VSS NAND2_X1
XI3_I339 I3_SEL_DIV_b3_3 DIVQ_21 I3_n21_5 VDD VSS NAND2_X1
XI3_I340 I3_n21_0 I3_n21_1 I3_o21_0 VDD VSS NAND2_X1
XI3_I341 I3_n21_2 I3_n21_3 I3_o21_1 VDD VSS NAND2_X1
XI3_I342 I3_n21_4 I3_n21_5 I3_o21_2 VDD VSS NAND2_X1
XI3_I343 I3_o21_0 I3_o21_1 I3_q21_1 VDD VSS NOR2_X1
XI3_I344 I3_SEL_AS_b3_3 S_21 I3_o21_2 I3_q21_2 VDD VSS AOI21_X1
XI3_I345 I3_q21_1 I3_q21_2 Y_21 VDD VSS NAND2_X1
XI3_I346 I3_SEL_AND_b3_4 AND_22 I3_n22_0 VDD VSS NAND2_X1
XI3_I347 I3_SEL_OR_b3_4 OR_22 I3_n22_1 VDD VSS NAND2_X1
XI3_I348 I3_SEL_XOR_b3_4 XOR_22 I3_n22_2 VDD VSS NAND2_X1
XI3_I349 I3_SEL_NOT_b3_4 NOT_22 I3_n22_3 VDD VSS NAND2_X1
XI3_I350 I3_SEL_MUL_b3_3 MULP_22 I3_n22_4 VDD VSS NAND2_X1
XI3_I351 I3_SEL_DIV_b3_3 DIVQ_22 I3_n22_5 VDD VSS NAND2_X1
XI3_I352 I3_n22_0 I3_n22_1 I3_o22_0 VDD VSS NAND2_X1
XI3_I353 I3_n22_2 I3_n22_3 I3_o22_1 VDD VSS NAND2_X1
XI3_I354 I3_n22_4 I3_n22_5 I3_o22_2 VDD VSS NAND2_X1
XI3_I355 I3_o22_0 I3_o22_1 I3_q22_1 VDD VSS NOR2_X1
XI3_I356 I3_SEL_AS_b3_4 S_22 I3_o22_2 I3_q22_2 VDD VSS AOI21_X1
XI3_I357 I3_q22_1 I3_q22_2 Y_22 VDD VSS NAND2_X1
XI3_I358 I3_SEL_AND_b3_4 AND_23 I3_n23_0 VDD VSS NAND2_X1
XI3_I359 I3_SEL_OR_b3_4 OR_23 I3_n23_1 VDD VSS NAND2_X1
XI3_I360 I3_SEL_XOR_b3_4 XOR_23 I3_n23_2 VDD VSS NAND2_X1
XI3_I361 I3_SEL_NOT_b3_4 NOT_23 I3_n23_3 VDD VSS NAND2_X1
XI3_I362 I3_SEL_MUL_b3_3 MULP_23 I3_n23_4 VDD VSS NAND2_X1
XI3_I363 I3_SEL_DIV_b3_3 DIVQ_23 I3_n23_5 VDD VSS NAND2_X1
XI3_I364 I3_n23_0 I3_n23_1 I3_o23_0 VDD VSS NAND2_X1
XI3_I365 I3_n23_2 I3_n23_3 I3_o23_1 VDD VSS NAND2_X1
XI3_I366 I3_n23_4 I3_n23_5 I3_o23_2 VDD VSS NAND2_X1
XI3_I367 I3_o23_0 I3_o23_1 I3_q23_1 VDD VSS NOR2_X1
XI3_I368 I3_SEL_AS_b3_4 S_23 I3_o23_2 I3_q23_2 VDD VSS AOI21_X1
XI3_I369 I3_q23_1 I3_q23_2 Y_23 VDD VSS NAND2_X1
XI3_I370 I3_SEL_AND_b3_4 AND_24 I3_n24_0 VDD VSS NAND2_X1
XI3_I371 I3_SEL_OR_b3_4 OR_24 I3_n24_1 VDD VSS NAND2_X1
XI3_I372 I3_SEL_XOR_b3_4 XOR_24 I3_n24_2 VDD VSS NAND2_X1
XI3_I373 I3_SEL_NOT_b3_4 NOT_24 I3_n24_3 VDD VSS NAND2_X1
XI3_I374 I3_SEL_MUL_b3_4 MULP_24 I3_n24_4 VDD VSS NAND2_X1
XI3_I375 I3_SEL_DIV_b3_4 DIVQ_24 I3_n24_5 VDD VSS NAND2_X1
XI3_I376 I3_n24_0 I3_n24_1 I3_o24_0 VDD VSS NAND2_X1
XI3_I377 I3_n24_2 I3_n24_3 I3_o24_1 VDD VSS NAND2_X1
XI3_I378 I3_n24_4 I3_n24_5 I3_o24_2 VDD VSS NAND2_X1
XI3_I379 I3_o24_0 I3_o24_1 I3_q24_1 VDD VSS NOR2_X1
XI3_I380 I3_SEL_AS_b3_4 S_24 I3_o24_2 I3_q24_2 VDD VSS AOI21_X1
XI3_I381 I3_q24_1 I3_q24_2 Y_24 VDD VSS NAND2_X1
XI3_I382 I3_SEL_AND_b3_4 AND_25 I3_n25_0 VDD VSS NAND2_X1
XI3_I383 I3_SEL_OR_b3_4 OR_25 I3_n25_1 VDD VSS NAND2_X1
XI3_I384 I3_SEL_XOR_b3_4 XOR_25 I3_n25_2 VDD VSS NAND2_X1
XI3_I385 I3_SEL_NOT_b3_4 NOT_25 I3_n25_3 VDD VSS NAND2_X1
XI3_I386 I3_SEL_MUL_b3_4 MULP_25 I3_n25_4 VDD VSS NAND2_X1
XI3_I387 I3_SEL_DIV_b3_4 DIVQ_25 I3_n25_5 VDD VSS NAND2_X1
XI3_I388 I3_n25_0 I3_n25_1 I3_o25_0 VDD VSS NAND2_X1
XI3_I389 I3_n25_2 I3_n25_3 I3_o25_1 VDD VSS NAND2_X1
XI3_I390 I3_n25_4 I3_n25_5 I3_o25_2 VDD VSS NAND2_X1
XI3_I391 I3_o25_0 I3_o25_1 I3_q25_1 VDD VSS NOR2_X1
XI3_I392 I3_SEL_AS_b3_4 S_25 I3_o25_2 I3_q25_2 VDD VSS AOI21_X1
XI3_I393 I3_q25_1 I3_q25_2 Y_25 VDD VSS NAND2_X1
XI3_I394 I3_SEL_AND_b3_4 AND_26 I3_n26_0 VDD VSS NAND2_X1
XI3_I395 I3_SEL_OR_b3_4 OR_26 I3_n26_1 VDD VSS NAND2_X1
XI3_I396 I3_SEL_XOR_b3_4 XOR_26 I3_n26_2 VDD VSS NAND2_X1
XI3_I397 I3_SEL_NOT_b3_4 NOT_26 I3_n26_3 VDD VSS NAND2_X1
XI3_I398 I3_SEL_MUL_b3_4 MULP_26 I3_n26_4 VDD VSS NAND2_X1
XI3_I399 I3_SEL_DIV_b3_4 DIVQ_26 I3_n26_5 VDD VSS NAND2_X1
XI3_I400 I3_n26_0 I3_n26_1 I3_o26_0 VDD VSS NAND2_X1
XI3_I401 I3_n26_2 I3_n26_3 I3_o26_1 VDD VSS NAND2_X1
XI3_I402 I3_n26_4 I3_n26_5 I3_o26_2 VDD VSS NAND2_X1
XI3_I403 I3_o26_0 I3_o26_1 I3_q26_1 VDD VSS NOR2_X1
XI3_I404 I3_SEL_AS_b3_4 S_26 I3_o26_2 I3_q26_2 VDD VSS AOI21_X1
XI3_I405 I3_q26_1 I3_q26_2 Y_26 VDD VSS NAND2_X1
XI3_I406 I3_SEL_AND_b3_5 AND_27 I3_n27_0 VDD VSS NAND2_X1
XI3_I407 I3_SEL_OR_b3_5 OR_27 I3_n27_1 VDD VSS NAND2_X1
XI3_I408 I3_SEL_XOR_b3_5 XOR_27 I3_n27_2 VDD VSS NAND2_X1
XI3_I409 I3_SEL_NOT_b3_5 NOT_27 I3_n27_3 VDD VSS NAND2_X1
XI3_I410 I3_SEL_MUL_b3_4 MULP_27 I3_n27_4 VDD VSS NAND2_X1
XI3_I411 I3_SEL_DIV_b3_4 DIVQ_27 I3_n27_5 VDD VSS NAND2_X1
XI3_I412 I3_n27_0 I3_n27_1 I3_o27_0 VDD VSS NAND2_X1
XI3_I413 I3_n27_2 I3_n27_3 I3_o27_1 VDD VSS NAND2_X1
XI3_I414 I3_n27_4 I3_n27_5 I3_o27_2 VDD VSS NAND2_X1
XI3_I415 I3_o27_0 I3_o27_1 I3_q27_1 VDD VSS NOR2_X1
XI3_I416 I3_SEL_AS_b3_5 S_27 I3_o27_2 I3_q27_2 VDD VSS AOI21_X1
XI3_I417 I3_q27_1 I3_q27_2 Y_27 VDD VSS NAND2_X1
XI3_I418 I3_SEL_AND_b3_5 AND_28 I3_n28_0 VDD VSS NAND2_X1
XI3_I419 I3_SEL_OR_b3_5 OR_28 I3_n28_1 VDD VSS NAND2_X1
XI3_I420 I3_SEL_XOR_b3_5 XOR_28 I3_n28_2 VDD VSS NAND2_X1
XI3_I421 I3_SEL_NOT_b3_5 NOT_28 I3_n28_3 VDD VSS NAND2_X1
XI3_I422 I3_SEL_MUL_b3_4 MULP_28 I3_n28_4 VDD VSS NAND2_X1
XI3_I423 I3_SEL_DIV_b3_4 DIVQ_28 I3_n28_5 VDD VSS NAND2_X1
XI3_I424 I3_n28_0 I3_n28_1 I3_o28_0 VDD VSS NAND2_X1
XI3_I425 I3_n28_2 I3_n28_3 I3_o28_1 VDD VSS NAND2_X1
XI3_I426 I3_n28_4 I3_n28_5 I3_o28_2 VDD VSS NAND2_X1
XI3_I427 I3_o28_0 I3_o28_1 I3_q28_1 VDD VSS NOR2_X1
XI3_I428 I3_SEL_AS_b3_5 S_28 I3_o28_2 I3_q28_2 VDD VSS AOI21_X1
XI3_I429 I3_q28_1 I3_q28_2 Y_28 VDD VSS NAND2_X1
XI3_I430 I3_SEL_AND_b3_5 AND_29 I3_n29_0 VDD VSS NAND2_X1
XI3_I431 I3_SEL_OR_b3_5 OR_29 I3_n29_1 VDD VSS NAND2_X1
XI3_I432 I3_SEL_XOR_b3_5 XOR_29 I3_n29_2 VDD VSS NAND2_X1
XI3_I433 I3_SEL_NOT_b3_5 NOT_29 I3_n29_3 VDD VSS NAND2_X1
XI3_I434 I3_SEL_MUL_b3_4 MULP_29 I3_n29_4 VDD VSS NAND2_X1
XI3_I435 I3_SEL_DIV_b3_4 DIVQ_29 I3_n29_5 VDD VSS NAND2_X1
XI3_I436 I3_n29_0 I3_n29_1 I3_o29_0 VDD VSS NAND2_X1
XI3_I437 I3_n29_2 I3_n29_3 I3_o29_1 VDD VSS NAND2_X1
XI3_I438 I3_n29_4 I3_n29_5 I3_o29_2 VDD VSS NAND2_X1
XI3_I439 I3_o29_0 I3_o29_1 I3_q29_1 VDD VSS NOR2_X1
XI3_I440 I3_SEL_AS_b3_5 S_29 I3_o29_2 I3_q29_2 VDD VSS AOI21_X1
XI3_I441 I3_q29_1 I3_q29_2 Y_29 VDD VSS NAND2_X1
XI3_I442 I3_SEL_AND_b3_5 AND_30 I3_n30_0 VDD VSS NAND2_X1
XI3_I443 I3_SEL_OR_b3_5 OR_30 I3_n30_1 VDD VSS NAND2_X1
XI3_I444 I3_SEL_XOR_b3_5 XOR_30 I3_n30_2 VDD VSS NAND2_X1
XI3_I445 I3_SEL_NOT_b3_5 NOT_30 I3_n30_3 VDD VSS NAND2_X1
XI3_I446 I3_SEL_MUL_b3_5 MULP_30 I3_n30_4 VDD VSS NAND2_X1
XI3_I447 I3_SEL_DIV_b3_5 DIVQ_30 I3_n30_5 VDD VSS NAND2_X1
XI3_I448 I3_n30_0 I3_n30_1 I3_o30_0 VDD VSS NAND2_X1
XI3_I449 I3_n30_2 I3_n30_3 I3_o30_1 VDD VSS NAND2_X1
XI3_I450 I3_n30_4 I3_n30_5 I3_o30_2 VDD VSS NAND2_X1
XI3_I451 I3_o30_0 I3_o30_1 I3_q30_1 VDD VSS NOR2_X1
XI3_I452 I3_SEL_AS_b3_5 S_30 I3_o30_2 I3_q30_2 VDD VSS AOI21_X1
XI3_I453 I3_q30_1 I3_q30_2 Y_30 VDD VSS NAND2_X1
XI3_I454 I3_SEL_AND_b3_5 AND_31 I3_n31_0 VDD VSS NAND2_X1
XI3_I455 I3_SEL_OR_b3_5 OR_31 I3_n31_1 VDD VSS NAND2_X1
XI3_I456 I3_SEL_XOR_b3_5 XOR_31 I3_n31_2 VDD VSS NAND2_X1
XI3_I457 I3_SEL_NOT_b3_5 NOT_31 I3_n31_3 VDD VSS NAND2_X1
XI3_I458 I3_SEL_MUL_b3_5 MULP_31 I3_n31_4 VDD VSS NAND2_X1
XI3_I459 I3_SEL_DIV_b3_5 DIVQ_31 I3_n31_5 VDD VSS NAND2_X1
XI3_I460 I3_n31_0 I3_n31_1 I3_o31_0 VDD VSS NAND2_X1
XI3_I461 I3_n31_2 I3_n31_3 I3_o31_1 VDD VSS NAND2_X1
XI3_I462 I3_n31_4 I3_n31_5 I3_o31_2 VDD VSS NAND2_X1
XI3_I463 I3_o31_0 I3_o31_1 I3_q31_1 VDD VSS NOR2_X1
XI3_I464 I3_SEL_AS_b3_5 S_31 I3_o31_2 I3_q31_2 VDD VSS AOI21_X1
XI3_I465 I3_q31_1 I3_q31_2 Y_31 VDD VSS NAND2_X1
XI3_I466 I3_SEL_MUL_b3_5 MULP_32 I3_hm32 VDD VSS NAND2_X1
XI3_I467 I3_SEL_DIV_b3_5 DIVR_0 I3_hd32 VDD VSS NAND2_X1
XI3_I468 I3_hm32 I3_hd32 Y_32 VDD VSS NAND2_X1
XI3_I469 I3_SEL_MUL_b3_5 MULP_33 I3_hm33 VDD VSS NAND2_X1
XI3_I470 I3_SEL_DIV_b3_5 DIVR_1 I3_hd33 VDD VSS NAND2_X1
XI3_I471 I3_hm33 I3_hd33 Y_33 VDD VSS NAND2_X1
XI3_I472 I3_SEL_MUL_b3_5 MULP_34 I3_hm34 VDD VSS NAND2_X1
XI3_I473 I3_SEL_DIV_b3_5 DIVR_2 I3_hd34 VDD VSS NAND2_X1
XI3_I474 I3_hm34 I3_hd34 Y_34 VDD VSS NAND2_X1
XI3_I475 I3_SEL_MUL_b3_6 MULP_35 I3_hm35 VDD VSS NAND2_X1
XI3_I476 I3_SEL_DIV_b3_6 DIVR_3 I3_hd35 VDD VSS NAND2_X1
XI3_I477 I3_hm35 I3_hd35 Y_35 VDD VSS NAND2_X1
XI3_I478 I3_SEL_MUL_b3_6 MULP_36 I3_hm36 VDD VSS NAND2_X1
XI3_I479 I3_SEL_DIV_b3_6 DIVR_4 I3_hd36 VDD VSS NAND2_X1
XI3_I480 I3_hm36 I3_hd36 Y_36 VDD VSS NAND2_X1
XI3_I481 I3_SEL_MUL_b3_6 MULP_37 I3_hm37 VDD VSS NAND2_X1
XI3_I482 I3_SEL_DIV_b3_6 DIVR_5 I3_hd37 VDD VSS NAND2_X1
XI3_I483 I3_hm37 I3_hd37 Y_37 VDD VSS NAND2_X1
XI3_I484 I3_SEL_MUL_b3_6 MULP_38 I3_hm38 VDD VSS NAND2_X1
XI3_I485 I3_SEL_DIV_b3_6 DIVR_6 I3_hd38 VDD VSS NAND2_X1
XI3_I486 I3_hm38 I3_hd38 Y_38 VDD VSS NAND2_X1
XI3_I487 I3_SEL_MUL_b3_6 MULP_39 I3_hm39 VDD VSS NAND2_X1
XI3_I488 I3_SEL_DIV_b3_6 DIVR_7 I3_hd39 VDD VSS NAND2_X1
XI3_I489 I3_hm39 I3_hd39 Y_39 VDD VSS NAND2_X1
XI3_I490 I3_SEL_MUL_b3_6 MULP_40 I3_hm40 VDD VSS NAND2_X1
XI3_I491 I3_SEL_DIV_b3_6 DIVR_8 I3_hd40 VDD VSS NAND2_X1
XI3_I492 I3_hm40 I3_hd40 Y_40 VDD VSS NAND2_X1
XI3_I493 I3_SEL_MUL_b3_7 MULP_41 I3_hm41 VDD VSS NAND2_X1
XI3_I494 I3_SEL_DIV_b3_7 DIVR_9 I3_hd41 VDD VSS NAND2_X1
XI3_I495 I3_hm41 I3_hd41 Y_41 VDD VSS NAND2_X1
XI3_I496 I3_SEL_MUL_b3_7 MULP_42 I3_hm42 VDD VSS NAND2_X1
XI3_I497 I3_SEL_DIV_b3_7 DIVR_10 I3_hd42 VDD VSS NAND2_X1
XI3_I498 I3_hm42 I3_hd42 Y_42 VDD VSS NAND2_X1
XI3_I499 I3_SEL_MUL_b3_7 MULP_43 I3_hm43 VDD VSS NAND2_X1
XI3_I500 I3_SEL_DIV_b3_7 DIVR_11 I3_hd43 VDD VSS NAND2_X1
XI3_I501 I3_hm43 I3_hd43 Y_43 VDD VSS NAND2_X1
XI3_I502 I3_SEL_MUL_b3_7 MULP_44 I3_hm44 VDD VSS NAND2_X1
XI3_I503 I3_SEL_DIV_b3_7 DIVR_12 I3_hd44 VDD VSS NAND2_X1
XI3_I504 I3_hm44 I3_hd44 Y_44 VDD VSS NAND2_X1
XI3_I505 I3_SEL_MUL_b3_7 MULP_45 I3_hm45 VDD VSS NAND2_X1
XI3_I506 I3_SEL_DIV_b3_7 DIVR_13 I3_hd45 VDD VSS NAND2_X1
XI3_I507 I3_hm45 I3_hd45 Y_45 VDD VSS NAND2_X1
XI3_I508 I3_SEL_MUL_b3_7 MULP_46 I3_hm46 VDD VSS NAND2_X1
XI3_I509 I3_SEL_DIV_b3_7 DIVR_14 I3_hd46 VDD VSS NAND2_X1
XI3_I510 I3_hm46 I3_hd46 Y_46 VDD VSS NAND2_X1
XI3_I511 I3_SEL_MUL_b3_8 MULP_47 I3_hm47 VDD VSS NAND2_X1
XI3_I512 I3_SEL_DIV_b3_8 DIVR_15 I3_hd47 VDD VSS NAND2_X1
XI3_I513 I3_hm47 I3_hd47 Y_47 VDD VSS NAND2_X1
XI3_I514 I3_SEL_MUL_b3_8 MULP_48 I3_hm48 VDD VSS NAND2_X1
XI3_I515 I3_SEL_DIV_b3_8 DIVR_16 I3_hd48 VDD VSS NAND2_X1
XI3_I516 I3_hm48 I3_hd48 Y_48 VDD VSS NAND2_X1
XI3_I517 I3_SEL_MUL_b3_8 MULP_49 I3_hm49 VDD VSS NAND2_X1
XI3_I518 I3_SEL_DIV_b3_8 DIVR_17 I3_hd49 VDD VSS NAND2_X1
XI3_I519 I3_hm49 I3_hd49 Y_49 VDD VSS NAND2_X1
XI3_I520 I3_SEL_MUL_b3_8 MULP_50 I3_hm50 VDD VSS NAND2_X1
XI3_I521 I3_SEL_DIV_b3_8 DIVR_18 I3_hd50 VDD VSS NAND2_X1
XI3_I522 I3_hm50 I3_hd50 Y_50 VDD VSS NAND2_X1
XI3_I523 I3_SEL_MUL_b3_8 MULP_51 I3_hm51 VDD VSS NAND2_X1
XI3_I524 I3_SEL_DIV_b3_8 DIVR_19 I3_hd51 VDD VSS NAND2_X1
XI3_I525 I3_hm51 I3_hd51 Y_51 VDD VSS NAND2_X1
XI3_I526 I3_SEL_MUL_b3_8 MULP_52 I3_hm52 VDD VSS NAND2_X1
XI3_I527 I3_SEL_DIV_b3_8 DIVR_20 I3_hd52 VDD VSS NAND2_X1
XI3_I528 I3_hm52 I3_hd52 Y_52 VDD VSS NAND2_X1
XI3_I529 I3_SEL_MUL_b3_9 MULP_53 I3_hm53 VDD VSS NAND2_X1
XI3_I530 I3_SEL_DIV_b3_9 DIVR_21 I3_hd53 VDD VSS NAND2_X1
XI3_I531 I3_hm53 I3_hd53 Y_53 VDD VSS NAND2_X1
XI3_I532 I3_SEL_MUL_b3_9 MULP_54 I3_hm54 VDD VSS NAND2_X1
XI3_I533 I3_SEL_DIV_b3_9 DIVR_22 I3_hd54 VDD VSS NAND2_X1
XI3_I534 I3_hm54 I3_hd54 Y_54 VDD VSS NAND2_X1
XI3_I535 I3_SEL_MUL_b3_9 MULP_55 I3_hm55 VDD VSS NAND2_X1
XI3_I536 I3_SEL_DIV_b3_9 DIVR_23 I3_hd55 VDD VSS NAND2_X1
XI3_I537 I3_hm55 I3_hd55 Y_55 VDD VSS NAND2_X1
XI3_I538 I3_SEL_MUL_b3_9 MULP_56 I3_hm56 VDD VSS NAND2_X1
XI3_I539 I3_SEL_DIV_b3_9 DIVR_24 I3_hd56 VDD VSS NAND2_X1
XI3_I540 I3_hm56 I3_hd56 Y_56 VDD VSS NAND2_X1
XI3_I541 I3_SEL_MUL_b3_9 MULP_57 I3_hm57 VDD VSS NAND2_X1
XI3_I542 I3_SEL_DIV_b3_9 DIVR_25 I3_hd57 VDD VSS NAND2_X1
XI3_I543 I3_hm57 I3_hd57 Y_57 VDD VSS NAND2_X1
XI3_I544 I3_SEL_MUL_b3_9 MULP_58 I3_hm58 VDD VSS NAND2_X1
XI3_I545 I3_SEL_DIV_b3_9 DIVR_26 I3_hd58 VDD VSS NAND2_X1
XI3_I546 I3_hm58 I3_hd58 Y_58 VDD VSS NAND2_X1
XI3_I547 I3_SEL_MUL_b3_10 MULP_59 I3_hm59 VDD VSS NAND2_X1
XI3_I548 I3_SEL_DIV_b3_10 DIVR_27 I3_hd59 VDD VSS NAND2_X1
XI3_I549 I3_hm59 I3_hd59 Y_59 VDD VSS NAND2_X1
XI3_I550 I3_SEL_MUL_b3_10 MULP_60 I3_hm60 VDD VSS NAND2_X1
XI3_I551 I3_SEL_DIV_b3_10 DIVR_28 I3_hd60 VDD VSS NAND2_X1
XI3_I552 I3_hm60 I3_hd60 Y_60 VDD VSS NAND2_X1
XI3_I553 I3_SEL_MUL_b3_10 MULP_61 I3_hm61 VDD VSS NAND2_X1
XI3_I554 I3_SEL_DIV_b3_10 DIVR_29 I3_hd61 VDD VSS NAND2_X1
XI3_I555 I3_hm61 I3_hd61 Y_61 VDD VSS NAND2_X1
XI3_I556 I3_SEL_MUL_b3_10 MULP_62 I3_hm62 VDD VSS NAND2_X1
XI3_I557 I3_SEL_DIV_b3_10 DIVR_30 I3_hd62 VDD VSS NAND2_X1
XI3_I558 I3_hm62 I3_hd62 Y_62 VDD VSS NAND2_X1
XI3_I559 I3_SEL_MUL_b3_10 MULP_63 I3_hm63 VDD VSS NAND2_X1
XI3_I560 I3_SEL_DIV_b3_10 DIVR_31 I3_hd63 VDD VSS NAND2_X1
XI3_I561 I3_hm63 I3_hd63 Y_63 VDD VSS NAND2_X1
XI4_I0 Y_0 Y_1 I4_z0_0 VDD VSS NOR2_X1
XI4_I1 Y_2 Y_3 I4_z0_1 VDD VSS NOR2_X1
XI4_I2 Y_4 Y_5 I4_z0_2 VDD VSS NOR2_X1
XI4_I3 Y_6 Y_7 I4_z0_3 VDD VSS NOR2_X1
XI4_I4 Y_8 Y_9 I4_z0_4 VDD VSS NOR2_X1
XI4_I5 Y_10 Y_11 I4_z0_5 VDD VSS NOR2_X1
XI4_I6 Y_12 Y_13 I4_z0_6 VDD VSS NOR2_X1
XI4_I7 Y_14 Y_15 I4_z0_7 VDD VSS NOR2_X1
XI4_I8 Y_16 Y_17 I4_z0_8 VDD VSS NOR2_X1
XI4_I9 Y_18 Y_19 I4_z0_9 VDD VSS NOR2_X1
XI4_I10 Y_20 Y_21 I4_z0_10 VDD VSS NOR2_X1
XI4_I11 Y_22 Y_23 I4_z0_11 VDD VSS NOR2_X1
XI4_I12 Y_24 Y_25 I4_z0_12 VDD VSS NOR2_X1
XI4_I13 Y_26 Y_27 I4_z0_13 VDD VSS NOR2_X1
XI4_I14 Y_28 Y_29 I4_z0_14 VDD VSS NOR2_X1
XI4_I15 Y_30 Y_31 I4_z0_15 VDD VSS NOR2_X1
XI4_I16 Y_32 Y_33 I4_z0_16 VDD VSS NOR2_X1
XI4_I17 Y_34 Y_35 I4_z0_17 VDD VSS NOR2_X1
XI4_I18 Y_36 Y_37 I4_z0_18 VDD VSS NOR2_X1
XI4_I19 Y_38 Y_39 I4_z0_19 VDD VSS NOR2_X1
XI4_I20 Y_40 Y_41 I4_z0_20 VDD VSS NOR2_X1
XI4_I21 Y_42 Y_43 I4_z0_21 VDD VSS NOR2_X1
XI4_I22 Y_44 Y_45 I4_z0_22 VDD VSS NOR2_X1
XI4_I23 Y_46 Y_47 I4_z0_23 VDD VSS NOR2_X1
XI4_I24 Y_48 Y_49 I4_z0_24 VDD VSS NOR2_X1
XI4_I25 Y_50 Y_51 I4_z0_25 VDD VSS NOR2_X1
XI4_I26 Y_52 Y_53 I4_z0_26 VDD VSS NOR2_X1
XI4_I27 Y_54 Y_55 I4_z0_27 VDD VSS NOR2_X1
XI4_I28 Y_56 Y_57 I4_z0_28 VDD VSS NOR2_X1
XI4_I29 Y_58 Y_59 I4_z0_29 VDD VSS NOR2_X1
XI4_I30 Y_60 Y_61 I4_z0_30 VDD VSS NOR2_X1
XI4_I31 Y_62 Y_63 I4_z0_31 VDD VSS NOR2_X1
XI4_I32 I4_z0_0 I4_z0_1 I4_z1_0 VDD VSS NAND2_X1
XI4_I33 I4_z0_2 I4_z0_3 I4_z1_1 VDD VSS NAND2_X1
XI4_I34 I4_z0_4 I4_z0_5 I4_z1_2 VDD VSS NAND2_X1
XI4_I35 I4_z0_6 I4_z0_7 I4_z1_3 VDD VSS NAND2_X1
XI4_I36 I4_z0_8 I4_z0_9 I4_z1_4 VDD VSS NAND2_X1
XI4_I37 I4_z0_10 I4_z0_11 I4_z1_5 VDD VSS NAND2_X1
XI4_I38 I4_z0_12 I4_z0_13 I4_z1_6 VDD VSS NAND2_X1
XI4_I39 I4_z0_14 I4_z0_15 I4_z1_7 VDD VSS NAND2_X1
XI4_I40 I4_z0_16 I4_z0_17 I4_z1_8 VDD VSS NAND2_X1
XI4_I41 I4_z0_18 I4_z0_19 I4_z1_9 VDD VSS NAND2_X1
XI4_I42 I4_z0_20 I4_z0_21 I4_z1_10 VDD VSS NAND2_X1
XI4_I43 I4_z0_22 I4_z0_23 I4_z1_11 VDD VSS NAND2_X1
XI4_I44 I4_z0_24 I4_z0_25 I4_z1_12 VDD VSS NAND2_X1
XI4_I45 I4_z0_26 I4_z0_27 I4_z1_13 VDD VSS NAND2_X1
XI4_I46 I4_z0_28 I4_z0_29 I4_z1_14 VDD VSS NAND2_X1
XI4_I47 I4_z0_30 I4_z0_31 I4_z1_15 VDD VSS NAND2_X1
XI4_I48 I4_z1_0 I4_z1_1 I4_z2_0 VDD VSS NOR2_X1
XI4_I49 I4_z1_2 I4_z1_3 I4_z2_1 VDD VSS NOR2_X1
XI4_I50 I4_z1_4 I4_z1_5 I4_z2_2 VDD VSS NOR2_X1
XI4_I51 I4_z1_6 I4_z1_7 I4_z2_3 VDD VSS NOR2_X1
XI4_I52 I4_z1_8 I4_z1_9 I4_z2_4 VDD VSS NOR2_X1
XI4_I53 I4_z1_10 I4_z1_11 I4_z2_5 VDD VSS NOR2_X1
XI4_I54 I4_z1_12 I4_z1_13 I4_z2_6 VDD VSS NOR2_X1
XI4_I55 I4_z1_14 I4_z1_15 I4_z2_7 VDD VSS NOR2_X1
XI4_I56 I4_z2_0 I4_z2_1 I4_z3_0 VDD VSS NAND2_X1
XI4_I57 I4_z2_2 I4_z2_3 I4_z3_1 VDD VSS NAND2_X1
XI4_I58 I4_z2_4 I4_z2_5 I4_z3_2 VDD VSS NAND2_X1
XI4_I59 I4_z2_6 I4_z2_7 I4_z3_3 VDD VSS NAND2_X1
XI4_I60 I4_z3_0 I4_z3_1 I4_z4_0 VDD VSS NOR2_X1
XI4_I61 I4_z3_2 I4_z3_3 I4_z4_1 VDD VSS NOR2_X1
XI4_I62 I4_z4_0 I4_z4_1 I4_z5_0 VDD VSS NAND2_X1
XI4_I63 I4_z5_0 Z VDD VSS INV_X1
XI4_I64 CO SEL_AS I4_cn VDD VSS NAND2_X1
XI4_I65 I4_cn C VDD VSS INV_X1
XI4_I66 CM CO I4_ovf VDD VSS XOR2_X1
XI4_I67 SEL_AS I4_ovf I4_v1 VDD VSS NAND2_X1
XI4_I68 SEL_DIV DIVV I4_v2 VDD VSS NAND2_X1
XI4_I69 I4_v1 I4_v2 V VDD VSS NAND2_X1
XI4_I70 SEL_DIV DIVDZ I4_dzn VDD VSS NAND2_X1
XI4_I71 I4_dzn DZ VDD VSS INV_X1
.ENDS CORE32
