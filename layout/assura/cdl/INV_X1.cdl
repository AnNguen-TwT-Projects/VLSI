* INV_X1: generated by layout/scs2cdl.py from cells/ -- do not edit

.SUBCKT INV_X1 A Y VDD VSS
MN0 Y A VSS VSS nmos1v w=0.12u l=0.1u
MP0 Y A VDD VDD pmos1v w=0.24u l=0.1u
.ENDS INV_X1
