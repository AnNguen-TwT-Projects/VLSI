* INV_X4: generated by layout/scs2cdl.py from cells/ -- do not edit

.SUBCKT INV_X4 A Y VDD VSS
MN1 Y A VSS VSS nmos1v w=0.48u l=0.1u
MP2 Y A VDD VDD pmos1v w=0.96u l=0.1u
.ENDS INV_X4
