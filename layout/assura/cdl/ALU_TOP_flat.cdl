* ALU_TOP phang xuong cell la: sinh boi layout/pnr/prep.py

.SUBCKT AOI21_X1 A1 A2 B Y VDD VSS
MN0 Y A1 n1 VSS nmos1v w=0.24u l=0.1u
MN1 n1 A2 VSS VSS nmos1v w=0.24u l=0.1u
MN2 Y B VSS VSS nmos1v w=0.12u l=0.1u
MP0 p1 A1 VDD VDD pmos1v w=0.48u l=0.1u
MP1 p1 A2 VDD VDD pmos1v w=0.48u l=0.1u
MP2 Y B p1 VDD pmos1v w=0.48u l=0.1u
.ENDS AOI21_X1

.SUBCKT BOOTH_ENC X2 X1 X0 ONE TWO VDD VSS
MN1 aan X1 VSS VSS nmos1v w=0.12u l=0.1u
MP2 aan X1 VDD VDD pmos1v w=0.24u l=0.1u
MN3 abn X0 VSS VSS nmos1v w=0.12u l=0.1u
MP4 abn X0 VDD VDD pmos1v w=0.24u l=0.1u
MN5 ONE X1 an1 VSS nmos1v w=0.24u l=0.1u
MN6 an1 X0 VSS VSS nmos1v w=0.24u l=0.1u
MN7 ONE aan an2 VSS nmos1v w=0.24u l=0.1u
MN8 an2 abn VSS VSS nmos1v w=0.24u l=0.1u
MP9 ap1 X1 VDD VDD pmos1v w=0.48u l=0.1u
MP10 ap1 X0 VDD VDD pmos1v w=0.48u l=0.1u
MP11 ONE aan ap1 VDD pmos1v w=0.48u l=0.1u
MP12 ONE abn ap1 VDD pmos1v w=0.48u l=0.1u
MN13 ban X2 VSS VSS nmos1v w=0.12u l=0.1u
MP14 ban X2 VDD VDD pmos1v w=0.24u l=0.1u
MN15 bbn X1 VSS VSS nmos1v w=0.12u l=0.1u
MP16 bbn X1 VDD VDD pmos1v w=0.24u l=0.1u
MN17 e X2 bn1 VSS nmos1v w=0.24u l=0.1u
MN18 bn1 bbn VSS VSS nmos1v w=0.24u l=0.1u
MN19 e ban bn2 VSS nmos1v w=0.24u l=0.1u
MN20 bn2 X1 VSS VSS nmos1v w=0.24u l=0.1u
MP21 bp1 X2 VDD VDD pmos1v w=0.48u l=0.1u
MP22 bp1 bbn VDD VDD pmos1v w=0.48u l=0.1u
MP23 e ban bp1 VDD pmos1v w=0.48u l=0.1u
MP24 e X1 bp1 VDD pmos1v w=0.48u l=0.1u
MN25 TWO e VSS VSS nmos1v w=0.12u l=0.1u
MN26 TWO ONE VSS VSS nmos1v w=0.12u l=0.1u
MP27 cp e VDD VDD pmos1v w=0.48u l=0.1u
MP28 TWO ONE cp VDD pmos1v w=0.48u l=0.1u
.ENDS BOOTH_ENC

.SUBCKT BOOTH_SEL AJ AJM ONE TWO NEG PP VDD VSS
MN1 xn ONE n1 VSS nmos1v w=0.24u l=0.1u
MN2 n1 AJ VSS VSS nmos1v w=0.24u l=0.1u
MN3 xn TWO n2 VSS nmos1v w=0.24u l=0.1u
MN4 n2 AJM VSS VSS nmos1v w=0.24u l=0.1u
MP5 p1 ONE VDD VDD pmos1v w=0.48u l=0.1u
MP6 p1 AJ VDD VDD pmos1v w=0.48u l=0.1u
MP7 xn TWO p1 VDD pmos1v w=0.48u l=0.1u
MP8 xn AJM p1 VDD pmos1v w=0.48u l=0.1u
MN9 xan xn VSS VSS nmos1v w=0.12u l=0.1u
MP10 xan xn VDD VDD pmos1v w=0.24u l=0.1u
MN11 xbn NEG VSS VSS nmos1v w=0.12u l=0.1u
MP12 xbn NEG VDD VDD pmos1v w=0.24u l=0.1u
MN13 PP xn xn1 VSS nmos1v w=0.24u l=0.1u
MN14 xn1 xbn VSS VSS nmos1v w=0.24u l=0.1u
MN15 PP xan xn2 VSS nmos1v w=0.24u l=0.1u
MN16 xn2 NEG VSS VSS nmos1v w=0.24u l=0.1u
MP17 xp1 xn VDD VDD pmos1v w=0.48u l=0.1u
MP18 xp1 xbn VDD VDD pmos1v w=0.48u l=0.1u
MP19 PP xan xp1 VDD pmos1v w=0.48u l=0.1u
MP20 PP NEG xp1 VDD pmos1v w=0.48u l=0.1u
.ENDS BOOTH_SEL

.SUBCKT XOR2_X1 A B Y VDD VSS
MN0 An A VSS VSS nmos1v w=0.12u l=0.1u
MP0 An A VDD VDD pmos1v w=0.24u l=0.1u
MN1 Bn B VSS VSS nmos1v w=0.12u l=0.1u
MP1 Bn B VDD VDD pmos1v w=0.24u l=0.1u
MN2 Y A n1 VSS nmos1v w=0.24u l=0.1u
MN3 n1 B VSS VSS nmos1v w=0.24u l=0.1u
MN4 Y An n2 VSS nmos1v w=0.24u l=0.1u
MN5 n2 Bn VSS VSS nmos1v w=0.24u l=0.1u
MP2 p1 A VDD VDD pmos1v w=0.48u l=0.1u
MP3 p1 B VDD VDD pmos1v w=0.48u l=0.1u
MP4 Y An p1 VDD pmos1v w=0.48u l=0.1u
MP5 Y Bn p1 VDD pmos1v w=0.48u l=0.1u
.ENDS XOR2_X1

.SUBCKT NAND2_X1 A B Y VDD VSS
MN0 Y A n1 VSS nmos1v w=0.24u l=0.1u
MN1 n1 B VSS VSS nmos1v w=0.24u l=0.1u
MP0 Y A VDD VDD pmos1v w=0.24u l=0.1u
MP1 Y B VDD VDD pmos1v w=0.24u l=0.1u
.ENDS NAND2_X1

.SUBCKT CAS_X1 X D T CI S CO VDD VSS
XI0 D T b VDD VSS XOR2_X1
XI1 X b p VDD VSS XOR2_X1
XI2 p CI S VDD VSS XOR2_X1
XI3 X b g_n VDD VSS NAND2_X1
XI4 p CI pc_n VDD VSS NAND2_X1
XI5 g_n pc_n CO VDD VSS NAND2_X1
.ENDS CAS_X1

.SUBCKT CMP42 X1 X2 X3 X4 CI S C CO VDD VSS
MN1 an1 X1 VSS VSS nmos1v w=0.24u l=0.1u
MN2 acon X2 an1 VSS nmos1v w=0.24u l=0.1u
MN3 an2 X1 VSS VSS nmos1v w=0.24u l=0.1u
MN4 an2 X2 VSS VSS nmos1v w=0.24u l=0.1u
MN5 acon X3 an2 VSS nmos1v w=0.24u l=0.1u
MN6 an3 X1 VSS VSS nmos1v w=0.24u l=0.1u
MN7 an3 X2 VSS VSS nmos1v w=0.24u l=0.1u
MN8 an3 X3 VSS VSS nmos1v w=0.24u l=0.1u
MN9 asn acon an3 VSS nmos1v w=0.24u l=0.1u
MN10 an4 X1 VSS VSS nmos1v w=0.36u l=0.1u
MN11 an5 X2 an4 VSS nmos1v w=0.36u l=0.1u
MN12 asn X3 an5 VSS nmos1v w=0.36u l=0.1u
MP13 ap1 X1 VDD VDD pmos1v w=0.48u l=0.1u
MP14 acon X2 ap1 VDD pmos1v w=0.48u l=0.1u
MP15 ap2 X1 VDD VDD pmos1v w=0.48u l=0.1u
MP16 ap2 X2 VDD VDD pmos1v w=0.48u l=0.1u
MP17 acon X3 ap2 VDD pmos1v w=0.48u l=0.1u
MP18 ap3 X1 VDD VDD pmos1v w=0.48u l=0.1u
MP19 ap3 X2 VDD VDD pmos1v w=0.48u l=0.1u
MP20 ap3 X3 VDD VDD pmos1v w=0.48u l=0.1u
MP21 asn acon ap3 VDD pmos1v w=0.48u l=0.1u
MP22 ap4 X1 VDD VDD pmos1v w=0.72u l=0.1u
MP23 ap5 X2 ap4 VDD pmos1v w=0.72u l=0.1u
MP24 asn X3 ap5 VDD pmos1v w=0.72u l=0.1u
MN25 s1 asn VSS VSS nmos1v w=0.12u l=0.1u
MP26 s1 asn VDD VDD pmos1v w=0.24u l=0.1u
MN27 CO acon VSS VSS nmos1v w=0.12u l=0.1u
MP28 CO acon VDD VDD pmos1v w=0.24u l=0.1u
MN29 bn1 s1 VSS VSS nmos1v w=0.24u l=0.1u
MN30 bcon X4 bn1 VSS nmos1v w=0.24u l=0.1u
MN31 bn2 s1 VSS VSS nmos1v w=0.24u l=0.1u
MN32 bn2 X4 VSS VSS nmos1v w=0.24u l=0.1u
MN33 bcon CI bn2 VSS nmos1v w=0.24u l=0.1u
MN34 bn3 s1 VSS VSS nmos1v w=0.24u l=0.1u
MN35 bn3 X4 VSS VSS nmos1v w=0.24u l=0.1u
MN36 bn3 CI VSS VSS nmos1v w=0.24u l=0.1u
MN37 bsn bcon bn3 VSS nmos1v w=0.24u l=0.1u
MN38 bn4 s1 VSS VSS nmos1v w=0.36u l=0.1u
MN39 bn5 X4 bn4 VSS nmos1v w=0.36u l=0.1u
MN40 bsn CI bn5 VSS nmos1v w=0.36u l=0.1u
MP41 bp1 s1 VDD VDD pmos1v w=0.48u l=0.1u
MP42 bcon X4 bp1 VDD pmos1v w=0.48u l=0.1u
MP43 bp2 s1 VDD VDD pmos1v w=0.48u l=0.1u
MP44 bp2 X4 VDD VDD pmos1v w=0.48u l=0.1u
MP45 bcon CI bp2 VDD pmos1v w=0.48u l=0.1u
MP46 bp3 s1 VDD VDD pmos1v w=0.48u l=0.1u
MP47 bp3 X4 VDD VDD pmos1v w=0.48u l=0.1u
MP48 bp3 CI VDD VDD pmos1v w=0.48u l=0.1u
MP49 bsn bcon bp3 VDD pmos1v w=0.48u l=0.1u
MP50 bp4 s1 VDD VDD pmos1v w=0.72u l=0.1u
MP51 bp5 X4 bp4 VDD pmos1v w=0.72u l=0.1u
MP52 bsn CI bp5 VDD pmos1v w=0.72u l=0.1u
MN53 S bsn VSS VSS nmos1v w=0.12u l=0.1u
MP54 S bsn VDD VDD pmos1v w=0.24u l=0.1u
MN55 C bcon VSS VSS nmos1v w=0.12u l=0.1u
MP56 C bcon VDD VDD pmos1v w=0.24u l=0.1u
.ENDS CMP42

.SUBCKT FA_X1 A B CI S CO VDD VSS
MN1 n1 A VSS VSS nmos1v w=0.24u l=0.1u
MN2 con B n1 VSS nmos1v w=0.24u l=0.1u
MN3 n2 A VSS VSS nmos1v w=0.24u l=0.1u
MN4 n2 B VSS VSS nmos1v w=0.24u l=0.1u
MN5 con CI n2 VSS nmos1v w=0.24u l=0.1u
MN6 n3 A VSS VSS nmos1v w=0.24u l=0.1u
MN7 n3 B VSS VSS nmos1v w=0.24u l=0.1u
MN8 n3 CI VSS VSS nmos1v w=0.24u l=0.1u
MN9 sn con n3 VSS nmos1v w=0.24u l=0.1u
MN10 n4 A VSS VSS nmos1v w=0.36u l=0.1u
MN11 n5 B n4 VSS nmos1v w=0.36u l=0.1u
MN12 sn CI n5 VSS nmos1v w=0.36u l=0.1u
MP13 p1 A VDD VDD pmos1v w=0.48u l=0.1u
MP14 con B p1 VDD pmos1v w=0.48u l=0.1u
MP15 p2 A VDD VDD pmos1v w=0.48u l=0.1u
MP16 p2 B VDD VDD pmos1v w=0.48u l=0.1u
MP17 con CI p2 VDD pmos1v w=0.48u l=0.1u
MP18 p3 A VDD VDD pmos1v w=0.48u l=0.1u
MP19 p3 B VDD VDD pmos1v w=0.48u l=0.1u
MP20 p3 CI VDD VDD pmos1v w=0.48u l=0.1u
MP21 sn con p3 VDD pmos1v w=0.48u l=0.1u
MP22 p4 A VDD VDD pmos1v w=0.72u l=0.1u
MP23 p5 B p4 VDD pmos1v w=0.72u l=0.1u
MP24 sn CI p5 VDD pmos1v w=0.72u l=0.1u
MN25 S sn VSS VSS nmos1v w=0.12u l=0.1u
MP26 S sn VDD VDD pmos1v w=0.24u l=0.1u
MN27 CO con VSS VSS nmos1v w=0.12u l=0.1u
MP28 CO con VDD VDD pmos1v w=0.24u l=0.1u
.ENDS FA_X1

.SUBCKT HA_X1 A B S CO VDD VSS
MN1 xan A VSS VSS nmos1v w=0.12u l=0.1u
MP2 xan A VDD VDD pmos1v w=0.24u l=0.1u
MN3 xbn B VSS VSS nmos1v w=0.12u l=0.1u
MP4 xbn B VDD VDD pmos1v w=0.24u l=0.1u
MN5 S A xn1 VSS nmos1v w=0.24u l=0.1u
MN6 xn1 B VSS VSS nmos1v w=0.24u l=0.1u
MN7 S xan xn2 VSS nmos1v w=0.24u l=0.1u
MN8 xn2 xbn VSS VSS nmos1v w=0.24u l=0.1u
MP9 xp1 A VDD VDD pmos1v w=0.48u l=0.1u
MP10 xp1 B VDD VDD pmos1v w=0.48u l=0.1u
MP11 S xan xp1 VDD pmos1v w=0.48u l=0.1u
MP12 S xbn xp1 VDD pmos1v w=0.48u l=0.1u
MN13 con A an VSS nmos1v w=0.24u l=0.1u
MN14 an B VSS VSS nmos1v w=0.24u l=0.1u
MP15 con A VDD VDD pmos1v w=0.24u l=0.1u
MP16 con B VDD VDD pmos1v w=0.24u l=0.1u
MN17 CO con VSS VSS nmos1v w=0.12u l=0.1u
MP18 CO con VDD VDD pmos1v w=0.24u l=0.1u
.ENDS HA_X1

.SUBCKT INV_X1 A Y VDD VSS
MN0 Y A VSS VSS nmos1v w=0.12u l=0.1u
MP0 Y A VDD VDD pmos1v w=0.24u l=0.1u
.ENDS INV_X1

.SUBCKT INV_X4 A Y VDD VSS
MN1 Y A VSS VSS nmos1v w=0.48u l=0.1u
MP2 Y A VDD VDD pmos1v w=0.96u l=0.1u
.ENDS INV_X4

.SUBCKT NOR2_X1 A B Y VDD VSS
MN0 Y A VSS VSS nmos1v w=0.12u l=0.1u
MN1 Y B VSS VSS nmos1v w=0.12u l=0.1u
MP0 p1 A VDD VDD pmos1v w=0.48u l=0.1u
MP1 Y B p1 VDD pmos1v w=0.48u l=0.1u
.ENDS NOR2_X1

.SUBCKT OAI21_X1 A1 A2 B Y VDD VSS
MN0 Y A1 n1 VSS nmos1v w=0.24u l=0.1u
MN1 Y A2 n1 VSS nmos1v w=0.24u l=0.1u
MN2 n1 B VSS VSS nmos1v w=0.24u l=0.1u
MP0 p1 A1 VDD VDD pmos1v w=0.48u l=0.1u
MP1 Y A2 p1 VDD pmos1v w=0.48u l=0.1u
MP2 Y B VDD VDD pmos1v w=0.24u l=0.1u
.ENDS OAI21_X1

.SUBCKT XNOR2_X1 A B Y VDD VSS
MN0 An A VSS VSS nmos1v w=0.12u l=0.1u
MP0 An A VDD VDD pmos1v w=0.24u l=0.1u
MN1 Bn B VSS VSS nmos1v w=0.12u l=0.1u
MP1 Bn B VDD VDD pmos1v w=0.24u l=0.1u
MN2 Y A n1 VSS nmos1v w=0.24u l=0.1u
MN3 n1 Bn VSS VSS nmos1v w=0.24u l=0.1u
MN4 Y An n2 VSS nmos1v w=0.24u l=0.1u
MN5 n2 B VSS VSS nmos1v w=0.24u l=0.1u
MP2 p1 A VDD VDD pmos1v w=0.48u l=0.1u
MP3 p1 Bn VDD VDD pmos1v w=0.48u l=0.1u
MP4 Y An p1 VDD pmos1v w=0.48u l=0.1u
MP5 Y B p1 VDD pmos1v w=0.48u l=0.1u
.ENDS XNOR2_X1

.SUBCKT ALU_TOP A_0 A_1 A_2 A_3 A_4 A_5 A_6 A_7 B_0 B_1 B_2 B_3 B_4 B_5 B_6 B_7 OP_0 OP_1 OP_2 OP_3 Y_0 Y_1 Y_2 Y_3 Y_4 Y_5 Y_6 Y_7 Y_8 Y_9 Y_10 Y_11 Y_12 Y_13 Y_14 Y_15 Z C V DZ VDD VSS
XI0_I0 B_1 B_0 VSS I0_one0 I0_two0 VDD VSS BOOTH_ENC
XI0_I1 A_0 VSS I0_one0 I0_two0 B_1 I0_pp0_0 VDD VSS BOOTH_SEL
XI0_I2 A_1 A_0 I0_one0 I0_two0 B_1 I0_pp0_1 VDD VSS BOOTH_SEL
XI0_I3 A_2 A_1 I0_one0 I0_two0 B_1 I0_pp0_2 VDD VSS BOOTH_SEL
XI0_I4 A_3 A_2 I0_one0 I0_two0 B_1 I0_pp0_3 VDD VSS BOOTH_SEL
XI0_I5 A_4 A_3 I0_one0 I0_two0 B_1 I0_pp0_4 VDD VSS BOOTH_SEL
XI0_I6 A_5 A_4 I0_one0 I0_two0 B_1 I0_pp0_5 VDD VSS BOOTH_SEL
XI0_I7 A_6 A_5 I0_one0 I0_two0 B_1 I0_pp0_6 VDD VSS BOOTH_SEL
XI0_I8 A_7 A_6 I0_one0 I0_two0 B_1 I0_pp0_7 VDD VSS BOOTH_SEL
XI0_I9 A_7 A_7 I0_one0 I0_two0 B_1 I0_pp0_8 VDD VSS BOOTH_SEL
XI0_I10 I0_pp0_8 I0_sn0 VDD VSS INV_X1
XI0_I11 B_3 B_2 B_1 I0_one1 I0_two1 VDD VSS BOOTH_ENC
XI0_I12 A_0 VSS I0_one1 I0_two1 B_3 I0_pp1_0 VDD VSS BOOTH_SEL
XI0_I13 A_1 A_0 I0_one1 I0_two1 B_3 I0_pp1_1 VDD VSS BOOTH_SEL
XI0_I14 A_2 A_1 I0_one1 I0_two1 B_3 I0_pp1_2 VDD VSS BOOTH_SEL
XI0_I15 A_3 A_2 I0_one1 I0_two1 B_3 I0_pp1_3 VDD VSS BOOTH_SEL
XI0_I16 A_4 A_3 I0_one1 I0_two1 B_3 I0_pp1_4 VDD VSS BOOTH_SEL
XI0_I17 A_5 A_4 I0_one1 I0_two1 B_3 I0_pp1_5 VDD VSS BOOTH_SEL
XI0_I18 A_6 A_5 I0_one1 I0_two1 B_3 I0_pp1_6 VDD VSS BOOTH_SEL
XI0_I19 A_7 A_6 I0_one1 I0_two1 B_3 I0_pp1_7 VDD VSS BOOTH_SEL
XI0_I20 A_7 A_7 I0_one1 I0_two1 B_3 I0_pp1_8 VDD VSS BOOTH_SEL
XI0_I21 I0_pp1_8 I0_sn1 VDD VSS INV_X1
XI0_I22 B_5 B_4 B_3 I0_one2 I0_two2 VDD VSS BOOTH_ENC
XI0_I23 A_0 VSS I0_one2 I0_two2 B_5 I0_pp2_0 VDD VSS BOOTH_SEL
XI0_I24 A_1 A_0 I0_one2 I0_two2 B_5 I0_pp2_1 VDD VSS BOOTH_SEL
XI0_I25 A_2 A_1 I0_one2 I0_two2 B_5 I0_pp2_2 VDD VSS BOOTH_SEL
XI0_I26 A_3 A_2 I0_one2 I0_two2 B_5 I0_pp2_3 VDD VSS BOOTH_SEL
XI0_I27 A_4 A_3 I0_one2 I0_two2 B_5 I0_pp2_4 VDD VSS BOOTH_SEL
XI0_I28 A_5 A_4 I0_one2 I0_two2 B_5 I0_pp2_5 VDD VSS BOOTH_SEL
XI0_I29 A_6 A_5 I0_one2 I0_two2 B_5 I0_pp2_6 VDD VSS BOOTH_SEL
XI0_I30 A_7 A_6 I0_one2 I0_two2 B_5 I0_pp2_7 VDD VSS BOOTH_SEL
XI0_I31 A_7 A_7 I0_one2 I0_two2 B_5 I0_pp2_8 VDD VSS BOOTH_SEL
XI0_I32 I0_pp2_8 I0_sn2 VDD VSS INV_X1
XI0_I33 B_7 B_6 B_5 I0_one3 I0_two3 VDD VSS BOOTH_ENC
XI0_I34 A_0 VSS I0_one3 I0_two3 B_7 I0_pp3_0 VDD VSS BOOTH_SEL
XI0_I35 A_1 A_0 I0_one3 I0_two3 B_7 I0_pp3_1 VDD VSS BOOTH_SEL
XI0_I36 A_2 A_1 I0_one3 I0_two3 B_7 I0_pp3_2 VDD VSS BOOTH_SEL
XI0_I37 A_3 A_2 I0_one3 I0_two3 B_7 I0_pp3_3 VDD VSS BOOTH_SEL
XI0_I38 A_4 A_3 I0_one3 I0_two3 B_7 I0_pp3_4 VDD VSS BOOTH_SEL
XI0_I39 A_5 A_4 I0_one3 I0_two3 B_7 I0_pp3_5 VDD VSS BOOTH_SEL
XI0_I40 A_6 A_5 I0_one3 I0_two3 B_7 I0_pp3_6 VDD VSS BOOTH_SEL
XI0_I41 A_7 A_6 I0_one3 I0_two3 B_7 I0_pp3_7 VDD VSS BOOTH_SEL
XI0_I42 A_7 A_7 I0_one3 I0_two3 B_7 I0_pp3_8 VDD VSS BOOTH_SEL
XI0_I43 I0_pp3_8 I0_sn3 VDD VSS INV_X1
XI0_I44 I0_pp0_2 I0_pp1_0 B_3 I0_fa1_0 I0_fa1_1 VDD VSS FA_X1
XI0_I45 I0_pp0_3 I0_pp1_1 I0_ha2_0 I0_ha2_1 VDD VSS HA_X1
XI0_I46 I0_pp0_4 I0_pp1_2 I0_pp2_0 I0_fa3_0 I0_fa3_1 VDD VSS FA_X1
XI0_I47 I0_pp0_5 I0_pp1_3 I0_pp2_1 I0_fa4_0 I0_fa4_1 VDD VSS FA_X1
XI0_I48 I0_pp0_6 I0_pp1_4 I0_pp2_2 I0_pp3_0 B_7 I0_cm5_0 I0_cm5_1 I0_cm5_2 VDD VSS CMP42
XI0_I49 I0_pp0_7 I0_pp1_5 I0_pp2_3 I0_pp3_1 I0_cm5_2 I0_cm6_0 I0_cm6_1 I0_cm6_2 VDD VSS CMP42
XI0_I50 I0_pp0_8 I0_pp1_6 I0_pp2_4 I0_pp3_2 I0_cm6_2 I0_cm7_0 I0_cm7_1 I0_cm7_2 VDD VSS CMP42
XI0_I51 I0_pp0_8 I0_pp1_7 I0_pp2_5 I0_pp3_3 I0_cm7_2 I0_cm8_0 I0_cm8_1 I0_cm8_2 VDD VSS CMP42
XI0_I52 I0_pp0_8 I0_pp1_8 I0_pp2_6 I0_pp3_4 I0_cm8_2 I0_cm9_0 I0_cm9_1 I0_cm9_2 VDD VSS CMP42
XI0_I53 I0_sn0 I0_sn1 I0_pp2_7 I0_pp3_5 I0_cm9_2 I0_cm10_0 I0_cm10_1 I0_cm10_2 VDD VSS CMP42
XI0_I54 VDD I0_pp2_8 I0_pp3_6 VSS I0_cm10_2 I0_cm11_0 I0_cm11_1 I0_cm11_2 VDD VSS CMP42
XI0_I55 I0_sn2 I0_pp3_7 I0_cm11_2 I0_fa12_0 I0_fa12_1 VDD VSS FA_X1
XI0_I56 VDD I0_pp3_8 I0_ha13_0 I0_ha13_1 VDD VSS HA_X1
XI0_I57 I0_ha2_1 I0_fa3_0 B_5 I0_fa14_0 I0_fa14_1 VDD VSS FA_X1
XI0_I58 I0_fa3_1 I0_fa4_0 I0_ha15_0 I0_ha15_1 VDD VSS HA_X1
XI0_I59 I0_fa4_1 I0_cm5_0 I0_ha16_0 I0_ha16_1 VDD VSS HA_X1
XI0_I60 I0_cm5_1 I0_cm6_0 I0_ha17_0 I0_ha17_1 VDD VSS HA_X1
XI0_I61 I0_cm6_1 I0_cm7_0 I0_ha18_0 I0_ha18_1 VDD VSS HA_X1
XI0_I62 I0_cm7_1 I0_cm8_0 I0_ha19_0 I0_ha19_1 VDD VSS HA_X1
XI0_I63 I0_cm8_1 I0_cm9_0 I0_ha20_0 I0_ha20_1 VDD VSS HA_X1
XI0_I64 I0_cm9_1 I0_cm10_0 I0_ha21_0 I0_ha21_1 VDD VSS HA_X1
XI0_I65 I0_cm10_1 I0_cm11_0 I0_ha22_0 I0_ha22_1 VDD VSS HA_X1
XI0_I66 I0_cm11_1 I0_fa12_0 I0_ha23_0 I0_ha23_1 VDD VSS HA_X1
XI0_I67 I0_fa12_1 I0_ha13_0 I0_ha24_0 I0_ha24_1 VDD VSS HA_X1
XI0_I68 I0_ha13_1 I0_sn3 I0_ha25_0 I0_ha25_1 VDD VSS HA_X1
XI0_I69 I0_pp0_0 B_1 MULP_0 I0_rc1 VDD VSS HA_X1
XI0_I70 I0_pp0_1 I0_rc1 MULP_1 I0_rc2 VDD VSS HA_X1
XI0_I71 I0_fa1_0 I0_rc2 MULP_2 I0_rc3 VDD VSS HA_X1
XI0_I72 I0_fa1_1 I0_ha2_0 I0_rc3 MULP_3 I0_rc4 VDD VSS FA_X1
XI0_I73 I0_fa14_0 I0_rc4 MULP_4 I0_rc5 VDD VSS HA_X1
XI0_I74 I0_fa14_1 I0_ha15_0 I0_rc5 MULP_5 I0_rc6 VDD VSS FA_X1
XI0_I75 I0_ha15_1 I0_ha16_0 I0_rc6 MULP_6 I0_rc7 VDD VSS FA_X1
XI0_I76 I0_ha16_1 I0_ha17_0 I0_rc7 MULP_7 I0_rc8 VDD VSS FA_X1
XI0_I77_I0 I0_ha17_1 I0_ha18_0 I0_I77_gn0 VDD VSS NAND2_X1
XI0_I77_I1 I0_ha18_1 I0_ha19_0 I0_I77_gn1 VDD VSS NAND2_X1
XI0_I77_I2 I0_ha19_1 I0_ha20_0 I0_I77_gn2 VDD VSS NAND2_X1
XI0_I77_I3 I0_ha20_1 I0_ha21_0 I0_I77_gn3 VDD VSS NAND2_X1
XI0_I77_I4 I0_ha21_1 I0_ha22_0 I0_I77_gn4 VDD VSS NAND2_X1
XI0_I77_I5 I0_ha22_1 I0_ha23_0 I0_I77_gn5 VDD VSS NAND2_X1
XI0_I77_I6 I0_ha23_1 I0_ha24_0 I0_I77_gn6 VDD VSS NAND2_X1
XI0_I77_I7 I0_ha24_1 I0_ha25_0 I0_I77_gn7 VDD VSS NAND2_X1
XI0_I77_I8 I0_ha17_1 I0_ha18_0 I0_I77_pn0 VDD VSS XNOR2_X1
XI0_I77_I9 I0_ha18_1 I0_ha19_0 I0_I77_pn1 VDD VSS XNOR2_X1
XI0_I77_I10 I0_ha19_1 I0_ha20_0 I0_I77_pn2 VDD VSS XNOR2_X1
XI0_I77_I11 I0_ha20_1 I0_ha21_0 I0_I77_pn3 VDD VSS XNOR2_X1
XI0_I77_I12 I0_ha21_1 I0_ha22_0 I0_I77_pn4 VDD VSS XNOR2_X1
XI0_I77_I13 I0_ha22_1 I0_ha23_0 I0_I77_pn5 VDD VSS XNOR2_X1
XI0_I77_I14 I0_ha23_1 I0_ha24_0 I0_I77_pn6 VDD VSS XNOR2_X1
XI0_I77_I15 I0_ha24_1 I0_ha25_0 I0_I77_pn7 VDD VSS XNOR2_X1
XI0_I77_I16 I0_rc8 I0_I77_cinn VDD VSS INV_X1
XI0_I77_I17_XG I0_I77_pn0 I0_I77_cinn I0_I77_gn0 I0_I77_G0_0 VDD VSS OAI21_X1
XI0_I77_I18 I0_I77_G0_0 I0_I77_G0_0n VDD VSS INV_X1
XI0_I77_I19_XG I0_I77_pn1 I0_I77_G0_0n I0_I77_gn1 I0_I77_G1_0 VDD VSS OAI21_X1
XI0_I77_I20_XG I0_I77_pn2 I0_I77_gn1 I0_I77_gn2 I0_I77_G2_1 VDD VSS OAI21_X1
XI0_I77_I20_XP I0_I77_pn2 I0_I77_pn1 I0_I77_P2_1 VDD VSS NOR2_X1
XI0_I77_I21_XG I0_I77_pn3 I0_I77_gn2 I0_I77_gn3 I0_I77_G3_2 VDD VSS OAI21_X1
XI0_I77_I21_XP I0_I77_pn3 I0_I77_pn2 I0_I77_P3_2 VDD VSS NOR2_X1
XI0_I77_I22_XG I0_I77_pn4 I0_I77_gn3 I0_I77_gn4 I0_I77_G4_3 VDD VSS OAI21_X1
XI0_I77_I22_XP I0_I77_pn4 I0_I77_pn3 I0_I77_P4_3 VDD VSS NOR2_X1
XI0_I77_I23_XG I0_I77_pn5 I0_I77_gn4 I0_I77_gn5 I0_I77_G5_4 VDD VSS OAI21_X1
XI0_I77_I23_XP I0_I77_pn5 I0_I77_pn4 I0_I77_P5_4 VDD VSS NOR2_X1
XI0_I77_I24_XG I0_I77_pn6 I0_I77_gn5 I0_I77_gn6 I0_I77_G6_5 VDD VSS OAI21_X1
XI0_I77_I24_XP I0_I77_pn6 I0_I77_pn5 I0_I77_P6_5 VDD VSS NOR2_X1
XI0_I77_I25_XG I0_I77_pn7 I0_I77_gn6 I0_I77_gn7 I0_I77_G7_6 VDD VSS OAI21_X1
XI0_I77_I25_XP I0_I77_pn7 I0_I77_pn6 I0_I77_P7_6 VDD VSS NOR2_X1
XI0_I77_I26_XG I0_I77_P2_1 I0_I77_G0_0 I0_I77_G2_1 I0_I77_G2_0n VDD VSS AOI21_X1
XI0_I77_I27_XG I0_I77_P3_2 I0_I77_G1_0 I0_I77_G3_2 I0_I77_G3_0n VDD VSS AOI21_X1
XI0_I77_I28_XG I0_I77_P4_3 I0_I77_G2_1 I0_I77_G4_3 I0_I77_G4_1n VDD VSS AOI21_X1
XI0_I77_I28_XP I0_I77_P4_3 I0_I77_P2_1 I0_I77_P4_1n VDD VSS NAND2_X1
XI0_I77_I29_XG I0_I77_P5_4 I0_I77_G3_2 I0_I77_G5_4 I0_I77_G5_2n VDD VSS AOI21_X1
XI0_I77_I29_XP I0_I77_P5_4 I0_I77_P3_2 I0_I77_P5_2n VDD VSS NAND2_X1
XI0_I77_I30_XG I0_I77_P6_5 I0_I77_G4_3 I0_I77_G6_5 I0_I77_G6_3n VDD VSS AOI21_X1
XI0_I77_I30_XP I0_I77_P6_5 I0_I77_P4_3 I0_I77_P6_3n VDD VSS NAND2_X1
XI0_I77_I31_XG I0_I77_P7_6 I0_I77_G5_4 I0_I77_G7_6 I0_I77_G7_4n VDD VSS AOI21_X1
XI0_I77_I31_XP I0_I77_P7_6 I0_I77_P5_4 I0_I77_P7_4n VDD VSS NAND2_X1
XI0_I77_I32_XG I0_I77_P4_1n I0_I77_G0_0n I0_I77_G4_1n I0_I77_G4_0 VDD VSS OAI21_X1
XI0_I77_I33 I0_I77_G1_0 I0_I77_G1_0n VDD VSS INV_X1
XI0_I77_I34_XG I0_I77_P5_2n I0_I77_G1_0n I0_I77_G5_2n I0_I77_G5_0 VDD VSS OAI21_X1
XI0_I77_I35_XG I0_I77_P6_3n I0_I77_G2_0n I0_I77_G6_3n I0_kc7 VDD VSS OAI21_X1
XI0_I77_I36_XG I0_I77_P7_4n I0_I77_G3_0n I0_I77_G7_4n I0_kc8 VDD VSS OAI21_X1
XI0_I77_I37 I0_I77_pn0 I0_rc8 MULP_8 VDD VSS XNOR2_X1
XI0_I77_I38 I0_I77_pn1 I0_I77_G0_0 MULP_9 VDD VSS XNOR2_X1
XI0_I77_I39 I0_I77_pn2 I0_I77_G1_0 MULP_10 VDD VSS XNOR2_X1
XI0_I77_I40 I0_I77_pn3 I0_I77_G2_0n MULP_11 VDD VSS XOR2_X1
XI0_I77_I41 I0_I77_pn4 I0_I77_G3_0n MULP_12 VDD VSS XOR2_X1
XI0_I77_I42 I0_I77_pn5 I0_I77_G4_0 MULP_13 VDD VSS XNOR2_X1
XI0_I77_I43 I0_I77_pn6 I0_I77_G5_0 MULP_14 VDD VSS XNOR2_X1
XI0_I77_I44 I0_I77_pn7 I0_kc7 MULP_15 VDD VSS XNOR2_X1
XI1_I0 A_7 A_0 I1_nakn1 VDD VSS NAND2_X1
XI1_I1 A_1 I1_nakn1 I1_aa1 VDD VSS XNOR2_X1
XI1_I2 I1_nakn1 I1_nak1 VDD VSS INV_X1
XI1_I3 A_7 A_1 I1_nak1 I1_nakn2 VDD VSS AOI21_X1
XI1_I4 A_2 I1_nakn2 I1_aa2 VDD VSS XNOR2_X1
XI1_I5 I1_nakn2 I1_nak2 VDD VSS INV_X1
XI1_I6 A_7 A_2 I1_nak2 I1_nakn3 VDD VSS AOI21_X1
XI1_I7 A_3 I1_nakn3 I1_aa3 VDD VSS XNOR2_X1
XI1_I8 I1_nakn3 I1_nak3 VDD VSS INV_X1
XI1_I9 A_7 A_3 I1_nak3 I1_nakn4 VDD VSS AOI21_X1
XI1_I10 A_4 I1_nakn4 I1_aa4 VDD VSS XNOR2_X1
XI1_I11 I1_nakn4 I1_nak4 VDD VSS INV_X1
XI1_I12 A_7 A_4 I1_nak4 I1_nakn5 VDD VSS AOI21_X1
XI1_I13 A_5 I1_nakn5 I1_aa5 VDD VSS XNOR2_X1
XI1_I14 I1_nakn5 I1_nak5 VDD VSS INV_X1
XI1_I15 A_7 A_5 I1_nak5 I1_nakn6 VDD VSS AOI21_X1
XI1_I16 A_6 I1_nakn6 I1_aa6 VDD VSS XNOR2_X1
XI1_I17 I1_nakn6 I1_nak6 VDD VSS INV_X1
XI1_I18 A_7 A_6 I1_nak6 I1_nakn7 VDD VSS AOI21_X1
XI1_I19 A_7 I1_nakn7 I1_aa7 VDD VSS XNOR2_X1
XI1_I20 B_7 B_0 I1_nbkn1 VDD VSS NAND2_X1
XI1_I21 B_1 I1_nbkn1 I1_dd1 VDD VSS XNOR2_X1
XI1_I22 I1_nbkn1 I1_nbk1 VDD VSS INV_X1
XI1_I23 B_7 B_1 I1_nbk1 I1_nbkn2 VDD VSS AOI21_X1
XI1_I24 B_2 I1_nbkn2 I1_dd2 VDD VSS XNOR2_X1
XI1_I25 I1_nbkn2 I1_nbk2 VDD VSS INV_X1
XI1_I26 B_7 B_2 I1_nbk2 I1_nbkn3 VDD VSS AOI21_X1
XI1_I27 B_3 I1_nbkn3 I1_dd3 VDD VSS XNOR2_X1
XI1_I28 I1_nbkn3 I1_nbk3 VDD VSS INV_X1
XI1_I29 B_7 B_3 I1_nbk3 I1_nbkn4 VDD VSS AOI21_X1
XI1_I30 B_4 I1_nbkn4 I1_dd4 VDD VSS XNOR2_X1
XI1_I31 I1_nbkn4 I1_nbk4 VDD VSS INV_X1
XI1_I32 B_7 B_4 I1_nbk4 I1_nbkn5 VDD VSS AOI21_X1
XI1_I33 B_5 I1_nbkn5 I1_dd5 VDD VSS XNOR2_X1
XI1_I34 I1_nbkn5 I1_nbk5 VDD VSS INV_X1
XI1_I35 B_7 B_5 I1_nbk5 I1_nbkn6 VDD VSS AOI21_X1
XI1_I36 B_6 I1_nbkn6 I1_dd6 VDD VSS XNOR2_X1
XI1_I37 I1_nbkn6 I1_nbk6 VDD VSS INV_X1
XI1_I38 B_7 B_6 I1_nbk6 I1_nbkn7 VDD VSS AOI21_X1
XI1_I39 B_7 I1_nbkn7 I1_dd7 VDD VSS XNOR2_X1
XI1_I40 I1_aa7 B_0 VDD VDD I1_p0_0 I1_c0_0 VDD VSS CAS_X1
XI1_I41 VSS I1_dd1 VDD I1_c0_0 I1_p0_1 I1_c0_1 VDD VSS CAS_X1
XI1_I42 VSS I1_dd2 VDD I1_c0_1 I1_p0_2 I1_c0_2 VDD VSS CAS_X1
XI1_I43 VSS I1_dd3 VDD I1_c0_2 I1_p0_3 I1_c0_3 VDD VSS CAS_X1
XI1_I44 VSS I1_dd4 VDD I1_c0_3 I1_p0_4 I1_c0_4 VDD VSS CAS_X1
XI1_I45 VSS I1_dd5 VDD I1_c0_4 I1_p0_5 I1_c0_5 VDD VSS CAS_X1
XI1_I46 VSS I1_dd6 VDD I1_c0_5 I1_p0_6 I1_c0_6 VDD VSS CAS_X1
XI1_I47 VSS I1_dd7 VDD I1_c0_6 I1_p0_7 I1_c0_7 VDD VSS CAS_X1
XI1_I48 VSS VSS VDD I1_c0_7 I1_p0_8 I1_c0_8 VDD VSS CAS_X1
XI1_I49 I1_p0_8 I1_qu7 VDD VSS INV_X4
XI1_I50 I1_aa6 B_0 I1_qu7 I1_qu7 I1_p1_0 I1_c1_0 VDD VSS CAS_X1
XI1_I51 I1_p0_0 I1_dd1 I1_qu7 I1_c1_0 I1_p1_1 I1_c1_1 VDD VSS CAS_X1
XI1_I52 I1_p0_1 I1_dd2 I1_qu7 I1_c1_1 I1_p1_2 I1_c1_2 VDD VSS CAS_X1
XI1_I53 I1_p0_2 I1_dd3 I1_qu7 I1_c1_2 I1_p1_3 I1_c1_3 VDD VSS CAS_X1
XI1_I54 I1_p0_3 I1_dd4 I1_qu7 I1_c1_3 I1_p1_4 I1_c1_4 VDD VSS CAS_X1
XI1_I55 I1_p0_4 I1_dd5 I1_qu7 I1_c1_4 I1_p1_5 I1_c1_5 VDD VSS CAS_X1
XI1_I56 I1_p0_5 I1_dd6 I1_qu7 I1_c1_5 I1_p1_6 I1_c1_6 VDD VSS CAS_X1
XI1_I57 I1_p0_6 I1_dd7 I1_qu7 I1_c1_6 I1_p1_7 I1_c1_7 VDD VSS CAS_X1
XI1_I58 I1_p0_7 VSS I1_qu7 I1_c1_7 I1_p1_8 I1_c1_8 VDD VSS CAS_X1
XI1_I59 I1_p1_8 I1_qu6 VDD VSS INV_X4
XI1_I60 I1_aa5 B_0 I1_qu6 I1_qu6 I1_p2_0 I1_c2_0 VDD VSS CAS_X1
XI1_I61 I1_p1_0 I1_dd1 I1_qu6 I1_c2_0 I1_p2_1 I1_c2_1 VDD VSS CAS_X1
XI1_I62 I1_p1_1 I1_dd2 I1_qu6 I1_c2_1 I1_p2_2 I1_c2_2 VDD VSS CAS_X1
XI1_I63 I1_p1_2 I1_dd3 I1_qu6 I1_c2_2 I1_p2_3 I1_c2_3 VDD VSS CAS_X1
XI1_I64 I1_p1_3 I1_dd4 I1_qu6 I1_c2_3 I1_p2_4 I1_c2_4 VDD VSS CAS_X1
XI1_I65 I1_p1_4 I1_dd5 I1_qu6 I1_c2_4 I1_p2_5 I1_c2_5 VDD VSS CAS_X1
XI1_I66 I1_p1_5 I1_dd6 I1_qu6 I1_c2_5 I1_p2_6 I1_c2_6 VDD VSS CAS_X1
XI1_I67 I1_p1_6 I1_dd7 I1_qu6 I1_c2_6 I1_p2_7 I1_c2_7 VDD VSS CAS_X1
XI1_I68 I1_p1_7 VSS I1_qu6 I1_c2_7 I1_p2_8 I1_c2_8 VDD VSS CAS_X1
XI1_I69 I1_p2_8 I1_qu5 VDD VSS INV_X4
XI1_I70 I1_aa4 B_0 I1_qu5 I1_qu5 I1_p3_0 I1_c3_0 VDD VSS CAS_X1
XI1_I71 I1_p2_0 I1_dd1 I1_qu5 I1_c3_0 I1_p3_1 I1_c3_1 VDD VSS CAS_X1
XI1_I72 I1_p2_1 I1_dd2 I1_qu5 I1_c3_1 I1_p3_2 I1_c3_2 VDD VSS CAS_X1
XI1_I73 I1_p2_2 I1_dd3 I1_qu5 I1_c3_2 I1_p3_3 I1_c3_3 VDD VSS CAS_X1
XI1_I74 I1_p2_3 I1_dd4 I1_qu5 I1_c3_3 I1_p3_4 I1_c3_4 VDD VSS CAS_X1
XI1_I75 I1_p2_4 I1_dd5 I1_qu5 I1_c3_4 I1_p3_5 I1_c3_5 VDD VSS CAS_X1
XI1_I76 I1_p2_5 I1_dd6 I1_qu5 I1_c3_5 I1_p3_6 I1_c3_6 VDD VSS CAS_X1
XI1_I77 I1_p2_6 I1_dd7 I1_qu5 I1_c3_6 I1_p3_7 I1_c3_7 VDD VSS CAS_X1
XI1_I78 I1_p2_7 VSS I1_qu5 I1_c3_7 I1_p3_8 I1_c3_8 VDD VSS CAS_X1
XI1_I79 I1_p3_8 I1_qu4 VDD VSS INV_X4
XI1_I80 I1_aa3 B_0 I1_qu4 I1_qu4 I1_p4_0 I1_c4_0 VDD VSS CAS_X1
XI1_I81 I1_p3_0 I1_dd1 I1_qu4 I1_c4_0 I1_p4_1 I1_c4_1 VDD VSS CAS_X1
XI1_I82 I1_p3_1 I1_dd2 I1_qu4 I1_c4_1 I1_p4_2 I1_c4_2 VDD VSS CAS_X1
XI1_I83 I1_p3_2 I1_dd3 I1_qu4 I1_c4_2 I1_p4_3 I1_c4_3 VDD VSS CAS_X1
XI1_I84 I1_p3_3 I1_dd4 I1_qu4 I1_c4_3 I1_p4_4 I1_c4_4 VDD VSS CAS_X1
XI1_I85 I1_p3_4 I1_dd5 I1_qu4 I1_c4_4 I1_p4_5 I1_c4_5 VDD VSS CAS_X1
XI1_I86 I1_p3_5 I1_dd6 I1_qu4 I1_c4_5 I1_p4_6 I1_c4_6 VDD VSS CAS_X1
XI1_I87 I1_p3_6 I1_dd7 I1_qu4 I1_c4_6 I1_p4_7 I1_c4_7 VDD VSS CAS_X1
XI1_I88 I1_p3_7 VSS I1_qu4 I1_c4_7 I1_p4_8 I1_c4_8 VDD VSS CAS_X1
XI1_I89 I1_p4_8 I1_qu3 VDD VSS INV_X4
XI1_I90 I1_aa2 B_0 I1_qu3 I1_qu3 I1_p5_0 I1_c5_0 VDD VSS CAS_X1
XI1_I91 I1_p4_0 I1_dd1 I1_qu3 I1_c5_0 I1_p5_1 I1_c5_1 VDD VSS CAS_X1
XI1_I92 I1_p4_1 I1_dd2 I1_qu3 I1_c5_1 I1_p5_2 I1_c5_2 VDD VSS CAS_X1
XI1_I93 I1_p4_2 I1_dd3 I1_qu3 I1_c5_2 I1_p5_3 I1_c5_3 VDD VSS CAS_X1
XI1_I94 I1_p4_3 I1_dd4 I1_qu3 I1_c5_3 I1_p5_4 I1_c5_4 VDD VSS CAS_X1
XI1_I95 I1_p4_4 I1_dd5 I1_qu3 I1_c5_4 I1_p5_5 I1_c5_5 VDD VSS CAS_X1
XI1_I96 I1_p4_5 I1_dd6 I1_qu3 I1_c5_5 I1_p5_6 I1_c5_6 VDD VSS CAS_X1
XI1_I97 I1_p4_6 I1_dd7 I1_qu3 I1_c5_6 I1_p5_7 I1_c5_7 VDD VSS CAS_X1
XI1_I98 I1_p4_7 VSS I1_qu3 I1_c5_7 I1_p5_8 I1_c5_8 VDD VSS CAS_X1
XI1_I99 I1_p5_8 I1_qu2 VDD VSS INV_X4
XI1_I100 I1_aa1 B_0 I1_qu2 I1_qu2 I1_p6_0 I1_c6_0 VDD VSS CAS_X1
XI1_I101 I1_p5_0 I1_dd1 I1_qu2 I1_c6_0 I1_p6_1 I1_c6_1 VDD VSS CAS_X1
XI1_I102 I1_p5_1 I1_dd2 I1_qu2 I1_c6_1 I1_p6_2 I1_c6_2 VDD VSS CAS_X1
XI1_I103 I1_p5_2 I1_dd3 I1_qu2 I1_c6_2 I1_p6_3 I1_c6_3 VDD VSS CAS_X1
XI1_I104 I1_p5_3 I1_dd4 I1_qu2 I1_c6_3 I1_p6_4 I1_c6_4 VDD VSS CAS_X1
XI1_I105 I1_p5_4 I1_dd5 I1_qu2 I1_c6_4 I1_p6_5 I1_c6_5 VDD VSS CAS_X1
XI1_I106 I1_p5_5 I1_dd6 I1_qu2 I1_c6_5 I1_p6_6 I1_c6_6 VDD VSS CAS_X1
XI1_I107 I1_p5_6 I1_dd7 I1_qu2 I1_c6_6 I1_p6_7 I1_c6_7 VDD VSS CAS_X1
XI1_I108 I1_p5_7 VSS I1_qu2 I1_c6_7 I1_p6_8 I1_c6_8 VDD VSS CAS_X1
XI1_I109 I1_p6_8 I1_qu1 VDD VSS INV_X4
XI1_I110 A_0 B_0 I1_qu1 I1_qu1 I1_p7_0 I1_c7_0 VDD VSS CAS_X1
XI1_I111 I1_p6_0 I1_dd1 I1_qu1 I1_c7_0 I1_p7_1 I1_c7_1 VDD VSS CAS_X1
XI1_I112 I1_p6_1 I1_dd2 I1_qu1 I1_c7_1 I1_p7_2 I1_c7_2 VDD VSS CAS_X1
XI1_I113 I1_p6_2 I1_dd3 I1_qu1 I1_c7_2 I1_p7_3 I1_c7_3 VDD VSS CAS_X1
XI1_I114 I1_p6_3 I1_dd4 I1_qu1 I1_c7_3 I1_p7_4 I1_c7_4 VDD VSS CAS_X1
XI1_I115 I1_p6_4 I1_dd5 I1_qu1 I1_c7_4 I1_p7_5 I1_c7_5 VDD VSS CAS_X1
XI1_I116 I1_p6_5 I1_dd6 I1_qu1 I1_c7_5 I1_p7_6 I1_c7_6 VDD VSS CAS_X1
XI1_I117 I1_p6_6 I1_dd7 I1_qu1 I1_c7_6 I1_p7_7 I1_c7_7 VDD VSS CAS_X1
XI1_I118 I1_p6_7 VSS I1_qu1 I1_c7_7 I1_p7_8 I1_c7_8 VDD VSS CAS_X1
XI1_I119 I1_p7_8 DIVQ_0 VDD VSS INV_X1
XI1_I120 B_0 I1_p7_8 I1_dmn0 VDD VSS NAND2_X1
XI1_I121 I1_dmn0 I1_dm0 VDD VSS INV_X1
XI1_I122 I1_p7_0 I1_dm0 VSS VSS DIVR_0 I1_rc0 VDD VSS CAS_X1
XI1_I123 I1_dd1 I1_p7_8 I1_dmn1 VDD VSS NAND2_X1
XI1_I124 I1_dmn1 I1_dm1 VDD VSS INV_X1
XI1_I125 I1_p7_1 I1_dm1 VSS I1_rc0 I1_ru1 I1_rc1 VDD VSS CAS_X1
XI1_I126 I1_dd2 I1_p7_8 I1_dmn2 VDD VSS NAND2_X1
XI1_I127 I1_dmn2 I1_dm2 VDD VSS INV_X1
XI1_I128 I1_p7_2 I1_dm2 VSS I1_rc1 I1_ru2 I1_rc2 VDD VSS CAS_X1
XI1_I129 I1_dd3 I1_p7_8 I1_dmn3 VDD VSS NAND2_X1
XI1_I130 I1_dmn3 I1_dm3 VDD VSS INV_X1
XI1_I131 I1_p7_3 I1_dm3 VSS I1_rc2 I1_ru3 I1_rc3 VDD VSS CAS_X1
XI1_I132 I1_dd4 I1_p7_8 I1_dmn4 VDD VSS NAND2_X1
XI1_I133 I1_dmn4 I1_dm4 VDD VSS INV_X1
XI1_I134 I1_p7_4 I1_dm4 VSS I1_rc3 I1_ru4 I1_rc4 VDD VSS CAS_X1
XI1_I135 I1_dd5 I1_p7_8 I1_dmn5 VDD VSS NAND2_X1
XI1_I136 I1_dmn5 I1_dm5 VDD VSS INV_X1
XI1_I137 I1_p7_5 I1_dm5 VSS I1_rc4 I1_ru5 I1_rc5 VDD VSS CAS_X1
XI1_I138 I1_dd6 I1_p7_8 I1_dmn6 VDD VSS NAND2_X1
XI1_I139 I1_dmn6 I1_dm6 VDD VSS INV_X1
XI1_I140 I1_p7_6 I1_dm6 VSS I1_rc5 I1_ru6 I1_rc6 VDD VSS CAS_X1
XI1_I141 I1_dd7 I1_p7_8 I1_dmn7 VDD VSS NAND2_X1
XI1_I142 I1_dmn7 I1_dm7 VDD VSS INV_X1
XI1_I143 I1_p7_7 I1_dm7 VSS I1_rc6 I1_ru7 I1_rc7 VDD VSS CAS_X1
XI1_I144 A_7 B_7 I1_sq VDD VSS XOR2_X1
XI1_I145 I1_sq DIVQ_0 I1_nqkn1 VDD VSS NAND2_X1
XI1_I146 I1_qu1 I1_nqkn1 DIVQ_1 VDD VSS XNOR2_X1
XI1_I147 I1_nqkn1 I1_nqk1 VDD VSS INV_X1
XI1_I148 I1_sq I1_qu1 I1_nqk1 I1_nqkn2 VDD VSS AOI21_X1
XI1_I149 I1_qu2 I1_nqkn2 DIVQ_2 VDD VSS XNOR2_X1
XI1_I150 I1_nqkn2 I1_nqk2 VDD VSS INV_X1
XI1_I151 I1_sq I1_qu2 I1_nqk2 I1_nqkn3 VDD VSS AOI21_X1
XI1_I152 I1_qu3 I1_nqkn3 DIVQ_3 VDD VSS XNOR2_X1
XI1_I153 I1_nqkn3 I1_nqk3 VDD VSS INV_X1
XI1_I154 I1_sq I1_qu3 I1_nqk3 I1_nqkn4 VDD VSS AOI21_X1
XI1_I155 I1_qu4 I1_nqkn4 DIVQ_4 VDD VSS XNOR2_X1
XI1_I156 I1_nqkn4 I1_nqk4 VDD VSS INV_X1
XI1_I157 I1_sq I1_qu4 I1_nqk4 I1_nqkn5 VDD VSS AOI21_X1
XI1_I158 I1_qu5 I1_nqkn5 DIVQ_5 VDD VSS XNOR2_X1
XI1_I159 I1_nqkn5 I1_nqk5 VDD VSS INV_X1
XI1_I160 I1_sq I1_qu5 I1_nqk5 I1_nqkn6 VDD VSS AOI21_X1
XI1_I161 I1_qu6 I1_nqkn6 DIVQ_6 VDD VSS XNOR2_X1
XI1_I162 I1_nqkn6 I1_nqk6 VDD VSS INV_X1
XI1_I163 I1_sq I1_qu6 I1_nqk6 I1_nqkn7 VDD VSS AOI21_X1
XI1_I164 I1_qu7 I1_nqkn7 DIVQ_7 VDD VSS XNOR2_X1
XI1_I165 A_7 DIVR_0 I1_nrkn1 VDD VSS NAND2_X1
XI1_I166 I1_ru1 I1_nrkn1 DIVR_1 VDD VSS XNOR2_X1
XI1_I167 I1_nrkn1 I1_nrk1 VDD VSS INV_X1
XI1_I168 A_7 I1_ru1 I1_nrk1 I1_nrkn2 VDD VSS AOI21_X1
XI1_I169 I1_ru2 I1_nrkn2 DIVR_2 VDD VSS XNOR2_X1
XI1_I170 I1_nrkn2 I1_nrk2 VDD VSS INV_X1
XI1_I171 A_7 I1_ru2 I1_nrk2 I1_nrkn3 VDD VSS AOI21_X1
XI1_I172 I1_ru3 I1_nrkn3 DIVR_3 VDD VSS XNOR2_X1
XI1_I173 I1_nrkn3 I1_nrk3 VDD VSS INV_X1
XI1_I174 A_7 I1_ru3 I1_nrk3 I1_nrkn4 VDD VSS AOI21_X1
XI1_I175 I1_ru4 I1_nrkn4 DIVR_4 VDD VSS XNOR2_X1
XI1_I176 I1_nrkn4 I1_nrk4 VDD VSS INV_X1
XI1_I177 A_7 I1_ru4 I1_nrk4 I1_nrkn5 VDD VSS AOI21_X1
XI1_I178 I1_ru5 I1_nrkn5 DIVR_5 VDD VSS XNOR2_X1
XI1_I179 I1_nrkn5 I1_nrk5 VDD VSS INV_X1
XI1_I180 A_7 I1_ru5 I1_nrk5 I1_nrkn6 VDD VSS AOI21_X1
XI1_I181 I1_ru6 I1_nrkn6 DIVR_6 VDD VSS XNOR2_X1
XI1_I182 I1_nrkn6 I1_nrk6 VDD VSS INV_X1
XI1_I183 A_7 I1_ru6 I1_nrk6 I1_nrkn7 VDD VSS AOI21_X1
XI1_I184 I1_ru7 I1_nrkn7 DIVR_7 VDD VSS XNOR2_X1
XI1_I185 B_0 B_1 I1_z1_0 VDD VSS NOR2_X1
XI1_I186 B_2 B_3 I1_z1_1 VDD VSS NOR2_X1
XI1_I187 B_4 B_5 I1_z1_2 VDD VSS NOR2_X1
XI1_I188 B_6 B_7 I1_z1_3 VDD VSS NOR2_X1
XI1_I189 I1_z1_0 I1_z1_1 I1_z2_0 VDD VSS NAND2_X1
XI1_I190 I1_z1_2 I1_z1_3 I1_z2_1 VDD VSS NAND2_X1
XI1_I191 I1_z2_0 I1_z2_1 DIVDZ VDD VSS NOR2_X1
XI1_I192 I1_sq I1_sqn VDD VSS INV_X1
XI1_I193 DIVQ_7 I1_sqn I1_vn VDD VSS NAND2_X1
XI1_I194 I1_vn DIVDZ DIVV VDD VSS NOR2_X1
XI2_I0_I0 OP_0 I2_I0_opn0 VDD VSS INV_X1
XI2_I0_I1 OP_1 I2_I0_opn1 VDD VSS INV_X1
XI2_I0_I2 OP_2 I2_I0_opn2 VDD VSS INV_X1
XI2_I0_I3 OP_3 I2_I0_opn3 VDD VSS INV_X1
XI2_I0_I4 I2_I0_opn3 I2_I0_opn2 I2_I0_h00 VDD VSS NAND2_X1
XI2_I0_I5 I2_I0_opn3 OP_2 I2_I0_h01 VDD VSS NAND2_X1
XI2_I0_I6 OP_3 I2_I0_opn2 I2_I0_h10 VDD VSS NAND2_X1
XI2_I0_I7 I2_I0_opn1 I2_I0_opn0 I2_I0_l00 VDD VSS NAND2_X1
XI2_I0_I8 I2_I0_opn1 OP_0 I2_I0_l01 VDD VSS NAND2_X1
XI2_I0_I9 OP_1 I2_I0_opn0 I2_I0_l10 VDD VSS NAND2_X1
XI2_I0_I10 OP_1 OP_0 I2_I0_l11 VDD VSS NAND2_X1
XI2_I0_I11 I2_I0_h00 OP_1 I2_SEL_AS VDD VSS NOR2_X1
XI2_I0_I12 I2_I0_h00 I2_I0_l10 I2_SEL_AND VDD VSS NOR2_X1
XI2_I0_I13 I2_I0_h00 I2_I0_l11 I2_SEL_OR VDD VSS NOR2_X1
XI2_I0_I14 I2_I0_h01 I2_I0_l00 I2_SEL_XOR VDD VSS NOR2_X1
XI2_I0_I15 I2_I0_h01 I2_I0_l01 I2_SEL_NOT VDD VSS NOR2_X1
XI2_I0_I16 I2_I0_h10 I2_I0_l01 I2_SEL_MUL VDD VSS NOR2_X1
XI2_I0_I17 I2_I0_h10 I2_I0_l11 I2_SEL_DIV VDD VSS NOR2_X1
XI2_I1_I0 B_0 OP_0 I2_I1_bx0 VDD VSS XOR2_X1
XI2_I1_I1 B_1 OP_0 I2_I1_bx1 VDD VSS XOR2_X1
XI2_I1_I2 B_2 OP_0 I2_I1_bx2 VDD VSS XOR2_X1
XI2_I1_I3 B_3 OP_0 I2_I1_bx3 VDD VSS XOR2_X1
XI2_I1_I4 B_4 OP_0 I2_I1_bx4 VDD VSS XOR2_X1
XI2_I1_I5 B_5 OP_0 I2_I1_bx5 VDD VSS XOR2_X1
XI2_I1_I6 B_6 OP_0 I2_I1_bx6 VDD VSS XOR2_X1
XI2_I1_I7 B_7 OP_0 I2_I1_bx7 VDD VSS XOR2_X1
XI2_I1_I8_I0 A_0 I2_I1_bx0 I2_I1_I8_gn0 VDD VSS NAND2_X1
XI2_I1_I8_I1 A_1 I2_I1_bx1 I2_I1_I8_gn1 VDD VSS NAND2_X1
XI2_I1_I8_I2 A_2 I2_I1_bx2 I2_I1_I8_gn2 VDD VSS NAND2_X1
XI2_I1_I8_I3 A_3 I2_I1_bx3 I2_I1_I8_gn3 VDD VSS NAND2_X1
XI2_I1_I8_I4 A_4 I2_I1_bx4 I2_I1_I8_gn4 VDD VSS NAND2_X1
XI2_I1_I8_I5 A_5 I2_I1_bx5 I2_I1_I8_gn5 VDD VSS NAND2_X1
XI2_I1_I8_I6 A_6 I2_I1_bx6 I2_I1_I8_gn6 VDD VSS NAND2_X1
XI2_I1_I8_I7 A_7 I2_I1_bx7 I2_I1_I8_gn7 VDD VSS NAND2_X1
XI2_I1_I8_I8 A_0 I2_I1_bx0 I2_I1_I8_pn0 VDD VSS XNOR2_X1
XI2_I1_I8_I9 A_1 I2_I1_bx1 I2_I1_I8_pn1 VDD VSS XNOR2_X1
XI2_I1_I8_I10 A_2 I2_I1_bx2 I2_I1_I8_pn2 VDD VSS XNOR2_X1
XI2_I1_I8_I11 A_3 I2_I1_bx3 I2_I1_I8_pn3 VDD VSS XNOR2_X1
XI2_I1_I8_I12 A_4 I2_I1_bx4 I2_I1_I8_pn4 VDD VSS XNOR2_X1
XI2_I1_I8_I13 A_5 I2_I1_bx5 I2_I1_I8_pn5 VDD VSS XNOR2_X1
XI2_I1_I8_I14 A_6 I2_I1_bx6 I2_I1_I8_pn6 VDD VSS XNOR2_X1
XI2_I1_I8_I15 A_7 I2_I1_bx7 I2_I1_I8_pn7 VDD VSS XNOR2_X1
XI2_I1_I8_I16 OP_0 I2_I1_I8_cinn VDD VSS INV_X1
XI2_I1_I8_I17_XG I2_I1_I8_pn0 I2_I1_I8_cinn I2_I1_I8_gn0 I2_I1_I8_G0_0 VDD VSS OAI21_X1
XI2_I1_I8_I18 I2_I1_I8_G0_0 I2_I1_I8_G0_0n VDD VSS INV_X1
XI2_I1_I8_I19_XG I2_I1_I8_pn1 I2_I1_I8_G0_0n I2_I1_I8_gn1 I2_I1_I8_G1_0 VDD VSS OAI21_X1
XI2_I1_I8_I20_XG I2_I1_I8_pn2 I2_I1_I8_gn1 I2_I1_I8_gn2 I2_I1_I8_G2_1 VDD VSS OAI21_X1
XI2_I1_I8_I20_XP I2_I1_I8_pn2 I2_I1_I8_pn1 I2_I1_I8_P2_1 VDD VSS NOR2_X1
XI2_I1_I8_I21_XG I2_I1_I8_pn3 I2_I1_I8_gn2 I2_I1_I8_gn3 I2_I1_I8_G3_2 VDD VSS OAI21_X1
XI2_I1_I8_I21_XP I2_I1_I8_pn3 I2_I1_I8_pn2 I2_I1_I8_P3_2 VDD VSS NOR2_X1
XI2_I1_I8_I22_XG I2_I1_I8_pn4 I2_I1_I8_gn3 I2_I1_I8_gn4 I2_I1_I8_G4_3 VDD VSS OAI21_X1
XI2_I1_I8_I22_XP I2_I1_I8_pn4 I2_I1_I8_pn3 I2_I1_I8_P4_3 VDD VSS NOR2_X1
XI2_I1_I8_I23_XG I2_I1_I8_pn5 I2_I1_I8_gn4 I2_I1_I8_gn5 I2_I1_I8_G5_4 VDD VSS OAI21_X1
XI2_I1_I8_I23_XP I2_I1_I8_pn5 I2_I1_I8_pn4 I2_I1_I8_P5_4 VDD VSS NOR2_X1
XI2_I1_I8_I24_XG I2_I1_I8_pn6 I2_I1_I8_gn5 I2_I1_I8_gn6 I2_I1_I8_G6_5 VDD VSS OAI21_X1
XI2_I1_I8_I24_XP I2_I1_I8_pn6 I2_I1_I8_pn5 I2_I1_I8_P6_5 VDD VSS NOR2_X1
XI2_I1_I8_I25_XG I2_I1_I8_pn7 I2_I1_I8_gn6 I2_I1_I8_gn7 I2_I1_I8_G7_6 VDD VSS OAI21_X1
XI2_I1_I8_I25_XP I2_I1_I8_pn7 I2_I1_I8_pn6 I2_I1_I8_P7_6 VDD VSS NOR2_X1
XI2_I1_I8_I26_XG I2_I1_I8_P2_1 I2_I1_I8_G0_0 I2_I1_I8_G2_1 I2_I1_I8_G2_0n VDD VSS AOI21_X1
XI2_I1_I8_I27_XG I2_I1_I8_P3_2 I2_I1_I8_G1_0 I2_I1_I8_G3_2 I2_I1_I8_G3_0n VDD VSS AOI21_X1
XI2_I1_I8_I28_XG I2_I1_I8_P4_3 I2_I1_I8_G2_1 I2_I1_I8_G4_3 I2_I1_I8_G4_1n VDD VSS AOI21_X1
XI2_I1_I8_I28_XP I2_I1_I8_P4_3 I2_I1_I8_P2_1 I2_I1_I8_P4_1n VDD VSS NAND2_X1
XI2_I1_I8_I29_XG I2_I1_I8_P5_4 I2_I1_I8_G3_2 I2_I1_I8_G5_4 I2_I1_I8_G5_2n VDD VSS AOI21_X1
XI2_I1_I8_I29_XP I2_I1_I8_P5_4 I2_I1_I8_P3_2 I2_I1_I8_P5_2n VDD VSS NAND2_X1
XI2_I1_I8_I30_XG I2_I1_I8_P6_5 I2_I1_I8_G4_3 I2_I1_I8_G6_5 I2_I1_I8_G6_3n VDD VSS AOI21_X1
XI2_I1_I8_I30_XP I2_I1_I8_P6_5 I2_I1_I8_P4_3 I2_I1_I8_P6_3n VDD VSS NAND2_X1
XI2_I1_I8_I31_XG I2_I1_I8_P7_6 I2_I1_I8_G5_4 I2_I1_I8_G7_6 I2_I1_I8_G7_4n VDD VSS AOI21_X1
XI2_I1_I8_I31_XP I2_I1_I8_P7_6 I2_I1_I8_P5_4 I2_I1_I8_P7_4n VDD VSS NAND2_X1
XI2_I1_I8_I32_XG I2_I1_I8_P4_1n I2_I1_I8_G0_0n I2_I1_I8_G4_1n I2_I1_I8_G4_0 VDD VSS OAI21_X1
XI2_I1_I8_I33 I2_I1_I8_G1_0 I2_I1_I8_G1_0n VDD VSS INV_X1
XI2_I1_I8_I34_XG I2_I1_I8_P5_2n I2_I1_I8_G1_0n I2_I1_I8_G5_2n I2_I1_I8_G5_0 VDD VSS OAI21_X1
XI2_I1_I8_I35_XG I2_I1_I8_P6_3n I2_I1_I8_G2_0n I2_I1_I8_G6_3n I2_C7 VDD VSS OAI21_X1
XI2_I1_I8_I36_XG I2_I1_I8_P7_4n I2_I1_I8_G3_0n I2_I1_I8_G7_4n I2_C8 VDD VSS OAI21_X1
XI2_I1_I8_I37 I2_I1_I8_pn0 OP_0 I2_S_0 VDD VSS XNOR2_X1
XI2_I1_I8_I38 I2_I1_I8_pn1 I2_I1_I8_G0_0 I2_S_1 VDD VSS XNOR2_X1
XI2_I1_I8_I39 I2_I1_I8_pn2 I2_I1_I8_G1_0 I2_S_2 VDD VSS XNOR2_X1
XI2_I1_I8_I40 I2_I1_I8_pn3 I2_I1_I8_G2_0n I2_S_3 VDD VSS XOR2_X1
XI2_I1_I8_I41 I2_I1_I8_pn4 I2_I1_I8_G3_0n I2_S_4 VDD VSS XOR2_X1
XI2_I1_I8_I42 I2_I1_I8_pn5 I2_I1_I8_G4_0 I2_S_5 VDD VSS XNOR2_X1
XI2_I1_I8_I43 I2_I1_I8_pn6 I2_I1_I8_G5_0 I2_S_6 VDD VSS XNOR2_X1
XI2_I1_I8_I44 I2_I1_I8_pn7 I2_C7 I2_S_7 VDD VSS XNOR2_X1
XI2_I2_I0 A_0 B_0 I2_I2_nand0 VDD VSS NAND2_X1
XI2_I2_I1 I2_I2_nand0 I2_AND_0 VDD VSS INV_X1
XI2_I2_I2 A_0 B_0 I2_I2_nor0 VDD VSS NOR2_X1
XI2_I2_I3 I2_I2_nor0 I2_OR_0 VDD VSS INV_X1
XI2_I2_I4 A_0 B_0 I2_XOR_0 VDD VSS XOR2_X1
XI2_I2_I5 A_0 I2_NOT_0 VDD VSS INV_X1
XI2_I2_I6 A_1 B_1 I2_I2_nand1 VDD VSS NAND2_X1
XI2_I2_I7 I2_I2_nand1 I2_AND_1 VDD VSS INV_X1
XI2_I2_I8 A_1 B_1 I2_I2_nor1 VDD VSS NOR2_X1
XI2_I2_I9 I2_I2_nor1 I2_OR_1 VDD VSS INV_X1
XI2_I2_I10 A_1 B_1 I2_XOR_1 VDD VSS XOR2_X1
XI2_I2_I11 A_1 I2_NOT_1 VDD VSS INV_X1
XI2_I2_I12 A_2 B_2 I2_I2_nand2 VDD VSS NAND2_X1
XI2_I2_I13 I2_I2_nand2 I2_AND_2 VDD VSS INV_X1
XI2_I2_I14 A_2 B_2 I2_I2_nor2 VDD VSS NOR2_X1
XI2_I2_I15 I2_I2_nor2 I2_OR_2 VDD VSS INV_X1
XI2_I2_I16 A_2 B_2 I2_XOR_2 VDD VSS XOR2_X1
XI2_I2_I17 A_2 I2_NOT_2 VDD VSS INV_X1
XI2_I2_I18 A_3 B_3 I2_I2_nand3 VDD VSS NAND2_X1
XI2_I2_I19 I2_I2_nand3 I2_AND_3 VDD VSS INV_X1
XI2_I2_I20 A_3 B_3 I2_I2_nor3 VDD VSS NOR2_X1
XI2_I2_I21 I2_I2_nor3 I2_OR_3 VDD VSS INV_X1
XI2_I2_I22 A_3 B_3 I2_XOR_3 VDD VSS XOR2_X1
XI2_I2_I23 A_3 I2_NOT_3 VDD VSS INV_X1
XI2_I2_I24 A_4 B_4 I2_I2_nand4 VDD VSS NAND2_X1
XI2_I2_I25 I2_I2_nand4 I2_AND_4 VDD VSS INV_X1
XI2_I2_I26 A_4 B_4 I2_I2_nor4 VDD VSS NOR2_X1
XI2_I2_I27 I2_I2_nor4 I2_OR_4 VDD VSS INV_X1
XI2_I2_I28 A_4 B_4 I2_XOR_4 VDD VSS XOR2_X1
XI2_I2_I29 A_4 I2_NOT_4 VDD VSS INV_X1
XI2_I2_I30 A_5 B_5 I2_I2_nand5 VDD VSS NAND2_X1
XI2_I2_I31 I2_I2_nand5 I2_AND_5 VDD VSS INV_X1
XI2_I2_I32 A_5 B_5 I2_I2_nor5 VDD VSS NOR2_X1
XI2_I2_I33 I2_I2_nor5 I2_OR_5 VDD VSS INV_X1
XI2_I2_I34 A_5 B_5 I2_XOR_5 VDD VSS XOR2_X1
XI2_I2_I35 A_5 I2_NOT_5 VDD VSS INV_X1
XI2_I2_I36 A_6 B_6 I2_I2_nand6 VDD VSS NAND2_X1
XI2_I2_I37 I2_I2_nand6 I2_AND_6 VDD VSS INV_X1
XI2_I2_I38 A_6 B_6 I2_I2_nor6 VDD VSS NOR2_X1
XI2_I2_I39 I2_I2_nor6 I2_OR_6 VDD VSS INV_X1
XI2_I2_I40 A_6 B_6 I2_XOR_6 VDD VSS XOR2_X1
XI2_I2_I41 A_6 I2_NOT_6 VDD VSS INV_X1
XI2_I2_I42 A_7 B_7 I2_I2_nand7 VDD VSS NAND2_X1
XI2_I2_I43 I2_I2_nand7 I2_AND_7 VDD VSS INV_X1
XI2_I2_I44 A_7 B_7 I2_I2_nor7 VDD VSS NOR2_X1
XI2_I2_I45 I2_I2_nor7 I2_OR_7 VDD VSS INV_X1
XI2_I2_I46 A_7 B_7 I2_XOR_7 VDD VSS XOR2_X1
XI2_I2_I47 A_7 I2_NOT_7 VDD VSS INV_X1
XI2_I3_I0 I2_SEL_AND I2_AND_0 I2_I3_n0_0 VDD VSS NAND2_X1
XI2_I3_I1 I2_SEL_OR I2_OR_0 I2_I3_n0_1 VDD VSS NAND2_X1
XI2_I3_I2 I2_SEL_XOR I2_XOR_0 I2_I3_n0_2 VDD VSS NAND2_X1
XI2_I3_I3 I2_SEL_NOT I2_NOT_0 I2_I3_n0_3 VDD VSS NAND2_X1
XI2_I3_I4 I2_SEL_MUL MULP_0 I2_I3_n0_4 VDD VSS NAND2_X1
XI2_I3_I5 I2_SEL_DIV DIVQ_0 I2_I3_n0_5 VDD VSS NAND2_X1
XI2_I3_I6 I2_I3_n0_0 I2_I3_n0_1 I2_I3_o0_0 VDD VSS NAND2_X1
XI2_I3_I7 I2_I3_n0_2 I2_I3_n0_3 I2_I3_o0_1 VDD VSS NAND2_X1
XI2_I3_I8 I2_I3_n0_4 I2_I3_n0_5 I2_I3_o0_2 VDD VSS NAND2_X1
XI2_I3_I9 I2_I3_o0_0 I2_I3_o0_1 I2_I3_q0_1 VDD VSS NOR2_X1
XI2_I3_I10 I2_SEL_AS I2_S_0 I2_I3_o0_2 I2_I3_q0_2 VDD VSS AOI21_X1
XI2_I3_I11 I2_I3_q0_1 I2_I3_q0_2 Y_0 VDD VSS NAND2_X1
XI2_I3_I12 I2_SEL_AND I2_AND_1 I2_I3_n1_0 VDD VSS NAND2_X1
XI2_I3_I13 I2_SEL_OR I2_OR_1 I2_I3_n1_1 VDD VSS NAND2_X1
XI2_I3_I14 I2_SEL_XOR I2_XOR_1 I2_I3_n1_2 VDD VSS NAND2_X1
XI2_I3_I15 I2_SEL_NOT I2_NOT_1 I2_I3_n1_3 VDD VSS NAND2_X1
XI2_I3_I16 I2_SEL_MUL MULP_1 I2_I3_n1_4 VDD VSS NAND2_X1
XI2_I3_I17 I2_SEL_DIV DIVQ_1 I2_I3_n1_5 VDD VSS NAND2_X1
XI2_I3_I18 I2_I3_n1_0 I2_I3_n1_1 I2_I3_o1_0 VDD VSS NAND2_X1
XI2_I3_I19 I2_I3_n1_2 I2_I3_n1_3 I2_I3_o1_1 VDD VSS NAND2_X1
XI2_I3_I20 I2_I3_n1_4 I2_I3_n1_5 I2_I3_o1_2 VDD VSS NAND2_X1
XI2_I3_I21 I2_I3_o1_0 I2_I3_o1_1 I2_I3_q1_1 VDD VSS NOR2_X1
XI2_I3_I22 I2_SEL_AS I2_S_1 I2_I3_o1_2 I2_I3_q1_2 VDD VSS AOI21_X1
XI2_I3_I23 I2_I3_q1_1 I2_I3_q1_2 Y_1 VDD VSS NAND2_X1
XI2_I3_I24 I2_SEL_AND I2_AND_2 I2_I3_n2_0 VDD VSS NAND2_X1
XI2_I3_I25 I2_SEL_OR I2_OR_2 I2_I3_n2_1 VDD VSS NAND2_X1
XI2_I3_I26 I2_SEL_XOR I2_XOR_2 I2_I3_n2_2 VDD VSS NAND2_X1
XI2_I3_I27 I2_SEL_NOT I2_NOT_2 I2_I3_n2_3 VDD VSS NAND2_X1
XI2_I3_I28 I2_SEL_MUL MULP_2 I2_I3_n2_4 VDD VSS NAND2_X1
XI2_I3_I29 I2_SEL_DIV DIVQ_2 I2_I3_n2_5 VDD VSS NAND2_X1
XI2_I3_I30 I2_I3_n2_0 I2_I3_n2_1 I2_I3_o2_0 VDD VSS NAND2_X1
XI2_I3_I31 I2_I3_n2_2 I2_I3_n2_3 I2_I3_o2_1 VDD VSS NAND2_X1
XI2_I3_I32 I2_I3_n2_4 I2_I3_n2_5 I2_I3_o2_2 VDD VSS NAND2_X1
XI2_I3_I33 I2_I3_o2_0 I2_I3_o2_1 I2_I3_q2_1 VDD VSS NOR2_X1
XI2_I3_I34 I2_SEL_AS I2_S_2 I2_I3_o2_2 I2_I3_q2_2 VDD VSS AOI21_X1
XI2_I3_I35 I2_I3_q2_1 I2_I3_q2_2 Y_2 VDD VSS NAND2_X1
XI2_I3_I36 I2_SEL_AND I2_AND_3 I2_I3_n3_0 VDD VSS NAND2_X1
XI2_I3_I37 I2_SEL_OR I2_OR_3 I2_I3_n3_1 VDD VSS NAND2_X1
XI2_I3_I38 I2_SEL_XOR I2_XOR_3 I2_I3_n3_2 VDD VSS NAND2_X1
XI2_I3_I39 I2_SEL_NOT I2_NOT_3 I2_I3_n3_3 VDD VSS NAND2_X1
XI2_I3_I40 I2_SEL_MUL MULP_3 I2_I3_n3_4 VDD VSS NAND2_X1
XI2_I3_I41 I2_SEL_DIV DIVQ_3 I2_I3_n3_5 VDD VSS NAND2_X1
XI2_I3_I42 I2_I3_n3_0 I2_I3_n3_1 I2_I3_o3_0 VDD VSS NAND2_X1
XI2_I3_I43 I2_I3_n3_2 I2_I3_n3_3 I2_I3_o3_1 VDD VSS NAND2_X1
XI2_I3_I44 I2_I3_n3_4 I2_I3_n3_5 I2_I3_o3_2 VDD VSS NAND2_X1
XI2_I3_I45 I2_I3_o3_0 I2_I3_o3_1 I2_I3_q3_1 VDD VSS NOR2_X1
XI2_I3_I46 I2_SEL_AS I2_S_3 I2_I3_o3_2 I2_I3_q3_2 VDD VSS AOI21_X1
XI2_I3_I47 I2_I3_q3_1 I2_I3_q3_2 Y_3 VDD VSS NAND2_X1
XI2_I3_I48 I2_SEL_AND I2_AND_4 I2_I3_n4_0 VDD VSS NAND2_X1
XI2_I3_I49 I2_SEL_OR I2_OR_4 I2_I3_n4_1 VDD VSS NAND2_X1
XI2_I3_I50 I2_SEL_XOR I2_XOR_4 I2_I3_n4_2 VDD VSS NAND2_X1
XI2_I3_I51 I2_SEL_NOT I2_NOT_4 I2_I3_n4_3 VDD VSS NAND2_X1
XI2_I3_I52 I2_SEL_MUL MULP_4 I2_I3_n4_4 VDD VSS NAND2_X1
XI2_I3_I53 I2_SEL_DIV DIVQ_4 I2_I3_n4_5 VDD VSS NAND2_X1
XI2_I3_I54 I2_I3_n4_0 I2_I3_n4_1 I2_I3_o4_0 VDD VSS NAND2_X1
XI2_I3_I55 I2_I3_n4_2 I2_I3_n4_3 I2_I3_o4_1 VDD VSS NAND2_X1
XI2_I3_I56 I2_I3_n4_4 I2_I3_n4_5 I2_I3_o4_2 VDD VSS NAND2_X1
XI2_I3_I57 I2_I3_o4_0 I2_I3_o4_1 I2_I3_q4_1 VDD VSS NOR2_X1
XI2_I3_I58 I2_SEL_AS I2_S_4 I2_I3_o4_2 I2_I3_q4_2 VDD VSS AOI21_X1
XI2_I3_I59 I2_I3_q4_1 I2_I3_q4_2 Y_4 VDD VSS NAND2_X1
XI2_I3_I60 I2_SEL_AND I2_AND_5 I2_I3_n5_0 VDD VSS NAND2_X1
XI2_I3_I61 I2_SEL_OR I2_OR_5 I2_I3_n5_1 VDD VSS NAND2_X1
XI2_I3_I62 I2_SEL_XOR I2_XOR_5 I2_I3_n5_2 VDD VSS NAND2_X1
XI2_I3_I63 I2_SEL_NOT I2_NOT_5 I2_I3_n5_3 VDD VSS NAND2_X1
XI2_I3_I64 I2_SEL_MUL MULP_5 I2_I3_n5_4 VDD VSS NAND2_X1
XI2_I3_I65 I2_SEL_DIV DIVQ_5 I2_I3_n5_5 VDD VSS NAND2_X1
XI2_I3_I66 I2_I3_n5_0 I2_I3_n5_1 I2_I3_o5_0 VDD VSS NAND2_X1
XI2_I3_I67 I2_I3_n5_2 I2_I3_n5_3 I2_I3_o5_1 VDD VSS NAND2_X1
XI2_I3_I68 I2_I3_n5_4 I2_I3_n5_5 I2_I3_o5_2 VDD VSS NAND2_X1
XI2_I3_I69 I2_I3_o5_0 I2_I3_o5_1 I2_I3_q5_1 VDD VSS NOR2_X1
XI2_I3_I70 I2_SEL_AS I2_S_5 I2_I3_o5_2 I2_I3_q5_2 VDD VSS AOI21_X1
XI2_I3_I71 I2_I3_q5_1 I2_I3_q5_2 Y_5 VDD VSS NAND2_X1
XI2_I3_I72 I2_SEL_AND I2_AND_6 I2_I3_n6_0 VDD VSS NAND2_X1
XI2_I3_I73 I2_SEL_OR I2_OR_6 I2_I3_n6_1 VDD VSS NAND2_X1
XI2_I3_I74 I2_SEL_XOR I2_XOR_6 I2_I3_n6_2 VDD VSS NAND2_X1
XI2_I3_I75 I2_SEL_NOT I2_NOT_6 I2_I3_n6_3 VDD VSS NAND2_X1
XI2_I3_I76 I2_SEL_MUL MULP_6 I2_I3_n6_4 VDD VSS NAND2_X1
XI2_I3_I77 I2_SEL_DIV DIVQ_6 I2_I3_n6_5 VDD VSS NAND2_X1
XI2_I3_I78 I2_I3_n6_0 I2_I3_n6_1 I2_I3_o6_0 VDD VSS NAND2_X1
XI2_I3_I79 I2_I3_n6_2 I2_I3_n6_3 I2_I3_o6_1 VDD VSS NAND2_X1
XI2_I3_I80 I2_I3_n6_4 I2_I3_n6_5 I2_I3_o6_2 VDD VSS NAND2_X1
XI2_I3_I81 I2_I3_o6_0 I2_I3_o6_1 I2_I3_q6_1 VDD VSS NOR2_X1
XI2_I3_I82 I2_SEL_AS I2_S_6 I2_I3_o6_2 I2_I3_q6_2 VDD VSS AOI21_X1
XI2_I3_I83 I2_I3_q6_1 I2_I3_q6_2 Y_6 VDD VSS NAND2_X1
XI2_I3_I84 I2_SEL_AND I2_AND_7 I2_I3_n7_0 VDD VSS NAND2_X1
XI2_I3_I85 I2_SEL_OR I2_OR_7 I2_I3_n7_1 VDD VSS NAND2_X1
XI2_I3_I86 I2_SEL_XOR I2_XOR_7 I2_I3_n7_2 VDD VSS NAND2_X1
XI2_I3_I87 I2_SEL_NOT I2_NOT_7 I2_I3_n7_3 VDD VSS NAND2_X1
XI2_I3_I88 I2_SEL_MUL MULP_7 I2_I3_n7_4 VDD VSS NAND2_X1
XI2_I3_I89 I2_SEL_DIV DIVQ_7 I2_I3_n7_5 VDD VSS NAND2_X1
XI2_I3_I90 I2_I3_n7_0 I2_I3_n7_1 I2_I3_o7_0 VDD VSS NAND2_X1
XI2_I3_I91 I2_I3_n7_2 I2_I3_n7_3 I2_I3_o7_1 VDD VSS NAND2_X1
XI2_I3_I92 I2_I3_n7_4 I2_I3_n7_5 I2_I3_o7_2 VDD VSS NAND2_X1
XI2_I3_I93 I2_I3_o7_0 I2_I3_o7_1 I2_I3_q7_1 VDD VSS NOR2_X1
XI2_I3_I94 I2_SEL_AS I2_S_7 I2_I3_o7_2 I2_I3_q7_2 VDD VSS AOI21_X1
XI2_I3_I95 I2_I3_q7_1 I2_I3_q7_2 Y_7 VDD VSS NAND2_X1
XI2_I3_I96 I2_SEL_MUL MULP_8 I2_I3_hm8 VDD VSS NAND2_X1
XI2_I3_I97 I2_SEL_DIV DIVR_0 I2_I3_hd8 VDD VSS NAND2_X1
XI2_I3_I98 I2_I3_hm8 I2_I3_hd8 Y_8 VDD VSS NAND2_X1
XI2_I3_I99 I2_SEL_MUL MULP_9 I2_I3_hm9 VDD VSS NAND2_X1
XI2_I3_I100 I2_SEL_DIV DIVR_1 I2_I3_hd9 VDD VSS NAND2_X1
XI2_I3_I101 I2_I3_hm9 I2_I3_hd9 Y_9 VDD VSS NAND2_X1
XI2_I3_I102 I2_SEL_MUL MULP_10 I2_I3_hm10 VDD VSS NAND2_X1
XI2_I3_I103 I2_SEL_DIV DIVR_2 I2_I3_hd10 VDD VSS NAND2_X1
XI2_I3_I104 I2_I3_hm10 I2_I3_hd10 Y_10 VDD VSS NAND2_X1
XI2_I3_I105 I2_SEL_MUL MULP_11 I2_I3_hm11 VDD VSS NAND2_X1
XI2_I3_I106 I2_SEL_DIV DIVR_3 I2_I3_hd11 VDD VSS NAND2_X1
XI2_I3_I107 I2_I3_hm11 I2_I3_hd11 Y_11 VDD VSS NAND2_X1
XI2_I3_I108 I2_SEL_MUL MULP_12 I2_I3_hm12 VDD VSS NAND2_X1
XI2_I3_I109 I2_SEL_DIV DIVR_4 I2_I3_hd12 VDD VSS NAND2_X1
XI2_I3_I110 I2_I3_hm12 I2_I3_hd12 Y_12 VDD VSS NAND2_X1
XI2_I3_I111 I2_SEL_MUL MULP_13 I2_I3_hm13 VDD VSS NAND2_X1
XI2_I3_I112 I2_SEL_DIV DIVR_5 I2_I3_hd13 VDD VSS NAND2_X1
XI2_I3_I113 I2_I3_hm13 I2_I3_hd13 Y_13 VDD VSS NAND2_X1
XI2_I3_I114 I2_SEL_MUL MULP_14 I2_I3_hm14 VDD VSS NAND2_X1
XI2_I3_I115 I2_SEL_DIV DIVR_6 I2_I3_hd14 VDD VSS NAND2_X1
XI2_I3_I116 I2_I3_hm14 I2_I3_hd14 Y_14 VDD VSS NAND2_X1
XI2_I3_I117 I2_SEL_MUL MULP_15 I2_I3_hm15 VDD VSS NAND2_X1
XI2_I3_I118 I2_SEL_DIV DIVR_7 I2_I3_hd15 VDD VSS NAND2_X1
XI2_I3_I119 I2_I3_hm15 I2_I3_hd15 Y_15 VDD VSS NAND2_X1
XI2_I4_I0 Y_0 Y_1 I2_I4_za0 VDD VSS NOR2_X1
XI2_I4_I1 Y_2 Y_3 I2_I4_za1 VDD VSS NOR2_X1
XI2_I4_I2 Y_4 Y_5 I2_I4_za2 VDD VSS NOR2_X1
XI2_I4_I3 Y_6 Y_7 I2_I4_za3 VDD VSS NOR2_X1
XI2_I4_I4 Y_8 Y_9 I2_I4_za4 VDD VSS NOR2_X1
XI2_I4_I5 Y_10 Y_11 I2_I4_za5 VDD VSS NOR2_X1
XI2_I4_I6 Y_12 Y_13 I2_I4_za6 VDD VSS NOR2_X1
XI2_I4_I7 Y_14 Y_15 I2_I4_za7 VDD VSS NOR2_X1
XI2_I4_I8 I2_I4_za0 I2_I4_za1 I2_I4_zb0 VDD VSS NAND2_X1
XI2_I4_I9 I2_I4_za2 I2_I4_za3 I2_I4_zb1 VDD VSS NAND2_X1
XI2_I4_I10 I2_I4_za4 I2_I4_za5 I2_I4_zb2 VDD VSS NAND2_X1
XI2_I4_I11 I2_I4_za6 I2_I4_za7 I2_I4_zb3 VDD VSS NAND2_X1
XI2_I4_I12 I2_I4_zb0 I2_I4_zb1 I2_I4_zc0 VDD VSS NOR2_X1
XI2_I4_I13 I2_I4_zb2 I2_I4_zb3 I2_I4_zc1 VDD VSS NOR2_X1
XI2_I4_I14 I2_I4_zc0 I2_I4_zc1 I2_I4_zd VDD VSS NAND2_X1
XI2_I4_I15 I2_I4_zd Z VDD VSS INV_X1
XI2_I4_I16 I2_C8 I2_SEL_AS I2_I4_cn VDD VSS NAND2_X1
XI2_I4_I17 I2_I4_cn C VDD VSS INV_X1
XI2_I4_I18 I2_C7 I2_C8 I2_I4_ovf VDD VSS XOR2_X1
XI2_I4_I19 I2_SEL_AS I2_I4_ovf I2_I4_v1 VDD VSS NAND2_X1
XI2_I4_I20 I2_SEL_DIV DIVV I2_I4_v2 VDD VSS NAND2_X1
XI2_I4_I21 I2_I4_v1 I2_I4_v2 V VDD VSS NAND2_X1
XI2_I4_I22 I2_SEL_DIV DIVDZ I2_I4_dzn VDD VSS NAND2_X1
XI2_I4_I23 I2_I4_dzn DZ VDD VSS INV_X1
.ENDS ALU_TOP
