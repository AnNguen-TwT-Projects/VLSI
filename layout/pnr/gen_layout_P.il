;; layout/pnr/gen_layout_P.il -- sinh boi layout/gen_layout_cells.py, khong sua tay.
;; Chay trong VM qua layout/run_layout_A.sh (GEN=layout/pnr/gen_layout_P.il).
laErr = 0
procedure(laBox(cv lyr purp x1 y1 x2 y2)
  let((fig)
    fig = dbCreateRect(cv list(lyr purp) list(list(x1 y1) list(x2 y2)))
    unless(fig printf("LA_ERROR rect %s %s failed in %s\n" lyr purp cv~>cellName) laErr = laErr + 1)
    fig))
procedure(laPin(cv name dir x1 y1 x2 y2)
  let((fig net lb)
    fig = laBox(cv "Metal1" "pin" x1 y1 x2 y2)
    net = or(dbFindNetByName(cv name) dbCreateNet(cv name))
    unless(dbFindTermByName(cv name) dbCreateTerm(net name dir))
    dbCreatePin(net fig name)
    lb = car(errset(dbCreateLabel(cv list("Metal1" "label") list((x1 + x2) / 2.0 (y1 + y2) / 2.0)
                     name "centerCenter" "R0" "stick" 0.1)))
    unless(lb dbCreateLabel(cv list("Metal1" "pin") list((x1 + x2) / 2.0 (y1 + y2) / 2.0)
                     name "centerCenter" "R0" "stick" 0.1))))
procedure(laDraw(libName cellName w rects pins)
  let((lib cv)
    lib = ddGetObj(libName)
    unless(lib
      lib = ddCreateLib(libName strcat("./" libName))
      techBindTechFile(lib "gpdk090")
      printf("LA_LIB created %s\n" libName))
    cv = dbOpenCellViewByType(libName cellName "layout" "maskLayout" "w")
    foreach(r rects laBox(cv car(r) "drawing" nth(1 r) nth(2 r) nth(3 r) nth(4 r)))
    foreach(p pins laPin(cv car(p) cadr(p) nth(2 p) nth(3 p) nth(4 p) nth(5 p)))
    dbSave(cv)
    printf("LA_CELL %s/%s W=%.3f H=2.760 area=%.4f um2 shapes=%d\n" libName cellName w w * 2.76 length(rects))
    t))

procedure(laMain()
  ;; FILL1: 0 T (sau khi chia finger), 0 cot
  laDraw("ALU_CELLS_P" "FILL1" 0.27
    list(list("Oxide" 0 -0.12 0.27 0.24)
      list("Pimp" -0.02 -0.14 0.29 0.26)
      list("Oxide" 0 2.52 0.27 2.88)
      list("Nimp" -0.02 2.42 0.29 2.9)
      list("Nwell" -0.12 1.38 0.39 3)
      list("Nimp" 0 0.26 0.27 1)
      list("Pimp" 0 1.5 0.27 2.42)
      list("prBoundary" 0 0 0.27 2.76)
      list("Metal1" 0 -0.06 0.27 0.24)
      list("Metal1" 0 2.52 0.27 2.82))
    list(list("VSS" "inputOutput" 0 0 0.27 0.24)
      list("VDD" "inputOutput" 0 2.52 0.27 2.76)))
  ;; FILL2: 0 T (sau khi chia finger), 1 cot
  laDraw("ALU_CELLS_P" "FILL2" 0.54
    list(list("Oxide" 0 -0.12 0.54 0.24)
      list("Pimp" -0.02 -0.14 0.56 0.26)
      list("Oxide" 0 2.52 0.54 2.88)
      list("Nimp" -0.02 2.42 0.56 2.9)
      list("Nwell" -0.12 1.38 0.66 3)
      list("Nimp" 0 0.26 0.54 1)
      list("Pimp" 0 1.5 0.54 2.42)
      list("prBoundary" 0 0 0.54 2.76)
      list("Metal1" 0 -0.06 0.54 0.24)
      list("Metal1" 0 2.52 0.54 2.82)
      list("Cont" 0.21 -0.06 0.33 0.06)
      list("Cont" 0.21 2.7 0.33 2.82))
    list(list("VSS" "inputOutput" 0 0 0.54 0.24)
      list("VDD" "inputOutput" 0 2.52 0.54 2.76)))
  ;; FILL4: 0 T (sau khi chia finger), 3 cot
  laDraw("ALU_CELLS_P" "FILL4" 1.08
    list(list("Oxide" 0 -0.12 1.08 0.24)
      list("Pimp" -0.02 -0.14 1.1 0.26)
      list("Oxide" 0 2.52 1.08 2.88)
      list("Nimp" -0.02 2.42 1.1 2.9)
      list("Nwell" -0.12 1.38 1.2 3)
      list("Nimp" 0 0.26 1.08 1)
      list("Pimp" 0 1.5 1.08 2.42)
      list("prBoundary" 0 0 1.08 2.76)
      list("Metal1" 0 -0.06 1.08 0.24)
      list("Metal1" 0 2.52 1.08 2.82)
      list("Cont" 0.21 -0.06 0.33 0.06)
      list("Cont" 0.21 2.7 0.33 2.82)
      list("Cont" 0.48 -0.06 0.6 0.06)
      list("Cont" 0.48 2.7 0.6 2.82)
      list("Cont" 0.75 -0.06 0.87 0.06)
      list("Cont" 0.75 2.7 0.87 2.82))
    list(list("VSS" "inputOutput" 0 0 1.08 0.24)
      list("VDD" "inputOutput" 0 2.52 1.08 2.76)))
  ;; FILL8: 0 T (sau khi chia finger), 7 cot
  laDraw("ALU_CELLS_P" "FILL8" 2.16
    list(list("Oxide" 0 -0.12 2.16 0.24)
      list("Pimp" -0.02 -0.14 2.18 0.26)
      list("Oxide" 0 2.52 2.16 2.88)
      list("Nimp" -0.02 2.42 2.18 2.9)
      list("Nwell" -0.12 1.38 2.28 3)
      list("Nimp" 0 0.26 2.16 1)
      list("Pimp" 0 1.5 2.16 2.42)
      list("prBoundary" 0 0 2.16 2.76)
      list("Metal1" 0 -0.06 2.16 0.24)
      list("Metal1" 0 2.52 2.16 2.82)
      list("Cont" 0.21 -0.06 0.33 0.06)
      list("Cont" 0.21 2.7 0.33 2.82)
      list("Cont" 0.48 -0.06 0.6 0.06)
      list("Cont" 0.48 2.7 0.6 2.82)
      list("Cont" 0.75 -0.06 0.87 0.06)
      list("Cont" 0.75 2.7 0.87 2.82)
      list("Cont" 1.02 -0.06 1.14 0.06)
      list("Cont" 1.02 2.7 1.14 2.82)
      list("Cont" 1.29 -0.06 1.41 0.06)
      list("Cont" 1.29 2.7 1.41 2.82)
      list("Cont" 1.56 -0.06 1.68 0.06)
      list("Cont" 1.56 2.7 1.68 2.82)
      list("Cont" 1.83 -0.06 1.95 0.06)
      list("Cont" 1.83 2.7 1.95 2.82))
    list(list("VSS" "inputOutput" 0 0 2.16 0.24)
      list("VDD" "inputOutput" 0 2.52 2.16 2.76)))
  ;; TIE0: 0 T (sau khi chia finger), 1 cot
  laDraw("ALU_CELLS_P" "TIE0" 0.54
    list(list("Oxide" 0 -0.12 0.54 0.24)
      list("Pimp" -0.02 -0.14 0.56 0.26)
      list("Oxide" 0 2.52 0.54 2.88)
      list("Nimp" -0.02 2.42 0.56 2.9)
      list("Nwell" -0.12 1.38 0.66 3)
      list("Nimp" 0 0.26 0.54 1)
      list("Pimp" 0 1.5 0.54 2.42)
      list("prBoundary" 0 0 0.54 2.76)
      list("Metal1" 0 -0.06 0.54 0.24)
      list("Metal1" 0 2.52 0.54 2.82)
      list("Cont" 0.21 -0.06 0.33 0.06)
      list("Cont" 0.21 2.7 0.33 2.82)
      list("Metal1" 0.195 0 0.345 1.52))
    list(list("VSS" "inputOutput" 0 0 0.54 0.24)
      list("VDD" "inputOutput" 0 2.52 0.54 2.76)
      list("Y" "output" 0.195 1.12 0.345 1.52)))
  ;; TIE1: 0 T (sau khi chia finger), 1 cot
  laDraw("ALU_CELLS_P" "TIE1" 0.54
    list(list("Oxide" 0 -0.12 0.54 0.24)
      list("Pimp" -0.02 -0.14 0.56 0.26)
      list("Oxide" 0 2.52 0.54 2.88)
      list("Nimp" -0.02 2.42 0.56 2.9)
      list("Nwell" -0.12 1.38 0.66 3)
      list("Nimp" 0 0.26 0.54 1)
      list("Pimp" 0 1.5 0.54 2.42)
      list("prBoundary" 0 0 0.54 2.76)
      list("Metal1" 0 -0.06 0.54 0.24)
      list("Metal1" 0 2.52 0.54 2.82)
      list("Cont" 0.21 -0.06 0.33 0.06)
      list("Cont" 0.21 2.7 0.33 2.82)
      list("Metal1" 0.195 1.12 0.345 2.76))
    list(list("VSS" "inputOutput" 0 0 0.54 0.24)
      list("VDD" "inputOutput" 0 2.52 0.54 2.76)
      list("Y" "output" 0.195 1.12 0.345 1.52)))
  t)
unless(errset(laMain() t) printf("LA_ERROR SKILL error, see message above\n") laErr = laErr + 1)
printf("LA_SUMMARY errors=%d\n" laErr)
exit(if(laErr == 0 0 1))
