// MUL32 sau layout (RCX), corner NN
simulator lang=spectre
include "/home/buet/cadence/gpdk090_v4.6/models/spectre/gpdk090.scs" section=NN
include "../../cells/A/cells_A.scs"
include "MUL32_rcx.scs"
include "../../alu32/tb/tb_MUL32_p2.scs"
