// DIV8K sau layout: Assura RCX -> layout/rcx2scs.py - khong sua tay
simulator lang=spectre
subckt DIV8K A_0 A_1 A_2 A_3 A_4 A_5 A_6 A_7 B_0 B_1 B_2 B_3 B_4 B_5 B_6 B_7 Q_0 Q_1 Q_2 Q_3 Q_4 Q_5 Q_6 Q_7 R_0 R_1 R_2 R_3 R_4 R_5 R_6 R_7 V DZ VDD VSS
    I_MXI132_I15_MN1 (XI132_I15_Bn b7_7 VSS VSS) gpdk090_nmos1v w=0.12u l=0.1u ad=0.0696p as=0.0696p pd=1.16u ps=1.16u
    I_MXI132_I15_MN5 (XI132_I15_n2 b7_7 VSS VSS) gpdk090_nmos1v w=0.24u l=0.1u ad=0.0528p as=0.0816p pd=0.68u ps=1.16u
    I_MXI132_I15_MN4 (I132_pn7 XI132_I15_An XI132_I15_n2 VSS) gpdk090_nmos1v w=0.24u l=0.1u ad=0.0528p as=0.0528p pd=0.68u ps=0.68u
    I_MXI132_I15_MN2 (XI132_I15_n1 p6_6 I132_pn7 VSS) gpdk090_nmos1v w=0.24u l=0.1u ad=0.0528p as=0.0528p pd=0.68u ps=0.68u
    I_MXI132_I15_MN3 (VSS XI132_I15_Bn XI132_I15_n1 VSS) gpdk090_nmos1v w=0.24u l=0.1u ad=0.0816p as=0.0528p pd=1.16u ps=0.68u
    I_MXI132_I15_MN0 (XI132_I15_An p6_6 VSS VSS) gpdk090_nmos1v w=0.12u l=0.1u ad=0.0696p as=0.0696p pd=1.16u ps=1.16u
    I_MXI132_I13_MN1 (XI132_I13_Bn b7_5 VSS VSS) gpdk090_nmos1v w=0.12u l=0.1u ad=0.0696p as=0.0696p pd=1.16u ps=1.16u
    I_MXI132_I13_MN5 (XI132_I13_n2 b7_5 VSS VSS) gpdk090_nmos1v w=0.24u l=0.1u ad=0.0528p as=0.0816p pd=0.68u ps=1.16u
    I_MXI132_I13_MN4 (I132_pn5 XI132_I13_An XI132_I13_n2 VSS) gpdk090_nmos1v w=0.24u l=0.1u ad=0.0528p as=0.0528p pd=0.68u ps=0.68u
    I_MXI132_I13_MN2 (XI132_I13_n1 p6_4 I132_pn5 VSS) gpdk090_nmos1v w=0.24u l=0.1u ad=0.0528p as=0.0528p pd=0.68u ps=0.68u
    I_MXI132_I13_MN3 (VSS XI132_I13_Bn XI132_I13_n1 VSS) gpdk090_nmos1v w=0.24u l=0.1u ad=0.0816p as=0.0528p pd=1.16u ps=0.68u
    I_MXI132_I13_MN0 (XI132_I13_An p6_4 VSS VSS) gpdk090_nmos1v w=0.12u l=0.1u ad=0.0696p as=0.0696p pd=1.16u ps=1.16u
    I_MXI120_I44_MN1 (XI120_I44_Bn c6_7 VSS VSS) gpdk090_nmos1v w=0.12u l=0.1u ad=0.0696p as=0.0696p pd=1.16u ps=1.16u
    I_MXI120_I44_MN5 (XI120_I44_n2 c6_7 VSS VSS) gpdk090_nmos1v w=0.24u l=0.1u ad=0.0528p as=0.0816p pd=0.68u ps=1.16u
    I_MXI120_I44_MN4 (p6_7 XI120_I44_An XI120_I44_n2 VSS) gpdk090_nmos1v w=0.24u l=0.1u ad=0.0528p as=0.0528p pd=0.68u ps=0.68u
    I_MXI120_I44_MN2 (XI120_I44_n1 I120_pn7 p6_7 VSS) gpdk090_nmos1v w=0.24u l=0.1u ad=0.0528p as=0.0528p pd=0.68u ps=0.68u
    I_MXI120_I44_MN3 (VSS XI120_I44_Bn XI120_I44_n1 VSS) gpdk090_nmos1v w=0.24u l=0.1u ad=0.0816p as=0.0528p pd=1.16u ps=0.68u
    I_MXI120_I44_MN0 (XI120_I44_An I120_pn7 VSS VSS) gpdk090_nmos1v w=0.12u l=0.1u ad=0.0696p as=0.0696p pd=1.16u ps=1.16u
    I_MXI120_I43_MN1 (XI120_I43_Bn I120_G5_0 VSS VSS) gpdk090_nmos1v w=0.12u l=0.1u ad=0.0696p as=0.0696p pd=1.16u ps=1.16u
    I_MXI120_I43_MN5 (XI120_I43_n2 I120_G5_0 VSS VSS) gpdk090_nmos1v w=0.24u l=0.1u ad=0.0528p as=0.0816p pd=0.68u ps=1.16u
    I_MXI120_I43_MN4 (p6_6 XI120_I43_An XI120_I43_n2 VSS) gpdk090_nmos1v w=0.24u l=0.1u ad=0.0528p as=0.0528p pd=0.68u ps=0.68u
    I_MXI120_I43_MN2 (XI120_I43_n1 I120_pn6 p6_6 VSS) gpdk090_nmos1v w=0.24u l=0.1u ad=0.0528p as=0.0528p pd=0.68u ps=0.68u
    I_MXI120_I43_MN3 (VSS XI120_I43_Bn XI120_I43_n1 VSS) gpdk090_nmos1v w=0.24u l=0.1u ad=0.0816p as=0.0528p pd=1.16u ps=0.68u
    I_MXI120_I43_MN0 (XI120_I43_An I120_pn6 VSS VSS) gpdk090_nmos1v w=0.12u l=0.1u ad=0.0696p as=0.0696p pd=1.16u ps=1.16u
    I_MXI120_I15_MN1 (XI120_I15_Bn b6_7 VSS VSS) gpdk090_nmos1v w=0.12u l=0.1u ad=0.0696p as=0.0696p pd=1.16u ps=1.16u
    I_MXI120_I15_MN5 (XI120_I15_n2 b6_7 VSS VSS) gpdk090_nmos1v w=0.24u l=0.1u ad=0.0528p as=0.0816p pd=0.68u ps=1.16u
    I_MXI120_I15_MN4 (I120_pn7 XI120_I15_An XI120_I15_n2 VSS) gpdk090_nmos1v w=0.24u l=0.1u ad=0.0528p as=0.0528p pd=0.68u ps=0.68u
    I_MXI120_I15_MN2 (XI120_I15_n1 p5_6 I120_pn7 VSS) gpdk090_nmos1v w=0.24u l=0.1u ad=0.0528p as=0.0528p pd=0.68u ps=0.68u
    I_MXI120_I15_MN3 (VSS XI120_I15_Bn XI120_I15_n1 VSS) gpdk090_nmos1v w=0.24u l=0.1u ad=0.0816p as=0.0528p pd=1.16u ps=0.68u
    I_MXI120_I15_MN0 (XI120_I15_An p5_6 VSS VSS) gpdk090_nmos1v w=0.12u l=0.1u ad=0.0696p as=0.0696p pd=1.16u ps=1.16u
    I_MXI108_I44_MN1 (XI108_I44_Bn c5_7 VSS VSS) gpdk090_nmos1v w=0.12u l=0.1u ad=0.0696p as=0.0696p pd=1.16u ps=1.16u
    I_MXI108_I44_MN5 (XI108_I44_n2 c5_7 VSS VSS) gpdk090_nmos1v w=0.24u l=0.1u ad=0.0528p as=0.0816p pd=0.68u ps=1.16u
    I_MXI108_I44_MN4 (p5_7 XI108_I44_An XI108_I44_n2 VSS) gpdk090_nmos1v w=0.24u l=0.1u ad=0.0528p as=0.0528p pd=0.68u ps=0.68u
    I_MXI108_I44_MN2 (XI108_I44_n1 I108_pn7 p5_7 VSS) gpdk090_nmos1v w=0.24u l=0.1u ad=0.0528p as=0.0528p pd=0.68u ps=0.68u
    I_MXI108_I44_MN3 (VSS XI108_I44_Bn XI108_I44_n1 VSS) gpdk090_nmos1v w=0.24u l=0.1u ad=0.0816p as=0.0528p pd=1.16u ps=0.68u
    I_MXI108_I44_MN0 (XI108_I44_An I108_pn7 VSS VSS) gpdk090_nmos1v w=0.12u l=0.1u ad=0.0696p as=0.0696p pd=1.16u ps=1.16u
    I_MXI108_I43_MN1 (XI108_I43_Bn I108_G5_0 VSS VSS) gpdk090_nmos1v w=0.12u l=0.1u ad=0.0696p as=0.0696p pd=1.16u ps=1.16u
    I_MXI108_I43_MN5 (XI108_I43_n2 I108_G5_0 VSS VSS) gpdk090_nmos1v w=0.24u l=0.1u ad=0.0528p as=0.0816p pd=0.68u ps=1.16u
    I_MXI108_I43_MN4 (p5_6 XI108_I43_An XI108_I43_n2 VSS) gpdk090_nmos1v w=0.24u l=0.1u ad=0.0528p as=0.0528p pd=0.68u ps=0.68u
    I_MXI108_I43_MN2 (XI108_I43_n1 I108_pn6 p5_6 VSS) gpdk090_nmos1v w=0.24u l=0.1u ad=0.0528p as=0.0528p pd=0.68u ps=0.68u
    I_MXI108_I43_MN3 (VSS XI108_I43_Bn XI108_I43_n1 VSS) gpdk090_nmos1v w=0.24u l=0.1u ad=0.0816p as=0.0528p pd=1.16u ps=0.68u
    I_MXI108_I43_MN0 (XI108_I43_An I108_pn6 VSS VSS) gpdk090_nmos1v w=0.12u l=0.1u ad=0.0696p as=0.0696p pd=1.16u ps=1.16u
    I_MXI108_I15_MN1 (XI108_I15_Bn b5_7 VSS VSS) gpdk090_nmos1v w=0.12u l=0.1u ad=0.0696p as=0.0696p pd=1.16u ps=1.16u
    I_MXI108_I15_MN5 (XI108_I15_n2 b5_7 VSS VSS) gpdk090_nmos1v w=0.24u l=0.1u ad=0.0528p as=0.0816p pd=0.68u ps=1.16u
    I_MXI108_I15_MN4 (I108_pn7 XI108_I15_An XI108_I15_n2 VSS) gpdk090_nmos1v w=0.24u l=0.1u ad=0.0528p as=0.0528p pd=0.68u ps=0.68u
    I_MXI108_I15_MN2 (XI108_I15_n1 p4_6 I108_pn7 VSS) gpdk090_nmos1v w=0.24u l=0.1u ad=0.0528p as=0.0528p pd=0.68u ps=0.68u
    I_MXI108_I15_MN3 (VSS XI108_I15_Bn XI108_I15_n1 VSS) gpdk090_nmos1v w=0.24u l=0.1u ad=0.0816p as=0.0528p pd=1.16u ps=0.68u
    I_MXI108_I15_MN0 (XI108_I15_An p4_6 VSS VSS) gpdk090_nmos1v w=0.12u l=0.1u ad=0.0696p as=0.0696p pd=1.16u ps=1.16u
    I_MXI132_I14_MN1 (XI132_I14_Bn b7_6 VSS VSS) gpdk090_nmos1v w=0.12u l=0.1u ad=0.0696p as=0.0696p pd=1.16u ps=1.16u
    I_MXI132_I14_MN5 (XI132_I14_n2 b7_6 VSS VSS) gpdk090_nmos1v w=0.24u l=0.1u ad=0.0528p as=0.0816p pd=0.68u ps=1.16u
    I_MXI132_I14_MN4 (I132_pn6 XI132_I14_An XI132_I14_n2 VSS) gpdk090_nmos1v w=0.24u l=0.1u ad=0.0528p as=0.0528p pd=0.68u ps=0.68u
    I_MXI132_I14_MN2 (XI132_I14_n1 p6_5 I132_pn6 VSS) gpdk090_nmos1v w=0.24u l=0.1u ad=0.0528p as=0.0528p pd=0.68u ps=0.68u
    I_MXI132_I14_MN3 (VSS XI132_I14_Bn XI132_I14_n1 VSS) gpdk090_nmos1v w=0.24u l=0.1u ad=0.0816p as=0.0528p pd=1.16u ps=0.68u
    I_MXI132_I14_MN0 (XI132_I14_An p6_5 VSS VSS) gpdk090_nmos1v w=0.12u l=0.1u ad=0.0696p as=0.0696p pd=1.16u ps=1.16u
    I_MXI120_I42_MN1 (XI120_I42_Bn I120_G4_0 VSS VSS) gpdk090_nmos1v w=0.12u l=0.1u ad=0.0696p as=0.0696p pd=1.16u ps=1.16u
    I_MXI120_I42_MN5 (XI120_I42_n2 I120_G4_0 VSS VSS) gpdk090_nmos1v w=0.24u l=0.1u ad=0.0528p as=0.0816p pd=0.68u ps=1.16u
    I_MXI120_I42_MN4 (p6_5 XI120_I42_An XI120_I42_n2 VSS) gpdk090_nmos1v w=0.24u l=0.1u ad=0.0528p as=0.0528p pd=0.68u ps=0.68u
    I_MXI120_I42_MN2 (XI120_I42_n1 I120_pn5 p6_5 VSS) gpdk090_nmos1v w=0.24u l=0.1u ad=0.0528p as=0.0528p pd=0.68u ps=0.68u
    I_MXI120_I42_MN3 (VSS XI120_I42_Bn XI120_I42_n1 VSS) gpdk090_nmos1v w=0.24u l=0.1u ad=0.0816p as=0.0528p pd=1.16u ps=0.68u
    I_MXI120_I42_MN0 (XI120_I42_An I120_pn5 VSS VSS) gpdk090_nmos1v w=0.12u l=0.1u ad=0.0696p as=0.0696p pd=1.16u ps=1.16u
    I_MXI120_I13_MN1 (XI120_I13_Bn b6_5 VSS VSS) gpdk090_nmos1v w=0.12u l=0.1u ad=0.0696p as=0.0696p pd=1.16u ps=1.16u
    I_MXI120_I13_MN5 (XI120_I13_n2 b6_5 VSS VSS) gpdk090_nmos1v w=0.24u l=0.1u ad=0.0528p as=0.0816p pd=0.68u ps=1.16u
    I_MXI120_I13_MN4 (I120_pn5 XI120_I13_An XI120_I13_n2 VSS) gpdk090_nmos1v w=0.24u l=0.1u ad=0.0528p as=0.0528p pd=0.68u ps=0.68u
    I_MXI120_I13_MN2 (XI120_I13_n1 p5_4 I120_pn5 VSS) gpdk090_nmos1v w=0.24u l=0.1u ad=0.0528p as=0.0528p pd=0.68u ps=0.68u
    I_MXI120_I13_MN3 (VSS XI120_I13_Bn XI120_I13_n1 VSS) gpdk090_nmos1v w=0.24u l=0.1u ad=0.0816p as=0.0528p pd=1.16u ps=0.68u
    I_MXI120_I13_MN0 (XI120_I13_An p5_4 VSS VSS) gpdk090_nmos1v w=0.12u l=0.1u ad=0.0696p as=0.0696p pd=1.16u ps=1.16u
    I_MXI120_I14_MN1 (XI120_I14_Bn b6_6 VSS VSS) gpdk090_nmos1v w=0.12u l=0.1u ad=0.0696p as=0.0696p pd=1.16u ps=1.16u
    I_MXI120_I14_MN5 (XI120_I14_n2 b6_6 VSS VSS) gpdk090_nmos1v w=0.24u l=0.1u ad=0.0528p as=0.0816p pd=0.68u ps=1.16u
    I_MXI120_I14_MN4 (I120_pn6 XI120_I14_An XI120_I14_n2 VSS) gpdk090_nmos1v w=0.24u l=0.1u ad=0.0528p as=0.0528p pd=0.68u ps=0.68u
    I_MXI120_I14_MN2 (XI120_I14_n1 p5_5 I120_pn6 VSS) gpdk090_nmos1v w=0.24u l=0.1u ad=0.0528p as=0.0528p pd=0.68u ps=0.68u
    I_MXI120_I14_MN3 (VSS XI120_I14_Bn XI120_I14_n1 VSS) gpdk090_nmos1v w=0.24u l=0.1u ad=0.0816p as=0.0528p pd=1.16u ps=0.68u
    I_MXI120_I14_MN0 (XI120_I14_An p5_5 VSS VSS) gpdk090_nmos1v w=0.12u l=0.1u ad=0.0696p as=0.0696p pd=1.16u ps=1.16u
    I_MXI108_I42_MN1 (XI108_I42_Bn I108_G4_0 VSS VSS) gpdk090_nmos1v w=0.12u l=0.1u ad=0.0696p as=0.0696p pd=1.16u ps=1.16u
    I_MXI108_I42_MN5 (XI108_I42_n2 I108_G4_0 VSS VSS) gpdk090_nmos1v w=0.24u l=0.1u ad=0.0528p as=0.0816p pd=0.68u ps=1.16u
    I_MXI108_I42_MN4 (p5_5 XI108_I42_An XI108_I42_n2 VSS) gpdk090_nmos1v w=0.24u l=0.1u ad=0.0528p as=0.0528p pd=0.68u ps=0.68u
    I_MXI108_I42_MN2 (XI108_I42_n1 I108_pn5 p5_5 VSS) gpdk090_nmos1v w=0.24u l=0.1u ad=0.0528p as=0.0528p pd=0.68u ps=0.68u
    I_MXI108_I42_MN3 (VSS XI108_I42_Bn XI108_I42_n1 VSS) gpdk090_nmos1v w=0.24u l=0.1u ad=0.0816p as=0.0528p pd=1.16u ps=0.68u
    I_MXI108_I42_MN0 (XI108_I42_An I108_pn5 VSS VSS) gpdk090_nmos1v w=0.12u l=0.1u ad=0.0696p as=0.0696p pd=1.16u ps=1.16u
    I_MXI108_I14_MN1 (XI108_I14_Bn b5_6 VSS VSS) gpdk090_nmos1v w=0.12u l=0.1u ad=0.0696p as=0.0696p pd=1.16u ps=1.16u
    I_MXI108_I14_MN5 (XI108_I14_n2 b5_6 VSS VSS) gpdk090_nmos1v w=0.24u l=0.1u ad=0.0528p as=0.0816p pd=0.68u ps=1.16u
    I_MXI108_I14_MN4 (I108_pn6 XI108_I14_An XI108_I14_n2 VSS) gpdk090_nmos1v w=0.24u l=0.1u ad=0.0528p as=0.0528p pd=0.68u ps=0.68u
    I_MXI108_I14_MN2 (XI108_I14_n1 p4_5 I108_pn6 VSS) gpdk090_nmos1v w=0.24u l=0.1u ad=0.0528p as=0.0528p pd=0.68u ps=0.68u
    I_MXI108_I14_MN3 (VSS XI108_I14_Bn XI108_I14_n1 VSS) gpdk090_nmos1v w=0.24u l=0.1u ad=0.0816p as=0.0528p pd=1.16u ps=0.68u
    I_MXI108_I14_MN0 (XI108_I14_An p4_5 VSS VSS) gpdk090_nmos1v w=0.12u l=0.1u ad=0.0696p as=0.0696p pd=1.16u ps=1.16u
    I_MXI132_I43_MN1 (XI132_I43_Bn I132_G5_0 VSS VSS) gpdk090_nmos1v w=0.12u l=0.1u ad=0.0696p as=0.0696p pd=1.16u ps=1.16u
    I_MXI132_I43_MN5 (XI132_I43_n2 I132_G5_0 VSS VSS) gpdk090_nmos1v w=0.24u l=0.1u ad=0.0528p as=0.0816p pd=0.68u ps=1.16u
    I_MXI132_I43_MN4 (p7_6 XI132_I43_An XI132_I43_n2 VSS) gpdk090_nmos1v w=0.24u l=0.1u ad=0.0528p as=0.0528p pd=0.68u ps=0.68u
    I_MXI132_I43_MN2 (XI132_I43_n1 I132_pn6 p7_6 VSS) gpdk090_nmos1v w=0.24u l=0.1u ad=0.0528p as=0.0528p pd=0.68u ps=0.68u
    I_MXI132_I43_MN3 (VSS XI132_I43_Bn XI132_I43_n1 VSS) gpdk090_nmos1v w=0.24u l=0.1u ad=0.0816p as=0.0528p pd=1.16u ps=0.68u
    I_MXI132_I43_MN0 (XI132_I43_An I132_pn6 VSS VSS) gpdk090_nmos1v w=0.12u l=0.1u ad=0.0696p as=0.0696p pd=1.16u ps=1.16u
    I_MXI132_I12_MN1 (XI132_I12_Bn b7_4 VSS VSS) gpdk090_nmos1v w=0.12u l=0.1u ad=0.0696p as=0.0696p pd=1.16u ps=1.16u
    I_MXI132_I12_MN5 (XI132_I12_n2 b7_4 VSS VSS) gpdk090_nmos1v w=0.24u l=0.1u ad=0.0528p as=0.0816p pd=0.68u ps=1.16u
    I_MXI132_I12_MN4 (I132_pn4 XI132_I12_An XI132_I12_n2 VSS) gpdk090_nmos1v w=0.24u l=0.1u ad=0.0528p as=0.0528p pd=0.68u ps=0.68u
    I_MXI132_I12_MN2 (XI132_I12_n1 p6_3 I132_pn4 VSS) gpdk090_nmos1v w=0.24u l=0.1u ad=0.0528p as=0.0528p pd=0.68u ps=0.68u
    I_MXI132_I12_MN3 (VSS XI132_I12_Bn XI132_I12_n1 VSS) gpdk090_nmos1v w=0.24u l=0.1u ad=0.0816p as=0.0528p pd=1.16u ps=0.68u
    I_MXI132_I12_MN0 (XI132_I12_An p6_3 VSS VSS) gpdk090_nmos1v w=0.12u l=0.1u ad=0.0696p as=0.0696p pd=1.16u ps=1.16u
    I_MXI120_I12_MN1 (XI120_I12_Bn b6_4 VSS VSS) gpdk090_nmos1v w=0.12u l=0.1u ad=0.0696p as=0.0696p pd=1.16u ps=1.16u
    I_MXI120_I12_MN5 (XI120_I12_n2 b6_4 VSS VSS) gpdk090_nmos1v w=0.24u l=0.1u ad=0.0528p as=0.0816p pd=0.68u ps=1.16u
    I_MXI120_I12_MN4 (I120_pn4 XI120_I12_An XI120_I12_n2 VSS) gpdk090_nmos1v w=0.24u l=0.1u ad=0.0528p as=0.0528p pd=0.68u ps=0.68u
    I_MXI120_I12_MN2 (XI120_I12_n1 p5_3 I120_pn4 VSS) gpdk090_nmos1v w=0.24u l=0.1u ad=0.0528p as=0.0528p pd=0.68u ps=0.68u
    I_MXI120_I12_MN3 (VSS XI120_I12_Bn XI120_I12_n1 VSS) gpdk090_nmos1v w=0.24u l=0.1u ad=0.0816p as=0.0528p pd=1.16u ps=0.68u
    I_MXI120_I12_MN0 (XI120_I12_An p5_3 VSS VSS) gpdk090_nmos1v w=0.12u l=0.1u ad=0.0696p as=0.0696p pd=1.16u ps=1.16u
    I_MXI108_I11_MN1 (XI108_I11_Bn b5_3 VSS VSS) gpdk090_nmos1v w=0.12u l=0.1u ad=0.0696p as=0.0696p pd=1.16u ps=1.16u
    I_MXI108_I11_MN5 (XI108_I11_n2 b5_3 VSS VSS) gpdk090_nmos1v w=0.24u l=0.1u ad=0.0528p as=0.0816p pd=0.68u ps=1.16u
    I_MXI108_I11_MN4 (I108_pn3 XI108_I11_An XI108_I11_n2 VSS) gpdk090_nmos1v w=0.24u l=0.1u ad=0.0528p as=0.0528p pd=0.68u ps=0.68u
    I_MXI108_I11_MN2 (XI108_I11_n1 p4_2 I108_pn3 VSS) gpdk090_nmos1v w=0.24u l=0.1u ad=0.0528p as=0.0528p pd=0.68u ps=0.68u
    I_MXI108_I11_MN3 (VSS XI108_I11_Bn XI108_I11_n1 VSS) gpdk090_nmos1v w=0.24u l=0.1u ad=0.0816p as=0.0528p pd=1.16u ps=0.68u
    I_MXI108_I11_MN0 (XI108_I11_An p4_2 VSS VSS) gpdk090_nmos1v w=0.12u l=0.1u ad=0.0696p as=0.0696p pd=1.16u ps=1.16u
    I_MXI108_I12_MN1 (XI108_I12_Bn b5_4 VSS VSS) gpdk090_nmos1v w=0.12u l=0.1u ad=0.0696p as=0.0696p pd=1.16u ps=1.16u
    I_MXI108_I12_MN5 (XI108_I12_n2 b5_4 VSS VSS) gpdk090_nmos1v w=0.24u l=0.1u ad=0.0528p as=0.0816p pd=0.68u ps=1.16u
    I_MXI108_I12_MN4 (I108_pn4 XI108_I12_An XI108_I12_n2 VSS) gpdk090_nmos1v w=0.24u l=0.1u ad=0.0528p as=0.0528p pd=0.68u ps=0.68u
    I_MXI108_I12_MN2 (XI108_I12_n1 p4_3 I108_pn4 VSS) gpdk090_nmos1v w=0.24u l=0.1u ad=0.0528p as=0.0528p pd=0.68u ps=0.68u
    I_MXI108_I12_MN3 (VSS XI108_I12_Bn XI108_I12_n1 VSS) gpdk090_nmos1v w=0.24u l=0.1u ad=0.0816p as=0.0528p pd=1.16u ps=0.68u
    I_MXI108_I12_MN0 (XI108_I12_An p4_3 VSS VSS) gpdk090_nmos1v w=0.12u l=0.1u ad=0.0696p as=0.0696p pd=1.16u ps=1.16u
    I_MXI108_I13_MN1 (XI108_I13_Bn b5_5 VSS VSS) gpdk090_nmos1v w=0.12u l=0.1u ad=0.0696p as=0.0696p pd=1.16u ps=1.16u
    I_MXI108_I13_MN5 (XI108_I13_n2 b5_5 VSS VSS) gpdk090_nmos1v w=0.24u l=0.1u ad=0.0528p as=0.0816p pd=0.68u ps=1.16u
    I_MXI108_I13_MN4 (I108_pn5 XI108_I13_An XI108_I13_n2 VSS) gpdk090_nmos1v w=0.24u l=0.1u ad=0.0528p as=0.0528p pd=0.68u ps=0.68u
    I_MXI108_I13_MN2 (XI108_I13_n1 p4_4 I108_pn5 VSS) gpdk090_nmos1v w=0.24u l=0.1u ad=0.0528p as=0.0528p pd=0.68u ps=0.68u
    I_MXI108_I13_MN3 (VSS XI108_I13_Bn XI108_I13_n1 VSS) gpdk090_nmos1v w=0.24u l=0.1u ad=0.0816p as=0.0528p pd=1.16u ps=0.68u
    I_MXI108_I13_MN0 (XI108_I13_An p4_4 VSS VSS) gpdk090_nmos1v w=0.12u l=0.1u ad=0.0696p as=0.0696p pd=1.16u ps=1.16u
    I_MXI96_I43_MN1 (XI96_I43_Bn I96_G5_0 VSS VSS) gpdk090_nmos1v w=0.12u l=0.1u ad=0.0696p as=0.0696p pd=1.16u ps=1.16u
    I_MXI96_I43_MN5 (XI96_I43_n2 I96_G5_0 VSS VSS) gpdk090_nmos1v w=0.24u l=0.1u ad=0.0528p as=0.0816p pd=0.68u ps=1.16u
    I_MXI96_I43_MN4 (p4_6 XI96_I43_An XI96_I43_n2 VSS) gpdk090_nmos1v w=0.24u l=0.1u ad=0.0528p as=0.0528p pd=0.68u ps=0.68u
    I_MXI96_I43_MN2 (XI96_I43_n1 I96_pn6 p4_6 VSS) gpdk090_nmos1v w=0.24u l=0.1u ad=0.0528p as=0.0528p pd=0.68u ps=0.68u
    I_MXI96_I43_MN3 (VSS XI96_I43_Bn XI96_I43_n1 VSS) gpdk090_nmos1v w=0.24u l=0.1u ad=0.0816p as=0.0528p pd=1.16u ps=0.68u
    I_MXI96_I43_MN0 (XI96_I43_An I96_pn6 VSS VSS) gpdk090_nmos1v w=0.12u l=0.1u ad=0.0696p as=0.0696p pd=1.16u ps=1.16u
    I_MXI132_I44_MN1 (XI132_I44_Bn c7_7 VSS VSS) gpdk090_nmos1v w=0.12u l=0.1u ad=0.0696p as=0.0696p pd=1.16u ps=1.16u
    I_MXI132_I44_MN5 (XI132_I44_n2 c7_7 VSS VSS) gpdk090_nmos1v w=0.24u l=0.1u ad=0.0528p as=0.0816p pd=0.68u ps=1.16u
    I_MXI132_I44_MN4 (p7_7 XI132_I44_An XI132_I44_n2 VSS) gpdk090_nmos1v w=0.24u l=0.1u ad=0.0528p as=0.0528p pd=0.68u ps=0.68u
    I_MXI132_I44_MN2 (XI132_I44_n1 I132_pn7 p7_7 VSS) gpdk090_nmos1v w=0.24u l=0.1u ad=0.0528p as=0.0528p pd=0.68u ps=0.68u
    I_MXI132_I44_MN3 (VSS XI132_I44_Bn XI132_I44_n1 VSS) gpdk090_nmos1v w=0.24u l=0.1u ad=0.0816p as=0.0528p pd=1.16u ps=0.68u
    I_MXI132_I44_MN0 (XI132_I44_An I132_pn7 VSS VSS) gpdk090_nmos1v w=0.12u l=0.1u ad=0.0696p as=0.0696p pd=1.16u ps=1.16u
    I_MXI132_I11_MN1 (XI132_I11_Bn b7_3 VSS VSS) gpdk090_nmos1v w=0.12u l=0.1u ad=0.0696p as=0.0696p pd=1.16u ps=1.16u
    I_MXI132_I11_MN5 (XI132_I11_n2 b7_3 VSS VSS) gpdk090_nmos1v w=0.24u l=0.1u ad=0.0528p as=0.0816p pd=0.68u ps=1.16u
    I_MXI132_I11_MN4 (I132_pn3 XI132_I11_An XI132_I11_n2 VSS) gpdk090_nmos1v w=0.24u l=0.1u ad=0.0528p as=0.0528p pd=0.68u ps=0.68u
    I_MXI132_I11_MN2 (XI132_I11_n1 p6_2 I132_pn3 VSS) gpdk090_nmos1v w=0.24u l=0.1u ad=0.0528p as=0.0528p pd=0.68u ps=0.68u
    I_MXI132_I11_MN3 (VSS XI132_I11_Bn XI132_I11_n1 VSS) gpdk090_nmos1v w=0.24u l=0.1u ad=0.0816p as=0.0528p pd=1.16u ps=0.68u
    I_MXI132_I11_MN0 (XI132_I11_An p6_2 VSS VSS) gpdk090_nmos1v w=0.12u l=0.1u ad=0.0696p as=0.0696p pd=1.16u ps=1.16u
    I_MXI120_I39_MN1 (XI120_I39_Bn I120_G1_0 VSS VSS) gpdk090_nmos1v w=0.12u l=0.1u ad=0.0696p as=0.0696p pd=1.16u ps=1.16u
    I_MXI120_I39_MN5 (XI120_I39_n2 I120_G1_0 VSS VSS) gpdk090_nmos1v w=0.24u l=0.1u ad=0.0528p as=0.0816p pd=0.68u ps=1.16u
    I_MXI120_I39_MN4 (p6_2 XI120_I39_An XI120_I39_n2 VSS) gpdk090_nmos1v w=0.24u l=0.1u ad=0.0528p as=0.0528p pd=0.68u ps=0.68u
    I_MXI120_I39_MN2 (XI120_I39_n1 I120_pn2 p6_2 VSS) gpdk090_nmos1v w=0.24u l=0.1u ad=0.0528p as=0.0528p pd=0.68u ps=0.68u
    I_MXI120_I39_MN3 (VSS XI120_I39_Bn XI120_I39_n1 VSS) gpdk090_nmos1v w=0.24u l=0.1u ad=0.0816p as=0.0528p pd=1.16u ps=0.68u
    I_MXI120_I39_MN0 (XI120_I39_An I120_pn2 VSS VSS) gpdk090_nmos1v w=0.12u l=0.1u ad=0.0696p as=0.0696p pd=1.16u ps=1.16u
    I_MXI120_I9_MN1 (XI120_I9_Bn b6_1 VSS VSS) gpdk090_nmos1v w=0.12u l=0.1u ad=0.0696p as=0.0696p pd=1.16u ps=1.16u
    I_MXI120_I9_MN5 (XI120_I9_n2 b6_1 VSS VSS) gpdk090_nmos1v w=0.24u l=0.1u ad=0.0528p as=0.0816p pd=0.68u ps=1.16u
    I_MXI120_I9_MN4 (I120_pn1 XI120_I9_An XI120_I9_n2 VSS) gpdk090_nmos1v w=0.24u l=0.1u ad=0.0528p as=0.0528p pd=0.68u ps=0.68u
    I_MXI120_I9_MN2 (XI120_I9_n1 p5_0 I120_pn1 VSS) gpdk090_nmos1v w=0.24u l=0.1u ad=0.0528p as=0.0528p pd=0.68u ps=0.68u
    I_MXI120_I9_MN3 (VSS XI120_I9_Bn XI120_I9_n1 VSS) gpdk090_nmos1v w=0.24u l=0.1u ad=0.0816p as=0.0528p pd=1.16u ps=0.68u
    I_MXI120_I9_MN0 (XI120_I9_An p5_0 VSS VSS) gpdk090_nmos1v w=0.12u l=0.1u ad=0.0696p as=0.0696p pd=1.16u ps=1.16u
    I_MXI120_I11_MN1 (XI120_I11_Bn b6_3 VSS VSS) gpdk090_nmos1v w=0.12u l=0.1u ad=0.0696p as=0.0696p pd=1.16u ps=1.16u
    I_MXI120_I11_MN5 (XI120_I11_n2 b6_3 VSS VSS) gpdk090_nmos1v w=0.24u l=0.1u ad=0.0528p as=0.0816p pd=0.68u ps=1.16u
    I_MXI120_I11_MN4 (I120_pn3 XI120_I11_An XI120_I11_n2 VSS) gpdk090_nmos1v w=0.24u l=0.1u ad=0.0528p as=0.0528p pd=0.68u ps=0.68u
    I_MXI120_I11_MN2 (XI120_I11_n1 p5_2 I120_pn3 VSS) gpdk090_nmos1v w=0.24u l=0.1u ad=0.0528p as=0.0528p pd=0.68u ps=0.68u
    I_MXI120_I11_MN3 (VSS XI120_I11_Bn XI120_I11_n1 VSS) gpdk090_nmos1v w=0.24u l=0.1u ad=0.0816p as=0.0528p pd=1.16u ps=0.68u
    I_MXI120_I11_MN0 (XI120_I11_An p5_2 VSS VSS) gpdk090_nmos1v w=0.12u l=0.1u ad=0.0696p as=0.0696p pd=1.16u ps=1.16u
    I_MXI108_I38_MN1 (XI108_I38_Bn I108_G0_0 VSS VSS) gpdk090_nmos1v w=0.12u l=0.1u ad=0.0696p as=0.0696p pd=1.16u ps=1.16u
    I_MXI108_I38_MN5 (XI108_I38_n2 I108_G0_0 VSS VSS) gpdk090_nmos1v w=0.24u l=0.1u ad=0.0528p as=0.0816p pd=0.68u ps=1.16u
    I_MXI108_I38_MN4 (p5_1 XI108_I38_An XI108_I38_n2 VSS) gpdk090_nmos1v w=0.24u l=0.1u ad=0.0528p as=0.0528p pd=0.68u ps=0.68u
    I_MXI108_I38_MN2 (XI108_I38_n1 I108_pn1 p5_1 VSS) gpdk090_nmos1v w=0.24u l=0.1u ad=0.0528p as=0.0528p pd=0.68u ps=0.68u
    I_MXI108_I38_MN3 (VSS XI108_I38_Bn XI108_I38_n1 VSS) gpdk090_nmos1v w=0.24u l=0.1u ad=0.0816p as=0.0528p pd=1.16u ps=0.68u
    I_MXI108_I38_MN0 (XI108_I38_An I108_pn1 VSS VSS) gpdk090_nmos1v w=0.12u l=0.1u ad=0.0696p as=0.0696p pd=1.16u ps=1.16u
    I_MXI108_I9_MN1 (XI108_I9_Bn b5_1 VSS VSS) gpdk090_nmos1v w=0.12u l=0.1u ad=0.0696p as=0.0696p pd=1.16u ps=1.16u
    I_MXI108_I9_MN5 (XI108_I9_n2 b5_1 VSS VSS) gpdk090_nmos1v w=0.24u l=0.1u ad=0.0528p as=0.0816p pd=0.68u ps=1.16u
    I_MXI108_I9_MN4 (I108_pn1 XI108_I9_An XI108_I9_n2 VSS) gpdk090_nmos1v w=0.24u l=0.1u ad=0.0528p as=0.0528p pd=0.68u ps=0.68u
    I_MXI108_I9_MN2 (XI108_I9_n1 p4_0 I108_pn1 VSS) gpdk090_nmos1v w=0.24u l=0.1u ad=0.0528p as=0.0528p pd=0.68u ps=0.68u
    I_MXI108_I9_MN3 (VSS XI108_I9_Bn XI108_I9_n1 VSS) gpdk090_nmos1v w=0.24u l=0.1u ad=0.0816p as=0.0528p pd=1.16u ps=0.68u
    I_MXI108_I9_MN0 (XI108_I9_An p4_0 VSS VSS) gpdk090_nmos1v w=0.12u l=0.1u ad=0.0696p as=0.0696p pd=1.16u ps=1.16u
    I_MXI108_I39_MN1 (XI108_I39_Bn I108_G1_0 VSS VSS) gpdk090_nmos1v w=0.12u l=0.1u ad=0.0696p as=0.0696p pd=1.16u ps=1.16u
    I_MXI108_I39_MN5 (XI108_I39_n2 I108_G1_0 VSS VSS) gpdk090_nmos1v w=0.24u l=0.1u ad=0.0528p as=0.0816p pd=0.68u ps=1.16u
    I_MXI108_I39_MN4 (p5_2 XI108_I39_An XI108_I39_n2 VSS) gpdk090_nmos1v w=0.24u l=0.1u ad=0.0528p as=0.0528p pd=0.68u ps=0.68u
    I_MXI108_I39_MN2 (XI108_I39_n1 I108_pn2 p5_2 VSS) gpdk090_nmos1v w=0.24u l=0.1u ad=0.0528p as=0.0528p pd=0.68u ps=0.68u
    I_MXI108_I39_MN3 (VSS XI108_I39_Bn XI108_I39_n1 VSS) gpdk090_nmos1v w=0.24u l=0.1u ad=0.0816p as=0.0528p pd=1.16u ps=0.68u
    I_MXI108_I39_MN0 (XI108_I39_An I108_pn2 VSS VSS) gpdk090_nmos1v w=0.12u l=0.1u ad=0.0696p as=0.0696p pd=1.16u ps=1.16u
    I_MXI96_I39_MN1 (XI96_I39_Bn I96_G1_0 VSS VSS) gpdk090_nmos1v w=0.12u l=0.1u ad=0.0696p as=0.0696p pd=1.16u ps=1.16u
    I_MXI96_I39_MN5 (XI96_I39_n2 I96_G1_0 VSS VSS) gpdk090_nmos1v w=0.24u l=0.1u ad=0.0528p as=0.0816p pd=0.68u ps=1.16u
    I_MXI96_I39_MN4 (p4_2 XI96_I39_An XI96_I39_n2 VSS) gpdk090_nmos1v w=0.24u l=0.1u ad=0.0528p as=0.0528p pd=0.68u ps=0.68u
    I_MXI96_I39_MN2 (XI96_I39_n1 I96_pn2 p4_2 VSS) gpdk090_nmos1v w=0.24u l=0.1u ad=0.0528p as=0.0528p pd=0.68u ps=0.68u
    I_MXI96_I39_MN3 (VSS XI96_I39_Bn XI96_I39_n1 VSS) gpdk090_nmos1v w=0.24u l=0.1u ad=0.0816p as=0.0528p pd=1.16u ps=0.68u
    I_MXI96_I39_MN0 (XI96_I39_An I96_pn2 VSS VSS) gpdk090_nmos1v w=0.12u l=0.1u ad=0.0696p as=0.0696p pd=1.16u ps=1.16u
    I_MXI96_I42_MN1 (XI96_I42_Bn I96_G4_0 VSS VSS) gpdk090_nmos1v w=0.12u l=0.1u ad=0.0696p as=0.0696p pd=1.16u ps=1.16u
    I_MXI96_I42_MN5 (XI96_I42_n2 I96_G4_0 VSS VSS) gpdk090_nmos1v w=0.24u l=0.1u ad=0.0528p as=0.0816p pd=0.68u ps=1.16u
    I_MXI96_I42_MN4 (p4_5 XI96_I42_An XI96_I42_n2 VSS) gpdk090_nmos1v w=0.24u l=0.1u ad=0.0528p as=0.0528p pd=0.68u ps=0.68u
    I_MXI96_I42_MN2 (XI96_I42_n1 I96_pn5 p4_5 VSS) gpdk090_nmos1v w=0.24u l=0.1u ad=0.0528p as=0.0528p pd=0.68u ps=0.68u
    I_MXI96_I42_MN3 (VSS XI96_I42_Bn XI96_I42_n1 VSS) gpdk090_nmos1v w=0.24u l=0.1u ad=0.0816p as=0.0528p pd=1.16u ps=0.68u
    I_MXI96_I42_MN0 (XI96_I42_An I96_pn5 VSS VSS) gpdk090_nmos1v w=0.12u l=0.1u ad=0.0696p as=0.0696p pd=1.16u ps=1.16u
    I_MXI152_I15_MN1 (XI152_I15_Bn dm7 VSS VSS) gpdk090_nmos1v w=0.12u l=0.1u ad=0.0696p as=0.0696p pd=1.16u ps=1.16u
    I_MXI152_I15_MN5 (XI152_I15_n2 dm7 VSS VSS) gpdk090_nmos1v w=0.24u l=0.1u ad=0.0528p as=0.0816p pd=0.68u ps=1.16u
    I_MXI152_I15_MN4 (I152_pn7 XI152_I15_An XI152_I15_n2 VSS) gpdk090_nmos1v w=0.24u l=0.1u ad=0.0528p as=0.0528p pd=0.68u ps=0.68u
    I_MXI152_I15_MN2 (XI152_I15_n1 p7_7 I152_pn7 VSS) gpdk090_nmos1v w=0.24u l=0.1u ad=0.0528p as=0.0528p pd=0.68u ps=0.68u
    I_MXI152_I15_MN3 (VSS XI152_I15_Bn XI152_I15_n1 VSS) gpdk090_nmos1v w=0.24u l=0.1u ad=0.0816p as=0.0528p pd=1.16u ps=0.68u
    I_MXI152_I15_MN0 (XI152_I15_An p7_7 VSS VSS) gpdk090_nmos1v w=0.12u l=0.1u ad=0.0696p as=0.0696p pd=1.16u ps=1.16u
    I_MXI132_I42_MN1 (XI132_I42_Bn I132_G4_0 VSS VSS) gpdk090_nmos1v w=0.12u l=0.1u ad=0.0696p as=0.0696p pd=1.16u ps=1.16u
    I_MXI132_I42_MN5 (XI132_I42_n2 I132_G4_0 VSS VSS) gpdk090_nmos1v w=0.24u l=0.1u ad=0.0528p as=0.0816p pd=0.68u ps=1.16u
    I_MXI132_I42_MN4 (p7_5 XI132_I42_An XI132_I42_n2 VSS) gpdk090_nmos1v w=0.24u l=0.1u ad=0.0528p as=0.0528p pd=0.68u ps=0.68u
    I_MXI132_I42_MN2 (XI132_I42_n1 I132_pn5 p7_5 VSS) gpdk090_nmos1v w=0.24u l=0.1u ad=0.0528p as=0.0528p pd=0.68u ps=0.68u
    I_MXI132_I42_MN3 (VSS XI132_I42_Bn XI132_I42_n1 VSS) gpdk090_nmos1v w=0.24u l=0.1u ad=0.0816p as=0.0528p pd=1.16u ps=0.68u
    I_MXI132_I42_MN0 (XI132_I42_An I132_pn5 VSS VSS) gpdk090_nmos1v w=0.12u l=0.1u ad=0.0696p as=0.0696p pd=1.16u ps=1.16u
    I_MXI132_I10_MN1 (XI132_I10_Bn b7_2 VSS VSS) gpdk090_nmos1v w=0.12u l=0.1u ad=0.0696p as=0.0696p pd=1.16u ps=1.16u
    I_MXI132_I10_MN5 (XI132_I10_n2 b7_2 VSS VSS) gpdk090_nmos1v w=0.24u l=0.1u ad=0.0528p as=0.0816p pd=0.68u ps=1.16u
    I_MXI132_I10_MN4 (I132_pn2 XI132_I10_An XI132_I10_n2 VSS) gpdk090_nmos1v w=0.24u l=0.1u ad=0.0528p as=0.0528p pd=0.68u ps=0.68u
    I_MXI132_I10_MN2 (XI132_I10_n1 p6_1 I132_pn2 VSS) gpdk090_nmos1v w=0.24u l=0.1u ad=0.0528p as=0.0528p pd=0.68u ps=0.68u
    I_MXI132_I10_MN3 (VSS XI132_I10_Bn XI132_I10_n1 VSS) gpdk090_nmos1v w=0.24u l=0.1u ad=0.0816p as=0.0528p pd=1.16u ps=0.68u
    I_MXI132_I10_MN0 (XI132_I10_An p6_1 VSS VSS) gpdk090_nmos1v w=0.12u l=0.1u ad=0.0696p as=0.0696p pd=1.16u ps=1.16u
    I_MXI120_I38_MN1 (XI120_I38_Bn I120_G0_0 VSS VSS) gpdk090_nmos1v w=0.12u l=0.1u ad=0.0696p as=0.0696p pd=1.16u ps=1.16u
    I_MXI120_I38_MN5 (XI120_I38_n2 I120_G0_0 VSS VSS) gpdk090_nmos1v w=0.24u l=0.1u ad=0.0528p as=0.0816p pd=0.68u ps=1.16u
    I_MXI120_I38_MN4 (p6_1 XI120_I38_An XI120_I38_n2 VSS) gpdk090_nmos1v w=0.24u l=0.1u ad=0.0528p as=0.0528p pd=0.68u ps=0.68u
    I_MXI120_I38_MN2 (XI120_I38_n1 I120_pn1 p6_1 VSS) gpdk090_nmos1v w=0.24u l=0.1u ad=0.0528p as=0.0528p pd=0.68u ps=0.68u
    I_MXI120_I38_MN3 (VSS XI120_I38_Bn XI120_I38_n1 VSS) gpdk090_nmos1v w=0.24u l=0.1u ad=0.0816p as=0.0528p pd=1.16u ps=0.68u
    I_MXI120_I38_MN0 (XI120_I38_An I120_pn1 VSS VSS) gpdk090_nmos1v w=0.12u l=0.1u ad=0.0696p as=0.0696p pd=1.16u ps=1.16u
    I_MXI120_I10_MN1 (XI120_I10_Bn b6_2 VSS VSS) gpdk090_nmos1v w=0.12u l=0.1u ad=0.0696p as=0.0696p pd=1.16u ps=1.16u
    I_MXI120_I10_MN5 (XI120_I10_n2 b6_2 VSS VSS) gpdk090_nmos1v w=0.24u l=0.1u ad=0.0528p as=0.0816p pd=0.68u ps=1.16u
    I_MXI120_I10_MN4 (I120_pn2 XI120_I10_An XI120_I10_n2 VSS) gpdk090_nmos1v w=0.24u l=0.1u ad=0.0528p as=0.0528p pd=0.68u ps=0.68u
    I_MXI120_I10_MN2 (XI120_I10_n1 p5_1 I120_pn2 VSS) gpdk090_nmos1v w=0.24u l=0.1u ad=0.0528p as=0.0528p pd=0.68u ps=0.68u
    I_MXI120_I10_MN3 (VSS XI120_I10_Bn XI120_I10_n1 VSS) gpdk090_nmos1v w=0.24u l=0.1u ad=0.0816p as=0.0528p pd=1.16u ps=0.68u
    I_MXI120_I10_MN0 (XI120_I10_An p5_1 VSS VSS) gpdk090_nmos1v w=0.12u l=0.1u ad=0.0696p as=0.0696p pd=1.16u ps=1.16u
    I_MXI108_I37_MN1 (XI108_I37_Bn qu3 VSS VSS) gpdk090_nmos1v w=0.12u l=0.1u ad=0.0696p as=0.0696p pd=1.16u ps=1.16u
    I_MXI108_I37_MN5 (XI108_I37_n2 qu3 VSS VSS) gpdk090_nmos1v w=0.24u l=0.1u ad=0.0528p as=0.0816p pd=0.68u ps=1.16u
    I_MXI108_I37_MN4 (p5_0 XI108_I37_An XI108_I37_n2 VSS) gpdk090_nmos1v w=0.24u l=0.1u ad=0.0528p as=0.0528p pd=0.68u ps=0.68u
    I_MXI108_I37_MN2 (XI108_I37_n1 I108_pn0 p5_0 VSS) gpdk090_nmos1v w=0.24u l=0.1u ad=0.0528p as=0.0528p pd=0.68u ps=0.68u
    I_MXI108_I37_MN3 (VSS XI108_I37_Bn XI108_I37_n1 VSS) gpdk090_nmos1v w=0.24u l=0.1u ad=0.0816p as=0.0528p pd=1.16u ps=0.68u
    I_MXI108_I37_MN0 (XI108_I37_An I108_pn0 VSS VSS) gpdk090_nmos1v w=0.12u l=0.1u ad=0.0696p as=0.0696p pd=1.16u ps=1.16u
    I_MXI108_I8_MN1 (XI108_I8_Bn b5_0 VSS VSS) gpdk090_nmos1v w=0.12u l=0.1u ad=0.0696p as=0.0696p pd=1.16u ps=1.16u
    I_MXI108_I8_MN5 (XI108_I8_n2 b5_0 VSS VSS) gpdk090_nmos1v w=0.24u l=0.1u ad=0.0528p as=0.0816p pd=0.68u ps=1.16u
    I_MXI108_I8_MN4 (I108_pn0 XI108_I8_An XI108_I8_n2 VSS) gpdk090_nmos1v w=0.24u l=0.1u ad=0.0528p as=0.0528p pd=0.68u ps=0.68u
    I_MXI108_I8_MN2 (XI108_I8_n1 aa2 I108_pn0 VSS) gpdk090_nmos1v w=0.24u l=0.1u ad=0.0528p as=0.0528p pd=0.68u ps=0.68u
    I_MXI108_I8_MN3 (VSS XI108_I8_Bn XI108_I8_n1 VSS) gpdk090_nmos1v w=0.24u l=0.1u ad=0.0816p as=0.0528p pd=1.16u ps=0.68u
    I_MXI108_I8_MN0 (XI108_I8_An aa2 VSS VSS) gpdk090_nmos1v w=0.12u l=0.1u ad=0.0696p as=0.0696p pd=1.16u ps=1.16u
    I_MXI108_I10_MN1 (XI108_I10_Bn b5_2 VSS VSS) gpdk090_nmos1v w=0.12u l=0.1u ad=0.0696p as=0.0696p pd=1.16u ps=1.16u
    I_MXI108_I10_MN5 (XI108_I10_n2 b5_2 VSS VSS) gpdk090_nmos1v w=0.24u l=0.1u ad=0.0528p as=0.0816p pd=0.68u ps=1.16u
    I_MXI108_I10_MN4 (I108_pn2 XI108_I10_An XI108_I10_n2 VSS) gpdk090_nmos1v w=0.24u l=0.1u ad=0.0528p as=0.0528p pd=0.68u ps=0.68u
    I_MXI108_I10_MN2 (XI108_I10_n1 p4_1 I108_pn2 VSS) gpdk090_nmos1v w=0.24u l=0.1u ad=0.0528p as=0.0528p pd=0.68u ps=0.68u
    I_MXI108_I10_MN3 (VSS XI108_I10_Bn XI108_I10_n1 VSS) gpdk090_nmos1v w=0.24u l=0.1u ad=0.0816p as=0.0528p pd=1.16u ps=0.68u
    I_MXI108_I10_MN0 (XI108_I10_An p4_1 VSS VSS) gpdk090_nmos1v w=0.12u l=0.1u ad=0.0696p as=0.0696p pd=1.16u ps=1.16u
    I_MXI96_I38_MN1 (XI96_I38_Bn I96_G0_0 VSS VSS) gpdk090_nmos1v w=0.12u l=0.1u ad=0.0696p as=0.0696p pd=1.16u ps=1.16u
    I_MXI96_I38_MN5 (XI96_I38_n2 I96_G0_0 VSS VSS) gpdk090_nmos1v w=0.24u l=0.1u ad=0.0528p as=0.0816p pd=0.68u ps=1.16u
    I_MXI96_I38_MN4 (p4_1 XI96_I38_An XI96_I38_n2 VSS) gpdk090_nmos1v w=0.24u l=0.1u ad=0.0528p as=0.0528p pd=0.68u ps=0.68u
    I_MXI96_I38_MN2 (XI96_I38_n1 I96_pn1 p4_1 VSS) gpdk090_nmos1v w=0.24u l=0.1u ad=0.0528p as=0.0528p pd=0.68u ps=0.68u
    I_MXI96_I38_MN3 (VSS XI96_I38_Bn XI96_I38_n1 VSS) gpdk090_nmos1v w=0.24u l=0.1u ad=0.0816p as=0.0528p pd=1.16u ps=0.68u
    I_MXI96_I38_MN0 (XI96_I38_An I96_pn1 VSS VSS) gpdk090_nmos1v w=0.12u l=0.1u ad=0.0696p as=0.0696p pd=1.16u ps=1.16u
    I_MXI96_I9_MN1 (XI96_I9_Bn b4_1 VSS VSS) gpdk090_nmos1v w=0.12u l=0.1u ad=0.0696p as=0.0696p pd=1.16u ps=1.16u
    I_MXI96_I9_MN5 (XI96_I9_n2 b4_1 VSS VSS) gpdk090_nmos1v w=0.24u l=0.1u ad=0.0528p as=0.0816p pd=0.68u ps=1.16u
    I_MXI96_I9_MN4 (I96_pn1 XI96_I9_An XI96_I9_n2 VSS) gpdk090_nmos1v w=0.24u l=0.1u ad=0.0528p as=0.0528p pd=0.68u ps=0.68u
    I_MXI96_I9_MN2 (XI96_I9_n1 p3_0 I96_pn1 VSS) gpdk090_nmos1v w=0.24u l=0.1u ad=0.0528p as=0.0528p pd=0.68u ps=0.68u
    I_MXI96_I9_MN3 (VSS XI96_I9_Bn XI96_I9_n1 VSS) gpdk090_nmos1v w=0.24u l=0.1u ad=0.0816p as=0.0528p pd=1.16u ps=0.68u
    I_MXI96_I9_MN0 (XI96_I9_An p3_0 VSS VSS) gpdk090_nmos1v w=0.12u l=0.1u ad=0.0696p as=0.0696p pd=1.16u ps=1.16u
    I_MXI96_I44_MN1 (XI96_I44_Bn c4_7 VSS VSS) gpdk090_nmos1v w=0.12u l=0.1u ad=0.0696p as=0.0696p pd=1.16u ps=1.16u
    I_MXI96_I44_MN5 (XI96_I44_n2 c4_7 VSS VSS) gpdk090_nmos1v w=0.24u l=0.1u ad=0.0528p as=0.0816p pd=0.68u ps=1.16u
    I_MXI96_I44_MN4 (p4_7 XI96_I44_An XI96_I44_n2 VSS) gpdk090_nmos1v w=0.24u l=0.1u ad=0.0528p as=0.0528p pd=0.68u ps=0.68u
    I_MXI96_I44_MN2 (XI96_I44_n1 I96_pn7 p4_7 VSS) gpdk090_nmos1v w=0.24u l=0.1u ad=0.0528p as=0.0528p pd=0.68u ps=0.68u
    I_MXI96_I44_MN3 (VSS XI96_I44_Bn XI96_I44_n1 VSS) gpdk090_nmos1v w=0.24u l=0.1u ad=0.0816p as=0.0528p pd=1.16u ps=0.68u
    I_MXI96_I44_MN0 (XI96_I44_An I96_pn7 VSS VSS) gpdk090_nmos1v w=0.12u l=0.1u ad=0.0696p as=0.0696p pd=1.16u ps=1.16u
    I_MXI96_I15_MN1 (XI96_I15_Bn b4_7 VSS VSS) gpdk090_nmos1v w=0.12u l=0.1u ad=0.0696p as=0.0696p pd=1.16u ps=1.16u
    I_MXI96_I15_MN5 (XI96_I15_n2 b4_7 VSS VSS) gpdk090_nmos1v w=0.24u l=0.1u ad=0.0528p as=0.0816p pd=0.68u ps=1.16u
    I_MXI96_I15_MN4 (I96_pn7 XI96_I15_An XI96_I15_n2 VSS) gpdk090_nmos1v w=0.24u l=0.1u ad=0.0528p as=0.0528p pd=0.68u ps=0.68u
    I_MXI96_I15_MN2 (XI96_I15_n1 p3_6 I96_pn7 VSS) gpdk090_nmos1v w=0.24u l=0.1u ad=0.0528p as=0.0528p pd=0.68u ps=0.68u
    I_MXI96_I15_MN3 (VSS XI96_I15_Bn XI96_I15_n1 VSS) gpdk090_nmos1v w=0.24u l=0.1u ad=0.0816p as=0.0528p pd=1.16u ps=0.68u
    I_MXI96_I15_MN0 (XI96_I15_An p3_6 VSS VSS) gpdk090_nmos1v w=0.12u l=0.1u ad=0.0696p as=0.0696p pd=1.16u ps=1.16u
    I_MXI152_I14_MN1 (XI152_I14_Bn dm6 VSS VSS) gpdk090_nmos1v w=0.12u l=0.1u ad=0.0696p as=0.0696p pd=1.16u ps=1.16u
    I_MXI152_I14_MN5 (XI152_I14_n2 dm6 VSS VSS) gpdk090_nmos1v w=0.24u l=0.1u ad=0.0528p as=0.0816p pd=0.68u ps=1.16u
    I_MXI152_I14_MN4 (I152_pn6 XI152_I14_An XI152_I14_n2 VSS) gpdk090_nmos1v w=0.24u l=0.1u ad=0.0528p as=0.0528p pd=0.68u ps=0.68u
    I_MXI152_I14_MN2 (XI152_I14_n1 p7_6 I152_pn6 VSS) gpdk090_nmos1v w=0.24u l=0.1u ad=0.0528p as=0.0528p pd=0.68u ps=0.68u
    I_MXI152_I14_MN3 (VSS XI152_I14_Bn XI152_I14_n1 VSS) gpdk090_nmos1v w=0.24u l=0.1u ad=0.0816p as=0.0528p pd=1.16u ps=0.68u
    I_MXI152_I14_MN0 (XI152_I14_An p7_6 VSS VSS) gpdk090_nmos1v w=0.12u l=0.1u ad=0.0696p as=0.0696p pd=1.16u ps=1.16u
    I_MXI152_I13_MN1 (XI152_I13_Bn dm5 VSS VSS) gpdk090_nmos1v w=0.12u l=0.1u ad=0.0696p as=0.0696p pd=1.16u ps=1.16u
    I_MXI152_I13_MN5 (XI152_I13_n2 dm5 VSS VSS) gpdk090_nmos1v w=0.24u l=0.1u ad=0.0528p as=0.0816p pd=0.68u ps=1.16u
    I_MXI152_I13_MN4 (I152_pn5 XI152_I13_An XI152_I13_n2 VSS) gpdk090_nmos1v w=0.24u l=0.1u ad=0.0528p as=0.0528p pd=0.68u ps=0.68u
    I_MXI152_I13_MN2 (XI152_I13_n1 p7_5 I152_pn5 VSS) gpdk090_nmos1v w=0.24u l=0.1u ad=0.0528p as=0.0528p pd=0.68u ps=0.68u
    I_MXI152_I13_MN3 (VSS XI152_I13_Bn XI152_I13_n1 VSS) gpdk090_nmos1v w=0.24u l=0.1u ad=0.0816p as=0.0528p pd=1.16u ps=0.68u
    I_MXI152_I13_MN0 (XI152_I13_An p7_5 VSS VSS) gpdk090_nmos1v w=0.12u l=0.1u ad=0.0696p as=0.0696p pd=1.16u ps=1.16u
    I_MXI132_I39_MN1 (XI132_I39_Bn I132_G1_0 VSS VSS) gpdk090_nmos1v w=0.12u l=0.1u ad=0.0696p as=0.0696p pd=1.16u ps=1.16u
    I_MXI132_I39_MN5 (XI132_I39_n2 I132_G1_0 VSS VSS) gpdk090_nmos1v w=0.24u l=0.1u ad=0.0528p as=0.0816p pd=0.68u ps=1.16u
    I_MXI132_I39_MN4 (p7_2 XI132_I39_An XI132_I39_n2 VSS) gpdk090_nmos1v w=0.24u l=0.1u ad=0.0528p as=0.0528p pd=0.68u ps=0.68u
    I_MXI132_I39_MN2 (XI132_I39_n1 I132_pn2 p7_2 VSS) gpdk090_nmos1v w=0.24u l=0.1u ad=0.0528p as=0.0528p pd=0.68u ps=0.68u
    I_MXI132_I39_MN3 (VSS XI132_I39_Bn XI132_I39_n1 VSS) gpdk090_nmos1v w=0.24u l=0.1u ad=0.0816p as=0.0528p pd=1.16u ps=0.68u
    I_MXI132_I39_MN0 (XI132_I39_An I132_pn2 VSS VSS) gpdk090_nmos1v w=0.12u l=0.1u ad=0.0696p as=0.0696p pd=1.16u ps=1.16u
    I_MXI132_I9_MN1 (XI132_I9_Bn b7_1 VSS VSS) gpdk090_nmos1v w=0.12u l=0.1u ad=0.0696p as=0.0696p pd=1.16u ps=1.16u
    I_MXI132_I9_MN5 (XI132_I9_n2 b7_1 VSS VSS) gpdk090_nmos1v w=0.24u l=0.1u ad=0.0528p as=0.0816p pd=0.68u ps=1.16u
    I_MXI132_I9_MN4 (I132_pn1 XI132_I9_An XI132_I9_n2 VSS) gpdk090_nmos1v w=0.24u l=0.1u ad=0.0528p as=0.0528p pd=0.68u ps=0.68u
    I_MXI132_I9_MN2 (XI132_I9_n1 p6_0 I132_pn1 VSS) gpdk090_nmos1v w=0.24u l=0.1u ad=0.0528p as=0.0528p pd=0.68u ps=0.68u
    I_MXI132_I9_MN3 (VSS XI132_I9_Bn XI132_I9_n1 VSS) gpdk090_nmos1v w=0.24u l=0.1u ad=0.0816p as=0.0528p pd=1.16u ps=0.68u
    I_MXI132_I9_MN0 (XI132_I9_An p6_0 VSS VSS) gpdk090_nmos1v w=0.12u l=0.1u ad=0.0696p as=0.0696p pd=1.16u ps=1.16u
    I_MXI120_I37_MN1 (XI120_I37_Bn qu2 VSS VSS) gpdk090_nmos1v w=0.12u l=0.1u ad=0.0696p as=0.0696p pd=1.16u ps=1.16u
    I_MXI120_I37_MN5 (XI120_I37_n2 qu2 VSS VSS) gpdk090_nmos1v w=0.24u l=0.1u ad=0.0528p as=0.0816p pd=0.68u ps=1.16u
    I_MXI120_I37_MN4 (p6_0 XI120_I37_An XI120_I37_n2 VSS) gpdk090_nmos1v w=0.24u l=0.1u ad=0.0528p as=0.0528p pd=0.68u ps=0.68u
    I_MXI120_I37_MN2 (XI120_I37_n1 I120_pn0 p6_0 VSS) gpdk090_nmos1v w=0.24u l=0.1u ad=0.0528p as=0.0528p pd=0.68u ps=0.68u
    I_MXI120_I37_MN3 (VSS XI120_I37_Bn XI120_I37_n1 VSS) gpdk090_nmos1v w=0.24u l=0.1u ad=0.0816p as=0.0528p pd=1.16u ps=0.68u
    I_MXI120_I37_MN0 (XI120_I37_An I120_pn0 VSS VSS) gpdk090_nmos1v w=0.12u l=0.1u ad=0.0696p as=0.0696p pd=1.16u ps=1.16u
    I_MXI120_I8_MN1 (XI120_I8_Bn b6_0 VSS VSS) gpdk090_nmos1v w=0.12u l=0.1u ad=0.0696p as=0.0696p pd=1.16u ps=1.16u
    I_MXI120_I8_MN5 (XI120_I8_n2 b6_0 VSS VSS) gpdk090_nmos1v w=0.24u l=0.1u ad=0.0528p as=0.0816p pd=0.68u ps=1.16u
    I_MXI120_I8_MN4 (I120_pn0 XI120_I8_An XI120_I8_n2 VSS) gpdk090_nmos1v w=0.24u l=0.1u ad=0.0528p as=0.0528p pd=0.68u ps=0.68u
    I_MXI120_I8_MN2 (XI120_I8_n1 aa1 I120_pn0 VSS) gpdk090_nmos1v w=0.24u l=0.1u ad=0.0528p as=0.0528p pd=0.68u ps=0.68u
    I_MXI120_I8_MN3 (VSS XI120_I8_Bn XI120_I8_n1 VSS) gpdk090_nmos1v w=0.24u l=0.1u ad=0.0816p as=0.0528p pd=1.16u ps=0.68u
    I_MXI120_I8_MN0 (XI120_I8_An aa1 VSS VSS) gpdk090_nmos1v w=0.12u l=0.1u ad=0.0696p as=0.0696p pd=1.16u ps=1.16u
    I_MXI4_MN1 (XI4_Bn nakn2 VSS VSS) gpdk090_nmos1v w=0.12u l=0.1u ad=0.0696p as=0.0696p pd=1.16u ps=1.16u
    I_MXI4_MN5 (XI4_n2 nakn2 VSS VSS) gpdk090_nmos1v w=0.24u l=0.1u ad=0.0528p as=0.0816p pd=0.68u ps=1.16u
    I_MXI4_MN4 (aa2 XI4_An XI4_n2 VSS) gpdk090_nmos1v w=0.24u l=0.1u ad=0.0528p as=0.0528p pd=0.68u ps=0.68u
    I_MXI4_MN2 (XI4_n1 A_2 aa2 VSS) gpdk090_nmos1v w=0.24u l=0.1u ad=0.0528p as=0.0528p pd=0.68u ps=0.68u
    I_MXI4_MN3 (VSS XI4_Bn XI4_n1 VSS) gpdk090_nmos1v w=0.24u l=0.1u ad=0.0816p as=0.0528p pd=1.16u ps=0.68u
    I_MXI4_MN0 (XI4_An A_2 VSS VSS) gpdk090_nmos1v w=0.12u l=0.1u ad=0.0696p as=0.0696p pd=1.16u ps=1.16u
    I_MXI7_MN1 (XI7_Bn nakn3 VSS VSS) gpdk090_nmos1v w=0.12u l=0.1u ad=0.0696p as=0.0696p pd=1.16u ps=1.16u
    I_MXI7_MN5 (XI7_n2 nakn3 VSS VSS) gpdk090_nmos1v w=0.24u l=0.1u ad=0.0528p as=0.0816p pd=0.68u ps=1.16u
    I_MXI7_MN4 (aa3 XI7_An XI7_n2 VSS) gpdk090_nmos1v w=0.24u l=0.1u ad=0.0528p as=0.0528p pd=0.68u ps=0.68u
    I_MXI7_MN2 (XI7_n1 A_3 aa3 VSS) gpdk090_nmos1v w=0.24u l=0.1u ad=0.0528p as=0.0528p pd=0.68u ps=0.68u
    I_MXI7_MN3 (VSS XI7_Bn XI7_n1 VSS) gpdk090_nmos1v w=0.24u l=0.1u ad=0.0816p as=0.0528p pd=1.16u ps=0.68u
    I_MXI7_MN0 (XI7_An A_3 VSS VSS) gpdk090_nmos1v w=0.12u l=0.1u ad=0.0696p as=0.0696p pd=1.16u ps=1.16u
    I_MXI96_I37_MN1 (XI96_I37_Bn qu4 VSS VSS) gpdk090_nmos1v w=0.12u l=0.1u ad=0.0696p as=0.0696p pd=1.16u ps=1.16u
    I_MXI96_I37_MN5 (XI96_I37_n2 qu4 VSS VSS) gpdk090_nmos1v w=0.24u l=0.1u ad=0.0528p as=0.0816p pd=0.68u ps=1.16u
    I_MXI96_I37_MN4 (p4_0 XI96_I37_An XI96_I37_n2 VSS) gpdk090_nmos1v w=0.24u l=0.1u ad=0.0528p as=0.0528p pd=0.68u ps=0.68u
    I_MXI96_I37_MN2 (XI96_I37_n1 I96_pn0 p4_0 VSS) gpdk090_nmos1v w=0.24u l=0.1u ad=0.0528p as=0.0528p pd=0.68u ps=0.68u
    I_MXI96_I37_MN3 (VSS XI96_I37_Bn XI96_I37_n1 VSS) gpdk090_nmos1v w=0.24u l=0.1u ad=0.0816p as=0.0528p pd=1.16u ps=0.68u
    I_MXI96_I37_MN0 (XI96_I37_An I96_pn0 VSS VSS) gpdk090_nmos1v w=0.12u l=0.1u ad=0.0696p as=0.0696p pd=1.16u ps=1.16u
    I_MXI96_I8_MN1 (XI96_I8_Bn b4_0 VSS VSS) gpdk090_nmos1v w=0.12u l=0.1u ad=0.0696p as=0.0696p pd=1.16u ps=1.16u
    I_MXI96_I8_MN5 (XI96_I8_n2 b4_0 VSS VSS) gpdk090_nmos1v w=0.24u l=0.1u ad=0.0528p as=0.0816p pd=0.68u ps=1.16u
    I_MXI96_I8_MN4 (I96_pn0 XI96_I8_An XI96_I8_n2 VSS) gpdk090_nmos1v w=0.24u l=0.1u ad=0.0528p as=0.0528p pd=0.68u ps=0.68u
    I_MXI96_I8_MN2 (XI96_I8_n1 aa3 I96_pn0 VSS) gpdk090_nmos1v w=0.24u l=0.1u ad=0.0528p as=0.0528p pd=0.68u ps=0.68u
    I_MXI96_I8_MN3 (VSS XI96_I8_Bn XI96_I8_n1 VSS) gpdk090_nmos1v w=0.24u l=0.1u ad=0.0816p as=0.0528p pd=1.16u ps=0.68u
    I_MXI96_I8_MN0 (XI96_I8_An aa3 VSS VSS) gpdk090_nmos1v w=0.12u l=0.1u ad=0.0696p as=0.0696p pd=1.16u ps=1.16u
    I_MXI96_I10_MN1 (XI96_I10_Bn b4_2 VSS VSS) gpdk090_nmos1v w=0.12u l=0.1u ad=0.0696p as=0.0696p pd=1.16u ps=1.16u
    I_MXI96_I10_MN5 (XI96_I10_n2 b4_2 VSS VSS) gpdk090_nmos1v w=0.24u l=0.1u ad=0.0528p as=0.0816p pd=0.68u ps=1.16u
    I_MXI96_I10_MN4 (I96_pn2 XI96_I10_An XI96_I10_n2 VSS) gpdk090_nmos1v w=0.24u l=0.1u ad=0.0528p as=0.0528p pd=0.68u ps=0.68u
    I_MXI96_I10_MN2 (XI96_I10_n1 p3_1 I96_pn2 VSS) gpdk090_nmos1v w=0.24u l=0.1u ad=0.0528p as=0.0528p pd=0.68u ps=0.68u
    I_MXI96_I10_MN3 (VSS XI96_I10_Bn XI96_I10_n1 VSS) gpdk090_nmos1v w=0.24u l=0.1u ad=0.0816p as=0.0528p pd=1.16u ps=0.68u
    I_MXI96_I10_MN0 (XI96_I10_An p3_1 VSS VSS) gpdk090_nmos1v w=0.12u l=0.1u ad=0.0696p as=0.0696p pd=1.16u ps=1.16u
    I_MXI96_I14_MN1 (XI96_I14_Bn b4_6 VSS VSS) gpdk090_nmos1v w=0.12u l=0.1u ad=0.0696p as=0.0696p pd=1.16u ps=1.16u
    I_MXI96_I14_MN5 (XI96_I14_n2 b4_6 VSS VSS) gpdk090_nmos1v w=0.24u l=0.1u ad=0.0528p as=0.0816p pd=0.68u ps=1.16u
    I_MXI96_I14_MN4 (I96_pn6 XI96_I14_An XI96_I14_n2 VSS) gpdk090_nmos1v w=0.24u l=0.1u ad=0.0528p as=0.0528p pd=0.68u ps=0.68u
    I_MXI96_I14_MN2 (XI96_I14_n1 p3_5 I96_pn6 VSS) gpdk090_nmos1v w=0.24u l=0.1u ad=0.0528p as=0.0528p pd=0.68u ps=0.68u
    I_MXI96_I14_MN3 (VSS XI96_I14_Bn XI96_I14_n1 VSS) gpdk090_nmos1v w=0.24u l=0.1u ad=0.0816p as=0.0528p pd=1.16u ps=0.68u
    I_MXI96_I14_MN0 (XI96_I14_An p3_5 VSS VSS) gpdk090_nmos1v w=0.12u l=0.1u ad=0.0696p as=0.0696p pd=1.16u ps=1.16u
    I_MXI152_I12_MN1 (XI152_I12_Bn dm4 VSS VSS) gpdk090_nmos1v w=0.12u l=0.1u ad=0.0696p as=0.0696p pd=1.16u ps=1.16u
    I_MXI152_I12_MN5 (XI152_I12_n2 dm4 VSS VSS) gpdk090_nmos1v w=0.24u l=0.1u ad=0.0528p as=0.0816p pd=0.68u ps=1.16u
    I_MXI152_I12_MN4 (I152_pn4 XI152_I12_An XI152_I12_n2 VSS) gpdk090_nmos1v w=0.24u l=0.1u ad=0.0528p as=0.0528p pd=0.68u ps=0.68u
    I_MXI152_I12_MN2 (XI152_I12_n1 p7_4 I152_pn4 VSS) gpdk090_nmos1v w=0.24u l=0.1u ad=0.0528p as=0.0528p pd=0.68u ps=0.68u
    I_MXI152_I12_MN3 (VSS XI152_I12_Bn XI152_I12_n1 VSS) gpdk090_nmos1v w=0.24u l=0.1u ad=0.0816p as=0.0528p pd=1.16u ps=0.68u
    I_MXI152_I12_MN0 (XI152_I12_An p7_4 VSS VSS) gpdk090_nmos1v w=0.12u l=0.1u ad=0.0696p as=0.0696p pd=1.16u ps=1.16u
    I_MXI152_I11_MN1 (XI152_I11_Bn dm3 VSS VSS) gpdk090_nmos1v w=0.12u l=0.1u ad=0.0696p as=0.0696p pd=1.16u ps=1.16u
    I_MXI152_I11_MN5 (XI152_I11_n2 dm3 VSS VSS) gpdk090_nmos1v w=0.24u l=0.1u ad=0.0528p as=0.0816p pd=0.68u ps=1.16u
    I_MXI152_I11_MN4 (I152_pn3 XI152_I11_An XI152_I11_n2 VSS) gpdk090_nmos1v w=0.24u l=0.1u ad=0.0528p as=0.0528p pd=0.68u ps=0.68u
    I_MXI152_I11_MN2 (XI152_I11_n1 p7_3 I152_pn3 VSS) gpdk090_nmos1v w=0.24u l=0.1u ad=0.0528p as=0.0528p pd=0.68u ps=0.68u
    I_MXI152_I11_MN3 (VSS XI152_I11_Bn XI152_I11_n1 VSS) gpdk090_nmos1v w=0.24u l=0.1u ad=0.0816p as=0.0528p pd=1.16u ps=0.68u
    I_MXI152_I11_MN0 (XI152_I11_An p7_3 VSS VSS) gpdk090_nmos1v w=0.12u l=0.1u ad=0.0696p as=0.0696p pd=1.16u ps=1.16u
    I_MXI132_I38_MN1 (XI132_I38_Bn I132_G0_0 VSS VSS) gpdk090_nmos1v w=0.12u l=0.1u ad=0.0696p as=0.0696p pd=1.16u ps=1.16u
    I_MXI132_I38_MN5 (XI132_I38_n2 I132_G0_0 VSS VSS) gpdk090_nmos1v w=0.24u l=0.1u ad=0.0528p as=0.0816p pd=0.68u ps=1.16u
    I_MXI132_I38_MN4 (p7_1 XI132_I38_An XI132_I38_n2 VSS) gpdk090_nmos1v w=0.24u l=0.1u ad=0.0528p as=0.0528p pd=0.68u ps=0.68u
    I_MXI132_I38_MN2 (XI132_I38_n1 I132_pn1 p7_1 VSS) gpdk090_nmos1v w=0.24u l=0.1u ad=0.0528p as=0.0528p pd=0.68u ps=0.68u
    I_MXI132_I38_MN3 (VSS XI132_I38_Bn XI132_I38_n1 VSS) gpdk090_nmos1v w=0.24u l=0.1u ad=0.0816p as=0.0528p pd=1.16u ps=0.68u
    I_MXI132_I38_MN0 (XI132_I38_An I132_pn1 VSS VSS) gpdk090_nmos1v w=0.12u l=0.1u ad=0.0696p as=0.0696p pd=1.16u ps=1.16u
    I_MXI132_I37_MN1 (XI132_I37_Bn qu1 VSS VSS) gpdk090_nmos1v w=0.12u l=0.1u ad=0.0696p as=0.0696p pd=1.16u ps=1.16u
    I_MXI132_I37_MN5 (XI132_I37_n2 qu1 VSS VSS) gpdk090_nmos1v w=0.24u l=0.1u ad=0.0528p as=0.0816p pd=0.68u ps=1.16u
    I_MXI132_I37_MN4 (p7_0 XI132_I37_An XI132_I37_n2 VSS) gpdk090_nmos1v w=0.24u l=0.1u ad=0.0528p as=0.0528p pd=0.68u ps=0.68u
    I_MXI132_I37_MN2 (XI132_I37_n1 I132_pn0 p7_0 VSS) gpdk090_nmos1v w=0.24u l=0.1u ad=0.0528p as=0.0528p pd=0.68u ps=0.68u
    I_MXI132_I37_MN3 (VSS XI132_I37_Bn XI132_I37_n1 VSS) gpdk090_nmos1v w=0.24u l=0.1u ad=0.0816p as=0.0528p pd=1.16u ps=0.68u
    I_MXI132_I37_MN0 (XI132_I37_An I132_pn0 VSS VSS) gpdk090_nmos1v w=0.12u l=0.1u ad=0.0696p as=0.0696p pd=1.16u ps=1.16u
    I_MXI132_I8_MN1 (XI132_I8_Bn b7_0 VSS VSS) gpdk090_nmos1v w=0.12u l=0.1u ad=0.0696p as=0.0696p pd=1.16u ps=1.16u
    I_MXI132_I8_MN5 (XI132_I8_n2 b7_0 VSS VSS) gpdk090_nmos1v w=0.24u l=0.1u ad=0.0528p as=0.0816p pd=0.68u ps=1.16u
    I_MXI132_I8_MN4 (I132_pn0 XI132_I8_An XI132_I8_n2 VSS) gpdk090_nmos1v w=0.24u l=0.1u ad=0.0528p as=0.0528p pd=0.68u ps=0.68u
    I_MXI132_I8_MN2 (XI132_I8_n1 A_0 I132_pn0 VSS) gpdk090_nmos1v w=0.24u l=0.1u ad=0.0528p as=0.0528p pd=0.68u ps=0.68u
    I_MXI132_I8_MN3 (VSS XI132_I8_Bn XI132_I8_n1 VSS) gpdk090_nmos1v w=0.24u l=0.1u ad=0.0816p as=0.0528p pd=1.16u ps=0.68u
    I_MXI132_I8_MN0 (XI132_I8_An A_0 VSS VSS) gpdk090_nmos1v w=0.12u l=0.1u ad=0.0696p as=0.0696p pd=1.16u ps=1.16u
    I_MXI1_MN1 (XI1_Bn nakn1 VSS VSS) gpdk090_nmos1v w=0.12u l=0.1u ad=0.0696p as=0.0696p pd=1.16u ps=1.16u
    I_MXI1_MN5 (XI1_n2 nakn1 VSS VSS) gpdk090_nmos1v w=0.24u l=0.1u ad=0.0528p as=0.0816p pd=0.68u ps=1.16u
    I_MXI1_MN4 (aa1 XI1_An XI1_n2 VSS) gpdk090_nmos1v w=0.24u l=0.1u ad=0.0528p as=0.0528p pd=0.68u ps=0.68u
    I_MXI1_MN2 (XI1_n1 A_1 aa1 VSS) gpdk090_nmos1v w=0.24u l=0.1u ad=0.0528p as=0.0528p pd=0.68u ps=0.68u
    I_MXI1_MN3 (VSS XI1_Bn XI1_n1 VSS) gpdk090_nmos1v w=0.24u l=0.1u ad=0.0816p as=0.0528p pd=1.16u ps=0.68u
    I_MXI1_MN0 (XI1_An A_1 VSS VSS) gpdk090_nmos1v w=0.12u l=0.1u ad=0.0696p as=0.0696p pd=1.16u ps=1.16u
    I_MXI155_MN1 (XI155_Bn nqkn1 VSS VSS) gpdk090_nmos1v w=0.12u l=0.1u ad=0.0696p as=0.0696p pd=1.16u ps=1.16u
    I_MXI155_MN5 (XI155_n2 nqkn1 VSS VSS) gpdk090_nmos1v w=0.24u l=0.1u ad=0.0528p as=0.0816p pd=0.68u ps=1.16u
    I_MXI155_MN4 (Q_1 XI155_An XI155_n2 VSS) gpdk090_nmos1v w=0.24u l=0.1u ad=0.0528p as=0.0528p pd=0.68u ps=0.68u
    I_MXI155_MN2 (XI155_n1 qu1 Q_1 VSS) gpdk090_nmos1v w=0.24u l=0.1u ad=0.0528p as=0.0528p pd=0.68u ps=0.68u
    I_MXI155_MN3 (VSS XI155_Bn XI155_n1 VSS) gpdk090_nmos1v w=0.24u l=0.1u ad=0.0816p as=0.0528p pd=1.16u ps=0.68u
    I_MXI155_MN0 (XI155_An qu1 VSS VSS) gpdk090_nmos1v w=0.12u l=0.1u ad=0.0696p as=0.0696p pd=1.16u ps=1.16u
    I_MXI158_MN1 (XI158_Bn nqkn2 VSS VSS) gpdk090_nmos1v w=0.12u l=0.1u ad=0.0696p as=0.0696p pd=1.16u ps=1.16u
    I_MXI158_MN5 (XI158_n2 nqkn2 VSS VSS) gpdk090_nmos1v w=0.24u l=0.1u ad=0.0528p as=0.0816p pd=0.68u ps=1.16u
    I_MXI158_MN4 (Q_2 XI158_An XI158_n2 VSS) gpdk090_nmos1v w=0.24u l=0.1u ad=0.0528p as=0.0528p pd=0.68u ps=0.68u
    I_MXI158_MN2 (XI158_n1 qu2 Q_2 VSS) gpdk090_nmos1v w=0.24u l=0.1u ad=0.0528p as=0.0528p pd=0.68u ps=0.68u
    I_MXI158_MN3 (VSS XI158_Bn XI158_n1 VSS) gpdk090_nmos1v w=0.24u l=0.1u ad=0.0816p as=0.0528p pd=1.16u ps=0.68u
    I_MXI158_MN0 (XI158_An qu2 VSS VSS) gpdk090_nmos1v w=0.12u l=0.1u ad=0.0696p as=0.0696p pd=1.16u ps=1.16u
    I_MXI161_MN1 (XI161_Bn nqkn3 VSS VSS) gpdk090_nmos1v w=0.12u l=0.1u ad=0.0696p as=0.0696p pd=1.16u ps=1.16u
    I_MXI161_MN5 (XI161_n2 nqkn3 VSS VSS) gpdk090_nmos1v w=0.24u l=0.1u ad=0.0528p as=0.0816p pd=0.68u ps=1.16u
    I_MXI161_MN4 (Q_3 XI161_An XI161_n2 VSS) gpdk090_nmos1v w=0.24u l=0.1u ad=0.0528p as=0.0528p pd=0.68u ps=0.68u
    I_MXI161_MN2 (XI161_n1 qu3 Q_3 VSS) gpdk090_nmos1v w=0.24u l=0.1u ad=0.0528p as=0.0528p pd=0.68u ps=0.68u
    I_MXI161_MN3 (VSS XI161_Bn XI161_n1 VSS) gpdk090_nmos1v w=0.24u l=0.1u ad=0.0816p as=0.0528p pd=1.16u ps=0.68u
    I_MXI161_MN0 (XI161_An qu3 VSS VSS) gpdk090_nmos1v w=0.12u l=0.1u ad=0.0696p as=0.0696p pd=1.16u ps=1.16u
    I_MXI10_MN1 (XI10_Bn nakn4 VSS VSS) gpdk090_nmos1v w=0.12u l=0.1u ad=0.0696p as=0.0696p pd=1.16u ps=1.16u
    I_MXI10_MN5 (XI10_n2 nakn4 VSS VSS) gpdk090_nmos1v w=0.24u l=0.1u ad=0.0528p as=0.0816p pd=0.68u ps=1.16u
    I_MXI10_MN4 (aa4 XI10_An XI10_n2 VSS) gpdk090_nmos1v w=0.24u l=0.1u ad=0.0528p as=0.0528p pd=0.68u ps=0.68u
    I_MXI10_MN2 (XI10_n1 A_4 aa4 VSS) gpdk090_nmos1v w=0.24u l=0.1u ad=0.0528p as=0.0528p pd=0.68u ps=0.68u
    I_MXI10_MN3 (VSS XI10_Bn XI10_n1 VSS) gpdk090_nmos1v w=0.24u l=0.1u ad=0.0816p as=0.0528p pd=1.16u ps=0.68u
    I_MXI10_MN0 (XI10_An A_4 VSS VSS) gpdk090_nmos1v w=0.12u l=0.1u ad=0.0696p as=0.0696p pd=1.16u ps=1.16u
    I_MXI84_I8_MN1 (XI84_I8_Bn b3_0 VSS VSS) gpdk090_nmos1v w=0.12u l=0.1u ad=0.0696p as=0.0696p pd=1.16u ps=1.16u
    I_MXI84_I8_MN5 (XI84_I8_n2 b3_0 VSS VSS) gpdk090_nmos1v w=0.24u l=0.1u ad=0.0528p as=0.0816p pd=0.68u ps=1.16u
    I_MXI84_I8_MN4 (I84_pn0 XI84_I8_An XI84_I8_n2 VSS) gpdk090_nmos1v w=0.24u l=0.1u ad=0.0528p as=0.0528p pd=0.68u ps=0.68u
    I_MXI84_I8_MN2 (XI84_I8_n1 aa4 I84_pn0 VSS) gpdk090_nmos1v w=0.24u l=0.1u ad=0.0528p as=0.0528p pd=0.68u ps=0.68u
    I_MXI84_I8_MN3 (VSS XI84_I8_Bn XI84_I8_n1 VSS) gpdk090_nmos1v w=0.24u l=0.1u ad=0.0816p as=0.0528p pd=1.16u ps=0.68u
    I_MXI84_I8_MN0 (XI84_I8_An aa4 VSS VSS) gpdk090_nmos1v w=0.12u l=0.1u ad=0.0696p as=0.0696p pd=1.16u ps=1.16u
    I_MXI84_I37_MN1 (XI84_I37_Bn qu5 VSS VSS) gpdk090_nmos1v w=0.12u l=0.1u ad=0.0696p as=0.0696p pd=1.16u ps=1.16u
    I_MXI84_I37_MN5 (XI84_I37_n2 qu5 VSS VSS) gpdk090_nmos1v w=0.24u l=0.1u ad=0.0528p as=0.0816p pd=0.68u ps=1.16u
    I_MXI84_I37_MN4 (p3_0 XI84_I37_An XI84_I37_n2 VSS) gpdk090_nmos1v w=0.24u l=0.1u ad=0.0528p as=0.0528p pd=0.68u ps=0.68u
    I_MXI84_I37_MN2 (XI84_I37_n1 I84_pn0 p3_0 VSS) gpdk090_nmos1v w=0.24u l=0.1u ad=0.0528p as=0.0528p pd=0.68u ps=0.68u
    I_MXI84_I37_MN3 (VSS XI84_I37_Bn XI84_I37_n1 VSS) gpdk090_nmos1v w=0.24u l=0.1u ad=0.0816p as=0.0528p pd=1.16u ps=0.68u
    I_MXI84_I37_MN0 (XI84_I37_An I84_pn0 VSS VSS) gpdk090_nmos1v w=0.12u l=0.1u ad=0.0696p as=0.0696p pd=1.16u ps=1.16u
    I_MXI96_I11_MN1 (XI96_I11_Bn b4_3 VSS VSS) gpdk090_nmos1v w=0.12u l=0.1u ad=0.0696p as=0.0696p pd=1.16u ps=1.16u
    I_MXI96_I11_MN5 (XI96_I11_n2 b4_3 VSS VSS) gpdk090_nmos1v w=0.24u l=0.1u ad=0.0528p as=0.0816p pd=0.68u ps=1.16u
    I_MXI96_I11_MN4 (I96_pn3 XI96_I11_An XI96_I11_n2 VSS) gpdk090_nmos1v w=0.24u l=0.1u ad=0.0528p as=0.0528p pd=0.68u ps=0.68u
    I_MXI96_I11_MN2 (XI96_I11_n1 p3_2 I96_pn3 VSS) gpdk090_nmos1v w=0.24u l=0.1u ad=0.0528p as=0.0528p pd=0.68u ps=0.68u
    I_MXI96_I11_MN3 (VSS XI96_I11_Bn XI96_I11_n1 VSS) gpdk090_nmos1v w=0.24u l=0.1u ad=0.0816p as=0.0528p pd=1.16u ps=0.68u
    I_MXI96_I11_MN0 (XI96_I11_An p3_2 VSS VSS) gpdk090_nmos1v w=0.12u l=0.1u ad=0.0696p as=0.0696p pd=1.16u ps=1.16u
    I_MXI96_I12_MN1 (XI96_I12_Bn b4_4 VSS VSS) gpdk090_nmos1v w=0.12u l=0.1u ad=0.0696p as=0.0696p pd=1.16u ps=1.16u
    I_MXI96_I12_MN5 (XI96_I12_n2 b4_4 VSS VSS) gpdk090_nmos1v w=0.24u l=0.1u ad=0.0528p as=0.0816p pd=0.68u ps=1.16u
    I_MXI96_I12_MN4 (I96_pn4 XI96_I12_An XI96_I12_n2 VSS) gpdk090_nmos1v w=0.24u l=0.1u ad=0.0528p as=0.0528p pd=0.68u ps=0.68u
    I_MXI96_I12_MN2 (XI96_I12_n1 p3_3 I96_pn4 VSS) gpdk090_nmos1v w=0.24u l=0.1u ad=0.0528p as=0.0528p pd=0.68u ps=0.68u
    I_MXI96_I12_MN3 (VSS XI96_I12_Bn XI96_I12_n1 VSS) gpdk090_nmos1v w=0.24u l=0.1u ad=0.0816p as=0.0528p pd=1.16u ps=0.68u
    I_MXI96_I12_MN0 (XI96_I12_An p3_3 VSS VSS) gpdk090_nmos1v w=0.12u l=0.1u ad=0.0696p as=0.0696p pd=1.16u ps=1.16u
    I_MXI96_I13_MN1 (XI96_I13_Bn b4_5 VSS VSS) gpdk090_nmos1v w=0.12u l=0.1u ad=0.0696p as=0.0696p pd=1.16u ps=1.16u
    I_MXI96_I13_MN5 (XI96_I13_n2 b4_5 VSS VSS) gpdk090_nmos1v w=0.24u l=0.1u ad=0.0528p as=0.0816p pd=0.68u ps=1.16u
    I_MXI96_I13_MN4 (I96_pn5 XI96_I13_An XI96_I13_n2 VSS) gpdk090_nmos1v w=0.24u l=0.1u ad=0.0528p as=0.0528p pd=0.68u ps=0.68u
    I_MXI96_I13_MN2 (XI96_I13_n1 p3_4 I96_pn5 VSS) gpdk090_nmos1v w=0.24u l=0.1u ad=0.0528p as=0.0528p pd=0.68u ps=0.68u
    I_MXI96_I13_MN3 (VSS XI96_I13_Bn XI96_I13_n1 VSS) gpdk090_nmos1v w=0.24u l=0.1u ad=0.0816p as=0.0528p pd=1.16u ps=0.68u
    I_MXI96_I13_MN0 (XI96_I13_An p3_4 VSS VSS) gpdk090_nmos1v w=0.12u l=0.1u ad=0.0696p as=0.0696p pd=1.16u ps=1.16u
    I_MXI152_I10_MN1 (XI152_I10_Bn dm2 VSS VSS) gpdk090_nmos1v w=0.12u l=0.1u ad=0.0696p as=0.0696p pd=1.16u ps=1.16u
    I_MXI152_I10_MN5 (XI152_I10_n2 dm2 VSS VSS) gpdk090_nmos1v w=0.24u l=0.1u ad=0.0528p as=0.0816p pd=0.68u ps=1.16u
    I_MXI152_I10_MN4 (I152_pn2 XI152_I10_An XI152_I10_n2 VSS) gpdk090_nmos1v w=0.24u l=0.1u ad=0.0528p as=0.0528p pd=0.68u ps=0.68u
    I_MXI152_I10_MN2 (XI152_I10_n1 p7_2 I152_pn2 VSS) gpdk090_nmos1v w=0.24u l=0.1u ad=0.0528p as=0.0528p pd=0.68u ps=0.68u
    I_MXI152_I10_MN3 (VSS XI152_I10_Bn XI152_I10_n1 VSS) gpdk090_nmos1v w=0.24u l=0.1u ad=0.0816p as=0.0528p pd=1.16u ps=0.68u
    I_MXI152_I10_MN0 (XI152_I10_An p7_2 VSS VSS) gpdk090_nmos1v w=0.12u l=0.1u ad=0.0696p as=0.0696p pd=1.16u ps=1.16u
    I_MXI152_I8_MN1 (XI152_I8_Bn dm0 VSS VSS) gpdk090_nmos1v w=0.12u l=0.1u ad=0.0696p as=0.0696p pd=1.16u ps=1.16u
    I_MXI152_I8_MN5 (XI152_I8_n2 dm0 VSS VSS) gpdk090_nmos1v w=0.24u l=0.1u ad=0.0528p as=0.0816p pd=0.68u ps=1.16u
    I_MXI152_I8_MN4 (I152_pn0 XI152_I8_An XI152_I8_n2 VSS) gpdk090_nmos1v w=0.24u l=0.1u ad=0.0528p as=0.0528p pd=0.68u ps=0.68u
    I_MXI152_I8_MN2 (XI152_I8_n1 p7_0 I152_pn0 VSS) gpdk090_nmos1v w=0.24u l=0.1u ad=0.0528p as=0.0528p pd=0.68u ps=0.68u
    I_MXI152_I8_MN3 (VSS XI152_I8_Bn XI152_I8_n1 VSS) gpdk090_nmos1v w=0.24u l=0.1u ad=0.0816p as=0.0528p pd=1.16u ps=0.68u
    I_MXI152_I8_MN0 (XI152_I8_An p7_0 VSS VSS) gpdk090_nmos1v w=0.12u l=0.1u ad=0.0696p as=0.0696p pd=1.16u ps=1.16u
    I_MXI36_MN1 (XI36_Bn nbkn6 VSS VSS) gpdk090_nmos1v w=0.12u l=0.1u ad=0.0696p as=0.0696p pd=1.16u ps=1.16u
    I_MXI36_MN5 (XI36_n2 nbkn6 VSS VSS) gpdk090_nmos1v w=0.24u l=0.1u ad=0.0528p as=0.0816p pd=0.68u ps=1.16u
    I_MXI36_MN4 (dd6 XI36_An XI36_n2 VSS) gpdk090_nmos1v w=0.24u l=0.1u ad=0.0528p as=0.0528p pd=0.68u ps=0.68u
    I_MXI36_MN2 (XI36_n1 B_6 dd6 VSS) gpdk090_nmos1v w=0.24u l=0.1u ad=0.0528p as=0.0528p pd=0.68u ps=0.68u
    I_MXI36_MN3 (VSS XI36_Bn XI36_n1 VSS) gpdk090_nmos1v w=0.24u l=0.1u ad=0.0816p as=0.0528p pd=1.16u ps=0.68u
    I_MXI36_MN0 (XI36_An B_6 VSS VSS) gpdk090_nmos1v w=0.12u l=0.1u ad=0.0696p as=0.0696p pd=1.16u ps=1.16u
    I_MXI39_MN1 (XI39_Bn nbkn7 VSS VSS) gpdk090_nmos1v w=0.12u l=0.1u ad=0.0696p as=0.0696p pd=1.16u ps=1.16u
    I_MXI39_MN5 (XI39_n2 nbkn7 VSS VSS) gpdk090_nmos1v w=0.24u l=0.1u ad=0.0528p as=0.0816p pd=0.68u ps=1.16u
    I_MXI39_MN4 (dd7 XI39_An XI39_n2 VSS) gpdk090_nmos1v w=0.24u l=0.1u ad=0.0528p as=0.0528p pd=0.68u ps=0.68u
    I_MXI39_MN2 (XI39_n1 B_7 dd7 VSS) gpdk090_nmos1v w=0.24u l=0.1u ad=0.0528p as=0.0528p pd=0.68u ps=0.68u
    I_MXI39_MN3 (VSS XI39_Bn XI39_n1 VSS) gpdk090_nmos1v w=0.24u l=0.1u ad=0.0816p as=0.0528p pd=1.16u ps=0.68u
    I_MXI39_MN0 (XI39_An B_7 VSS VSS) gpdk090_nmos1v w=0.12u l=0.1u ad=0.0696p as=0.0696p pd=1.16u ps=1.16u
    I_MXI167_MN1 (XI167_Bn nqkn5 VSS VSS) gpdk090_nmos1v w=0.12u l=0.1u ad=0.0696p as=0.0696p pd=1.16u ps=1.16u
    I_MXI167_MN5 (XI167_n2 nqkn5 VSS VSS) gpdk090_nmos1v w=0.24u l=0.1u ad=0.0528p as=0.0816p pd=0.68u ps=1.16u
    I_MXI167_MN4 (Q_5 XI167_An XI167_n2 VSS) gpdk090_nmos1v w=0.24u l=0.1u ad=0.0528p as=0.0528p pd=0.68u ps=0.68u
    I_MXI167_MN2 (XI167_n1 qu5 Q_5 VSS) gpdk090_nmos1v w=0.24u l=0.1u ad=0.0528p as=0.0528p pd=0.68u ps=0.68u
    I_MXI167_MN3 (VSS XI167_Bn XI167_n1 VSS) gpdk090_nmos1v w=0.24u l=0.1u ad=0.0816p as=0.0528p pd=1.16u ps=0.68u
    I_MXI167_MN0 (XI167_An qu5 VSS VSS) gpdk090_nmos1v w=0.12u l=0.1u ad=0.0696p as=0.0696p pd=1.16u ps=1.16u
    I_MXI84_I9_MN1 (XI84_I9_Bn b3_1 VSS VSS) gpdk090_nmos1v w=0.12u l=0.1u ad=0.0696p as=0.0696p pd=1.16u ps=1.16u
    I_MXI84_I9_MN5 (XI84_I9_n2 b3_1 VSS VSS) gpdk090_nmos1v w=0.24u l=0.1u ad=0.0528p as=0.0816p pd=0.68u ps=1.16u
    I_MXI84_I9_MN4 (I84_pn1 XI84_I9_An XI84_I9_n2 VSS) gpdk090_nmos1v w=0.24u l=0.1u ad=0.0528p as=0.0528p pd=0.68u ps=0.68u
    I_MXI84_I9_MN2 (XI84_I9_n1 p2_0 I84_pn1 VSS) gpdk090_nmos1v w=0.24u l=0.1u ad=0.0528p as=0.0528p pd=0.68u ps=0.68u
    I_MXI84_I9_MN3 (VSS XI84_I9_Bn XI84_I9_n1 VSS) gpdk090_nmos1v w=0.24u l=0.1u ad=0.0816p as=0.0528p pd=1.16u ps=0.68u
    I_MXI84_I9_MN0 (XI84_I9_An p2_0 VSS VSS) gpdk090_nmos1v w=0.12u l=0.1u ad=0.0696p as=0.0696p pd=1.16u ps=1.16u
    I_MXI84_I38_MN1 (XI84_I38_Bn I84_G0_0 VSS VSS) gpdk090_nmos1v w=0.12u l=0.1u ad=0.0696p as=0.0696p pd=1.16u ps=1.16u
    I_MXI84_I38_MN5 (XI84_I38_n2 I84_G0_0 VSS VSS) gpdk090_nmos1v w=0.24u l=0.1u ad=0.0528p as=0.0816p pd=0.68u ps=1.16u
    I_MXI84_I38_MN4 (p3_1 XI84_I38_An XI84_I38_n2 VSS) gpdk090_nmos1v w=0.24u l=0.1u ad=0.0528p as=0.0528p pd=0.68u ps=0.68u
    I_MXI84_I38_MN2 (XI84_I38_n1 I84_pn1 p3_1 VSS) gpdk090_nmos1v w=0.24u l=0.1u ad=0.0528p as=0.0528p pd=0.68u ps=0.68u
    I_MXI84_I38_MN3 (VSS XI84_I38_Bn XI84_I38_n1 VSS) gpdk090_nmos1v w=0.24u l=0.1u ad=0.0816p as=0.0528p pd=1.16u ps=0.68u
    I_MXI84_I38_MN0 (XI84_I38_An I84_pn1 VSS VSS) gpdk090_nmos1v w=0.12u l=0.1u ad=0.0696p as=0.0696p pd=1.16u ps=1.16u
    I_MXI84_I42_MN1 (XI84_I42_Bn I84_G4_0 VSS VSS) gpdk090_nmos1v w=0.12u l=0.1u ad=0.0696p as=0.0696p pd=1.16u ps=1.16u
    I_MXI84_I42_MN5 (XI84_I42_n2 I84_G4_0 VSS VSS) gpdk090_nmos1v w=0.24u l=0.1u ad=0.0528p as=0.0816p pd=0.68u ps=1.16u
    I_MXI84_I42_MN4 (p3_5 XI84_I42_An XI84_I42_n2 VSS) gpdk090_nmos1v w=0.24u l=0.1u ad=0.0528p as=0.0528p pd=0.68u ps=0.68u
    I_MXI84_I42_MN2 (XI84_I42_n1 I84_pn5 p3_5 VSS) gpdk090_nmos1v w=0.24u l=0.1u ad=0.0528p as=0.0528p pd=0.68u ps=0.68u
    I_MXI84_I42_MN3 (VSS XI84_I42_Bn XI84_I42_n1 VSS) gpdk090_nmos1v w=0.24u l=0.1u ad=0.0816p as=0.0528p pd=1.16u ps=0.68u
    I_MXI84_I42_MN0 (XI84_I42_An I84_pn5 VSS VSS) gpdk090_nmos1v w=0.12u l=0.1u ad=0.0696p as=0.0696p pd=1.16u ps=1.16u
    I_MXI84_I44_MN1 (XI84_I44_Bn c3_7 VSS VSS) gpdk090_nmos1v w=0.12u l=0.1u ad=0.0696p as=0.0696p pd=1.16u ps=1.16u
    I_MXI84_I44_MN5 (XI84_I44_n2 c3_7 VSS VSS) gpdk090_nmos1v w=0.24u l=0.1u ad=0.0528p as=0.0816p pd=0.68u ps=1.16u
    I_MXI84_I44_MN4 (p3_7 XI84_I44_An XI84_I44_n2 VSS) gpdk090_nmos1v w=0.24u l=0.1u ad=0.0528p as=0.0528p pd=0.68u ps=0.68u
    I_MXI84_I44_MN2 (XI84_I44_n1 I84_pn7 p3_7 VSS) gpdk090_nmos1v w=0.24u l=0.1u ad=0.0528p as=0.0528p pd=0.68u ps=0.68u
    I_MXI84_I44_MN3 (VSS XI84_I44_Bn XI84_I44_n1 VSS) gpdk090_nmos1v w=0.24u l=0.1u ad=0.0816p as=0.0528p pd=1.16u ps=0.68u
    I_MXI84_I44_MN0 (XI84_I44_An I84_pn7 VSS VSS) gpdk090_nmos1v w=0.12u l=0.1u ad=0.0696p as=0.0696p pd=1.16u ps=1.16u
    I_MXI152_I43_MN1 (XI152_I43_Bn I152_G5_0 VSS VSS) gpdk090_nmos1v w=0.12u l=0.1u ad=0.0696p as=0.0696p pd=1.16u ps=1.16u
    I_MXI152_I43_MN5 (XI152_I43_n2 I152_G5_0 VSS VSS) gpdk090_nmos1v w=0.24u l=0.1u ad=0.0528p as=0.0816p pd=0.68u ps=1.16u
    I_MXI152_I43_MN4 (ru6 XI152_I43_An XI152_I43_n2 VSS) gpdk090_nmos1v w=0.24u l=0.1u ad=0.0528p as=0.0528p pd=0.68u ps=0.68u
    I_MXI152_I43_MN2 (XI152_I43_n1 I152_pn6 ru6 VSS) gpdk090_nmos1v w=0.24u l=0.1u ad=0.0528p as=0.0528p pd=0.68u ps=0.68u
    I_MXI152_I43_MN3 (VSS XI152_I43_Bn XI152_I43_n1 VSS) gpdk090_nmos1v w=0.24u l=0.1u ad=0.0816p as=0.0528p pd=1.16u ps=0.68u
    I_MXI152_I43_MN0 (XI152_I43_An I152_pn6 VSS VSS) gpdk090_nmos1v w=0.12u l=0.1u ad=0.0696p as=0.0696p pd=1.16u ps=1.16u
    I_MXI152_I9_MN1 (XI152_I9_Bn dm1 VSS VSS) gpdk090_nmos1v w=0.12u l=0.1u ad=0.0696p as=0.0696p pd=1.16u ps=1.16u
    I_MXI152_I9_MN5 (XI152_I9_n2 dm1 VSS VSS) gpdk090_nmos1v w=0.24u l=0.1u ad=0.0528p as=0.0816p pd=0.68u ps=1.16u
    I_MXI152_I9_MN4 (I152_pn1 XI152_I9_An XI152_I9_n2 VSS) gpdk090_nmos1v w=0.24u l=0.1u ad=0.0528p as=0.0528p pd=0.68u ps=0.68u
    I_MXI152_I9_MN2 (XI152_I9_n1 p7_1 I152_pn1 VSS) gpdk090_nmos1v w=0.24u l=0.1u ad=0.0528p as=0.0528p pd=0.68u ps=0.68u
    I_MXI152_I9_MN3 (VSS XI152_I9_Bn XI152_I9_n1 VSS) gpdk090_nmos1v w=0.24u l=0.1u ad=0.0816p as=0.0528p pd=1.16u ps=0.68u
    I_MXI152_I9_MN0 (XI152_I9_An p7_1 VSS VSS) gpdk090_nmos1v w=0.12u l=0.1u ad=0.0696p as=0.0696p pd=1.16u ps=1.16u
    I_MXI33_MN1 (XI33_Bn nbkn5 VSS VSS) gpdk090_nmos1v w=0.12u l=0.1u ad=0.0696p as=0.0696p pd=1.16u ps=1.16u
    I_MXI33_MN5 (XI33_n2 nbkn5 VSS VSS) gpdk090_nmos1v w=0.24u l=0.1u ad=0.0528p as=0.0816p pd=0.68u ps=1.16u
    I_MXI33_MN4 (dd5 XI33_An XI33_n2 VSS) gpdk090_nmos1v w=0.24u l=0.1u ad=0.0528p as=0.0528p pd=0.68u ps=0.68u
    I_MXI33_MN2 (XI33_n1 B_5 dd5 VSS) gpdk090_nmos1v w=0.24u l=0.1u ad=0.0528p as=0.0528p pd=0.68u ps=0.68u
    I_MXI33_MN3 (VSS XI33_Bn XI33_n1 VSS) gpdk090_nmos1v w=0.24u l=0.1u ad=0.0816p as=0.0528p pd=1.16u ps=0.68u
    I_MXI33_MN0 (XI33_An B_5 VSS VSS) gpdk090_nmos1v w=0.12u l=0.1u ad=0.0696p as=0.0696p pd=1.16u ps=1.16u
    I_MXI21_MN1 (XI21_Bn nbkn1 VSS VSS) gpdk090_nmos1v w=0.12u l=0.1u ad=0.0696p as=0.0696p pd=1.16u ps=1.16u
    I_MXI21_MN5 (XI21_n2 nbkn1 VSS VSS) gpdk090_nmos1v w=0.24u l=0.1u ad=0.0528p as=0.0816p pd=0.68u ps=1.16u
    I_MXI21_MN4 (dd1 XI21_An XI21_n2 VSS) gpdk090_nmos1v w=0.24u l=0.1u ad=0.0528p as=0.0528p pd=0.68u ps=0.68u
    I_MXI21_MN2 (XI21_n1 B_1 dd1 VSS) gpdk090_nmos1v w=0.24u l=0.1u ad=0.0528p as=0.0528p pd=0.68u ps=0.68u
    I_MXI21_MN3 (VSS XI21_Bn XI21_n1 VSS) gpdk090_nmos1v w=0.24u l=0.1u ad=0.0816p as=0.0528p pd=1.16u ps=0.68u
    I_MXI21_MN0 (XI21_An B_1 VSS VSS) gpdk090_nmos1v w=0.12u l=0.1u ad=0.0696p as=0.0696p pd=1.16u ps=1.16u
    I_MXI164_MN1 (XI164_Bn nqkn4 VSS VSS) gpdk090_nmos1v w=0.12u l=0.1u ad=0.0696p as=0.0696p pd=1.16u ps=1.16u
    I_MXI164_MN5 (XI164_n2 nqkn4 VSS VSS) gpdk090_nmos1v w=0.24u l=0.1u ad=0.0528p as=0.0816p pd=0.68u ps=1.16u
    I_MXI164_MN4 (Q_4 XI164_An XI164_n2 VSS) gpdk090_nmos1v w=0.24u l=0.1u ad=0.0528p as=0.0528p pd=0.68u ps=0.68u
    I_MXI164_MN2 (XI164_n1 qu4 Q_4 VSS) gpdk090_nmos1v w=0.24u l=0.1u ad=0.0528p as=0.0528p pd=0.68u ps=0.68u
    I_MXI164_MN3 (VSS XI164_Bn XI164_n1 VSS) gpdk090_nmos1v w=0.24u l=0.1u ad=0.0816p as=0.0528p pd=1.16u ps=0.68u
    I_MXI164_MN0 (XI164_An qu4 VSS VSS) gpdk090_nmos1v w=0.12u l=0.1u ad=0.0696p as=0.0696p pd=1.16u ps=1.16u
    I_MXI170_MN1 (XI170_Bn nqkn6 VSS VSS) gpdk090_nmos1v w=0.12u l=0.1u ad=0.0696p as=0.0696p pd=1.16u ps=1.16u
    I_MXI170_MN5 (XI170_n2 nqkn6 VSS VSS) gpdk090_nmos1v w=0.24u l=0.1u ad=0.0528p as=0.0816p pd=0.68u ps=1.16u
    I_MXI170_MN4 (Q_6 XI170_An XI170_n2 VSS) gpdk090_nmos1v w=0.24u l=0.1u ad=0.0528p as=0.0528p pd=0.68u ps=0.68u
    I_MXI170_MN2 (XI170_n1 qu6 Q_6 VSS) gpdk090_nmos1v w=0.24u l=0.1u ad=0.0528p as=0.0528p pd=0.68u ps=0.68u
    I_MXI170_MN3 (VSS XI170_Bn XI170_n1 VSS) gpdk090_nmos1v w=0.24u l=0.1u ad=0.0816p as=0.0528p pd=1.16u ps=0.68u
    I_MXI170_MN0 (XI170_An qu6 VSS VSS) gpdk090_nmos1v w=0.12u l=0.1u ad=0.0696p as=0.0696p pd=1.16u ps=1.16u
    I_MXI72_I37_MN1 (XI72_I37_Bn qu6 VSS VSS) gpdk090_nmos1v w=0.12u l=0.1u ad=0.0696p as=0.0696p pd=1.16u ps=1.16u
    I_MXI72_I37_MN5 (XI72_I37_n2 qu6 VSS VSS) gpdk090_nmos1v w=0.24u l=0.1u ad=0.0528p as=0.0816p pd=0.68u ps=1.16u
    I_MXI72_I37_MN4 (p2_0 XI72_I37_An XI72_I37_n2 VSS) gpdk090_nmos1v w=0.24u l=0.1u ad=0.0528p as=0.0528p pd=0.68u ps=0.68u
    I_MXI72_I37_MN2 (XI72_I37_n1 I72_pn0 p2_0 VSS) gpdk090_nmos1v w=0.24u l=0.1u ad=0.0528p as=0.0528p pd=0.68u ps=0.68u
    I_MXI72_I37_MN3 (VSS XI72_I37_Bn XI72_I37_n1 VSS) gpdk090_nmos1v w=0.24u l=0.1u ad=0.0816p as=0.0528p pd=1.16u ps=0.68u
    I_MXI72_I37_MN0 (XI72_I37_An I72_pn0 VSS VSS) gpdk090_nmos1v w=0.12u l=0.1u ad=0.0696p as=0.0696p pd=1.16u ps=1.16u
    I_MXI84_I10_MN1 (XI84_I10_Bn b3_2 VSS VSS) gpdk090_nmos1v w=0.12u l=0.1u ad=0.0696p as=0.0696p pd=1.16u ps=1.16u
    I_MXI84_I10_MN5 (XI84_I10_n2 b3_2 VSS VSS) gpdk090_nmos1v w=0.24u l=0.1u ad=0.0528p as=0.0816p pd=0.68u ps=1.16u
    I_MXI84_I10_MN4 (I84_pn2 XI84_I10_An XI84_I10_n2 VSS) gpdk090_nmos1v w=0.24u l=0.1u ad=0.0528p as=0.0528p pd=0.68u ps=0.68u
    I_MXI84_I10_MN2 (XI84_I10_n1 p2_1 I84_pn2 VSS) gpdk090_nmos1v w=0.24u l=0.1u ad=0.0528p as=0.0528p pd=0.68u ps=0.68u
    I_MXI84_I10_MN3 (VSS XI84_I10_Bn XI84_I10_n1 VSS) gpdk090_nmos1v w=0.24u l=0.1u ad=0.0816p as=0.0528p pd=1.16u ps=0.68u
    I_MXI84_I10_MN0 (XI84_I10_An p2_1 VSS VSS) gpdk090_nmos1v w=0.12u l=0.1u ad=0.0696p as=0.0696p pd=1.16u ps=1.16u
    I_MXI84_I39_MN1 (XI84_I39_Bn I84_G1_0 VSS VSS) gpdk090_nmos1v w=0.12u l=0.1u ad=0.0696p as=0.0696p pd=1.16u ps=1.16u
    I_MXI84_I39_MN5 (XI84_I39_n2 I84_G1_0 VSS VSS) gpdk090_nmos1v w=0.24u l=0.1u ad=0.0528p as=0.0816p pd=0.68u ps=1.16u
    I_MXI84_I39_MN4 (p3_2 XI84_I39_An XI84_I39_n2 VSS) gpdk090_nmos1v w=0.24u l=0.1u ad=0.0528p as=0.0528p pd=0.68u ps=0.68u
    I_MXI84_I39_MN2 (XI84_I39_n1 I84_pn2 p3_2 VSS) gpdk090_nmos1v w=0.24u l=0.1u ad=0.0528p as=0.0528p pd=0.68u ps=0.68u
    I_MXI84_I39_MN3 (VSS XI84_I39_Bn XI84_I39_n1 VSS) gpdk090_nmos1v w=0.24u l=0.1u ad=0.0816p as=0.0528p pd=1.16u ps=0.68u
    I_MXI84_I39_MN0 (XI84_I39_An I84_pn2 VSS VSS) gpdk090_nmos1v w=0.12u l=0.1u ad=0.0696p as=0.0696p pd=1.16u ps=1.16u
    I_MXI84_I43_MN1 (XI84_I43_Bn I84_G5_0 VSS VSS) gpdk090_nmos1v w=0.12u l=0.1u ad=0.0696p as=0.0696p pd=1.16u ps=1.16u
    I_MXI84_I43_MN5 (XI84_I43_n2 I84_G5_0 VSS VSS) gpdk090_nmos1v w=0.24u l=0.1u ad=0.0528p as=0.0816p pd=0.68u ps=1.16u
    I_MXI84_I43_MN4 (p3_6 XI84_I43_An XI84_I43_n2 VSS) gpdk090_nmos1v w=0.24u l=0.1u ad=0.0528p as=0.0528p pd=0.68u ps=0.68u
    I_MXI84_I43_MN2 (XI84_I43_n1 I84_pn6 p3_6 VSS) gpdk090_nmos1v w=0.24u l=0.1u ad=0.0528p as=0.0528p pd=0.68u ps=0.68u
    I_MXI84_I43_MN3 (VSS XI84_I43_Bn XI84_I43_n1 VSS) gpdk090_nmos1v w=0.24u l=0.1u ad=0.0816p as=0.0528p pd=1.16u ps=0.68u
    I_MXI84_I43_MN0 (XI84_I43_An I84_pn6 VSS VSS) gpdk090_nmos1v w=0.12u l=0.1u ad=0.0696p as=0.0696p pd=1.16u ps=1.16u
    I_MXI193_MN1 (XI193_Bn nrkn7 VSS VSS) gpdk090_nmos1v w=0.12u l=0.1u ad=0.0696p as=0.0696p pd=1.16u ps=1.16u
    I_MXI193_MN5 (XI193_n2 nrkn7 VSS VSS) gpdk090_nmos1v w=0.24u l=0.1u ad=0.0528p as=0.0816p pd=0.68u ps=1.16u
    I_MXI193_MN4 (R_7 XI193_An XI193_n2 VSS) gpdk090_nmos1v w=0.24u l=0.1u ad=0.0528p as=0.0528p pd=0.68u ps=0.68u
    I_MXI193_MN2 (XI193_n1 ru7 R_7 VSS) gpdk090_nmos1v w=0.24u l=0.1u ad=0.0528p as=0.0528p pd=0.68u ps=0.68u
    I_MXI193_MN3 (VSS XI193_Bn XI193_n1 VSS) gpdk090_nmos1v w=0.24u l=0.1u ad=0.0816p as=0.0528p pd=1.16u ps=0.68u
    I_MXI193_MN0 (XI193_An ru7 VSS VSS) gpdk090_nmos1v w=0.12u l=0.1u ad=0.0696p as=0.0696p pd=1.16u ps=1.16u
    I_MXI152_I44_MN1 (XI152_I44_Bn rc6 VSS VSS) gpdk090_nmos1v w=0.12u l=0.1u ad=0.0696p as=0.0696p pd=1.16u ps=1.16u
    I_MXI152_I44_MN5 (XI152_I44_n2 rc6 VSS VSS) gpdk090_nmos1v w=0.24u l=0.1u ad=0.0528p as=0.0816p pd=0.68u ps=1.16u
    I_MXI152_I44_MN4 (ru7 XI152_I44_An XI152_I44_n2 VSS) gpdk090_nmos1v w=0.24u l=0.1u ad=0.0528p as=0.0528p pd=0.68u ps=0.68u
    I_MXI152_I44_MN2 (XI152_I44_n1 I152_pn7 ru7 VSS) gpdk090_nmos1v w=0.24u l=0.1u ad=0.0528p as=0.0528p pd=0.68u ps=0.68u
    I_MXI152_I44_MN3 (VSS XI152_I44_Bn XI152_I44_n1 VSS) gpdk090_nmos1v w=0.24u l=0.1u ad=0.0816p as=0.0528p pd=1.16u ps=0.68u
    I_MXI152_I44_MN0 (XI152_I44_An I152_pn7 VSS VSS) gpdk090_nmos1v w=0.12u l=0.1u ad=0.0696p as=0.0696p pd=1.16u ps=1.16u
    I_MXI152_I42_MN1 (XI152_I42_Bn I152_G4_0 VSS VSS) gpdk090_nmos1v w=0.12u l=0.1u ad=0.0696p as=0.0696p pd=1.16u ps=1.16u
    I_MXI152_I42_MN5 (XI152_I42_n2 I152_G4_0 VSS VSS) gpdk090_nmos1v w=0.24u l=0.1u ad=0.0528p as=0.0816p pd=0.68u ps=1.16u
    I_MXI152_I42_MN4 (ru5 XI152_I42_An XI152_I42_n2 VSS) gpdk090_nmos1v w=0.24u l=0.1u ad=0.0528p as=0.0528p pd=0.68u ps=0.68u
    I_MXI152_I42_MN2 (XI152_I42_n1 I152_pn5 ru5 VSS) gpdk090_nmos1v w=0.24u l=0.1u ad=0.0528p as=0.0528p pd=0.68u ps=0.68u
    I_MXI152_I42_MN3 (VSS XI152_I42_Bn XI152_I42_n1 VSS) gpdk090_nmos1v w=0.24u l=0.1u ad=0.0816p as=0.0528p pd=1.16u ps=0.68u
    I_MXI152_I42_MN0 (XI152_I42_An I152_pn5 VSS VSS) gpdk090_nmos1v w=0.12u l=0.1u ad=0.0696p as=0.0696p pd=1.16u ps=1.16u
    I_MXI152_I39_MN1 (XI152_I39_Bn I152_G1_0 VSS VSS) gpdk090_nmos1v w=0.12u l=0.1u ad=0.0696p as=0.0696p pd=1.16u ps=1.16u
    I_MXI152_I39_MN5 (XI152_I39_n2 I152_G1_0 VSS VSS) gpdk090_nmos1v w=0.24u l=0.1u ad=0.0528p as=0.0816p pd=0.68u ps=1.16u
    I_MXI152_I39_MN4 (ru2 XI152_I39_An XI152_I39_n2 VSS) gpdk090_nmos1v w=0.24u l=0.1u ad=0.0528p as=0.0528p pd=0.68u ps=0.68u
    I_MXI152_I39_MN2 (XI152_I39_n1 I152_pn2 ru2 VSS) gpdk090_nmos1v w=0.24u l=0.1u ad=0.0528p as=0.0528p pd=0.68u ps=0.68u
    I_MXI152_I39_MN3 (VSS XI152_I39_Bn XI152_I39_n1 VSS) gpdk090_nmos1v w=0.24u l=0.1u ad=0.0816p as=0.0528p pd=1.16u ps=0.68u
    I_MXI152_I39_MN0 (XI152_I39_An I152_pn2 VSS VSS) gpdk090_nmos1v w=0.12u l=0.1u ad=0.0696p as=0.0696p pd=1.16u ps=1.16u
    I_MXI152_I38_MN1 (XI152_I38_Bn I152_G0_0 VSS VSS) gpdk090_nmos1v w=0.12u l=0.1u ad=0.0696p as=0.0696p pd=1.16u ps=1.16u
    I_MXI152_I38_MN5 (XI152_I38_n2 I152_G0_0 VSS VSS) gpdk090_nmos1v w=0.24u l=0.1u ad=0.0528p as=0.0816p pd=0.68u ps=1.16u
    I_MXI152_I38_MN4 (ru1 XI152_I38_An XI152_I38_n2 VSS) gpdk090_nmos1v w=0.24u l=0.1u ad=0.0528p as=0.0528p pd=0.68u ps=0.68u
    I_MXI152_I38_MN2 (XI152_I38_n1 I152_pn1 ru1 VSS) gpdk090_nmos1v w=0.24u l=0.1u ad=0.0528p as=0.0528p pd=0.68u ps=0.68u
    I_MXI152_I38_MN3 (VSS XI152_I38_Bn XI152_I38_n1 VSS) gpdk090_nmos1v w=0.24u l=0.1u ad=0.0816p as=0.0528p pd=1.16u ps=0.68u
    I_MXI152_I38_MN0 (XI152_I38_An I152_pn1 VSS VSS) gpdk090_nmos1v w=0.12u l=0.1u ad=0.0696p as=0.0696p pd=1.16u ps=1.16u
    I_MXI175_MN1 (XI175_Bn nrkn1 VSS VSS) gpdk090_nmos1v w=0.12u l=0.1u ad=0.0696p as=0.0696p pd=1.16u ps=1.16u
    I_MXI175_MN5 (XI175_n2 nrkn1 VSS VSS) gpdk090_nmos1v w=0.24u l=0.1u ad=0.0528p as=0.0816p pd=0.68u ps=1.16u
    I_MXI175_MN4 (R_1 XI175_An XI175_n2 VSS) gpdk090_nmos1v w=0.24u l=0.1u ad=0.0528p as=0.0528p pd=0.68u ps=0.68u
    I_MXI175_MN2 (XI175_n1 ru1 R_1 VSS) gpdk090_nmos1v w=0.24u l=0.1u ad=0.0528p as=0.0528p pd=0.68u ps=0.68u
    I_MXI175_MN3 (VSS XI175_Bn XI175_n1 VSS) gpdk090_nmos1v w=0.24u l=0.1u ad=0.0816p as=0.0528p pd=1.16u ps=0.68u
    I_MXI175_MN0 (XI175_An ru1 VSS VSS) gpdk090_nmos1v w=0.12u l=0.1u ad=0.0696p as=0.0696p pd=1.16u ps=1.16u
    I_MXI152_I37_MN1 (XI152_I37_Bn VSS VSS VSS) gpdk090_nmos1v w=0.12u l=0.1u ad=0.0696p as=0.0696p pd=1.16u ps=1.16u
    I_MXI152_I37_MN5 (XI152_I37_n2 VSS VSS VSS) gpdk090_nmos1v w=0.24u l=0.1u ad=0.0528p as=0.0816p pd=0.68u ps=1.16u
    I_MXI152_I37_MN4 (R_0 XI152_I37_An XI152_I37_n2 VSS) gpdk090_nmos1v w=0.24u l=0.1u ad=0.0528p as=0.0528p pd=0.68u ps=0.68u
    I_MXI152_I37_MN2 (XI152_I37_n1 I152_pn0 R_0 VSS) gpdk090_nmos1v w=0.24u l=0.1u ad=0.0528p as=0.0528p pd=0.68u ps=0.68u
    I_MXI152_I37_MN3 (VSS XI152_I37_Bn XI152_I37_n1 VSS) gpdk090_nmos1v w=0.24u l=0.1u ad=0.0816p as=0.0528p pd=1.16u ps=0.68u
    I_MXI152_I37_MN0 (XI152_I37_An I152_pn0 VSS VSS) gpdk090_nmos1v w=0.12u l=0.1u ad=0.0696p as=0.0696p pd=1.16u ps=1.16u
    I_MXI24_MN1 (XI24_Bn nbkn2 VSS VSS) gpdk090_nmos1v w=0.12u l=0.1u ad=0.0696p as=0.0696p pd=1.16u ps=1.16u
    I_MXI24_MN5 (XI24_n2 nbkn2 VSS VSS) gpdk090_nmos1v w=0.24u l=0.1u ad=0.0528p as=0.0816p pd=0.68u ps=1.16u
    I_MXI24_MN4 (dd2 XI24_An XI24_n2 VSS) gpdk090_nmos1v w=0.24u l=0.1u ad=0.0528p as=0.0528p pd=0.68u ps=0.68u
    I_MXI24_MN2 (XI24_n1 B_2 dd2 VSS) gpdk090_nmos1v w=0.24u l=0.1u ad=0.0528p as=0.0528p pd=0.68u ps=0.68u
    I_MXI24_MN3 (VSS XI24_Bn XI24_n1 VSS) gpdk090_nmos1v w=0.24u l=0.1u ad=0.0816p as=0.0528p pd=1.16u ps=0.68u
    I_MXI24_MN0 (XI24_An B_2 VSS VSS) gpdk090_nmos1v w=0.12u l=0.1u ad=0.0696p as=0.0696p pd=1.16u ps=1.16u
    I_MXI173_MN1 (XI173_Bn nqkn7 VSS VSS) gpdk090_nmos1v w=0.12u l=0.1u ad=0.0696p as=0.0696p pd=1.16u ps=1.16u
    I_MXI173_MN5 (XI173_n2 nqkn7 VSS VSS) gpdk090_nmos1v w=0.24u l=0.1u ad=0.0528p as=0.0816p pd=0.68u ps=1.16u
    I_MXI173_MN4 (Q_7 XI173_An XI173_n2 VSS) gpdk090_nmos1v w=0.24u l=0.1u ad=0.0528p as=0.0528p pd=0.68u ps=0.68u
    I_MXI173_MN2 (XI173_n1 qu7 Q_7 VSS) gpdk090_nmos1v w=0.24u l=0.1u ad=0.0528p as=0.0528p pd=0.68u ps=0.68u
    I_MXI173_MN3 (VSS XI173_Bn XI173_n1 VSS) gpdk090_nmos1v w=0.24u l=0.1u ad=0.0816p as=0.0528p pd=1.16u ps=0.68u
    I_MXI173_MN0 (XI173_An qu7 VSS VSS) gpdk090_nmos1v w=0.12u l=0.1u ad=0.0696p as=0.0696p pd=1.16u ps=1.16u
    I_MXI13_MN1 (XI13_Bn nakn5 VSS VSS) gpdk090_nmos1v w=0.12u l=0.1u ad=0.0696p as=0.0696p pd=1.16u ps=1.16u
    I_MXI13_MN5 (XI13_n2 nakn5 VSS VSS) gpdk090_nmos1v w=0.24u l=0.1u ad=0.0528p as=0.0816p pd=0.68u ps=1.16u
    I_MXI13_MN4 (aa5 XI13_An XI13_n2 VSS) gpdk090_nmos1v w=0.24u l=0.1u ad=0.0528p as=0.0528p pd=0.68u ps=0.68u
    I_MXI13_MN2 (XI13_n1 A_5 aa5 VSS) gpdk090_nmos1v w=0.24u l=0.1u ad=0.0528p as=0.0528p pd=0.68u ps=0.68u
    I_MXI13_MN3 (VSS XI13_Bn XI13_n1 VSS) gpdk090_nmos1v w=0.24u l=0.1u ad=0.0816p as=0.0528p pd=1.16u ps=0.68u
    I_MXI13_MN0 (XI13_An A_5 VSS VSS) gpdk090_nmos1v w=0.12u l=0.1u ad=0.0696p as=0.0696p pd=1.16u ps=1.16u
    I_MXI72_I8_MN1 (XI72_I8_Bn b2_0 VSS VSS) gpdk090_nmos1v w=0.12u l=0.1u ad=0.0696p as=0.0696p pd=1.16u ps=1.16u
    I_MXI72_I8_MN5 (XI72_I8_n2 b2_0 VSS VSS) gpdk090_nmos1v w=0.24u l=0.1u ad=0.0528p as=0.0816p pd=0.68u ps=1.16u
    I_MXI72_I8_MN4 (I72_pn0 XI72_I8_An XI72_I8_n2 VSS) gpdk090_nmos1v w=0.24u l=0.1u ad=0.0528p as=0.0528p pd=0.68u ps=0.68u
    I_MXI72_I8_MN2 (XI72_I8_n1 aa5 I72_pn0 VSS) gpdk090_nmos1v w=0.24u l=0.1u ad=0.0528p as=0.0528p pd=0.68u ps=0.68u
    I_MXI72_I8_MN3 (VSS XI72_I8_Bn XI72_I8_n1 VSS) gpdk090_nmos1v w=0.24u l=0.1u ad=0.0816p as=0.0528p pd=1.16u ps=0.68u
    I_MXI72_I8_MN0 (XI72_I8_An aa5 VSS VSS) gpdk090_nmos1v w=0.12u l=0.1u ad=0.0696p as=0.0696p pd=1.16u ps=1.16u
    I_MXI72_I38_MN1 (XI72_I38_Bn I72_G0_0 VSS VSS) gpdk090_nmos1v w=0.12u l=0.1u ad=0.0696p as=0.0696p pd=1.16u ps=1.16u
    I_MXI72_I38_MN5 (XI72_I38_n2 I72_G0_0 VSS VSS) gpdk090_nmos1v w=0.24u l=0.1u ad=0.0528p as=0.0816p pd=0.68u ps=1.16u
    I_MXI72_I38_MN4 (p2_1 XI72_I38_An XI72_I38_n2 VSS) gpdk090_nmos1v w=0.24u l=0.1u ad=0.0528p as=0.0528p pd=0.68u ps=0.68u
    I_MXI72_I38_MN2 (XI72_I38_n1 I72_pn1 p2_1 VSS) gpdk090_nmos1v w=0.24u l=0.1u ad=0.0528p as=0.0528p pd=0.68u ps=0.68u
    I_MXI72_I38_MN3 (VSS XI72_I38_Bn XI72_I38_n1 VSS) gpdk090_nmos1v w=0.24u l=0.1u ad=0.0816p as=0.0528p pd=1.16u ps=0.68u
    I_MXI72_I38_MN0 (XI72_I38_An I72_pn1 VSS VSS) gpdk090_nmos1v w=0.12u l=0.1u ad=0.0696p as=0.0696p pd=1.16u ps=1.16u
    I_MXI84_I11_MN1 (XI84_I11_Bn b3_3 VSS VSS) gpdk090_nmos1v w=0.12u l=0.1u ad=0.0696p as=0.0696p pd=1.16u ps=1.16u
    I_MXI84_I11_MN5 (XI84_I11_n2 b3_3 VSS VSS) gpdk090_nmos1v w=0.24u l=0.1u ad=0.0528p as=0.0816p pd=0.68u ps=1.16u
    I_MXI84_I11_MN4 (I84_pn3 XI84_I11_An XI84_I11_n2 VSS) gpdk090_nmos1v w=0.24u l=0.1u ad=0.0528p as=0.0528p pd=0.68u ps=0.68u
    I_MXI84_I11_MN2 (XI84_I11_n1 p2_2 I84_pn3 VSS) gpdk090_nmos1v w=0.24u l=0.1u ad=0.0528p as=0.0528p pd=0.68u ps=0.68u
    I_MXI84_I11_MN3 (VSS XI84_I11_Bn XI84_I11_n1 VSS) gpdk090_nmos1v w=0.24u l=0.1u ad=0.0816p as=0.0528p pd=1.16u ps=0.68u
    I_MXI84_I11_MN0 (XI84_I11_An p2_2 VSS VSS) gpdk090_nmos1v w=0.12u l=0.1u ad=0.0696p as=0.0696p pd=1.16u ps=1.16u
    I_MXI190_MN1 (XI190_Bn nrkn6 VSS VSS) gpdk090_nmos1v w=0.12u l=0.1u ad=0.0696p as=0.0696p pd=1.16u ps=1.16u
    I_MXI190_MN5 (XI190_n2 nrkn6 VSS VSS) gpdk090_nmos1v w=0.24u l=0.1u ad=0.0528p as=0.0816p pd=0.68u ps=1.16u
    I_MXI190_MN4 (R_6 XI190_An XI190_n2 VSS) gpdk090_nmos1v w=0.24u l=0.1u ad=0.0528p as=0.0528p pd=0.68u ps=0.68u
    I_MXI190_MN2 (XI190_n1 ru6 R_6 VSS) gpdk090_nmos1v w=0.24u l=0.1u ad=0.0528p as=0.0528p pd=0.68u ps=0.68u
    I_MXI190_MN3 (VSS XI190_Bn XI190_n1 VSS) gpdk090_nmos1v w=0.24u l=0.1u ad=0.0816p as=0.0528p pd=1.16u ps=0.68u
    I_MXI190_MN0 (XI190_An ru6 VSS VSS) gpdk090_nmos1v w=0.12u l=0.1u ad=0.0696p as=0.0696p pd=1.16u ps=1.16u
    I_MXI184_MN1 (XI184_Bn nrkn4 VSS VSS) gpdk090_nmos1v w=0.12u l=0.1u ad=0.0696p as=0.0696p pd=1.16u ps=1.16u
    I_MXI184_MN5 (XI184_n2 nrkn4 VSS VSS) gpdk090_nmos1v w=0.24u l=0.1u ad=0.0528p as=0.0816p pd=0.68u ps=1.16u
    I_MXI184_MN4 (R_4 XI184_An XI184_n2 VSS) gpdk090_nmos1v w=0.24u l=0.1u ad=0.0528p as=0.0528p pd=0.68u ps=0.68u
    I_MXI184_MN2 (XI184_n1 ru4 R_4 VSS) gpdk090_nmos1v w=0.24u l=0.1u ad=0.0528p as=0.0528p pd=0.68u ps=0.68u
    I_MXI184_MN3 (VSS XI184_Bn XI184_n1 VSS) gpdk090_nmos1v w=0.24u l=0.1u ad=0.0816p as=0.0528p pd=1.16u ps=0.68u
    I_MXI184_MN0 (XI184_An ru4 VSS VSS) gpdk090_nmos1v w=0.12u l=0.1u ad=0.0696p as=0.0696p pd=1.16u ps=1.16u
    I_MXI178_MN1 (XI178_Bn nrkn2 VSS VSS) gpdk090_nmos1v w=0.12u l=0.1u ad=0.0696p as=0.0696p pd=1.16u ps=1.16u
    I_MXI178_MN5 (XI178_n2 nrkn2 VSS VSS) gpdk090_nmos1v w=0.24u l=0.1u ad=0.0528p as=0.0816p pd=0.68u ps=1.16u
    I_MXI178_MN4 (R_2 XI178_An XI178_n2 VSS) gpdk090_nmos1v w=0.24u l=0.1u ad=0.0528p as=0.0528p pd=0.68u ps=0.68u
    I_MXI178_MN2 (XI178_n1 ru2 R_2 VSS) gpdk090_nmos1v w=0.24u l=0.1u ad=0.0528p as=0.0528p pd=0.68u ps=0.68u
    I_MXI178_MN3 (VSS XI178_Bn XI178_n1 VSS) gpdk090_nmos1v w=0.24u l=0.1u ad=0.0816p as=0.0528p pd=1.16u ps=0.68u
    I_MXI178_MN0 (XI178_An ru2 VSS VSS) gpdk090_nmos1v w=0.12u l=0.1u ad=0.0696p as=0.0696p pd=1.16u ps=1.16u
    I_MXI27_MN1 (XI27_Bn nbkn3 VSS VSS) gpdk090_nmos1v w=0.12u l=0.1u ad=0.0696p as=0.0696p pd=1.16u ps=1.16u
    I_MXI27_MN5 (XI27_n2 nbkn3 VSS VSS) gpdk090_nmos1v w=0.24u l=0.1u ad=0.0528p as=0.0816p pd=0.68u ps=1.16u
    I_MXI27_MN4 (dd3 XI27_An XI27_n2 VSS) gpdk090_nmos1v w=0.24u l=0.1u ad=0.0528p as=0.0528p pd=0.68u ps=0.68u
    I_MXI27_MN2 (XI27_n1 B_3 dd3 VSS) gpdk090_nmos1v w=0.24u l=0.1u ad=0.0528p as=0.0528p pd=0.68u ps=0.68u
    I_MXI27_MN3 (VSS XI27_Bn XI27_n1 VSS) gpdk090_nmos1v w=0.24u l=0.1u ad=0.0816p as=0.0528p pd=1.16u ps=0.68u
    I_MXI27_MN0 (XI27_An B_3 VSS VSS) gpdk090_nmos1v w=0.12u l=0.1u ad=0.0696p as=0.0696p pd=1.16u ps=1.16u
    I_MXI30_MN1 (XI30_Bn nbkn4 VSS VSS) gpdk090_nmos1v w=0.12u l=0.1u ad=0.0696p as=0.0696p pd=1.16u ps=1.16u
    I_MXI30_MN5 (XI30_n2 nbkn4 VSS VSS) gpdk090_nmos1v w=0.24u l=0.1u ad=0.0528p as=0.0816p pd=0.68u ps=1.16u
    I_MXI30_MN4 (dd4 XI30_An XI30_n2 VSS) gpdk090_nmos1v w=0.24u l=0.1u ad=0.0528p as=0.0528p pd=0.68u ps=0.68u
    I_MXI30_MN2 (XI30_n1 B_4 dd4 VSS) gpdk090_nmos1v w=0.24u l=0.1u ad=0.0528p as=0.0528p pd=0.68u ps=0.68u
    I_MXI30_MN3 (VSS XI30_Bn XI30_n1 VSS) gpdk090_nmos1v w=0.24u l=0.1u ad=0.0816p as=0.0528p pd=1.16u ps=0.68u
    I_MXI30_MN0 (XI30_An B_4 VSS VSS) gpdk090_nmos1v w=0.12u l=0.1u ad=0.0696p as=0.0696p pd=1.16u ps=1.16u
    I_MXI48_I8_MN1 (XI48_I8_Bn b0_0 VSS VSS) gpdk090_nmos1v w=0.12u l=0.1u ad=0.0696p as=0.0696p pd=1.16u ps=1.16u
    I_MXI48_I8_MN5 (XI48_I8_n2 b0_0 VSS VSS) gpdk090_nmos1v w=0.24u l=0.1u ad=0.0528p as=0.0816p pd=0.68u ps=1.16u
    I_MXI48_I8_MN4 (I48_pn0 XI48_I8_An XI48_I8_n2 VSS) gpdk090_nmos1v w=0.24u l=0.1u ad=0.0528p as=0.0528p pd=0.68u ps=0.68u
    I_MXI48_I8_MN2 (XI48_I8_n1 aa7 I48_pn0 VSS) gpdk090_nmos1v w=0.24u l=0.1u ad=0.0528p as=0.0528p pd=0.68u ps=0.68u
    I_MXI48_I8_MN3 (VSS XI48_I8_Bn XI48_I8_n1 VSS) gpdk090_nmos1v w=0.24u l=0.1u ad=0.0816p as=0.0528p pd=1.16u ps=0.68u
    I_MXI48_I8_MN0 (XI48_I8_An aa7 VSS VSS) gpdk090_nmos1v w=0.12u l=0.1u ad=0.0696p as=0.0696p pd=1.16u ps=1.16u
    I_MXI19_MN1 (XI19_Bn nakn7 VSS VSS) gpdk090_nmos1v w=0.12u l=0.1u ad=0.0696p as=0.0696p pd=1.16u ps=1.16u
    I_MXI19_MN5 (XI19_n2 nakn7 VSS VSS) gpdk090_nmos1v w=0.24u l=0.1u ad=0.0528p as=0.0816p pd=0.68u ps=1.16u
    I_MXI19_MN4 (aa7 XI19_An XI19_n2 VSS) gpdk090_nmos1v w=0.24u l=0.1u ad=0.0528p as=0.0528p pd=0.68u ps=0.68u
    I_MXI19_MN2 (XI19_n1 A_7 aa7 VSS) gpdk090_nmos1v w=0.24u l=0.1u ad=0.0528p as=0.0528p pd=0.68u ps=0.68u
    I_MXI19_MN3 (VSS XI19_Bn XI19_n1 VSS) gpdk090_nmos1v w=0.24u l=0.1u ad=0.0816p as=0.0528p pd=1.16u ps=0.68u
    I_MXI19_MN0 (XI19_An A_7 VSS VSS) gpdk090_nmos1v w=0.12u l=0.1u ad=0.0696p as=0.0696p pd=1.16u ps=1.16u
    I_MXI16_MN1 (XI16_Bn nakn6 VSS VSS) gpdk090_nmos1v w=0.12u l=0.1u ad=0.0696p as=0.0696p pd=1.16u ps=1.16u
    I_MXI16_MN5 (XI16_n2 nakn6 VSS VSS) gpdk090_nmos1v w=0.24u l=0.1u ad=0.0528p as=0.0816p pd=0.68u ps=1.16u
    I_MXI16_MN4 (aa6 XI16_An XI16_n2 VSS) gpdk090_nmos1v w=0.24u l=0.1u ad=0.0528p as=0.0528p pd=0.68u ps=0.68u
    I_MXI16_MN2 (XI16_n1 A_6 aa6 VSS) gpdk090_nmos1v w=0.24u l=0.1u ad=0.0528p as=0.0528p pd=0.68u ps=0.68u
    I_MXI16_MN3 (VSS XI16_Bn XI16_n1 VSS) gpdk090_nmos1v w=0.24u l=0.1u ad=0.0816p as=0.0528p pd=1.16u ps=0.68u
    I_MXI16_MN0 (XI16_An A_6 VSS VSS) gpdk090_nmos1v w=0.12u l=0.1u ad=0.0696p as=0.0696p pd=1.16u ps=1.16u
    I_MXI60_I37_MN1 (XI60_I37_Bn qu7 VSS VSS) gpdk090_nmos1v w=0.12u l=0.1u ad=0.0696p as=0.0696p pd=1.16u ps=1.16u
    I_MXI60_I37_MN5 (XI60_I37_n2 qu7 VSS VSS) gpdk090_nmos1v w=0.24u l=0.1u ad=0.0528p as=0.0816p pd=0.68u ps=1.16u
    I_MXI60_I37_MN4 (p1_0 XI60_I37_An XI60_I37_n2 VSS) gpdk090_nmos1v w=0.24u l=0.1u ad=0.0528p as=0.0528p pd=0.68u ps=0.68u
    I_MXI60_I37_MN2 (XI60_I37_n1 I60_pn0 p1_0 VSS) gpdk090_nmos1v w=0.24u l=0.1u ad=0.0528p as=0.0528p pd=0.68u ps=0.68u
    I_MXI60_I37_MN3 (VSS XI60_I37_Bn XI60_I37_n1 VSS) gpdk090_nmos1v w=0.24u l=0.1u ad=0.0816p as=0.0528p pd=1.16u ps=0.68u
    I_MXI60_I37_MN0 (XI60_I37_An I60_pn0 VSS VSS) gpdk090_nmos1v w=0.12u l=0.1u ad=0.0696p as=0.0696p pd=1.16u ps=1.16u
    I_MXI60_I8_MN1 (XI60_I8_Bn b1_0 VSS VSS) gpdk090_nmos1v w=0.12u l=0.1u ad=0.0696p as=0.0696p pd=1.16u ps=1.16u
    I_MXI60_I8_MN5 (XI60_I8_n2 b1_0 VSS VSS) gpdk090_nmos1v w=0.24u l=0.1u ad=0.0528p as=0.0816p pd=0.68u ps=1.16u
    I_MXI60_I8_MN4 (I60_pn0 XI60_I8_An XI60_I8_n2 VSS) gpdk090_nmos1v w=0.24u l=0.1u ad=0.0528p as=0.0528p pd=0.68u ps=0.68u
    I_MXI60_I8_MN2 (XI60_I8_n1 aa6 I60_pn0 VSS) gpdk090_nmos1v w=0.24u l=0.1u ad=0.0528p as=0.0528p pd=0.68u ps=0.68u
    I_MXI60_I8_MN3 (VSS XI60_I8_Bn XI60_I8_n1 VSS) gpdk090_nmos1v w=0.24u l=0.1u ad=0.0816p as=0.0528p pd=1.16u ps=0.68u
    I_MXI60_I8_MN0 (XI60_I8_An aa6 VSS VSS) gpdk090_nmos1v w=0.12u l=0.1u ad=0.0696p as=0.0696p pd=1.16u ps=1.16u
    I_MXI72_I9_MN1 (XI72_I9_Bn b2_1 VSS VSS) gpdk090_nmos1v w=0.12u l=0.1u ad=0.0696p as=0.0696p pd=1.16u ps=1.16u
    I_MXI72_I9_MN5 (XI72_I9_n2 b2_1 VSS VSS) gpdk090_nmos1v w=0.24u l=0.1u ad=0.0528p as=0.0816p pd=0.68u ps=1.16u
    I_MXI72_I9_MN4 (I72_pn1 XI72_I9_An XI72_I9_n2 VSS) gpdk090_nmos1v w=0.24u l=0.1u ad=0.0528p as=0.0528p pd=0.68u ps=0.68u
    I_MXI72_I9_MN2 (XI72_I9_n1 p1_0 I72_pn1 VSS) gpdk090_nmos1v w=0.24u l=0.1u ad=0.0528p as=0.0528p pd=0.68u ps=0.68u
    I_MXI72_I9_MN3 (VSS XI72_I9_Bn XI72_I9_n1 VSS) gpdk090_nmos1v w=0.24u l=0.1u ad=0.0816p as=0.0528p pd=1.16u ps=0.68u
    I_MXI72_I9_MN0 (XI72_I9_An p1_0 VSS VSS) gpdk090_nmos1v w=0.12u l=0.1u ad=0.0696p as=0.0696p pd=1.16u ps=1.16u
    I_MXI84_I12_MN1 (XI84_I12_Bn b3_4 VSS VSS) gpdk090_nmos1v w=0.12u l=0.1u ad=0.0696p as=0.0696p pd=1.16u ps=1.16u
    I_MXI84_I12_MN5 (XI84_I12_n2 b3_4 VSS VSS) gpdk090_nmos1v w=0.24u l=0.1u ad=0.0528p as=0.0816p pd=0.68u ps=1.16u
    I_MXI84_I12_MN4 (I84_pn4 XI84_I12_An XI84_I12_n2 VSS) gpdk090_nmos1v w=0.24u l=0.1u ad=0.0528p as=0.0528p pd=0.68u ps=0.68u
    I_MXI84_I12_MN2 (XI84_I12_n1 p2_3 I84_pn4 VSS) gpdk090_nmos1v w=0.24u l=0.1u ad=0.0528p as=0.0528p pd=0.68u ps=0.68u
    I_MXI84_I12_MN3 (VSS XI84_I12_Bn XI84_I12_n1 VSS) gpdk090_nmos1v w=0.24u l=0.1u ad=0.0816p as=0.0528p pd=1.16u ps=0.68u
    I_MXI84_I12_MN0 (XI84_I12_An p2_3 VSS VSS) gpdk090_nmos1v w=0.12u l=0.1u ad=0.0696p as=0.0696p pd=1.16u ps=1.16u
    I_MXI187_MN1 (XI187_Bn nrkn5 VSS VSS) gpdk090_nmos1v w=0.12u l=0.1u ad=0.0696p as=0.0696p pd=1.16u ps=1.16u
    I_MXI187_MN5 (XI187_n2 nrkn5 VSS VSS) gpdk090_nmos1v w=0.24u l=0.1u ad=0.0528p as=0.0816p pd=0.68u ps=1.16u
    I_MXI187_MN4 (R_5 XI187_An XI187_n2 VSS) gpdk090_nmos1v w=0.24u l=0.1u ad=0.0528p as=0.0528p pd=0.68u ps=0.68u
    I_MXI187_MN2 (XI187_n1 ru5 R_5 VSS) gpdk090_nmos1v w=0.24u l=0.1u ad=0.0528p as=0.0528p pd=0.68u ps=0.68u
    I_MXI187_MN3 (VSS XI187_Bn XI187_n1 VSS) gpdk090_nmos1v w=0.24u l=0.1u ad=0.0816p as=0.0528p pd=1.16u ps=0.68u
    I_MXI187_MN0 (XI187_An ru5 VSS VSS) gpdk090_nmos1v w=0.12u l=0.1u ad=0.0696p as=0.0696p pd=1.16u ps=1.16u
    I_MXI181_MN1 (XI181_Bn nrkn3 VSS VSS) gpdk090_nmos1v w=0.12u l=0.1u ad=0.0696p as=0.0696p pd=1.16u ps=1.16u
    I_MXI181_MN5 (XI181_n2 nrkn3 VSS VSS) gpdk090_nmos1v w=0.24u l=0.1u ad=0.0528p as=0.0816p pd=0.68u ps=1.16u
    I_MXI181_MN4 (R_3 XI181_An XI181_n2 VSS) gpdk090_nmos1v w=0.24u l=0.1u ad=0.0528p as=0.0528p pd=0.68u ps=0.68u
    I_MXI181_MN2 (XI181_n1 ru3 R_3 VSS) gpdk090_nmos1v w=0.24u l=0.1u ad=0.0528p as=0.0528p pd=0.68u ps=0.68u
    I_MXI181_MN3 (VSS XI181_Bn XI181_n1 VSS) gpdk090_nmos1v w=0.24u l=0.1u ad=0.0816p as=0.0528p pd=1.16u ps=0.68u
    I_MXI181_MN0 (XI181_An ru3 VSS VSS) gpdk090_nmos1v w=0.12u l=0.1u ad=0.0696p as=0.0696p pd=1.16u ps=1.16u
    I_MXI48_I11_MN1 (XI48_I11_Bn b0_3 VSS VSS) gpdk090_nmos1v w=0.12u l=0.1u ad=0.0696p as=0.0696p pd=1.16u ps=1.16u
    I_MXI48_I11_MN5 (XI48_I11_n2 b0_3 VSS VSS) gpdk090_nmos1v w=0.24u l=0.1u ad=0.0528p as=0.0816p pd=0.68u ps=1.16u
    I_MXI48_I11_MN4 (I48_pn3 XI48_I11_An XI48_I11_n2 VSS) gpdk090_nmos1v w=0.24u l=0.1u ad=0.0528p as=0.0528p pd=0.68u ps=0.68u
    I_MXI48_I11_MN2 (XI48_I11_n1 VSS I48_pn3 VSS) gpdk090_nmos1v w=0.24u l=0.1u ad=0.0528p as=0.0528p pd=0.68u ps=0.68u
    I_MXI48_I11_MN3 (VSS XI48_I11_Bn XI48_I11_n1 VSS) gpdk090_nmos1v w=0.24u l=0.1u ad=0.0816p as=0.0528p pd=1.16u ps=0.68u
    I_MXI48_I11_MN0 (XI48_I11_An VSS VSS VSS) gpdk090_nmos1v w=0.12u l=0.1u ad=0.0696p as=0.0696p pd=1.16u ps=1.16u
    I_MXI48_I10_MN1 (XI48_I10_Bn b0_2 VSS VSS) gpdk090_nmos1v w=0.12u l=0.1u ad=0.0696p as=0.0696p pd=1.16u ps=1.16u
    I_MXI48_I10_MN5 (XI48_I10_n2 b0_2 VSS VSS) gpdk090_nmos1v w=0.24u l=0.1u ad=0.0528p as=0.0816p pd=0.68u ps=1.16u
    I_MXI48_I10_MN4 (I48_pn2 XI48_I10_An XI48_I10_n2 VSS) gpdk090_nmos1v w=0.24u l=0.1u ad=0.0528p as=0.0528p pd=0.68u ps=0.68u
    I_MXI48_I10_MN2 (XI48_I10_n1 VSS I48_pn2 VSS) gpdk090_nmos1v w=0.24u l=0.1u ad=0.0528p as=0.0528p pd=0.68u ps=0.68u
    I_MXI48_I10_MN3 (VSS XI48_I10_Bn XI48_I10_n1 VSS) gpdk090_nmos1v w=0.24u l=0.1u ad=0.0816p as=0.0528p pd=1.16u ps=0.68u
    I_MXI48_I10_MN0 (XI48_I10_An VSS VSS VSS) gpdk090_nmos1v w=0.12u l=0.1u ad=0.0696p as=0.0696p pd=1.16u ps=1.16u
    I_MXI48_I9_MN1 (XI48_I9_Bn b0_1 VSS VSS) gpdk090_nmos1v w=0.12u l=0.1u ad=0.0696p as=0.0696p pd=1.16u ps=1.16u
    I_MXI48_I9_MN5 (XI48_I9_n2 b0_1 VSS VSS) gpdk090_nmos1v w=0.24u l=0.1u ad=0.0528p as=0.0816p pd=0.68u ps=1.16u
    I_MXI48_I9_MN4 (I48_pn1 XI48_I9_An XI48_I9_n2 VSS) gpdk090_nmos1v w=0.24u l=0.1u ad=0.0528p as=0.0528p pd=0.68u ps=0.68u
    I_MXI48_I9_MN2 (XI48_I9_n1 VSS I48_pn1 VSS) gpdk090_nmos1v w=0.24u l=0.1u ad=0.0528p as=0.0528p pd=0.68u ps=0.68u
    I_MXI48_I9_MN3 (VSS XI48_I9_Bn XI48_I9_n1 VSS) gpdk090_nmos1v w=0.24u l=0.1u ad=0.0816p as=0.0528p pd=1.16u ps=0.68u
    I_MXI48_I9_MN0 (XI48_I9_An VSS VSS VSS) gpdk090_nmos1v w=0.12u l=0.1u ad=0.0696p as=0.0696p pd=1.16u ps=1.16u
    I_MXI48_I37_MN1 (XI48_I37_Bn VDD VSS VSS) gpdk090_nmos1v w=0.12u l=0.1u ad=0.0696p as=0.0696p pd=1.16u ps=1.16u
    I_MXI48_I37_MN5 (XI48_I37_n2 VDD VSS VSS) gpdk090_nmos1v w=0.24u l=0.1u ad=0.0528p as=0.0816p pd=0.68u ps=1.16u
    I_MXI48_I37_MN4 (p0_0 XI48_I37_An XI48_I37_n2 VSS) gpdk090_nmos1v w=0.24u l=0.1u ad=0.0528p as=0.0528p pd=0.68u ps=0.68u
    I_MXI48_I37_MN2 (XI48_I37_n1 I48_pn0 p0_0 VSS) gpdk090_nmos1v w=0.24u l=0.1u ad=0.0528p as=0.0528p pd=0.68u ps=0.68u
    I_MXI48_I37_MN3 (VSS XI48_I37_Bn XI48_I37_n1 VSS) gpdk090_nmos1v w=0.24u l=0.1u ad=0.0816p as=0.0528p pd=1.16u ps=0.68u
    I_MXI48_I37_MN0 (XI48_I37_An I48_pn0 VSS VSS) gpdk090_nmos1v w=0.12u l=0.1u ad=0.0696p as=0.0696p pd=1.16u ps=1.16u
    I_MXI60_I9_MN1 (XI60_I9_Bn b1_1 VSS VSS) gpdk090_nmos1v w=0.12u l=0.1u ad=0.0696p as=0.0696p pd=1.16u ps=1.16u
    I_MXI60_I9_MN5 (XI60_I9_n2 b1_1 VSS VSS) gpdk090_nmos1v w=0.24u l=0.1u ad=0.0528p as=0.0816p pd=0.68u ps=1.16u
    I_MXI60_I9_MN4 (I60_pn1 XI60_I9_An XI60_I9_n2 VSS) gpdk090_nmos1v w=0.24u l=0.1u ad=0.0528p as=0.0528p pd=0.68u ps=0.68u
    I_MXI60_I9_MN2 (XI60_I9_n1 p0_0 I60_pn1 VSS) gpdk090_nmos1v w=0.24u l=0.1u ad=0.0528p as=0.0528p pd=0.68u ps=0.68u
    I_MXI60_I9_MN3 (VSS XI60_I9_Bn XI60_I9_n1 VSS) gpdk090_nmos1v w=0.24u l=0.1u ad=0.0816p as=0.0528p pd=1.16u ps=0.68u
    I_MXI60_I9_MN0 (XI60_I9_An p0_0 VSS VSS) gpdk090_nmos1v w=0.12u l=0.1u ad=0.0696p as=0.0696p pd=1.16u ps=1.16u
    I_MXI60_I38_MN1 (XI60_I38_Bn I60_G0_0 VSS VSS) gpdk090_nmos1v w=0.12u l=0.1u ad=0.0696p as=0.0696p pd=1.16u ps=1.16u
    I_MXI60_I38_MN5 (XI60_I38_n2 I60_G0_0 VSS VSS) gpdk090_nmos1v w=0.24u l=0.1u ad=0.0528p as=0.0816p pd=0.68u ps=1.16u
    I_MXI60_I38_MN4 (p1_1 XI60_I38_An XI60_I38_n2 VSS) gpdk090_nmos1v w=0.24u l=0.1u ad=0.0528p as=0.0528p pd=0.68u ps=0.68u
    I_MXI60_I38_MN2 (XI60_I38_n1 I60_pn1 p1_1 VSS) gpdk090_nmos1v w=0.24u l=0.1u ad=0.0528p as=0.0528p pd=0.68u ps=0.68u
    I_MXI60_I38_MN3 (VSS XI60_I38_Bn XI60_I38_n1 VSS) gpdk090_nmos1v w=0.24u l=0.1u ad=0.0816p as=0.0528p pd=1.16u ps=0.68u
    I_MXI60_I38_MN0 (XI60_I38_An I60_pn1 VSS VSS) gpdk090_nmos1v w=0.12u l=0.1u ad=0.0696p as=0.0696p pd=1.16u ps=1.16u
    I_MXI72_I10_MN1 (XI72_I10_Bn b2_2 VSS VSS) gpdk090_nmos1v w=0.12u l=0.1u ad=0.0696p as=0.0696p pd=1.16u ps=1.16u
    I_MXI72_I10_MN5 (XI72_I10_n2 b2_2 VSS VSS) gpdk090_nmos1v w=0.24u l=0.1u ad=0.0528p as=0.0816p pd=0.68u ps=1.16u
    I_MXI72_I10_MN4 (I72_pn2 XI72_I10_An XI72_I10_n2 VSS) gpdk090_nmos1v w=0.24u l=0.1u ad=0.0528p as=0.0528p pd=0.68u ps=0.68u
    I_MXI72_I10_MN2 (XI72_I10_n1 p1_1 I72_pn2 VSS) gpdk090_nmos1v w=0.24u l=0.1u ad=0.0528p as=0.0528p pd=0.68u ps=0.68u
    I_MXI72_I10_MN3 (VSS XI72_I10_Bn XI72_I10_n1 VSS) gpdk090_nmos1v w=0.24u l=0.1u ad=0.0816p as=0.0528p pd=1.16u ps=0.68u
    I_MXI72_I10_MN0 (XI72_I10_An p1_1 VSS VSS) gpdk090_nmos1v w=0.12u l=0.1u ad=0.0696p as=0.0696p pd=1.16u ps=1.16u
    I_MXI72_I39_MN1 (XI72_I39_Bn I72_G1_0 VSS VSS) gpdk090_nmos1v w=0.12u l=0.1u ad=0.0696p as=0.0696p pd=1.16u ps=1.16u
    I_MXI72_I39_MN5 (XI72_I39_n2 I72_G1_0 VSS VSS) gpdk090_nmos1v w=0.24u l=0.1u ad=0.0528p as=0.0816p pd=0.68u ps=1.16u
    I_MXI72_I39_MN4 (p2_2 XI72_I39_An XI72_I39_n2 VSS) gpdk090_nmos1v w=0.24u l=0.1u ad=0.0528p as=0.0528p pd=0.68u ps=0.68u
    I_MXI72_I39_MN2 (XI72_I39_n1 I72_pn2 p2_2 VSS) gpdk090_nmos1v w=0.24u l=0.1u ad=0.0528p as=0.0528p pd=0.68u ps=0.68u
    I_MXI72_I39_MN3 (VSS XI72_I39_Bn XI72_I39_n1 VSS) gpdk090_nmos1v w=0.24u l=0.1u ad=0.0816p as=0.0528p pd=1.16u ps=0.68u
    I_MXI72_I39_MN0 (XI72_I39_An I72_pn2 VSS VSS) gpdk090_nmos1v w=0.12u l=0.1u ad=0.0696p as=0.0696p pd=1.16u ps=1.16u
    I_MXI84_I13_MN1 (XI84_I13_Bn b3_5 VSS VSS) gpdk090_nmos1v w=0.12u l=0.1u ad=0.0696p as=0.0696p pd=1.16u ps=1.16u
    I_MXI84_I13_MN5 (XI84_I13_n2 b3_5 VSS VSS) gpdk090_nmos1v w=0.24u l=0.1u ad=0.0528p as=0.0816p pd=0.68u ps=1.16u
    I_MXI84_I13_MN4 (I84_pn5 XI84_I13_An XI84_I13_n2 VSS) gpdk090_nmos1v w=0.24u l=0.1u ad=0.0528p as=0.0528p pd=0.68u ps=0.68u
    I_MXI84_I13_MN2 (XI84_I13_n1 p2_4 I84_pn5 VSS) gpdk090_nmos1v w=0.24u l=0.1u ad=0.0528p as=0.0528p pd=0.68u ps=0.68u
    I_MXI84_I13_MN3 (VSS XI84_I13_Bn XI84_I13_n1 VSS) gpdk090_nmos1v w=0.24u l=0.1u ad=0.0816p as=0.0528p pd=1.16u ps=0.68u
    I_MXI84_I13_MN0 (XI84_I13_An p2_4 VSS VSS) gpdk090_nmos1v w=0.12u l=0.1u ad=0.0696p as=0.0696p pd=1.16u ps=1.16u
    I_MXI48_I12_MN1 (XI48_I12_Bn b0_4 VSS VSS) gpdk090_nmos1v w=0.12u l=0.1u ad=0.0696p as=0.0696p pd=1.16u ps=1.16u
    I_MXI48_I12_MN5 (XI48_I12_n2 b0_4 VSS VSS) gpdk090_nmos1v w=0.24u l=0.1u ad=0.0528p as=0.0816p pd=0.68u ps=1.16u
    I_MXI48_I12_MN4 (I48_pn4 XI48_I12_An XI48_I12_n2 VSS) gpdk090_nmos1v w=0.24u l=0.1u ad=0.0528p as=0.0528p pd=0.68u ps=0.68u
    I_MXI48_I12_MN2 (XI48_I12_n1 VSS I48_pn4 VSS) gpdk090_nmos1v w=0.24u l=0.1u ad=0.0528p as=0.0528p pd=0.68u ps=0.68u
    I_MXI48_I12_MN3 (VSS XI48_I12_Bn XI48_I12_n1 VSS) gpdk090_nmos1v w=0.24u l=0.1u ad=0.0816p as=0.0528p pd=1.16u ps=0.68u
    I_MXI48_I12_MN0 (XI48_I12_An VSS VSS VSS) gpdk090_nmos1v w=0.12u l=0.1u ad=0.0696p as=0.0696p pd=1.16u ps=1.16u
    I_MXI48_I38_MN1 (XI48_I38_Bn I48_G0_0 VSS VSS) gpdk090_nmos1v w=0.12u l=0.1u ad=0.0696p as=0.0696p pd=1.16u ps=1.16u
    I_MXI48_I38_MN5 (XI48_I38_n2 I48_G0_0 VSS VSS) gpdk090_nmos1v w=0.24u l=0.1u ad=0.0528p as=0.0816p pd=0.68u ps=1.16u
    I_MXI48_I38_MN4 (p0_1 XI48_I38_An XI48_I38_n2 VSS) gpdk090_nmos1v w=0.24u l=0.1u ad=0.0528p as=0.0528p pd=0.68u ps=0.68u
    I_MXI48_I38_MN2 (XI48_I38_n1 I48_pn1 p0_1 VSS) gpdk090_nmos1v w=0.24u l=0.1u ad=0.0528p as=0.0528p pd=0.68u ps=0.68u
    I_MXI48_I38_MN3 (VSS XI48_I38_Bn XI48_I38_n1 VSS) gpdk090_nmos1v w=0.24u l=0.1u ad=0.0816p as=0.0528p pd=1.16u ps=0.68u
    I_MXI48_I38_MN0 (XI48_I38_An I48_pn1 VSS VSS) gpdk090_nmos1v w=0.12u l=0.1u ad=0.0696p as=0.0696p pd=1.16u ps=1.16u
    I_MXI60_I11_MN1 (XI60_I11_Bn b1_3 VSS VSS) gpdk090_nmos1v w=0.12u l=0.1u ad=0.0696p as=0.0696p pd=1.16u ps=1.16u
    I_MXI60_I11_MN5 (XI60_I11_n2 b1_3 VSS VSS) gpdk090_nmos1v w=0.24u l=0.1u ad=0.0528p as=0.0816p pd=0.68u ps=1.16u
    I_MXI60_I11_MN4 (I60_pn3 XI60_I11_An XI60_I11_n2 VSS) gpdk090_nmos1v w=0.24u l=0.1u ad=0.0528p as=0.0528p pd=0.68u ps=0.68u
    I_MXI60_I11_MN2 (XI60_I11_n1 p0_2 I60_pn3 VSS) gpdk090_nmos1v w=0.24u l=0.1u ad=0.0528p as=0.0528p pd=0.68u ps=0.68u
    I_MXI60_I11_MN3 (VSS XI60_I11_Bn XI60_I11_n1 VSS) gpdk090_nmos1v w=0.24u l=0.1u ad=0.0816p as=0.0528p pd=1.16u ps=0.68u
    I_MXI60_I11_MN0 (XI60_I11_An p0_2 VSS VSS) gpdk090_nmos1v w=0.12u l=0.1u ad=0.0696p as=0.0696p pd=1.16u ps=1.16u
    I_MXI60_I10_MN1 (XI60_I10_Bn b1_2 VSS VSS) gpdk090_nmos1v w=0.12u l=0.1u ad=0.0696p as=0.0696p pd=1.16u ps=1.16u
    I_MXI60_I10_MN5 (XI60_I10_n2 b1_2 VSS VSS) gpdk090_nmos1v w=0.24u l=0.1u ad=0.0528p as=0.0816p pd=0.68u ps=1.16u
    I_MXI60_I10_MN4 (I60_pn2 XI60_I10_An XI60_I10_n2 VSS) gpdk090_nmos1v w=0.24u l=0.1u ad=0.0528p as=0.0528p pd=0.68u ps=0.68u
    I_MXI60_I10_MN2 (XI60_I10_n1 p0_1 I60_pn2 VSS) gpdk090_nmos1v w=0.24u l=0.1u ad=0.0528p as=0.0528p pd=0.68u ps=0.68u
    I_MXI60_I10_MN3 (VSS XI60_I10_Bn XI60_I10_n1 VSS) gpdk090_nmos1v w=0.24u l=0.1u ad=0.0816p as=0.0528p pd=1.16u ps=0.68u
    I_MXI60_I10_MN0 (XI60_I10_An p0_1 VSS VSS) gpdk090_nmos1v w=0.12u l=0.1u ad=0.0696p as=0.0696p pd=1.16u ps=1.16u
    I_MXI60_I39_MN1 (XI60_I39_Bn I60_G1_0 VSS VSS) gpdk090_nmos1v w=0.12u l=0.1u ad=0.0696p as=0.0696p pd=1.16u ps=1.16u
    I_MXI60_I39_MN5 (XI60_I39_n2 I60_G1_0 VSS VSS) gpdk090_nmos1v w=0.24u l=0.1u ad=0.0528p as=0.0816p pd=0.68u ps=1.16u
    I_MXI60_I39_MN4 (p1_2 XI60_I39_An XI60_I39_n2 VSS) gpdk090_nmos1v w=0.24u l=0.1u ad=0.0528p as=0.0528p pd=0.68u ps=0.68u
    I_MXI60_I39_MN2 (XI60_I39_n1 I60_pn2 p1_2 VSS) gpdk090_nmos1v w=0.24u l=0.1u ad=0.0528p as=0.0528p pd=0.68u ps=0.68u
    I_MXI60_I39_MN3 (VSS XI60_I39_Bn XI60_I39_n1 VSS) gpdk090_nmos1v w=0.24u l=0.1u ad=0.0816p as=0.0528p pd=1.16u ps=0.68u
    I_MXI60_I39_MN0 (XI60_I39_An I60_pn2 VSS VSS) gpdk090_nmos1v w=0.12u l=0.1u ad=0.0696p as=0.0696p pd=1.16u ps=1.16u
    I_MXI72_I11_MN1 (XI72_I11_Bn b2_3 VSS VSS) gpdk090_nmos1v w=0.12u l=0.1u ad=0.0696p as=0.0696p pd=1.16u ps=1.16u
    I_MXI72_I11_MN5 (XI72_I11_n2 b2_3 VSS VSS) gpdk090_nmos1v w=0.24u l=0.1u ad=0.0528p as=0.0816p pd=0.68u ps=1.16u
    I_MXI72_I11_MN4 (I72_pn3 XI72_I11_An XI72_I11_n2 VSS) gpdk090_nmos1v w=0.24u l=0.1u ad=0.0528p as=0.0528p pd=0.68u ps=0.68u
    I_MXI72_I11_MN2 (XI72_I11_n1 p1_2 I72_pn3 VSS) gpdk090_nmos1v w=0.24u l=0.1u ad=0.0528p as=0.0528p pd=0.68u ps=0.68u
    I_MXI72_I11_MN3 (VSS XI72_I11_Bn XI72_I11_n1 VSS) gpdk090_nmos1v w=0.24u l=0.1u ad=0.0816p as=0.0528p pd=1.16u ps=0.68u
    I_MXI72_I11_MN0 (XI72_I11_An p1_2 VSS VSS) gpdk090_nmos1v w=0.12u l=0.1u ad=0.0696p as=0.0696p pd=1.16u ps=1.16u
    I_MXI72_I12_MN1 (XI72_I12_Bn b2_4 VSS VSS) gpdk090_nmos1v w=0.12u l=0.1u ad=0.0696p as=0.0696p pd=1.16u ps=1.16u
    I_MXI72_I12_MN5 (XI72_I12_n2 b2_4 VSS VSS) gpdk090_nmos1v w=0.24u l=0.1u ad=0.0528p as=0.0816p pd=0.68u ps=1.16u
    I_MXI72_I12_MN4 (I72_pn4 XI72_I12_An XI72_I12_n2 VSS) gpdk090_nmos1v w=0.24u l=0.1u ad=0.0528p as=0.0528p pd=0.68u ps=0.68u
    I_MXI72_I12_MN2 (XI72_I12_n1 p1_3 I72_pn4 VSS) gpdk090_nmos1v w=0.24u l=0.1u ad=0.0528p as=0.0528p pd=0.68u ps=0.68u
    I_MXI72_I12_MN3 (VSS XI72_I12_Bn XI72_I12_n1 VSS) gpdk090_nmos1v w=0.24u l=0.1u ad=0.0816p as=0.0528p pd=1.16u ps=0.68u
    I_MXI72_I12_MN0 (XI72_I12_An p1_3 VSS VSS) gpdk090_nmos1v w=0.12u l=0.1u ad=0.0696p as=0.0696p pd=1.16u ps=1.16u
    I_MXI72_I42_MN1 (XI72_I42_Bn I72_G4_0 VSS VSS) gpdk090_nmos1v w=0.12u l=0.1u ad=0.0696p as=0.0696p pd=1.16u ps=1.16u
    I_MXI72_I42_MN5 (XI72_I42_n2 I72_G4_0 VSS VSS) gpdk090_nmos1v w=0.24u l=0.1u ad=0.0528p as=0.0816p pd=0.68u ps=1.16u
    I_MXI72_I42_MN4 (p2_5 XI72_I42_An XI72_I42_n2 VSS) gpdk090_nmos1v w=0.24u l=0.1u ad=0.0528p as=0.0528p pd=0.68u ps=0.68u
    I_MXI72_I42_MN2 (XI72_I42_n1 I72_pn5 p2_5 VSS) gpdk090_nmos1v w=0.24u l=0.1u ad=0.0528p as=0.0528p pd=0.68u ps=0.68u
    I_MXI72_I42_MN3 (VSS XI72_I42_Bn XI72_I42_n1 VSS) gpdk090_nmos1v w=0.24u l=0.1u ad=0.0816p as=0.0528p pd=1.16u ps=0.68u
    I_MXI72_I42_MN0 (XI72_I42_An I72_pn5 VSS VSS) gpdk090_nmos1v w=0.12u l=0.1u ad=0.0696p as=0.0696p pd=1.16u ps=1.16u
    I_MXI84_I14_MN1 (XI84_I14_Bn b3_6 VSS VSS) gpdk090_nmos1v w=0.12u l=0.1u ad=0.0696p as=0.0696p pd=1.16u ps=1.16u
    I_MXI84_I14_MN5 (XI84_I14_n2 b3_6 VSS VSS) gpdk090_nmos1v w=0.24u l=0.1u ad=0.0528p as=0.0816p pd=0.68u ps=1.16u
    I_MXI84_I14_MN4 (I84_pn6 XI84_I14_An XI84_I14_n2 VSS) gpdk090_nmos1v w=0.24u l=0.1u ad=0.0528p as=0.0528p pd=0.68u ps=0.68u
    I_MXI84_I14_MN2 (XI84_I14_n1 p2_5 I84_pn6 VSS) gpdk090_nmos1v w=0.24u l=0.1u ad=0.0528p as=0.0528p pd=0.68u ps=0.68u
    I_MXI84_I14_MN3 (VSS XI84_I14_Bn XI84_I14_n1 VSS) gpdk090_nmos1v w=0.24u l=0.1u ad=0.0816p as=0.0528p pd=1.16u ps=0.68u
    I_MXI84_I14_MN0 (XI84_I14_An p2_5 VSS VSS) gpdk090_nmos1v w=0.12u l=0.1u ad=0.0696p as=0.0696p pd=1.16u ps=1.16u
    I_MXI84_I15_MN1 (XI84_I15_Bn b3_7 VSS VSS) gpdk090_nmos1v w=0.12u l=0.1u ad=0.0696p as=0.0696p pd=1.16u ps=1.16u
    I_MXI84_I15_MN5 (XI84_I15_n2 b3_7 VSS VSS) gpdk090_nmos1v w=0.24u l=0.1u ad=0.0528p as=0.0816p pd=0.68u ps=1.16u
    I_MXI84_I15_MN4 (I84_pn7 XI84_I15_An XI84_I15_n2 VSS) gpdk090_nmos1v w=0.24u l=0.1u ad=0.0528p as=0.0528p pd=0.68u ps=0.68u
    I_MXI84_I15_MN2 (XI84_I15_n1 p2_6 I84_pn7 VSS) gpdk090_nmos1v w=0.24u l=0.1u ad=0.0528p as=0.0528p pd=0.68u ps=0.68u
    I_MXI84_I15_MN3 (VSS XI84_I15_Bn XI84_I15_n1 VSS) gpdk090_nmos1v w=0.24u l=0.1u ad=0.0816p as=0.0528p pd=1.16u ps=0.68u
    I_MXI84_I15_MN0 (XI84_I15_An p2_6 VSS VSS) gpdk090_nmos1v w=0.12u l=0.1u ad=0.0696p as=0.0696p pd=1.16u ps=1.16u
    I_MXI48_I13_MN1 (XI48_I13_Bn b0_5 VSS VSS) gpdk090_nmos1v w=0.12u l=0.1u ad=0.0696p as=0.0696p pd=1.16u ps=1.16u
    I_MXI48_I13_MN5 (XI48_I13_n2 b0_5 VSS VSS) gpdk090_nmos1v w=0.24u l=0.1u ad=0.0528p as=0.0816p pd=0.68u ps=1.16u
    I_MXI48_I13_MN4 (I48_pn5 XI48_I13_An XI48_I13_n2 VSS) gpdk090_nmos1v w=0.24u l=0.1u ad=0.0528p as=0.0528p pd=0.68u ps=0.68u
    I_MXI48_I13_MN2 (XI48_I13_n1 VSS I48_pn5 VSS) gpdk090_nmos1v w=0.24u l=0.1u ad=0.0528p as=0.0528p pd=0.68u ps=0.68u
    I_MXI48_I13_MN3 (VSS XI48_I13_Bn XI48_I13_n1 VSS) gpdk090_nmos1v w=0.24u l=0.1u ad=0.0816p as=0.0528p pd=1.16u ps=0.68u
    I_MXI48_I13_MN0 (XI48_I13_An VSS VSS VSS) gpdk090_nmos1v w=0.12u l=0.1u ad=0.0696p as=0.0696p pd=1.16u ps=1.16u
    I_MXI48_I42_MN1 (XI48_I42_Bn I48_G4_0 VSS VSS) gpdk090_nmos1v w=0.12u l=0.1u ad=0.0696p as=0.0696p pd=1.16u ps=1.16u
    I_MXI48_I42_MN5 (XI48_I42_n2 I48_G4_0 VSS VSS) gpdk090_nmos1v w=0.24u l=0.1u ad=0.0528p as=0.0816p pd=0.68u ps=1.16u
    I_MXI48_I42_MN4 (p0_5 XI48_I42_An XI48_I42_n2 VSS) gpdk090_nmos1v w=0.24u l=0.1u ad=0.0528p as=0.0528p pd=0.68u ps=0.68u
    I_MXI48_I42_MN2 (XI48_I42_n1 I48_pn5 p0_5 VSS) gpdk090_nmos1v w=0.24u l=0.1u ad=0.0528p as=0.0528p pd=0.68u ps=0.68u
    I_MXI48_I42_MN3 (VSS XI48_I42_Bn XI48_I42_n1 VSS) gpdk090_nmos1v w=0.24u l=0.1u ad=0.0816p as=0.0528p pd=1.16u ps=0.68u
    I_MXI48_I42_MN0 (XI48_I42_An I48_pn5 VSS VSS) gpdk090_nmos1v w=0.12u l=0.1u ad=0.0696p as=0.0696p pd=1.16u ps=1.16u
    I_MXI48_I39_MN1 (XI48_I39_Bn I48_G1_0 VSS VSS) gpdk090_nmos1v w=0.12u l=0.1u ad=0.0696p as=0.0696p pd=1.16u ps=1.16u
    I_MXI48_I39_MN5 (XI48_I39_n2 I48_G1_0 VSS VSS) gpdk090_nmos1v w=0.24u l=0.1u ad=0.0528p as=0.0816p pd=0.68u ps=1.16u
    I_MXI48_I39_MN4 (p0_2 XI48_I39_An XI48_I39_n2 VSS) gpdk090_nmos1v w=0.24u l=0.1u ad=0.0528p as=0.0528p pd=0.68u ps=0.68u
    I_MXI48_I39_MN2 (XI48_I39_n1 I48_pn2 p0_2 VSS) gpdk090_nmos1v w=0.24u l=0.1u ad=0.0528p as=0.0528p pd=0.68u ps=0.68u
    I_MXI48_I39_MN3 (VSS XI48_I39_Bn XI48_I39_n1 VSS) gpdk090_nmos1v w=0.24u l=0.1u ad=0.0816p as=0.0528p pd=1.16u ps=0.68u
    I_MXI48_I39_MN0 (XI48_I39_An I48_pn2 VSS VSS) gpdk090_nmos1v w=0.12u l=0.1u ad=0.0696p as=0.0696p pd=1.16u ps=1.16u
    I_MXI60_I12_MN1 (XI60_I12_Bn b1_4 VSS VSS) gpdk090_nmos1v w=0.12u l=0.1u ad=0.0696p as=0.0696p pd=1.16u ps=1.16u
    I_MXI60_I12_MN5 (XI60_I12_n2 b1_4 VSS VSS) gpdk090_nmos1v w=0.24u l=0.1u ad=0.0528p as=0.0816p pd=0.68u ps=1.16u
    I_MXI60_I12_MN4 (I60_pn4 XI60_I12_An XI60_I12_n2 VSS) gpdk090_nmos1v w=0.24u l=0.1u ad=0.0528p as=0.0528p pd=0.68u ps=0.68u
    I_MXI60_I12_MN2 (XI60_I12_n1 p0_3 I60_pn4 VSS) gpdk090_nmos1v w=0.24u l=0.1u ad=0.0528p as=0.0528p pd=0.68u ps=0.68u
    I_MXI60_I12_MN3 (VSS XI60_I12_Bn XI60_I12_n1 VSS) gpdk090_nmos1v w=0.24u l=0.1u ad=0.0816p as=0.0528p pd=1.16u ps=0.68u
    I_MXI60_I12_MN0 (XI60_I12_An p0_3 VSS VSS) gpdk090_nmos1v w=0.12u l=0.1u ad=0.0696p as=0.0696p pd=1.16u ps=1.16u
    I_MXI48_I14_MN1 (XI48_I14_Bn b0_6 VSS VSS) gpdk090_nmos1v w=0.12u l=0.1u ad=0.0696p as=0.0696p pd=1.16u ps=1.16u
    I_MXI48_I14_MN5 (XI48_I14_n2 b0_6 VSS VSS) gpdk090_nmos1v w=0.24u l=0.1u ad=0.0528p as=0.0816p pd=0.68u ps=1.16u
    I_MXI48_I14_MN4 (I48_pn6 XI48_I14_An XI48_I14_n2 VSS) gpdk090_nmos1v w=0.24u l=0.1u ad=0.0528p as=0.0528p pd=0.68u ps=0.68u
    I_MXI48_I14_MN2 (XI48_I14_n1 VSS I48_pn6 VSS) gpdk090_nmos1v w=0.24u l=0.1u ad=0.0528p as=0.0528p pd=0.68u ps=0.68u
    I_MXI48_I14_MN3 (VSS XI48_I14_Bn XI48_I14_n1 VSS) gpdk090_nmos1v w=0.24u l=0.1u ad=0.0816p as=0.0528p pd=1.16u ps=0.68u
    I_MXI48_I14_MN0 (XI48_I14_An VSS VSS VSS) gpdk090_nmos1v w=0.12u l=0.1u ad=0.0696p as=0.0696p pd=1.16u ps=1.16u
    I_MXI48_I43_MN1 (XI48_I43_Bn I48_G5_0 VSS VSS) gpdk090_nmos1v w=0.12u l=0.1u ad=0.0696p as=0.0696p pd=1.16u ps=1.16u
    I_MXI48_I43_MN5 (XI48_I43_n2 I48_G5_0 VSS VSS) gpdk090_nmos1v w=0.24u l=0.1u ad=0.0528p as=0.0816p pd=0.68u ps=1.16u
    I_MXI48_I43_MN4 (p0_6 XI48_I43_An XI48_I43_n2 VSS) gpdk090_nmos1v w=0.24u l=0.1u ad=0.0528p as=0.0528p pd=0.68u ps=0.68u
    I_MXI48_I43_MN2 (XI48_I43_n1 I48_pn6 p0_6 VSS) gpdk090_nmos1v w=0.24u l=0.1u ad=0.0528p as=0.0528p pd=0.68u ps=0.68u
    I_MXI48_I43_MN3 (VSS XI48_I43_Bn XI48_I43_n1 VSS) gpdk090_nmos1v w=0.24u l=0.1u ad=0.0816p as=0.0528p pd=1.16u ps=0.68u
    I_MXI48_I43_MN0 (XI48_I43_An I48_pn6 VSS VSS) gpdk090_nmos1v w=0.12u l=0.1u ad=0.0696p as=0.0696p pd=1.16u ps=1.16u
    I_MXI60_I13_MN1 (XI60_I13_Bn b1_5 VSS VSS) gpdk090_nmos1v w=0.12u l=0.1u ad=0.0696p as=0.0696p pd=1.16u ps=1.16u
    I_MXI60_I13_MN5 (XI60_I13_n2 b1_5 VSS VSS) gpdk090_nmos1v w=0.24u l=0.1u ad=0.0528p as=0.0816p pd=0.68u ps=1.16u
    I_MXI60_I13_MN4 (I60_pn5 XI60_I13_An XI60_I13_n2 VSS) gpdk090_nmos1v w=0.24u l=0.1u ad=0.0528p as=0.0528p pd=0.68u ps=0.68u
    I_MXI60_I13_MN2 (XI60_I13_n1 p0_4 I60_pn5 VSS) gpdk090_nmos1v w=0.24u l=0.1u ad=0.0528p as=0.0528p pd=0.68u ps=0.68u
    I_MXI60_I13_MN3 (VSS XI60_I13_Bn XI60_I13_n1 VSS) gpdk090_nmos1v w=0.24u l=0.1u ad=0.0816p as=0.0528p pd=1.16u ps=0.68u
    I_MXI60_I13_MN0 (XI60_I13_An p0_4 VSS VSS) gpdk090_nmos1v w=0.12u l=0.1u ad=0.0696p as=0.0696p pd=1.16u ps=1.16u
    I_MXI72_I13_MN1 (XI72_I13_Bn b2_5 VSS VSS) gpdk090_nmos1v w=0.12u l=0.1u ad=0.0696p as=0.0696p pd=1.16u ps=1.16u
    I_MXI72_I13_MN5 (XI72_I13_n2 b2_5 VSS VSS) gpdk090_nmos1v w=0.24u l=0.1u ad=0.0528p as=0.0816p pd=0.68u ps=1.16u
    I_MXI72_I13_MN4 (I72_pn5 XI72_I13_An XI72_I13_n2 VSS) gpdk090_nmos1v w=0.24u l=0.1u ad=0.0528p as=0.0528p pd=0.68u ps=0.68u
    I_MXI72_I13_MN2 (XI72_I13_n1 p1_4 I72_pn5 VSS) gpdk090_nmos1v w=0.24u l=0.1u ad=0.0528p as=0.0528p pd=0.68u ps=0.68u
    I_MXI72_I13_MN3 (VSS XI72_I13_Bn XI72_I13_n1 VSS) gpdk090_nmos1v w=0.24u l=0.1u ad=0.0816p as=0.0528p pd=1.16u ps=0.68u
    I_MXI72_I13_MN0 (XI72_I13_An p1_4 VSS VSS) gpdk090_nmos1v w=0.12u l=0.1u ad=0.0696p as=0.0696p pd=1.16u ps=1.16u
    I_MXI72_I14_MN1 (XI72_I14_Bn b2_6 VSS VSS) gpdk090_nmos1v w=0.12u l=0.1u ad=0.0696p as=0.0696p pd=1.16u ps=1.16u
    I_MXI72_I14_MN5 (XI72_I14_n2 b2_6 VSS VSS) gpdk090_nmos1v w=0.24u l=0.1u ad=0.0528p as=0.0816p pd=0.68u ps=1.16u
    I_MXI72_I14_MN4 (I72_pn6 XI72_I14_An XI72_I14_n2 VSS) gpdk090_nmos1v w=0.24u l=0.1u ad=0.0528p as=0.0528p pd=0.68u ps=0.68u
    I_MXI72_I14_MN2 (XI72_I14_n1 p1_5 I72_pn6 VSS) gpdk090_nmos1v w=0.24u l=0.1u ad=0.0528p as=0.0528p pd=0.68u ps=0.68u
    I_MXI72_I14_MN3 (VSS XI72_I14_Bn XI72_I14_n1 VSS) gpdk090_nmos1v w=0.24u l=0.1u ad=0.0816p as=0.0528p pd=1.16u ps=0.68u
    I_MXI72_I14_MN0 (XI72_I14_An p1_5 VSS VSS) gpdk090_nmos1v w=0.12u l=0.1u ad=0.0696p as=0.0696p pd=1.16u ps=1.16u
    I_MXI72_I44_MN1 (XI72_I44_Bn c2_7 VSS VSS) gpdk090_nmos1v w=0.12u l=0.1u ad=0.0696p as=0.0696p pd=1.16u ps=1.16u
    I_MXI72_I44_MN5 (XI72_I44_n2 c2_7 VSS VSS) gpdk090_nmos1v w=0.24u l=0.1u ad=0.0528p as=0.0816p pd=0.68u ps=1.16u
    I_MXI72_I44_MN4 (p2_7 XI72_I44_An XI72_I44_n2 VSS) gpdk090_nmos1v w=0.24u l=0.1u ad=0.0528p as=0.0528p pd=0.68u ps=0.68u
    I_MXI72_I44_MN2 (XI72_I44_n1 I72_pn7 p2_7 VSS) gpdk090_nmos1v w=0.24u l=0.1u ad=0.0528p as=0.0528p pd=0.68u ps=0.68u
    I_MXI72_I44_MN3 (VSS XI72_I44_Bn XI72_I44_n1 VSS) gpdk090_nmos1v w=0.24u l=0.1u ad=0.0816p as=0.0528p pd=1.16u ps=0.68u
    I_MXI72_I44_MN0 (XI72_I44_An I72_pn7 VSS VSS) gpdk090_nmos1v w=0.12u l=0.1u ad=0.0696p as=0.0696p pd=1.16u ps=1.16u
    I_MXI72_I43_MN1 (XI72_I43_Bn I72_G5_0 VSS VSS) gpdk090_nmos1v w=0.12u l=0.1u ad=0.0696p as=0.0696p pd=1.16u ps=1.16u
    I_MXI72_I43_MN5 (XI72_I43_n2 I72_G5_0 VSS VSS) gpdk090_nmos1v w=0.24u l=0.1u ad=0.0528p as=0.0816p pd=0.68u ps=1.16u
    I_MXI72_I43_MN4 (p2_6 XI72_I43_An XI72_I43_n2 VSS) gpdk090_nmos1v w=0.24u l=0.1u ad=0.0528p as=0.0528p pd=0.68u ps=0.68u
    I_MXI72_I43_MN2 (XI72_I43_n1 I72_pn6 p2_6 VSS) gpdk090_nmos1v w=0.24u l=0.1u ad=0.0528p as=0.0528p pd=0.68u ps=0.68u
    I_MXI72_I43_MN3 (VSS XI72_I43_Bn XI72_I43_n1 VSS) gpdk090_nmos1v w=0.24u l=0.1u ad=0.0816p as=0.0528p pd=1.16u ps=0.68u
    I_MXI72_I43_MN0 (XI72_I43_An I72_pn6 VSS VSS) gpdk090_nmos1v w=0.12u l=0.1u ad=0.0696p as=0.0696p pd=1.16u ps=1.16u
    I_MXI48_I15_MN1 (XI48_I15_Bn b0_7 VSS VSS) gpdk090_nmos1v w=0.12u l=0.1u ad=0.0696p as=0.0696p pd=1.16u ps=1.16u
    I_MXI48_I15_MN5 (XI48_I15_n2 b0_7 VSS VSS) gpdk090_nmos1v w=0.24u l=0.1u ad=0.0528p as=0.0816p pd=0.68u ps=1.16u
    I_MXI48_I15_MN4 (I48_pn7 XI48_I15_An XI48_I15_n2 VSS) gpdk090_nmos1v w=0.24u l=0.1u ad=0.0528p as=0.0528p pd=0.68u ps=0.68u
    I_MXI48_I15_MN2 (XI48_I15_n1 VSS I48_pn7 VSS) gpdk090_nmos1v w=0.24u l=0.1u ad=0.0528p as=0.0528p pd=0.68u ps=0.68u
    I_MXI48_I15_MN3 (VSS XI48_I15_Bn XI48_I15_n1 VSS) gpdk090_nmos1v w=0.24u l=0.1u ad=0.0816p as=0.0528p pd=1.16u ps=0.68u
    I_MXI48_I15_MN0 (XI48_I15_An VSS VSS VSS) gpdk090_nmos1v w=0.12u l=0.1u ad=0.0696p as=0.0696p pd=1.16u ps=1.16u
    I_MXI48_I44_MN1 (XI48_I44_Bn c0_7 VSS VSS) gpdk090_nmos1v w=0.12u l=0.1u ad=0.0696p as=0.0696p pd=1.16u ps=1.16u
    I_MXI48_I44_MN5 (XI48_I44_n2 c0_7 VSS VSS) gpdk090_nmos1v w=0.24u l=0.1u ad=0.0528p as=0.0816p pd=0.68u ps=1.16u
    I_MXI48_I44_MN4 (p0_7 XI48_I44_An XI48_I44_n2 VSS) gpdk090_nmos1v w=0.24u l=0.1u ad=0.0528p as=0.0528p pd=0.68u ps=0.68u
    I_MXI48_I44_MN2 (XI48_I44_n1 I48_pn7 p0_7 VSS) gpdk090_nmos1v w=0.24u l=0.1u ad=0.0528p as=0.0528p pd=0.68u ps=0.68u
    I_MXI48_I44_MN3 (VSS XI48_I44_Bn XI48_I44_n1 VSS) gpdk090_nmos1v w=0.24u l=0.1u ad=0.0816p as=0.0528p pd=1.16u ps=0.68u
    I_MXI48_I44_MN0 (XI48_I44_An I48_pn7 VSS VSS) gpdk090_nmos1v w=0.12u l=0.1u ad=0.0696p as=0.0696p pd=1.16u ps=1.16u
    I_MXI60_I14_MN1 (XI60_I14_Bn b1_6 VSS VSS) gpdk090_nmos1v w=0.12u l=0.1u ad=0.0696p as=0.0696p pd=1.16u ps=1.16u
    I_MXI60_I14_MN5 (XI60_I14_n2 b1_6 VSS VSS) gpdk090_nmos1v w=0.24u l=0.1u ad=0.0528p as=0.0816p pd=0.68u ps=1.16u
    I_MXI60_I14_MN4 (I60_pn6 XI60_I14_An XI60_I14_n2 VSS) gpdk090_nmos1v w=0.24u l=0.1u ad=0.0528p as=0.0528p pd=0.68u ps=0.68u
    I_MXI60_I14_MN2 (XI60_I14_n1 p0_5 I60_pn6 VSS) gpdk090_nmos1v w=0.24u l=0.1u ad=0.0528p as=0.0528p pd=0.68u ps=0.68u
    I_MXI60_I14_MN3 (VSS XI60_I14_Bn XI60_I14_n1 VSS) gpdk090_nmos1v w=0.24u l=0.1u ad=0.0816p as=0.0528p pd=1.16u ps=0.68u
    I_MXI60_I14_MN0 (XI60_I14_An p0_5 VSS VSS) gpdk090_nmos1v w=0.12u l=0.1u ad=0.0696p as=0.0696p pd=1.16u ps=1.16u
    I_MXI60_I15_MN1 (XI60_I15_Bn b1_7 VSS VSS) gpdk090_nmos1v w=0.12u l=0.1u ad=0.0696p as=0.0696p pd=1.16u ps=1.16u
    I_MXI60_I15_MN5 (XI60_I15_n2 b1_7 VSS VSS) gpdk090_nmos1v w=0.24u l=0.1u ad=0.0528p as=0.0816p pd=0.68u ps=1.16u
    I_MXI60_I15_MN4 (I60_pn7 XI60_I15_An XI60_I15_n2 VSS) gpdk090_nmos1v w=0.24u l=0.1u ad=0.0528p as=0.0528p pd=0.68u ps=0.68u
    I_MXI60_I15_MN2 (XI60_I15_n1 p0_6 I60_pn7 VSS) gpdk090_nmos1v w=0.24u l=0.1u ad=0.0528p as=0.0528p pd=0.68u ps=0.68u
    I_MXI60_I15_MN3 (VSS XI60_I15_Bn XI60_I15_n1 VSS) gpdk090_nmos1v w=0.24u l=0.1u ad=0.0816p as=0.0528p pd=1.16u ps=0.68u
    I_MXI60_I15_MN0 (XI60_I15_An p0_6 VSS VSS) gpdk090_nmos1v w=0.12u l=0.1u ad=0.0696p as=0.0696p pd=1.16u ps=1.16u
    I_MXI60_I43_MN1 (XI60_I43_Bn I60_G5_0 VSS VSS) gpdk090_nmos1v w=0.12u l=0.1u ad=0.0696p as=0.0696p pd=1.16u ps=1.16u
    I_MXI60_I43_MN5 (XI60_I43_n2 I60_G5_0 VSS VSS) gpdk090_nmos1v w=0.24u l=0.1u ad=0.0528p as=0.0816p pd=0.68u ps=1.16u
    I_MXI60_I43_MN4 (p1_6 XI60_I43_An XI60_I43_n2 VSS) gpdk090_nmos1v w=0.24u l=0.1u ad=0.0528p as=0.0528p pd=0.68u ps=0.68u
    I_MXI60_I43_MN2 (XI60_I43_n1 I60_pn6 p1_6 VSS) gpdk090_nmos1v w=0.24u l=0.1u ad=0.0528p as=0.0528p pd=0.68u ps=0.68u
    I_MXI60_I43_MN3 (VSS XI60_I43_Bn XI60_I43_n1 VSS) gpdk090_nmos1v w=0.24u l=0.1u ad=0.0816p as=0.0528p pd=1.16u ps=0.68u
    I_MXI60_I43_MN0 (XI60_I43_An I60_pn6 VSS VSS) gpdk090_nmos1v w=0.12u l=0.1u ad=0.0696p as=0.0696p pd=1.16u ps=1.16u
    I_MXI60_I42_MN1 (XI60_I42_Bn I60_G4_0 VSS VSS) gpdk090_nmos1v w=0.12u l=0.1u ad=0.0696p as=0.0696p pd=1.16u ps=1.16u
    I_MXI60_I42_MN5 (XI60_I42_n2 I60_G4_0 VSS VSS) gpdk090_nmos1v w=0.24u l=0.1u ad=0.0528p as=0.0816p pd=0.68u ps=1.16u
    I_MXI60_I42_MN4 (p1_5 XI60_I42_An XI60_I42_n2 VSS) gpdk090_nmos1v w=0.24u l=0.1u ad=0.0528p as=0.0528p pd=0.68u ps=0.68u
    I_MXI60_I42_MN2 (XI60_I42_n1 I60_pn5 p1_5 VSS) gpdk090_nmos1v w=0.24u l=0.1u ad=0.0528p as=0.0528p pd=0.68u ps=0.68u
    I_MXI60_I42_MN3 (VSS XI60_I42_Bn XI60_I42_n1 VSS) gpdk090_nmos1v w=0.24u l=0.1u ad=0.0816p as=0.0528p pd=1.16u ps=0.68u
    I_MXI60_I42_MN0 (XI60_I42_An I60_pn5 VSS VSS) gpdk090_nmos1v w=0.12u l=0.1u ad=0.0696p as=0.0696p pd=1.16u ps=1.16u
    I_MXI60_I44_MN1 (XI60_I44_Bn c1_7 VSS VSS) gpdk090_nmos1v w=0.12u l=0.1u ad=0.0696p as=0.0696p pd=1.16u ps=1.16u
    I_MXI60_I44_MN5 (XI60_I44_n2 c1_7 VSS VSS) gpdk090_nmos1v w=0.24u l=0.1u ad=0.0528p as=0.0816p pd=0.68u ps=1.16u
    I_MXI60_I44_MN4 (p1_7 XI60_I44_An XI60_I44_n2 VSS) gpdk090_nmos1v w=0.24u l=0.1u ad=0.0528p as=0.0528p pd=0.68u ps=0.68u
    I_MXI60_I44_MN2 (XI60_I44_n1 I60_pn7 p1_7 VSS) gpdk090_nmos1v w=0.24u l=0.1u ad=0.0528p as=0.0528p pd=0.68u ps=0.68u
    I_MXI60_I44_MN3 (VSS XI60_I44_Bn XI60_I44_n1 VSS) gpdk090_nmos1v w=0.24u l=0.1u ad=0.0816p as=0.0528p pd=1.16u ps=0.68u
    I_MXI60_I44_MN0 (XI60_I44_An I60_pn7 VSS VSS) gpdk090_nmos1v w=0.12u l=0.1u ad=0.0696p as=0.0696p pd=1.16u ps=1.16u
    I_MXI72_I15_MN1 (XI72_I15_Bn b2_7 VSS VSS) gpdk090_nmos1v w=0.12u l=0.1u ad=0.0696p as=0.0696p pd=1.16u ps=1.16u
    I_MXI72_I15_MN5 (XI72_I15_n2 b2_7 VSS VSS) gpdk090_nmos1v w=0.24u l=0.1u ad=0.0528p as=0.0816p pd=0.68u ps=1.16u
    I_MXI72_I15_MN4 (I72_pn7 XI72_I15_An XI72_I15_n2 VSS) gpdk090_nmos1v w=0.24u l=0.1u ad=0.0528p as=0.0528p pd=0.68u ps=0.68u
    I_MXI72_I15_MN2 (XI72_I15_n1 p1_6 I72_pn7 VSS) gpdk090_nmos1v w=0.24u l=0.1u ad=0.0528p as=0.0528p pd=0.68u ps=0.68u
    I_MXI72_I15_MN3 (VSS XI72_I15_Bn XI72_I15_n1 VSS) gpdk090_nmos1v w=0.24u l=0.1u ad=0.0816p as=0.0528p pd=1.16u ps=0.68u
    I_MXI72_I15_MN0 (XI72_I15_An p1_6 VSS VSS) gpdk090_nmos1v w=0.12u l=0.1u ad=0.0696p as=0.0696p pd=1.16u ps=1.16u
    I_MXI123_MN1 (qu1 p6_8 VSS VSS) gpdk090_nmos1v w=0.24u l=0.1u ad=0.0528p as=0.0816p pd=0.68u ps=1.16u
    I_MXI123_MN1_1 (VSS p6_8 qu1 VSS) gpdk090_nmos1v w=0.24u l=0.1u ad=0.0816p as=0.0528p pd=1.16u ps=0.68u
    I_MXI111_MN1 (qu2 p5_8 VSS VSS) gpdk090_nmos1v w=0.24u l=0.1u ad=0.0528p as=0.0816p pd=0.68u ps=1.16u
    I_MXI111_MN1_1 (VSS p5_8 qu2 VSS) gpdk090_nmos1v w=0.24u l=0.1u ad=0.0816p as=0.0528p pd=1.16u ps=0.68u
    I_MXI99_MN1 (qu3 p4_8 VSS VSS) gpdk090_nmos1v w=0.24u l=0.1u ad=0.0528p as=0.0816p pd=0.68u ps=1.16u
    I_MXI99_MN1_1 (VSS p4_8 qu3 VSS) gpdk090_nmos1v w=0.24u l=0.1u ad=0.0816p as=0.0528p pd=1.16u ps=0.68u
    I_MXI87_MN1 (qu4 p3_8 VSS VSS) gpdk090_nmos1v w=0.24u l=0.1u ad=0.0528p as=0.0816p pd=0.68u ps=1.16u
    I_MXI87_MN1_1 (VSS p3_8 qu4 VSS) gpdk090_nmos1v w=0.24u l=0.1u ad=0.0816p as=0.0528p pd=1.16u ps=0.68u
    I_MXI75_MN1 (qu5 p2_8 VSS VSS) gpdk090_nmos1v w=0.24u l=0.1u ad=0.0528p as=0.0816p pd=0.68u ps=1.16u
    I_MXI75_MN1_1 (VSS p2_8 qu5 VSS) gpdk090_nmos1v w=0.24u l=0.1u ad=0.0816p as=0.0528p pd=1.16u ps=0.68u
    I_MXI51_MN1 (qu7 p0_8 VSS VSS) gpdk090_nmos1v w=0.24u l=0.1u ad=0.0528p as=0.0816p pd=0.68u ps=1.16u
    I_MXI51_MN1_1 (VSS p0_8 qu7 VSS) gpdk090_nmos1v w=0.24u l=0.1u ad=0.0816p as=0.0528p pd=1.16u ps=0.68u
    I_MXI63_MN1 (qu6 p1_8 VSS VSS) gpdk090_nmos1v w=0.24u l=0.1u ad=0.0528p as=0.0816p pd=0.68u ps=1.16u
    I_MXI63_MN1_1 (VSS p1_8 qu6 VSS) gpdk090_nmos1v w=0.24u l=0.1u ad=0.0816p as=0.0528p pd=1.16u ps=0.68u
    I_MXI120_I31_XG_MN2 (I120_G7_4n I120_G7_6 VSS VSS) gpdk090_nmos1v w=0.12u l=0.1u ad=0.0468p as=0.0696p pd=0.68u ps=1.16u
    I_MXI120_I31_XG_MN0 (XI120_I31_XG_n1 I120_P7_6 I120_G7_4n VSS) gpdk090_nmos1v w=0.24u l=0.1u ad=0.0528p as=0.0468p pd=0.68u ps=0.68u
    I_MXI120_I31_XG_MN1 (VSS I120_G5_4 XI120_I31_XG_n1 VSS) gpdk090_nmos1v w=0.24u l=0.1u ad=0.0816p as=0.0528p pd=1.16u ps=0.68u
    I_MXI120_I30_XG_MN2 (I120_G6_3n I120_G6_5 VSS VSS) gpdk090_nmos1v w=0.12u l=0.1u ad=0.0468p as=0.0696p pd=0.68u ps=1.16u
    I_MXI120_I30_XG_MN0 (XI120_I30_XG_n1 I120_P6_5 I120_G6_3n VSS) gpdk090_nmos1v w=0.24u l=0.1u ad=0.0528p as=0.0468p pd=0.68u ps=0.68u
    I_MXI120_I30_XG_MN1 (VSS I120_G4_3 XI120_I30_XG_n1 VSS) gpdk090_nmos1v w=0.24u l=0.1u ad=0.0816p as=0.0528p pd=1.16u ps=0.68u
    I_MXI120_I29_XG_MN2 (I120_G5_2n I120_G5_4 VSS VSS) gpdk090_nmos1v w=0.12u l=0.1u ad=0.0468p as=0.0696p pd=0.68u ps=1.16u
    I_MXI120_I29_XG_MN0 (XI120_I29_XG_n1 I120_P5_4 I120_G5_2n VSS) gpdk090_nmos1v w=0.24u l=0.1u ad=0.0528p as=0.0468p pd=0.68u ps=0.68u
    I_MXI120_I29_XG_MN1 (VSS I120_G3_2 XI120_I29_XG_n1 VSS) gpdk090_nmos1v w=0.24u l=0.1u ad=0.0816p as=0.0528p pd=1.16u ps=0.68u
    I_MXI108_I30_XG_MN2 (I108_G6_3n I108_G6_5 VSS VSS) gpdk090_nmos1v w=0.12u l=0.1u ad=0.0468p as=0.0696p pd=0.68u ps=1.16u
    I_MXI108_I30_XG_MN0 (XI108_I30_XG_n1 I108_P6_5 I108_G6_3n VSS) gpdk090_nmos1v w=0.24u l=0.1u ad=0.0528p as=0.0468p pd=0.68u ps=0.68u
    I_MXI108_I30_XG_MN1 (VSS I108_G4_3 XI108_I30_XG_n1 VSS) gpdk090_nmos1v w=0.24u l=0.1u ad=0.0816p as=0.0528p pd=1.16u ps=0.68u
    I_MXI108_I27_XG_MN2 (I108_G3_0n I108_G3_2 VSS VSS) gpdk090_nmos1v w=0.12u l=0.1u ad=0.0468p as=0.0696p pd=0.68u ps=1.16u
    I_MXI108_I27_XG_MN0 (XI108_I27_XG_n1 I108_P3_2 I108_G3_0n VSS) gpdk090_nmos1v w=0.24u l=0.1u ad=0.0528p as=0.0468p pd=0.68u ps=0.68u
    I_MXI108_I27_XG_MN1 (VSS I108_G1_0 XI108_I27_XG_n1 VSS) gpdk090_nmos1v w=0.24u l=0.1u ad=0.0816p as=0.0528p pd=1.16u ps=0.68u
    I_MXI108_I29_XG_MN2 (I108_G5_2n I108_G5_4 VSS VSS) gpdk090_nmos1v w=0.12u l=0.1u ad=0.0468p as=0.0696p pd=0.68u ps=1.16u
    I_MXI108_I29_XG_MN0 (XI108_I29_XG_n1 I108_P5_4 I108_G5_2n VSS) gpdk090_nmos1v w=0.24u l=0.1u ad=0.0528p as=0.0468p pd=0.68u ps=0.68u
    I_MXI108_I29_XG_MN1 (VSS I108_G3_2 XI108_I29_XG_n1 VSS) gpdk090_nmos1v w=0.24u l=0.1u ad=0.0816p as=0.0528p pd=1.16u ps=0.68u
    I_MXI108_I31_XG_MN2 (I108_G7_4n I108_G7_6 VSS VSS) gpdk090_nmos1v w=0.12u l=0.1u ad=0.0468p as=0.0696p pd=0.68u ps=1.16u
    I_MXI108_I31_XG_MN0 (XI108_I31_XG_n1 I108_P7_6 I108_G7_4n VSS) gpdk090_nmos1v w=0.24u l=0.1u ad=0.0528p as=0.0468p pd=0.68u ps=0.68u
    I_MXI108_I31_XG_MN1 (VSS I108_G5_4 XI108_I31_XG_n1 VSS) gpdk090_nmos1v w=0.24u l=0.1u ad=0.0816p as=0.0528p pd=1.16u ps=0.68u
    I_MXI132_I31_XG_MN2 (I132_G7_4n I132_G7_6 VSS VSS) gpdk090_nmos1v w=0.12u l=0.1u ad=0.0468p as=0.0696p pd=0.68u ps=1.16u
    I_MXI132_I31_XG_MN0 (XI132_I31_XG_n1 I132_P7_6 I132_G7_4n VSS) gpdk090_nmos1v w=0.24u l=0.1u ad=0.0528p as=0.0468p pd=0.68u ps=0.68u
    I_MXI132_I31_XG_MN1 (VSS I132_G5_4 XI132_I31_XG_n1 VSS) gpdk090_nmos1v w=0.24u l=0.1u ad=0.0816p as=0.0528p pd=1.16u ps=0.68u
    I_MXI120_I26_XG_MN2 (I120_G2_0n I120_G2_1 VSS VSS) gpdk090_nmos1v w=0.12u l=0.1u ad=0.0468p as=0.0696p pd=0.68u ps=1.16u
    I_MXI120_I26_XG_MN0 (XI120_I26_XG_n1 I120_P2_1 I120_G2_0n VSS) gpdk090_nmos1v w=0.24u l=0.1u ad=0.0528p as=0.0468p pd=0.68u ps=0.68u
    I_MXI120_I26_XG_MN1 (VSS I120_G0_0 XI120_I26_XG_n1 VSS) gpdk090_nmos1v w=0.24u l=0.1u ad=0.0816p as=0.0528p pd=1.16u ps=0.68u
    I_MXI120_I28_XG_MN2 (I120_G4_1n I120_G4_3 VSS VSS) gpdk090_nmos1v w=0.12u l=0.1u ad=0.0468p as=0.0696p pd=0.68u ps=1.16u
    I_MXI120_I28_XG_MN0 (XI120_I28_XG_n1 I120_P4_3 I120_G4_1n VSS) gpdk090_nmos1v w=0.24u l=0.1u ad=0.0528p as=0.0468p pd=0.68u ps=0.68u
    I_MXI120_I28_XG_MN1 (VSS I120_G2_1 XI120_I28_XG_n1 VSS) gpdk090_nmos1v w=0.24u l=0.1u ad=0.0816p as=0.0528p pd=1.16u ps=0.68u
    I_MXI120_I27_XG_MN2 (I120_G3_0n I120_G3_2 VSS VSS) gpdk090_nmos1v w=0.12u l=0.1u ad=0.0468p as=0.0696p pd=0.68u ps=1.16u
    I_MXI120_I27_XG_MN0 (XI120_I27_XG_n1 I120_P3_2 I120_G3_0n VSS) gpdk090_nmos1v w=0.24u l=0.1u ad=0.0528p as=0.0468p pd=0.68u ps=0.68u
    I_MXI120_I27_XG_MN1 (VSS I120_G1_0 XI120_I27_XG_n1 VSS) gpdk090_nmos1v w=0.24u l=0.1u ad=0.0816p as=0.0528p pd=1.16u ps=0.68u
    I_MXI108_I26_XG_MN2 (I108_G2_0n I108_G2_1 VSS VSS) gpdk090_nmos1v w=0.12u l=0.1u ad=0.0468p as=0.0696p pd=0.68u ps=1.16u
    I_MXI108_I26_XG_MN0 (XI108_I26_XG_n1 I108_P2_1 I108_G2_0n VSS) gpdk090_nmos1v w=0.24u l=0.1u ad=0.0528p as=0.0468p pd=0.68u ps=0.68u
    I_MXI108_I26_XG_MN1 (VSS I108_G0_0 XI108_I26_XG_n1 VSS) gpdk090_nmos1v w=0.24u l=0.1u ad=0.0816p as=0.0528p pd=1.16u ps=0.68u
    I_MXI108_I28_XG_MN2 (I108_G4_1n I108_G4_3 VSS VSS) gpdk090_nmos1v w=0.12u l=0.1u ad=0.0468p as=0.0696p pd=0.68u ps=1.16u
    I_MXI108_I28_XG_MN0 (XI108_I28_XG_n1 I108_P4_3 I108_G4_1n VSS) gpdk090_nmos1v w=0.24u l=0.1u ad=0.0528p as=0.0468p pd=0.68u ps=0.68u
    I_MXI108_I28_XG_MN1 (VSS I108_G2_1 XI108_I28_XG_n1 VSS) gpdk090_nmos1v w=0.24u l=0.1u ad=0.0816p as=0.0528p pd=1.16u ps=0.68u
    I_MXI132_I29_XG_MN2 (I132_G5_2n I132_G5_4 VSS VSS) gpdk090_nmos1v w=0.12u l=0.1u ad=0.0468p as=0.0696p pd=0.68u ps=1.16u
    I_MXI132_I29_XG_MN0 (XI132_I29_XG_n1 I132_P5_4 I132_G5_2n VSS) gpdk090_nmos1v w=0.24u l=0.1u ad=0.0528p as=0.0468p pd=0.68u ps=0.68u
    I_MXI132_I29_XG_MN1 (VSS I132_G3_2 XI132_I29_XG_n1 VSS) gpdk090_nmos1v w=0.24u l=0.1u ad=0.0816p as=0.0528p pd=1.16u ps=0.68u
    I_MXI132_I27_XG_MN2 (I132_G3_0n I132_G3_2 VSS VSS) gpdk090_nmos1v w=0.12u l=0.1u ad=0.0468p as=0.0696p pd=0.68u ps=1.16u
    I_MXI132_I27_XG_MN0 (XI132_I27_XG_n1 I132_P3_2 I132_G3_0n VSS) gpdk090_nmos1v w=0.24u l=0.1u ad=0.0528p as=0.0468p pd=0.68u ps=0.68u
    I_MXI132_I27_XG_MN1 (VSS I132_G1_0 XI132_I27_XG_n1 VSS) gpdk090_nmos1v w=0.24u l=0.1u ad=0.0816p as=0.0528p pd=1.16u ps=0.68u
    I_MXI132_I30_XG_MN2 (I132_G6_3n I132_G6_5 VSS VSS) gpdk090_nmos1v w=0.12u l=0.1u ad=0.0468p as=0.0696p pd=0.68u ps=1.16u
    I_MXI132_I30_XG_MN0 (XI132_I30_XG_n1 I132_P6_5 I132_G6_3n VSS) gpdk090_nmos1v w=0.24u l=0.1u ad=0.0528p as=0.0468p pd=0.68u ps=0.68u
    I_MXI132_I30_XG_MN1 (VSS I132_G4_3 XI132_I30_XG_n1 VSS) gpdk090_nmos1v w=0.24u l=0.1u ad=0.0816p as=0.0528p pd=1.16u ps=0.68u
    I_MXI132_I28_XG_MN2 (I132_G4_1n I132_G4_3 VSS VSS) gpdk090_nmos1v w=0.12u l=0.1u ad=0.0468p as=0.0696p pd=0.68u ps=1.16u
    I_MXI132_I28_XG_MN0 (XI132_I28_XG_n1 I132_P4_3 I132_G4_1n VSS) gpdk090_nmos1v w=0.24u l=0.1u ad=0.0528p as=0.0468p pd=0.68u ps=0.68u
    I_MXI132_I28_XG_MN1 (VSS I132_G2_1 XI132_I28_XG_n1 VSS) gpdk090_nmos1v w=0.24u l=0.1u ad=0.0816p as=0.0528p pd=1.16u ps=0.68u
    I_MXI96_I27_XG_MN2 (I96_G3_0n I96_G3_2 VSS VSS) gpdk090_nmos1v w=0.12u l=0.1u ad=0.0468p as=0.0696p pd=0.68u ps=1.16u
    I_MXI96_I27_XG_MN0 (XI96_I27_XG_n1 I96_P3_2 I96_G3_0n VSS) gpdk090_nmos1v w=0.24u l=0.1u ad=0.0528p as=0.0468p pd=0.68u ps=0.68u
    I_MXI96_I27_XG_MN1 (VSS I96_G1_0 XI96_I27_XG_n1 VSS) gpdk090_nmos1v w=0.24u l=0.1u ad=0.0816p as=0.0528p pd=1.16u ps=0.68u
    I_MXI96_I29_XG_MN2 (I96_G5_2n I96_G5_4 VSS VSS) gpdk090_nmos1v w=0.12u l=0.1u ad=0.0468p as=0.0696p pd=0.68u ps=1.16u
    I_MXI96_I29_XG_MN0 (XI96_I29_XG_n1 I96_P5_4 I96_G5_2n VSS) gpdk090_nmos1v w=0.24u l=0.1u ad=0.0528p as=0.0468p pd=0.68u ps=0.68u
    I_MXI96_I29_XG_MN1 (VSS I96_G3_2 XI96_I29_XG_n1 VSS) gpdk090_nmos1v w=0.24u l=0.1u ad=0.0816p as=0.0528p pd=1.16u ps=0.68u
    I_MXI96_I31_XG_MN2 (I96_G7_4n I96_G7_6 VSS VSS) gpdk090_nmos1v w=0.12u l=0.1u ad=0.0468p as=0.0696p pd=0.68u ps=1.16u
    I_MXI96_I31_XG_MN0 (XI96_I31_XG_n1 I96_P7_6 I96_G7_4n VSS) gpdk090_nmos1v w=0.24u l=0.1u ad=0.0528p as=0.0468p pd=0.68u ps=0.68u
    I_MXI96_I31_XG_MN1 (VSS I96_G5_4 XI96_I31_XG_n1 VSS) gpdk090_nmos1v w=0.24u l=0.1u ad=0.0816p as=0.0528p pd=1.16u ps=0.68u
    I_MXI132_I26_XG_MN2 (I132_G2_0n I132_G2_1 VSS VSS) gpdk090_nmos1v w=0.12u l=0.1u ad=0.0468p as=0.0696p pd=0.68u ps=1.16u
    I_MXI132_I26_XG_MN0 (XI132_I26_XG_n1 I132_P2_1 I132_G2_0n VSS) gpdk090_nmos1v w=0.24u l=0.1u ad=0.0528p as=0.0468p pd=0.68u ps=0.68u
    I_MXI132_I26_XG_MN1 (VSS I132_G0_0 XI132_I26_XG_n1 VSS) gpdk090_nmos1v w=0.24u l=0.1u ad=0.0816p as=0.0528p pd=1.16u ps=0.68u
    I_MXI6_MN2 (nakn3 nak2 VSS VSS) gpdk090_nmos1v w=0.12u l=0.1u ad=0.0468p as=0.0696p pd=0.68u ps=1.16u
    I_MXI6_MN0 (XI6_n1 A_7 nakn3 VSS) gpdk090_nmos1v w=0.24u l=0.1u ad=0.0528p as=0.0468p pd=0.68u ps=0.68u
    I_MXI6_MN1 (VSS A_2 XI6_n1 VSS) gpdk090_nmos1v w=0.24u l=0.1u ad=0.0816p as=0.0528p pd=1.16u ps=0.68u
    I_MXI96_I26_XG_MN2 (I96_G2_0n I96_G2_1 VSS VSS) gpdk090_nmos1v w=0.12u l=0.1u ad=0.0468p as=0.0696p pd=0.68u ps=1.16u
    I_MXI96_I26_XG_MN0 (XI96_I26_XG_n1 I96_P2_1 I96_G2_0n VSS) gpdk090_nmos1v w=0.24u l=0.1u ad=0.0528p as=0.0468p pd=0.68u ps=0.68u
    I_MXI96_I26_XG_MN1 (VSS I96_G0_0 XI96_I26_XG_n1 VSS) gpdk090_nmos1v w=0.24u l=0.1u ad=0.0816p as=0.0528p pd=1.16u ps=0.68u
    I_MXI96_I28_XG_MN2 (I96_G4_1n I96_G4_3 VSS VSS) gpdk090_nmos1v w=0.12u l=0.1u ad=0.0468p as=0.0696p pd=0.68u ps=1.16u
    I_MXI96_I28_XG_MN0 (XI96_I28_XG_n1 I96_P4_3 I96_G4_1n VSS) gpdk090_nmos1v w=0.24u l=0.1u ad=0.0528p as=0.0468p pd=0.68u ps=0.68u
    I_MXI96_I28_XG_MN1 (VSS I96_G2_1 XI96_I28_XG_n1 VSS) gpdk090_nmos1v w=0.24u l=0.1u ad=0.0816p as=0.0528p pd=1.16u ps=0.68u
    I_MXI96_I30_XG_MN2 (I96_G6_3n I96_G6_5 VSS VSS) gpdk090_nmos1v w=0.12u l=0.1u ad=0.0468p as=0.0696p pd=0.68u ps=1.16u
    I_MXI96_I30_XG_MN0 (XI96_I30_XG_n1 I96_P6_5 I96_G6_3n VSS) gpdk090_nmos1v w=0.24u l=0.1u ad=0.0528p as=0.0468p pd=0.68u ps=0.68u
    I_MXI96_I30_XG_MN1 (VSS I96_G4_3 XI96_I30_XG_n1 VSS) gpdk090_nmos1v w=0.24u l=0.1u ad=0.0816p as=0.0528p pd=1.16u ps=0.68u
    I_MXI152_I31_XG_MN2 (I152_G7_4n I152_G7_6 VSS VSS) gpdk090_nmos1v w=0.12u l=0.1u ad=0.0468p as=0.0696p pd=0.68u ps=1.16u
    I_MXI152_I31_XG_MN0 (XI152_I31_XG_n1 I152_P7_6 I152_G7_4n VSS) gpdk090_nmos1v w=0.24u l=0.1u ad=0.0528p as=0.0468p pd=0.68u ps=0.68u
    I_MXI152_I31_XG_MN1 (VSS I152_G5_4 XI152_I31_XG_n1 VSS) gpdk090_nmos1v w=0.24u l=0.1u ad=0.0816p as=0.0528p pd=1.16u ps=0.68u
    I_MXI3_MN2 (nakn2 nak1 VSS VSS) gpdk090_nmos1v w=0.12u l=0.1u ad=0.0468p as=0.0696p pd=0.68u ps=1.16u
    I_MXI3_MN0 (XI3_n1 A_7 nakn2 VSS) gpdk090_nmos1v w=0.24u l=0.1u ad=0.0528p as=0.0468p pd=0.68u ps=0.68u
    I_MXI3_MN1 (VSS A_1 XI3_n1 VSS) gpdk090_nmos1v w=0.24u l=0.1u ad=0.0816p as=0.0528p pd=1.16u ps=0.68u
    I_MXI160_MN2 (nqkn3 nqk2 VSS VSS) gpdk090_nmos1v w=0.12u l=0.1u ad=0.0468p as=0.0696p pd=0.68u ps=1.16u
    I_MXI160_MN0 (XI160_n1 sq nqkn3 VSS) gpdk090_nmos1v w=0.24u l=0.1u ad=0.0528p as=0.0468p pd=0.68u ps=0.68u
    I_MXI160_MN1 (VSS qu2 XI160_n1 VSS) gpdk090_nmos1v w=0.24u l=0.1u ad=0.0816p as=0.0528p pd=1.16u ps=0.68u
    I_MXI9_MN2 (nakn4 nak3 VSS VSS) gpdk090_nmos1v w=0.12u l=0.1u ad=0.0468p as=0.0696p pd=0.68u ps=1.16u
    I_MXI9_MN0 (XI9_n1 A_7 nakn4 VSS) gpdk090_nmos1v w=0.24u l=0.1u ad=0.0528p as=0.0468p pd=0.68u ps=0.68u
    I_MXI9_MN1 (VSS A_3 XI9_n1 VSS) gpdk090_nmos1v w=0.24u l=0.1u ad=0.0816p as=0.0528p pd=1.16u ps=0.68u
    I_MXI152_I29_XG_MN2 (I152_G5_2n I152_G5_4 VSS VSS) gpdk090_nmos1v w=0.12u l=0.1u ad=0.0468p as=0.0696p pd=0.68u ps=1.16u
    I_MXI152_I29_XG_MN0 (XI152_I29_XG_n1 I152_P5_4 I152_G5_2n VSS) gpdk090_nmos1v w=0.24u l=0.1u ad=0.0528p as=0.0468p pd=0.68u ps=0.68u
    I_MXI152_I29_XG_MN1 (VSS I152_G3_2 XI152_I29_XG_n1 VSS) gpdk090_nmos1v w=0.24u l=0.1u ad=0.0816p as=0.0528p pd=1.16u ps=0.68u
    I_MXI152_I27_XG_MN2 (I152_G3_0n I152_G3_2 VSS VSS) gpdk090_nmos1v w=0.12u l=0.1u ad=0.0468p as=0.0696p pd=0.68u ps=1.16u
    I_MXI152_I27_XG_MN0 (XI152_I27_XG_n1 I152_P3_2 I152_G3_0n VSS) gpdk090_nmos1v w=0.24u l=0.1u ad=0.0528p as=0.0468p pd=0.68u ps=0.68u
    I_MXI152_I27_XG_MN1 (VSS I152_G1_0 XI152_I27_XG_n1 VSS) gpdk090_nmos1v w=0.24u l=0.1u ad=0.0816p as=0.0528p pd=1.16u ps=0.68u
    I_MXI157_MN2 (nqkn2 nqk1 VSS VSS) gpdk090_nmos1v w=0.12u l=0.1u ad=0.0468p as=0.0696p pd=0.68u ps=1.16u
    I_MXI157_MN0 (XI157_n1 sq nqkn2 VSS) gpdk090_nmos1v w=0.24u l=0.1u ad=0.0528p as=0.0468p pd=0.68u ps=0.68u
    I_MXI157_MN1 (VSS qu1 XI157_n1 VSS) gpdk090_nmos1v w=0.24u l=0.1u ad=0.0816p as=0.0528p pd=1.16u ps=0.68u
    I_MXI163_MN2 (nqkn4 nqk3 VSS VSS) gpdk090_nmos1v w=0.12u l=0.1u ad=0.0468p as=0.0696p pd=0.68u ps=1.16u
    I_MXI163_MN0 (XI163_n1 sq nqkn4 VSS) gpdk090_nmos1v w=0.24u l=0.1u ad=0.0528p as=0.0468p pd=0.68u ps=0.68u
    I_MXI163_MN1 (VSS qu3 XI163_n1 VSS) gpdk090_nmos1v w=0.24u l=0.1u ad=0.0816p as=0.0528p pd=1.16u ps=0.68u
    I_MXI166_MN2 (nqkn5 nqk4 VSS VSS) gpdk090_nmos1v w=0.12u l=0.1u ad=0.0468p as=0.0696p pd=0.68u ps=1.16u
    I_MXI166_MN0 (XI166_n1 sq nqkn5 VSS) gpdk090_nmos1v w=0.24u l=0.1u ad=0.0528p as=0.0468p pd=0.68u ps=0.68u
    I_MXI166_MN1 (VSS qu4 XI166_n1 VSS) gpdk090_nmos1v w=0.24u l=0.1u ad=0.0816p as=0.0528p pd=1.16u ps=0.68u
    I_MXI12_MN2 (nakn5 nak4 VSS VSS) gpdk090_nmos1v w=0.12u l=0.1u ad=0.0468p as=0.0696p pd=0.68u ps=1.16u
    I_MXI12_MN0 (XI12_n1 A_7 nakn5 VSS) gpdk090_nmos1v w=0.24u l=0.1u ad=0.0528p as=0.0468p pd=0.68u ps=0.68u
    I_MXI12_MN1 (VSS A_4 XI12_n1 VSS) gpdk090_nmos1v w=0.24u l=0.1u ad=0.0816p as=0.0528p pd=1.16u ps=0.68u
    I_MXI84_I26_XG_MN2 (I84_G2_0n I84_G2_1 VSS VSS) gpdk090_nmos1v w=0.12u l=0.1u ad=0.0468p as=0.0696p pd=0.68u ps=1.16u
    I_MXI84_I26_XG_MN0 (XI84_I26_XG_n1 I84_P2_1 I84_G2_0n VSS) gpdk090_nmos1v w=0.24u l=0.1u ad=0.0528p as=0.0468p pd=0.68u ps=0.68u
    I_MXI84_I26_XG_MN1 (VSS I84_G0_0 XI84_I26_XG_n1 VSS) gpdk090_nmos1v w=0.24u l=0.1u ad=0.0816p as=0.0528p pd=1.16u ps=0.68u
    I_MXI152_I30_XG_MN2 (I152_G6_3n I152_G6_5 VSS VSS) gpdk090_nmos1v w=0.12u l=0.1u ad=0.0468p as=0.0696p pd=0.68u ps=1.16u
    I_MXI152_I30_XG_MN0 (XI152_I30_XG_n1 I152_P6_5 I152_G6_3n VSS) gpdk090_nmos1v w=0.24u l=0.1u ad=0.0528p as=0.0468p pd=0.68u ps=0.68u
    I_MXI152_I30_XG_MN1 (VSS I152_G4_3 XI152_I30_XG_n1 VSS) gpdk090_nmos1v w=0.24u l=0.1u ad=0.0816p as=0.0528p pd=1.16u ps=0.68u
    I_MXI152_I28_XG_MN2 (I152_G4_1n I152_G4_3 VSS VSS) gpdk090_nmos1v w=0.12u l=0.1u ad=0.0468p as=0.0696p pd=0.68u ps=1.16u
    I_MXI152_I28_XG_MN0 (XI152_I28_XG_n1 I152_P4_3 I152_G4_1n VSS) gpdk090_nmos1v w=0.24u l=0.1u ad=0.0528p as=0.0468p pd=0.68u ps=0.68u
    I_MXI152_I28_XG_MN1 (VSS I152_G2_1 XI152_I28_XG_n1 VSS) gpdk090_nmos1v w=0.24u l=0.1u ad=0.0816p as=0.0528p pd=1.16u ps=0.68u
    I_MXI35_MN2 (nbkn6 nbk5 VSS VSS) gpdk090_nmos1v w=0.12u l=0.1u ad=0.0468p as=0.0696p pd=0.68u ps=1.16u
    I_MXI35_MN0 (XI35_n1 B_7 nbkn6 VSS) gpdk090_nmos1v w=0.24u l=0.1u ad=0.0528p as=0.0468p pd=0.68u ps=0.68u
    I_MXI35_MN1 (VSS B_5 XI35_n1 VSS) gpdk090_nmos1v w=0.24u l=0.1u ad=0.0816p as=0.0528p pd=1.16u ps=0.68u
    I_MXI38_MN2 (nbkn7 nbk6 VSS VSS) gpdk090_nmos1v w=0.12u l=0.1u ad=0.0468p as=0.0696p pd=0.68u ps=1.16u
    I_MXI38_MN0 (XI38_n1 B_7 nbkn7 VSS) gpdk090_nmos1v w=0.24u l=0.1u ad=0.0528p as=0.0468p pd=0.68u ps=0.68u
    I_MXI38_MN1 (VSS B_6 XI38_n1 VSS) gpdk090_nmos1v w=0.24u l=0.1u ad=0.0816p as=0.0528p pd=1.16u ps=0.68u
    I_MXI23_MN2 (nbkn2 nbk1 VSS VSS) gpdk090_nmos1v w=0.12u l=0.1u ad=0.0468p as=0.0696p pd=0.68u ps=1.16u
    I_MXI23_MN0 (XI23_n1 B_7 nbkn2 VSS) gpdk090_nmos1v w=0.24u l=0.1u ad=0.0528p as=0.0468p pd=0.68u ps=0.68u
    I_MXI23_MN1 (VSS B_1 XI23_n1 VSS) gpdk090_nmos1v w=0.24u l=0.1u ad=0.0816p as=0.0528p pd=1.16u ps=0.68u
    I_MXI172_MN2 (nqkn7 nqk6 VSS VSS) gpdk090_nmos1v w=0.12u l=0.1u ad=0.0468p as=0.0696p pd=0.68u ps=1.16u
    I_MXI172_MN0 (XI172_n1 sq nqkn7 VSS) gpdk090_nmos1v w=0.24u l=0.1u ad=0.0528p as=0.0468p pd=0.68u ps=0.68u
    I_MXI172_MN1 (VSS qu6 XI172_n1 VSS) gpdk090_nmos1v w=0.24u l=0.1u ad=0.0816p as=0.0528p pd=1.16u ps=0.68u
    I_MXI169_MN2 (nqkn6 nqk5 VSS VSS) gpdk090_nmos1v w=0.12u l=0.1u ad=0.0468p as=0.0696p pd=0.68u ps=1.16u
    I_MXI169_MN0 (XI169_n1 sq nqkn6 VSS) gpdk090_nmos1v w=0.24u l=0.1u ad=0.0528p as=0.0468p pd=0.68u ps=0.68u
    I_MXI169_MN1 (VSS qu5 XI169_n1 VSS) gpdk090_nmos1v w=0.24u l=0.1u ad=0.0816p as=0.0528p pd=1.16u ps=0.68u
    I_MXI84_I28_XG_MN2 (I84_G4_1n I84_G4_3 VSS VSS) gpdk090_nmos1v w=0.12u l=0.1u ad=0.0468p as=0.0696p pd=0.68u ps=1.16u
    I_MXI84_I28_XG_MN0 (XI84_I28_XG_n1 I84_P4_3 I84_G4_1n VSS) gpdk090_nmos1v w=0.24u l=0.1u ad=0.0528p as=0.0468p pd=0.68u ps=0.68u
    I_MXI84_I28_XG_MN1 (VSS I84_G2_1 XI84_I28_XG_n1 VSS) gpdk090_nmos1v w=0.24u l=0.1u ad=0.0816p as=0.0528p pd=1.16u ps=0.68u
    I_MXI84_I30_XG_MN2 (I84_G6_3n I84_G6_5 VSS VSS) gpdk090_nmos1v w=0.12u l=0.1u ad=0.0468p as=0.0696p pd=0.68u ps=1.16u
    I_MXI84_I30_XG_MN0 (XI84_I30_XG_n1 I84_P6_5 I84_G6_3n VSS) gpdk090_nmos1v w=0.24u l=0.1u ad=0.0528p as=0.0468p pd=0.68u ps=0.68u
    I_MXI84_I30_XG_MN1 (VSS I84_G4_3 XI84_I30_XG_n1 VSS) gpdk090_nmos1v w=0.24u l=0.1u ad=0.0816p as=0.0528p pd=1.16u ps=0.68u
    I_MXI152_I26_XG_MN2 (I152_G2_0n I152_G2_1 VSS VSS) gpdk090_nmos1v w=0.12u l=0.1u ad=0.0468p as=0.0696p pd=0.68u ps=1.16u
    I_MXI152_I26_XG_MN0 (XI152_I26_XG_n1 I152_P2_1 I152_G2_0n VSS) gpdk090_nmos1v w=0.24u l=0.1u ad=0.0528p as=0.0468p pd=0.68u ps=0.68u
    I_MXI152_I26_XG_MN1 (VSS I152_G0_0 XI152_I26_XG_n1 VSS) gpdk090_nmos1v w=0.24u l=0.1u ad=0.0816p as=0.0528p pd=1.16u ps=0.68u
    I_MXI29_MN2 (nbkn4 nbk3 VSS VSS) gpdk090_nmos1v w=0.12u l=0.1u ad=0.0468p as=0.0696p pd=0.68u ps=1.16u
    I_MXI29_MN0 (XI29_n1 B_7 nbkn4 VSS) gpdk090_nmos1v w=0.24u l=0.1u ad=0.0528p as=0.0468p pd=0.68u ps=0.68u
    I_MXI29_MN1 (VSS B_3 XI29_n1 VSS) gpdk090_nmos1v w=0.24u l=0.1u ad=0.0816p as=0.0528p pd=1.16u ps=0.68u
    I_MXI32_MN2 (nbkn5 nbk4 VSS VSS) gpdk090_nmos1v w=0.12u l=0.1u ad=0.0468p as=0.0696p pd=0.68u ps=1.16u
    I_MXI32_MN0 (XI32_n1 B_7 nbkn5 VSS) gpdk090_nmos1v w=0.24u l=0.1u ad=0.0528p as=0.0468p pd=0.68u ps=0.68u
    I_MXI32_MN1 (VSS B_4 XI32_n1 VSS) gpdk090_nmos1v w=0.24u l=0.1u ad=0.0816p as=0.0528p pd=1.16u ps=0.68u
    I_MXI15_MN2 (nakn6 nak5 VSS VSS) gpdk090_nmos1v w=0.12u l=0.1u ad=0.0468p as=0.0696p pd=0.68u ps=1.16u
    I_MXI15_MN0 (XI15_n1 A_7 nakn6 VSS) gpdk090_nmos1v w=0.24u l=0.1u ad=0.0528p as=0.0468p pd=0.68u ps=0.68u
    I_MXI15_MN1 (VSS A_5 XI15_n1 VSS) gpdk090_nmos1v w=0.24u l=0.1u ad=0.0816p as=0.0528p pd=1.16u ps=0.68u
    I_MXI84_I27_XG_MN2 (I84_G3_0n I84_G3_2 VSS VSS) gpdk090_nmos1v w=0.12u l=0.1u ad=0.0468p as=0.0696p pd=0.68u ps=1.16u
    I_MXI84_I27_XG_MN0 (XI84_I27_XG_n1 I84_P3_2 I84_G3_0n VSS) gpdk090_nmos1v w=0.24u l=0.1u ad=0.0528p as=0.0468p pd=0.68u ps=0.68u
    I_MXI84_I27_XG_MN1 (VSS I84_G1_0 XI84_I27_XG_n1 VSS) gpdk090_nmos1v w=0.24u l=0.1u ad=0.0816p as=0.0528p pd=1.16u ps=0.68u
    I_MXI84_I29_XG_MN2 (I84_G5_2n I84_G5_4 VSS VSS) gpdk090_nmos1v w=0.12u l=0.1u ad=0.0468p as=0.0696p pd=0.68u ps=1.16u
    I_MXI84_I29_XG_MN0 (XI84_I29_XG_n1 I84_P5_4 I84_G5_2n VSS) gpdk090_nmos1v w=0.24u l=0.1u ad=0.0528p as=0.0468p pd=0.68u ps=0.68u
    I_MXI84_I29_XG_MN1 (VSS I84_G3_2 XI84_I29_XG_n1 VSS) gpdk090_nmos1v w=0.24u l=0.1u ad=0.0816p as=0.0528p pd=1.16u ps=0.68u
    I_MXI192_MN2 (nrkn7 nrk6 VSS VSS) gpdk090_nmos1v w=0.12u l=0.1u ad=0.0468p as=0.0696p pd=0.68u ps=1.16u
    I_MXI192_MN0 (XI192_n1 A_7 nrkn7 VSS) gpdk090_nmos1v w=0.24u l=0.1u ad=0.0528p as=0.0468p pd=0.68u ps=0.68u
    I_MXI192_MN1 (VSS ru6 XI192_n1 VSS) gpdk090_nmos1v w=0.24u l=0.1u ad=0.0816p as=0.0528p pd=1.16u ps=0.68u
    I_MXI183_MN2 (nrkn4 nrk3 VSS VSS) gpdk090_nmos1v w=0.12u l=0.1u ad=0.0468p as=0.0696p pd=0.68u ps=1.16u
    I_MXI183_MN0 (XI183_n1 A_7 nrkn4 VSS) gpdk090_nmos1v w=0.24u l=0.1u ad=0.0528p as=0.0468p pd=0.68u ps=0.68u
    I_MXI183_MN1 (VSS ru3 XI183_n1 VSS) gpdk090_nmos1v w=0.24u l=0.1u ad=0.0816p as=0.0528p pd=1.16u ps=0.68u
    I_MXI180_MN2 (nrkn3 nrk2 VSS VSS) gpdk090_nmos1v w=0.12u l=0.1u ad=0.0468p as=0.0696p pd=0.68u ps=1.16u
    I_MXI180_MN0 (XI180_n1 A_7 nrkn3 VSS) gpdk090_nmos1v w=0.24u l=0.1u ad=0.0528p as=0.0468p pd=0.68u ps=0.68u
    I_MXI180_MN1 (VSS ru2 XI180_n1 VSS) gpdk090_nmos1v w=0.24u l=0.1u ad=0.0816p as=0.0528p pd=1.16u ps=0.68u
    I_MXI177_MN2 (nrkn2 nrk1 VSS VSS) gpdk090_nmos1v w=0.12u l=0.1u ad=0.0468p as=0.0696p pd=0.68u ps=1.16u
    I_MXI177_MN0 (XI177_n1 A_7 nrkn2 VSS) gpdk090_nmos1v w=0.24u l=0.1u ad=0.0528p as=0.0468p pd=0.68u ps=0.68u
    I_MXI177_MN1 (VSS ru1 XI177_n1 VSS) gpdk090_nmos1v w=0.24u l=0.1u ad=0.0816p as=0.0528p pd=1.16u ps=0.68u
    I_MXI26_MN2 (nbkn3 nbk2 VSS VSS) gpdk090_nmos1v w=0.12u l=0.1u ad=0.0468p as=0.0696p pd=0.68u ps=1.16u
    I_MXI26_MN0 (XI26_n1 B_7 nbkn3 VSS) gpdk090_nmos1v w=0.24u l=0.1u ad=0.0528p as=0.0468p pd=0.68u ps=0.68u
    I_MXI26_MN1 (VSS B_2 XI26_n1 VSS) gpdk090_nmos1v w=0.24u l=0.1u ad=0.0816p as=0.0528p pd=1.16u ps=0.68u
    I_MXI18_MN2 (nakn7 nak6 VSS VSS) gpdk090_nmos1v w=0.12u l=0.1u ad=0.0468p as=0.0696p pd=0.68u ps=1.16u
    I_MXI18_MN0 (XI18_n1 A_7 nakn7 VSS) gpdk090_nmos1v w=0.24u l=0.1u ad=0.0528p as=0.0468p pd=0.68u ps=0.68u
    I_MXI18_MN1 (VSS A_6 XI18_n1 VSS) gpdk090_nmos1v w=0.24u l=0.1u ad=0.0816p as=0.0528p pd=1.16u ps=0.68u
    I_MXI84_I31_XG_MN2 (I84_G7_4n I84_G7_6 VSS VSS) gpdk090_nmos1v w=0.12u l=0.1u ad=0.0468p as=0.0696p pd=0.68u ps=1.16u
    I_MXI84_I31_XG_MN0 (XI84_I31_XG_n1 I84_P7_6 I84_G7_4n VSS) gpdk090_nmos1v w=0.24u l=0.1u ad=0.0528p as=0.0468p pd=0.68u ps=0.68u
    I_MXI84_I31_XG_MN1 (VSS I84_G5_4 XI84_I31_XG_n1 VSS) gpdk090_nmos1v w=0.24u l=0.1u ad=0.0816p as=0.0528p pd=1.16u ps=0.68u
    I_MXI189_MN2 (nrkn6 nrk5 VSS VSS) gpdk090_nmos1v w=0.12u l=0.1u ad=0.0468p as=0.0696p pd=0.68u ps=1.16u
    I_MXI189_MN0 (XI189_n1 A_7 nrkn6 VSS) gpdk090_nmos1v w=0.24u l=0.1u ad=0.0528p as=0.0468p pd=0.68u ps=0.68u
    I_MXI189_MN1 (VSS ru5 XI189_n1 VSS) gpdk090_nmos1v w=0.24u l=0.1u ad=0.0816p as=0.0528p pd=1.16u ps=0.68u
    I_MXI186_MN2 (nrkn5 nrk4 VSS VSS) gpdk090_nmos1v w=0.12u l=0.1u ad=0.0468p as=0.0696p pd=0.68u ps=1.16u
    I_MXI186_MN0 (XI186_n1 A_7 nrkn5 VSS) gpdk090_nmos1v w=0.24u l=0.1u ad=0.0528p as=0.0468p pd=0.68u ps=0.68u
    I_MXI186_MN1 (VSS ru4 XI186_n1 VSS) gpdk090_nmos1v w=0.24u l=0.1u ad=0.0816p as=0.0528p pd=1.16u ps=0.68u
    I_MXI72_I26_XG_MN2 (I72_G2_0n I72_G2_1 VSS VSS) gpdk090_nmos1v w=0.12u l=0.1u ad=0.0468p as=0.0696p pd=0.68u ps=1.16u
    I_MXI72_I26_XG_MN0 (XI72_I26_XG_n1 I72_P2_1 I72_G2_0n VSS) gpdk090_nmos1v w=0.24u l=0.1u ad=0.0528p as=0.0468p pd=0.68u ps=0.68u
    I_MXI72_I26_XG_MN1 (VSS I72_G0_0 XI72_I26_XG_n1 VSS) gpdk090_nmos1v w=0.24u l=0.1u ad=0.0816p as=0.0528p pd=1.16u ps=0.68u
    I_MXI48_I28_XG_MN2 (I48_G4_1n I48_G4_3 VSS VSS) gpdk090_nmos1v w=0.12u l=0.1u ad=0.0468p as=0.0696p pd=0.68u ps=1.16u
    I_MXI48_I28_XG_MN0 (XI48_I28_XG_n1 I48_P4_3 I48_G4_1n VSS) gpdk090_nmos1v w=0.24u l=0.1u ad=0.0528p as=0.0468p pd=0.68u ps=0.68u
    I_MXI48_I28_XG_MN1 (VSS I48_G2_1 XI48_I28_XG_n1 VSS) gpdk090_nmos1v w=0.24u l=0.1u ad=0.0816p as=0.0528p pd=1.16u ps=0.68u
    I_MXI48_I26_XG_MN2 (I48_G2_0n I48_G2_1 VSS VSS) gpdk090_nmos1v w=0.12u l=0.1u ad=0.0468p as=0.0696p pd=0.68u ps=1.16u
    I_MXI48_I26_XG_MN0 (XI48_I26_XG_n1 I48_P2_1 I48_G2_0n VSS) gpdk090_nmos1v w=0.24u l=0.1u ad=0.0528p as=0.0468p pd=0.68u ps=0.68u
    I_MXI48_I26_XG_MN1 (VSS I48_G0_0 XI48_I26_XG_n1 VSS) gpdk090_nmos1v w=0.24u l=0.1u ad=0.0816p as=0.0528p pd=1.16u ps=0.68u
    I_MXI72_I28_XG_MN2 (I72_G4_1n I72_G4_3 VSS VSS) gpdk090_nmos1v w=0.12u l=0.1u ad=0.0468p as=0.0696p pd=0.68u ps=1.16u
    I_MXI72_I28_XG_MN0 (XI72_I28_XG_n1 I72_P4_3 I72_G4_1n VSS) gpdk090_nmos1v w=0.24u l=0.1u ad=0.0528p as=0.0468p pd=0.68u ps=0.68u
    I_MXI72_I28_XG_MN1 (VSS I72_G2_1 XI72_I28_XG_n1 VSS) gpdk090_nmos1v w=0.24u l=0.1u ad=0.0816p as=0.0528p pd=1.16u ps=0.68u
    I_MXI48_I30_XG_MN2 (I48_G6_3n I48_G6_5 VSS VSS) gpdk090_nmos1v w=0.12u l=0.1u ad=0.0468p as=0.0696p pd=0.68u ps=1.16u
    I_MXI48_I30_XG_MN0 (XI48_I30_XG_n1 I48_P6_5 I48_G6_3n VSS) gpdk090_nmos1v w=0.24u l=0.1u ad=0.0528p as=0.0468p pd=0.68u ps=0.68u
    I_MXI48_I30_XG_MN1 (VSS I48_G4_3 XI48_I30_XG_n1 VSS) gpdk090_nmos1v w=0.24u l=0.1u ad=0.0816p as=0.0528p pd=1.16u ps=0.68u
    I_MXI48_I27_XG_MN2 (I48_G3_0n I48_G3_2 VSS VSS) gpdk090_nmos1v w=0.12u l=0.1u ad=0.0468p as=0.0696p pd=0.68u ps=1.16u
    I_MXI48_I27_XG_MN0 (XI48_I27_XG_n1 I48_P3_2 I48_G3_0n VSS) gpdk090_nmos1v w=0.24u l=0.1u ad=0.0528p as=0.0468p pd=0.68u ps=0.68u
    I_MXI48_I27_XG_MN1 (VSS I48_G1_0 XI48_I27_XG_n1 VSS) gpdk090_nmos1v w=0.24u l=0.1u ad=0.0816p as=0.0528p pd=1.16u ps=0.68u
    I_MXI60_I27_XG_MN2 (I60_G3_0n I60_G3_2 VSS VSS) gpdk090_nmos1v w=0.12u l=0.1u ad=0.0468p as=0.0696p pd=0.68u ps=1.16u
    I_MXI60_I27_XG_MN0 (XI60_I27_XG_n1 I60_P3_2 I60_G3_0n VSS) gpdk090_nmos1v w=0.24u l=0.1u ad=0.0528p as=0.0468p pd=0.68u ps=0.68u
    I_MXI60_I27_XG_MN1 (VSS I60_G1_0 XI60_I27_XG_n1 VSS) gpdk090_nmos1v w=0.24u l=0.1u ad=0.0816p as=0.0528p pd=1.16u ps=0.68u
    I_MXI60_I26_XG_MN2 (I60_G2_0n I60_G2_1 VSS VSS) gpdk090_nmos1v w=0.12u l=0.1u ad=0.0468p as=0.0696p pd=0.68u ps=1.16u
    I_MXI60_I26_XG_MN0 (XI60_I26_XG_n1 I60_P2_1 I60_G2_0n VSS) gpdk090_nmos1v w=0.24u l=0.1u ad=0.0528p as=0.0468p pd=0.68u ps=0.68u
    I_MXI60_I26_XG_MN1 (VSS I60_G0_0 XI60_I26_XG_n1 VSS) gpdk090_nmos1v w=0.24u l=0.1u ad=0.0816p as=0.0528p pd=1.16u ps=0.68u
    I_MXI60_I28_XG_MN2 (I60_G4_1n I60_G4_3 VSS VSS) gpdk090_nmos1v w=0.12u l=0.1u ad=0.0468p as=0.0696p pd=0.68u ps=1.16u
    I_MXI60_I28_XG_MN0 (XI60_I28_XG_n1 I60_P4_3 I60_G4_1n VSS) gpdk090_nmos1v w=0.24u l=0.1u ad=0.0528p as=0.0468p pd=0.68u ps=0.68u
    I_MXI60_I28_XG_MN1 (VSS I60_G2_1 XI60_I28_XG_n1 VSS) gpdk090_nmos1v w=0.24u l=0.1u ad=0.0816p as=0.0528p pd=1.16u ps=0.68u
    I_MXI72_I27_XG_MN2 (I72_G3_0n I72_G3_2 VSS VSS) gpdk090_nmos1v w=0.12u l=0.1u ad=0.0468p as=0.0696p pd=0.68u ps=1.16u
    I_MXI72_I27_XG_MN0 (XI72_I27_XG_n1 I72_P3_2 I72_G3_0n VSS) gpdk090_nmos1v w=0.24u l=0.1u ad=0.0528p as=0.0468p pd=0.68u ps=0.68u
    I_MXI72_I27_XG_MN1 (VSS I72_G1_0 XI72_I27_XG_n1 VSS) gpdk090_nmos1v w=0.24u l=0.1u ad=0.0816p as=0.0528p pd=1.16u ps=0.68u
    I_MXI72_I29_XG_MN2 (I72_G5_2n I72_G5_4 VSS VSS) gpdk090_nmos1v w=0.12u l=0.1u ad=0.0468p as=0.0696p pd=0.68u ps=1.16u
    I_MXI72_I29_XG_MN0 (XI72_I29_XG_n1 I72_P5_4 I72_G5_2n VSS) gpdk090_nmos1v w=0.24u l=0.1u ad=0.0528p as=0.0468p pd=0.68u ps=0.68u
    I_MXI72_I29_XG_MN1 (VSS I72_G3_2 XI72_I29_XG_n1 VSS) gpdk090_nmos1v w=0.24u l=0.1u ad=0.0816p as=0.0528p pd=1.16u ps=0.68u
    I_MXI48_I31_XG_MN2 (I48_G7_4n I48_G7_6 VSS VSS) gpdk090_nmos1v w=0.12u l=0.1u ad=0.0468p as=0.0696p pd=0.68u ps=1.16u
    I_MXI48_I31_XG_MN0 (XI48_I31_XG_n1 I48_P7_6 I48_G7_4n VSS) gpdk090_nmos1v w=0.24u l=0.1u ad=0.0528p as=0.0468p pd=0.68u ps=0.68u
    I_MXI48_I31_XG_MN1 (VSS I48_G5_4 XI48_I31_XG_n1 VSS) gpdk090_nmos1v w=0.24u l=0.1u ad=0.0816p as=0.0528p pd=1.16u ps=0.68u
    I_MXI48_I29_XG_MN2 (I48_G5_2n I48_G5_4 VSS VSS) gpdk090_nmos1v w=0.12u l=0.1u ad=0.0468p as=0.0696p pd=0.68u ps=1.16u
    I_MXI48_I29_XG_MN0 (XI48_I29_XG_n1 I48_P5_4 I48_G5_2n VSS) gpdk090_nmos1v w=0.24u l=0.1u ad=0.0528p as=0.0468p pd=0.68u ps=0.68u
    I_MXI48_I29_XG_MN1 (VSS I48_G3_2 XI48_I29_XG_n1 VSS) gpdk090_nmos1v w=0.24u l=0.1u ad=0.0816p as=0.0528p pd=1.16u ps=0.68u
    I_MXI60_I29_XG_MN2 (I60_G5_2n I60_G5_4 VSS VSS) gpdk090_nmos1v w=0.12u l=0.1u ad=0.0468p as=0.0696p pd=0.68u ps=1.16u
    I_MXI60_I29_XG_MN0 (XI60_I29_XG_n1 I60_P5_4 I60_G5_2n VSS) gpdk090_nmos1v w=0.24u l=0.1u ad=0.0528p as=0.0468p pd=0.68u ps=0.68u
    I_MXI60_I29_XG_MN1 (VSS I60_G3_2 XI60_I29_XG_n1 VSS) gpdk090_nmos1v w=0.24u l=0.1u ad=0.0816p as=0.0528p pd=1.16u ps=0.68u
    I_MXI60_I30_XG_MN2 (I60_G6_3n I60_G6_5 VSS VSS) gpdk090_nmos1v w=0.12u l=0.1u ad=0.0468p as=0.0696p pd=0.68u ps=1.16u
    I_MXI60_I30_XG_MN0 (XI60_I30_XG_n1 I60_P6_5 I60_G6_3n VSS) gpdk090_nmos1v w=0.24u l=0.1u ad=0.0528p as=0.0468p pd=0.68u ps=0.68u
    I_MXI60_I30_XG_MN1 (VSS I60_G4_3 XI60_I30_XG_n1 VSS) gpdk090_nmos1v w=0.24u l=0.1u ad=0.0816p as=0.0528p pd=1.16u ps=0.68u
    I_MXI72_I30_XG_MN2 (I72_G6_3n I72_G6_5 VSS VSS) gpdk090_nmos1v w=0.12u l=0.1u ad=0.0468p as=0.0696p pd=0.68u ps=1.16u
    I_MXI72_I30_XG_MN0 (XI72_I30_XG_n1 I72_P6_5 I72_G6_3n VSS) gpdk090_nmos1v w=0.24u l=0.1u ad=0.0528p as=0.0468p pd=0.68u ps=0.68u
    I_MXI72_I30_XG_MN1 (VSS I72_G4_3 XI72_I30_XG_n1 VSS) gpdk090_nmos1v w=0.24u l=0.1u ad=0.0816p as=0.0528p pd=1.16u ps=0.68u
    I_MXI60_I31_XG_MN2 (I60_G7_4n I60_G7_6 VSS VSS) gpdk090_nmos1v w=0.12u l=0.1u ad=0.0468p as=0.0696p pd=0.68u ps=1.16u
    I_MXI60_I31_XG_MN0 (XI60_I31_XG_n1 I60_P7_6 I60_G7_4n VSS) gpdk090_nmos1v w=0.24u l=0.1u ad=0.0528p as=0.0468p pd=0.68u ps=0.68u
    I_MXI60_I31_XG_MN1 (VSS I60_G5_4 XI60_I31_XG_n1 VSS) gpdk090_nmos1v w=0.24u l=0.1u ad=0.0816p as=0.0528p pd=1.16u ps=0.68u
    I_MXI72_I31_XG_MN2 (I72_G7_4n I72_G7_6 VSS VSS) gpdk090_nmos1v w=0.12u l=0.1u ad=0.0468p as=0.0696p pd=0.68u ps=1.16u
    I_MXI72_I31_XG_MN0 (XI72_I31_XG_n1 I72_P7_6 I72_G7_4n VSS) gpdk090_nmos1v w=0.24u l=0.1u ad=0.0528p as=0.0468p pd=0.68u ps=0.68u
    I_MXI72_I31_XG_MN1 (VSS I72_G5_4 XI72_I31_XG_n1 VSS) gpdk090_nmos1v w=0.24u l=0.1u ad=0.0816p as=0.0528p pd=1.16u ps=0.68u
    I_MXI120_I36_XG_MN2 (XI120_I36_XG_n1 I120_G7_4n VSS VSS) gpdk090_nmos1v w=0.24u l=0.1u ad=0.0528p as=0.0816p pd=0.68u ps=1.16u
    I_MXI120_I36_XG_MN0 (c6_8 I120_P7_4n XI120_I36_XG_n1 VSS) gpdk090_nmos1v w=0.24u l=0.1u ad=0.0528p as=0.0528p pd=0.68u ps=0.68u
    I_MXI120_I36_XG_MN1 (XI120_I36_XG_n1 I120_G3_0n c6_8 VSS) gpdk090_nmos1v w=0.24u l=0.1u ad=0.0816p as=0.0528p pd=1.16u ps=0.68u
    I_MXI120_I25_XG_MN2 (XI120_I25_XG_n1 I120_gn7 VSS VSS) gpdk090_nmos1v w=0.24u l=0.1u ad=0.0528p as=0.0816p pd=0.68u ps=1.16u
    I_MXI120_I25_XG_MN0 (I120_G7_6 I120_pn7 XI120_I25_XG_n1 VSS) gpdk090_nmos1v w=0.24u l=0.1u ad=0.0528p as=0.0528p pd=0.68u ps=0.68u
    I_MXI120_I25_XG_MN1 (XI120_I25_XG_n1 I120_gn6 I120_G7_6 VSS) gpdk090_nmos1v w=0.24u l=0.1u ad=0.0816p as=0.0528p pd=1.16u ps=0.68u
    I_MXI108_I35_XG_MN2 (XI108_I35_XG_n1 I108_G6_3n VSS VSS) gpdk090_nmos1v w=0.24u l=0.1u ad=0.0528p as=0.0816p pd=0.68u ps=1.16u
    I_MXI108_I35_XG_MN0 (c5_7 I108_P6_3n XI108_I35_XG_n1 VSS) gpdk090_nmos1v w=0.24u l=0.1u ad=0.0528p as=0.0528p pd=0.68u ps=0.68u
    I_MXI108_I35_XG_MN1 (XI108_I35_XG_n1 I108_G2_0n c5_7 VSS) gpdk090_nmos1v w=0.24u l=0.1u ad=0.0816p as=0.0528p pd=1.16u ps=0.68u
    I_MXI108_I34_XG_MN2 (XI108_I34_XG_n1 I108_G5_2n VSS VSS) gpdk090_nmos1v w=0.24u l=0.1u ad=0.0528p as=0.0816p pd=0.68u ps=1.16u
    I_MXI108_I34_XG_MN0 (I108_G5_0 I108_P5_2n XI108_I34_XG_n1 VSS) gpdk090_nmos1v w=0.24u l=0.1u ad=0.0528p as=0.0528p pd=0.68u ps=0.68u
    I_MXI108_I34_XG_MN1 (XI108_I34_XG_n1 I108_G1_0n I108_G5_0 VSS) gpdk090_nmos1v w=0.24u l=0.1u ad=0.0816p as=0.0528p pd=1.16u ps=0.68u
    I_MXI108_I25_XG_MN2 (XI108_I25_XG_n1 I108_gn7 VSS VSS) gpdk090_nmos1v w=0.24u l=0.1u ad=0.0528p as=0.0816p pd=0.68u ps=1.16u
    I_MXI108_I25_XG_MN0 (I108_G7_6 I108_pn7 XI108_I25_XG_n1 VSS) gpdk090_nmos1v w=0.24u l=0.1u ad=0.0528p as=0.0528p pd=0.68u ps=0.68u
    I_MXI108_I25_XG_MN1 (XI108_I25_XG_n1 I108_gn6 I108_G7_6 VSS) gpdk090_nmos1v w=0.24u l=0.1u ad=0.0816p as=0.0528p pd=1.16u ps=0.68u
    I_MXI132_I25_XG_MN2 (XI132_I25_XG_n1 I132_gn7 VSS VSS) gpdk090_nmos1v w=0.24u l=0.1u ad=0.0528p as=0.0816p pd=0.68u ps=1.16u
    I_MXI132_I25_XG_MN0 (I132_G7_6 I132_pn7 XI132_I25_XG_n1 VSS) gpdk090_nmos1v w=0.24u l=0.1u ad=0.0528p as=0.0528p pd=0.68u ps=0.68u
    I_MXI132_I25_XG_MN1 (XI132_I25_XG_n1 I132_gn6 I132_G7_6 VSS) gpdk090_nmos1v w=0.24u l=0.1u ad=0.0816p as=0.0528p pd=1.16u ps=0.68u
    I_MXI132_I24_XG_MN2 (XI132_I24_XG_n1 I132_gn6 VSS VSS) gpdk090_nmos1v w=0.24u l=0.1u ad=0.0528p as=0.0816p pd=0.68u ps=1.16u
    I_MXI132_I24_XG_MN0 (I132_G6_5 I132_pn6 XI132_I24_XG_n1 VSS) gpdk090_nmos1v w=0.24u l=0.1u ad=0.0528p as=0.0528p pd=0.68u ps=0.68u
    I_MXI132_I24_XG_MN1 (XI132_I24_XG_n1 I132_gn5 I132_G6_5 VSS) gpdk090_nmos1v w=0.24u l=0.1u ad=0.0816p as=0.0528p pd=1.16u ps=0.68u
    I_MXI120_I35_XG_MN2 (XI120_I35_XG_n1 I120_G6_3n VSS VSS) gpdk090_nmos1v w=0.24u l=0.1u ad=0.0528p as=0.0816p pd=0.68u ps=1.16u
    I_MXI120_I35_XG_MN0 (c6_7 I120_P6_3n XI120_I35_XG_n1 VSS) gpdk090_nmos1v w=0.24u l=0.1u ad=0.0528p as=0.0528p pd=0.68u ps=0.68u
    I_MXI120_I35_XG_MN1 (XI120_I35_XG_n1 I120_G2_0n c6_7 VSS) gpdk090_nmos1v w=0.24u l=0.1u ad=0.0816p as=0.0528p pd=1.16u ps=0.68u
    I_MXI120_I34_XG_MN2 (XI120_I34_XG_n1 I120_G5_2n VSS VSS) gpdk090_nmos1v w=0.24u l=0.1u ad=0.0528p as=0.0816p pd=0.68u ps=1.16u
    I_MXI120_I34_XG_MN0 (I120_G5_0 I120_P5_2n XI120_I34_XG_n1 VSS) gpdk090_nmos1v w=0.24u l=0.1u ad=0.0528p as=0.0528p pd=0.68u ps=0.68u
    I_MXI120_I34_XG_MN1 (XI120_I34_XG_n1 I120_G1_0n I120_G5_0 VSS) gpdk090_nmos1v w=0.24u l=0.1u ad=0.0816p as=0.0528p pd=1.16u ps=0.68u
    I_MXI120_I23_XG_MN2 (XI120_I23_XG_n1 I120_gn5 VSS VSS) gpdk090_nmos1v w=0.24u l=0.1u ad=0.0528p as=0.0816p pd=0.68u ps=1.16u
    I_MXI120_I23_XG_MN0 (I120_G5_4 I120_pn5 XI120_I23_XG_n1 VSS) gpdk090_nmos1v w=0.24u l=0.1u ad=0.0528p as=0.0528p pd=0.68u ps=0.68u
    I_MXI120_I23_XG_MN1 (XI120_I23_XG_n1 I120_gn4 I120_G5_4 VSS) gpdk090_nmos1v w=0.24u l=0.1u ad=0.0816p as=0.0528p pd=1.16u ps=0.68u
    I_MXI120_I24_XG_MN2 (XI120_I24_XG_n1 I120_gn6 VSS VSS) gpdk090_nmos1v w=0.24u l=0.1u ad=0.0528p as=0.0816p pd=0.68u ps=1.16u
    I_MXI120_I24_XG_MN0 (I120_G6_5 I120_pn6 XI120_I24_XG_n1 VSS) gpdk090_nmos1v w=0.24u l=0.1u ad=0.0528p as=0.0528p pd=0.68u ps=0.68u
    I_MXI120_I24_XG_MN1 (XI120_I24_XG_n1 I120_gn5 I120_G6_5 VSS) gpdk090_nmos1v w=0.24u l=0.1u ad=0.0816p as=0.0528p pd=1.16u ps=0.68u
    I_MXI108_I23_XG_MN2 (XI108_I23_XG_n1 I108_gn5 VSS VSS) gpdk090_nmos1v w=0.24u l=0.1u ad=0.0528p as=0.0816p pd=0.68u ps=1.16u
    I_MXI108_I23_XG_MN0 (I108_G5_4 I108_pn5 XI108_I23_XG_n1 VSS) gpdk090_nmos1v w=0.24u l=0.1u ad=0.0528p as=0.0528p pd=0.68u ps=0.68u
    I_MXI108_I23_XG_MN1 (XI108_I23_XG_n1 I108_gn4 I108_G5_4 VSS) gpdk090_nmos1v w=0.24u l=0.1u ad=0.0816p as=0.0528p pd=1.16u ps=0.68u
    I_MXI108_I36_XG_MN2 (XI108_I36_XG_n1 I108_G7_4n VSS VSS) gpdk090_nmos1v w=0.24u l=0.1u ad=0.0528p as=0.0816p pd=0.68u ps=1.16u
    I_MXI108_I36_XG_MN0 (c5_8 I108_P7_4n XI108_I36_XG_n1 VSS) gpdk090_nmos1v w=0.24u l=0.1u ad=0.0528p as=0.0528p pd=0.68u ps=0.68u
    I_MXI108_I36_XG_MN1 (XI108_I36_XG_n1 I108_G3_0n c5_8 VSS) gpdk090_nmos1v w=0.24u l=0.1u ad=0.0816p as=0.0528p pd=1.16u ps=0.68u
    I_MXI108_I24_XG_MN2 (XI108_I24_XG_n1 I108_gn6 VSS VSS) gpdk090_nmos1v w=0.24u l=0.1u ad=0.0528p as=0.0816p pd=0.68u ps=1.16u
    I_MXI108_I24_XG_MN0 (I108_G6_5 I108_pn6 XI108_I24_XG_n1 VSS) gpdk090_nmos1v w=0.24u l=0.1u ad=0.0528p as=0.0528p pd=0.68u ps=0.68u
    I_MXI108_I24_XG_MN1 (XI108_I24_XG_n1 I108_gn5 I108_G6_5 VSS) gpdk090_nmos1v w=0.24u l=0.1u ad=0.0816p as=0.0528p pd=1.16u ps=0.68u
    I_MXI132_I36_XG_MN2 (XI132_I36_XG_n1 I132_G7_4n VSS VSS) gpdk090_nmos1v w=0.24u l=0.1u ad=0.0528p as=0.0816p pd=0.68u ps=1.16u
    I_MXI132_I36_XG_MN0 (c7_8 I132_P7_4n XI132_I36_XG_n1 VSS) gpdk090_nmos1v w=0.24u l=0.1u ad=0.0528p as=0.0528p pd=0.68u ps=0.68u
    I_MXI132_I36_XG_MN1 (XI132_I36_XG_n1 I132_G3_0n c7_8 VSS) gpdk090_nmos1v w=0.24u l=0.1u ad=0.0816p as=0.0528p pd=1.16u ps=0.68u
    I_MXI132_I23_XG_MN2 (XI132_I23_XG_n1 I132_gn5 VSS VSS) gpdk090_nmos1v w=0.24u l=0.1u ad=0.0528p as=0.0816p pd=0.68u ps=1.16u
    I_MXI132_I23_XG_MN0 (I132_G5_4 I132_pn5 XI132_I23_XG_n1 VSS) gpdk090_nmos1v w=0.24u l=0.1u ad=0.0528p as=0.0528p pd=0.68u ps=0.68u
    I_MXI132_I23_XG_MN1 (XI132_I23_XG_n1 I132_gn4 I132_G5_4 VSS) gpdk090_nmos1v w=0.24u l=0.1u ad=0.0816p as=0.0528p pd=1.16u ps=0.68u
    I_MXI132_I22_XG_MN2 (XI132_I22_XG_n1 I132_gn4 VSS VSS) gpdk090_nmos1v w=0.24u l=0.1u ad=0.0528p as=0.0816p pd=0.68u ps=1.16u
    I_MXI132_I22_XG_MN0 (I132_G4_3 I132_pn4 XI132_I22_XG_n1 VSS) gpdk090_nmos1v w=0.24u l=0.1u ad=0.0528p as=0.0528p pd=0.68u ps=0.68u
    I_MXI132_I22_XG_MN1 (XI132_I22_XG_n1 I132_gn3 I132_G4_3 VSS) gpdk090_nmos1v w=0.24u l=0.1u ad=0.0816p as=0.0528p pd=1.16u ps=0.68u
    I_MXI120_I32_XG_MN2 (XI120_I32_XG_n1 I120_G4_1n VSS VSS) gpdk090_nmos1v w=0.24u l=0.1u ad=0.0528p as=0.0816p pd=0.68u ps=1.16u
    I_MXI120_I32_XG_MN0 (I120_G4_0 I120_P4_1n XI120_I32_XG_n1 VSS) gpdk090_nmos1v w=0.24u l=0.1u ad=0.0528p as=0.0528p pd=0.68u ps=0.68u
    I_MXI120_I32_XG_MN1 (XI120_I32_XG_n1 I120_G0_0n I120_G4_0 VSS) gpdk090_nmos1v w=0.24u l=0.1u ad=0.0816p as=0.0528p pd=1.16u ps=0.68u
    I_MXI120_I22_XG_MN2 (XI120_I22_XG_n1 I120_gn4 VSS VSS) gpdk090_nmos1v w=0.24u l=0.1u ad=0.0528p as=0.0816p pd=0.68u ps=1.16u
    I_MXI120_I22_XG_MN0 (I120_G4_3 I120_pn4 XI120_I22_XG_n1 VSS) gpdk090_nmos1v w=0.24u l=0.1u ad=0.0528p as=0.0528p pd=0.68u ps=0.68u
    I_MXI120_I22_XG_MN1 (XI120_I22_XG_n1 I120_gn3 I120_G4_3 VSS) gpdk090_nmos1v w=0.24u l=0.1u ad=0.0816p as=0.0528p pd=1.16u ps=0.68u
    I_MXI120_I21_XG_MN2 (XI120_I21_XG_n1 I120_gn3 VSS VSS) gpdk090_nmos1v w=0.24u l=0.1u ad=0.0528p as=0.0816p pd=0.68u ps=1.16u
    I_MXI120_I21_XG_MN0 (I120_G3_2 I120_pn3 XI120_I21_XG_n1 VSS) gpdk090_nmos1v w=0.24u l=0.1u ad=0.0528p as=0.0528p pd=0.68u ps=0.68u
    I_MXI120_I21_XG_MN1 (XI120_I21_XG_n1 I120_gn2 I120_G3_2 VSS) gpdk090_nmos1v w=0.24u l=0.1u ad=0.0816p as=0.0528p pd=1.16u ps=0.68u
    I_MXI108_I32_XG_MN2 (XI108_I32_XG_n1 I108_G4_1n VSS VSS) gpdk090_nmos1v w=0.24u l=0.1u ad=0.0528p as=0.0816p pd=0.68u ps=1.16u
    I_MXI108_I32_XG_MN0 (I108_G4_0 I108_P4_1n XI108_I32_XG_n1 VSS) gpdk090_nmos1v w=0.24u l=0.1u ad=0.0528p as=0.0528p pd=0.68u ps=0.68u
    I_MXI108_I32_XG_MN1 (XI108_I32_XG_n1 I108_G0_0n I108_G4_0 VSS) gpdk090_nmos1v w=0.24u l=0.1u ad=0.0816p as=0.0528p pd=1.16u ps=0.68u
    I_MXI108_I21_XG_MN2 (XI108_I21_XG_n1 I108_gn3 VSS VSS) gpdk090_nmos1v w=0.24u l=0.1u ad=0.0528p as=0.0816p pd=0.68u ps=1.16u
    I_MXI108_I21_XG_MN0 (I108_G3_2 I108_pn3 XI108_I21_XG_n1 VSS) gpdk090_nmos1v w=0.24u l=0.1u ad=0.0528p as=0.0528p pd=0.68u ps=0.68u
    I_MXI108_I21_XG_MN1 (XI108_I21_XG_n1 I108_gn2 I108_G3_2 VSS) gpdk090_nmos1v w=0.24u l=0.1u ad=0.0816p as=0.0528p pd=1.16u ps=0.68u
    I_MXI108_I22_XG_MN2 (XI108_I22_XG_n1 I108_gn4 VSS VSS) gpdk090_nmos1v w=0.24u l=0.1u ad=0.0528p as=0.0816p pd=0.68u ps=1.16u
    I_MXI108_I22_XG_MN0 (I108_G4_3 I108_pn4 XI108_I22_XG_n1 VSS) gpdk090_nmos1v w=0.24u l=0.1u ad=0.0528p as=0.0528p pd=0.68u ps=0.68u
    I_MXI108_I22_XG_MN1 (XI108_I22_XG_n1 I108_gn3 I108_G4_3 VSS) gpdk090_nmos1v w=0.24u l=0.1u ad=0.0816p as=0.0528p pd=1.16u ps=0.68u
    I_MXI132_I34_XG_MN2 (XI132_I34_XG_n1 I132_G5_2n VSS VSS) gpdk090_nmos1v w=0.24u l=0.1u ad=0.0528p as=0.0816p pd=0.68u ps=1.16u
    I_MXI132_I34_XG_MN0 (I132_G5_0 I132_P5_2n XI132_I34_XG_n1 VSS) gpdk090_nmos1v w=0.24u l=0.1u ad=0.0528p as=0.0528p pd=0.68u ps=0.68u
    I_MXI132_I34_XG_MN1 (XI132_I34_XG_n1 I132_G1_0n I132_G5_0 VSS) gpdk090_nmos1v w=0.24u l=0.1u ad=0.0816p as=0.0528p pd=1.16u ps=0.68u
    I_MXI132_I35_XG_MN2 (XI132_I35_XG_n1 I132_G6_3n VSS VSS) gpdk090_nmos1v w=0.24u l=0.1u ad=0.0528p as=0.0816p pd=0.68u ps=1.16u
    I_MXI132_I35_XG_MN0 (c7_7 I132_P6_3n XI132_I35_XG_n1 VSS) gpdk090_nmos1v w=0.24u l=0.1u ad=0.0528p as=0.0528p pd=0.68u ps=0.68u
    I_MXI132_I35_XG_MN1 (XI132_I35_XG_n1 I132_G2_0n c7_7 VSS) gpdk090_nmos1v w=0.24u l=0.1u ad=0.0816p as=0.0528p pd=1.16u ps=0.68u
    I_MXI132_I21_XG_MN2 (XI132_I21_XG_n1 I132_gn3 VSS VSS) gpdk090_nmos1v w=0.24u l=0.1u ad=0.0528p as=0.0816p pd=0.68u ps=1.16u
    I_MXI132_I21_XG_MN0 (I132_G3_2 I132_pn3 XI132_I21_XG_n1 VSS) gpdk090_nmos1v w=0.24u l=0.1u ad=0.0528p as=0.0528p pd=0.68u ps=0.68u
    I_MXI132_I21_XG_MN1 (XI132_I21_XG_n1 I132_gn2 I132_G3_2 VSS) gpdk090_nmos1v w=0.24u l=0.1u ad=0.0816p as=0.0528p pd=1.16u ps=0.68u
    I_MXI120_I19_XG_MN2 (XI120_I19_XG_n1 I120_gn1 VSS VSS) gpdk090_nmos1v w=0.24u l=0.1u ad=0.0528p as=0.0816p pd=0.68u ps=1.16u
    I_MXI120_I19_XG_MN0 (I120_G1_0 I120_pn1 XI120_I19_XG_n1 VSS) gpdk090_nmos1v w=0.24u l=0.1u ad=0.0528p as=0.0528p pd=0.68u ps=0.68u
    I_MXI120_I19_XG_MN1 (XI120_I19_XG_n1 I120_G0_0n I120_G1_0 VSS) gpdk090_nmos1v w=0.24u l=0.1u ad=0.0816p as=0.0528p pd=1.16u ps=0.68u
    I_MXI120_I20_XG_MN2 (XI120_I20_XG_n1 I120_gn2 VSS VSS) gpdk090_nmos1v w=0.24u l=0.1u ad=0.0528p as=0.0816p pd=0.68u ps=1.16u
    I_MXI120_I20_XG_MN0 (I120_G2_1 I120_pn2 XI120_I20_XG_n1 VSS) gpdk090_nmos1v w=0.24u l=0.1u ad=0.0528p as=0.0528p pd=0.68u ps=0.68u
    I_MXI120_I20_XG_MN1 (XI120_I20_XG_n1 I120_gn1 I120_G2_1 VSS) gpdk090_nmos1v w=0.24u l=0.1u ad=0.0816p as=0.0528p pd=1.16u ps=0.68u
    I_MXI108_I19_XG_MN2 (XI108_I19_XG_n1 I108_gn1 VSS VSS) gpdk090_nmos1v w=0.24u l=0.1u ad=0.0528p as=0.0816p pd=0.68u ps=1.16u
    I_MXI108_I19_XG_MN0 (I108_G1_0 I108_pn1 XI108_I19_XG_n1 VSS) gpdk090_nmos1v w=0.24u l=0.1u ad=0.0528p as=0.0528p pd=0.68u ps=0.68u
    I_MXI108_I19_XG_MN1 (XI108_I19_XG_n1 I108_G0_0n I108_G1_0 VSS) gpdk090_nmos1v w=0.24u l=0.1u ad=0.0816p as=0.0528p pd=1.16u ps=0.68u
    I_MXI108_I20_XG_MN2 (XI108_I20_XG_n1 I108_gn2 VSS VSS) gpdk090_nmos1v w=0.24u l=0.1u ad=0.0528p as=0.0816p pd=0.68u ps=1.16u
    I_MXI108_I20_XG_MN0 (I108_G2_1 I108_pn2 XI108_I20_XG_n1 VSS) gpdk090_nmos1v w=0.24u l=0.1u ad=0.0528p as=0.0528p pd=0.68u ps=0.68u
    I_MXI108_I20_XG_MN1 (XI108_I20_XG_n1 I108_gn1 I108_G2_1 VSS) gpdk090_nmos1v w=0.24u l=0.1u ad=0.0816p as=0.0528p pd=1.16u ps=0.68u
    I_MXI96_I34_XG_MN2 (XI96_I34_XG_n1 I96_G5_2n VSS VSS) gpdk090_nmos1v w=0.24u l=0.1u ad=0.0528p as=0.0816p pd=0.68u ps=1.16u
    I_MXI96_I34_XG_MN0 (I96_G5_0 I96_P5_2n XI96_I34_XG_n1 VSS) gpdk090_nmos1v w=0.24u l=0.1u ad=0.0528p as=0.0528p pd=0.68u ps=0.68u
    I_MXI96_I34_XG_MN1 (XI96_I34_XG_n1 I96_G1_0n I96_G5_0 VSS) gpdk090_nmos1v w=0.24u l=0.1u ad=0.0816p as=0.0528p pd=1.16u ps=0.68u
    I_MXI96_I36_XG_MN2 (XI96_I36_XG_n1 I96_G7_4n VSS VSS) gpdk090_nmos1v w=0.24u l=0.1u ad=0.0528p as=0.0816p pd=0.68u ps=1.16u
    I_MXI96_I36_XG_MN0 (c4_8 I96_P7_4n XI96_I36_XG_n1 VSS) gpdk090_nmos1v w=0.24u l=0.1u ad=0.0528p as=0.0528p pd=0.68u ps=0.68u
    I_MXI96_I36_XG_MN1 (XI96_I36_XG_n1 I96_G3_0n c4_8 VSS) gpdk090_nmos1v w=0.24u l=0.1u ad=0.0816p as=0.0528p pd=1.16u ps=0.68u
    I_MXI132_I32_XG_MN2 (XI132_I32_XG_n1 I132_G4_1n VSS VSS) gpdk090_nmos1v w=0.24u l=0.1u ad=0.0528p as=0.0816p pd=0.68u ps=1.16u
    I_MXI132_I32_XG_MN0 (I132_G4_0 I132_P4_1n XI132_I32_XG_n1 VSS) gpdk090_nmos1v w=0.24u l=0.1u ad=0.0528p as=0.0528p pd=0.68u ps=0.68u
    I_MXI132_I32_XG_MN1 (XI132_I32_XG_n1 I132_G0_0n I132_G4_0 VSS) gpdk090_nmos1v w=0.24u l=0.1u ad=0.0816p as=0.0528p pd=1.16u ps=0.68u
    I_MXI132_I20_XG_MN2 (XI132_I20_XG_n1 I132_gn2 VSS VSS) gpdk090_nmos1v w=0.24u l=0.1u ad=0.0528p as=0.0816p pd=0.68u ps=1.16u
    I_MXI132_I20_XG_MN0 (I132_G2_1 I132_pn2 XI132_I20_XG_n1 VSS) gpdk090_nmos1v w=0.24u l=0.1u ad=0.0528p as=0.0528p pd=0.68u ps=0.68u
    I_MXI132_I20_XG_MN1 (XI132_I20_XG_n1 I132_gn1 I132_G2_1 VSS) gpdk090_nmos1v w=0.24u l=0.1u ad=0.0816p as=0.0528p pd=1.16u ps=0.68u
    I_MXI120_I17_XG_MN2 (XI120_I17_XG_n1 I120_gn0 VSS VSS) gpdk090_nmos1v w=0.24u l=0.1u ad=0.0528p as=0.0816p pd=0.68u ps=1.16u
    I_MXI120_I17_XG_MN0 (I120_G0_0 I120_pn0 XI120_I17_XG_n1 VSS) gpdk090_nmos1v w=0.24u l=0.1u ad=0.0528p as=0.0528p pd=0.68u ps=0.68u
    I_MXI120_I17_XG_MN1 (XI120_I17_XG_n1 I120_cinn I120_G0_0 VSS) gpdk090_nmos1v w=0.24u l=0.1u ad=0.0816p as=0.0528p pd=1.16u ps=0.68u
    I_MXI108_I17_XG_MN2 (XI108_I17_XG_n1 I108_gn0 VSS VSS) gpdk090_nmos1v w=0.24u l=0.1u ad=0.0528p as=0.0816p pd=0.68u ps=1.16u
    I_MXI108_I17_XG_MN0 (I108_G0_0 I108_pn0 XI108_I17_XG_n1 VSS) gpdk090_nmos1v w=0.24u l=0.1u ad=0.0528p as=0.0528p pd=0.68u ps=0.68u
    I_MXI108_I17_XG_MN1 (XI108_I17_XG_n1 I108_cinn I108_G0_0 VSS) gpdk090_nmos1v w=0.24u l=0.1u ad=0.0816p as=0.0528p pd=1.16u ps=0.68u
    I_MXI96_I19_XG_MN2 (XI96_I19_XG_n1 I96_gn1 VSS VSS) gpdk090_nmos1v w=0.24u l=0.1u ad=0.0528p as=0.0816p pd=0.68u ps=1.16u
    I_MXI96_I19_XG_MN0 (I96_G1_0 I96_pn1 XI96_I19_XG_n1 VSS) gpdk090_nmos1v w=0.24u l=0.1u ad=0.0528p as=0.0528p pd=0.68u ps=0.68u
    I_MXI96_I19_XG_MN1 (XI96_I19_XG_n1 I96_G0_0n I96_G1_0 VSS) gpdk090_nmos1v w=0.24u l=0.1u ad=0.0816p as=0.0528p pd=1.16u ps=0.68u
    I_MXI96_I32_XG_MN2 (XI96_I32_XG_n1 I96_G4_1n VSS VSS) gpdk090_nmos1v w=0.24u l=0.1u ad=0.0528p as=0.0816p pd=0.68u ps=1.16u
    I_MXI96_I32_XG_MN0 (I96_G4_0 I96_P4_1n XI96_I32_XG_n1 VSS) gpdk090_nmos1v w=0.24u l=0.1u ad=0.0528p as=0.0528p pd=0.68u ps=0.68u
    I_MXI96_I32_XG_MN1 (XI96_I32_XG_n1 I96_G0_0n I96_G4_0 VSS) gpdk090_nmos1v w=0.24u l=0.1u ad=0.0816p as=0.0528p pd=1.16u ps=0.68u
    I_MXI96_I35_XG_MN2 (XI96_I35_XG_n1 I96_G6_3n VSS VSS) gpdk090_nmos1v w=0.24u l=0.1u ad=0.0528p as=0.0816p pd=0.68u ps=1.16u
    I_MXI96_I35_XG_MN0 (c4_7 I96_P6_3n XI96_I35_XG_n1 VSS) gpdk090_nmos1v w=0.24u l=0.1u ad=0.0528p as=0.0528p pd=0.68u ps=0.68u
    I_MXI96_I35_XG_MN1 (XI96_I35_XG_n1 I96_G2_0n c4_7 VSS) gpdk090_nmos1v w=0.24u l=0.1u ad=0.0816p as=0.0528p pd=1.16u ps=0.68u
    I_MXI96_I25_XG_MN2 (XI96_I25_XG_n1 I96_gn7 VSS VSS) gpdk090_nmos1v w=0.24u l=0.1u ad=0.0528p as=0.0816p pd=0.68u ps=1.16u
    I_MXI96_I25_XG_MN0 (I96_G7_6 I96_pn7 XI96_I25_XG_n1 VSS) gpdk090_nmos1v w=0.24u l=0.1u ad=0.0528p as=0.0528p pd=0.68u ps=0.68u
    I_MXI96_I25_XG_MN1 (XI96_I25_XG_n1 I96_gn6 I96_G7_6 VSS) gpdk090_nmos1v w=0.24u l=0.1u ad=0.0816p as=0.0528p pd=1.16u ps=0.68u
    I_MXI152_I25_XG_MN2 (XI152_I25_XG_n1 I152_gn7 VSS VSS) gpdk090_nmos1v w=0.24u l=0.1u ad=0.0528p as=0.0816p pd=0.68u ps=1.16u
    I_MXI152_I25_XG_MN0 (I152_G7_6 I152_pn7 XI152_I25_XG_n1 VSS) gpdk090_nmos1v w=0.24u l=0.1u ad=0.0528p as=0.0528p pd=0.68u ps=0.68u
    I_MXI152_I25_XG_MN1 (XI152_I25_XG_n1 I152_gn6 I152_G7_6 VSS) gpdk090_nmos1v w=0.24u l=0.1u ad=0.0816p as=0.0528p pd=1.16u ps=0.68u
    I_MXI152_I24_XG_MN2 (XI152_I24_XG_n1 I152_gn6 VSS VSS) gpdk090_nmos1v w=0.24u l=0.1u ad=0.0528p as=0.0816p pd=0.68u ps=1.16u
    I_MXI152_I24_XG_MN0 (I152_G6_5 I152_pn6 XI152_I24_XG_n1 VSS) gpdk090_nmos1v w=0.24u l=0.1u ad=0.0528p as=0.0528p pd=0.68u ps=0.68u
    I_MXI152_I24_XG_MN1 (XI152_I24_XG_n1 I152_gn5 I152_G6_5 VSS) gpdk090_nmos1v w=0.24u l=0.1u ad=0.0816p as=0.0528p pd=1.16u ps=0.68u
    I_MXI132_I19_XG_MN2 (XI132_I19_XG_n1 I132_gn1 VSS VSS) gpdk090_nmos1v w=0.24u l=0.1u ad=0.0528p as=0.0816p pd=0.68u ps=1.16u
    I_MXI132_I19_XG_MN0 (I132_G1_0 I132_pn1 XI132_I19_XG_n1 VSS) gpdk090_nmos1v w=0.24u l=0.1u ad=0.0528p as=0.0528p pd=0.68u ps=0.68u
    I_MXI132_I19_XG_MN1 (XI132_I19_XG_n1 I132_G0_0n I132_G1_0 VSS) gpdk090_nmos1v w=0.24u l=0.1u ad=0.0816p as=0.0528p pd=1.16u ps=0.68u
    I_MXI96_I17_XG_MN2 (XI96_I17_XG_n1 I96_gn0 VSS VSS) gpdk090_nmos1v w=0.24u l=0.1u ad=0.0528p as=0.0816p pd=0.68u ps=1.16u
    I_MXI96_I17_XG_MN0 (I96_G0_0 I96_pn0 XI96_I17_XG_n1 VSS) gpdk090_nmos1v w=0.24u l=0.1u ad=0.0528p as=0.0528p pd=0.68u ps=0.68u
    I_MXI96_I17_XG_MN1 (XI96_I17_XG_n1 I96_cinn I96_G0_0 VSS) gpdk090_nmos1v w=0.24u l=0.1u ad=0.0816p as=0.0528p pd=1.16u ps=0.68u
    I_MXI96_I20_XG_MN2 (XI96_I20_XG_n1 I96_gn2 VSS VSS) gpdk090_nmos1v w=0.24u l=0.1u ad=0.0528p as=0.0816p pd=0.68u ps=1.16u
    I_MXI96_I20_XG_MN0 (I96_G2_1 I96_pn2 XI96_I20_XG_n1 VSS) gpdk090_nmos1v w=0.24u l=0.1u ad=0.0528p as=0.0528p pd=0.68u ps=0.68u
    I_MXI96_I20_XG_MN1 (XI96_I20_XG_n1 I96_gn1 I96_G2_1 VSS) gpdk090_nmos1v w=0.24u l=0.1u ad=0.0816p as=0.0528p pd=1.16u ps=0.68u
    I_MXI96_I21_XG_MN2 (XI96_I21_XG_n1 I96_gn3 VSS VSS) gpdk090_nmos1v w=0.24u l=0.1u ad=0.0528p as=0.0816p pd=0.68u ps=1.16u
    I_MXI96_I21_XG_MN0 (I96_G3_2 I96_pn3 XI96_I21_XG_n1 VSS) gpdk090_nmos1v w=0.24u l=0.1u ad=0.0528p as=0.0528p pd=0.68u ps=0.68u
    I_MXI96_I21_XG_MN1 (XI96_I21_XG_n1 I96_gn2 I96_G3_2 VSS) gpdk090_nmos1v w=0.24u l=0.1u ad=0.0816p as=0.0528p pd=1.16u ps=0.68u
    I_MXI96_I22_XG_MN2 (XI96_I22_XG_n1 I96_gn4 VSS VSS) gpdk090_nmos1v w=0.24u l=0.1u ad=0.0528p as=0.0816p pd=0.68u ps=1.16u
    I_MXI96_I22_XG_MN0 (I96_G4_3 I96_pn4 XI96_I22_XG_n1 VSS) gpdk090_nmos1v w=0.24u l=0.1u ad=0.0528p as=0.0528p pd=0.68u ps=0.68u
    I_MXI96_I22_XG_MN1 (XI96_I22_XG_n1 I96_gn3 I96_G4_3 VSS) gpdk090_nmos1v w=0.24u l=0.1u ad=0.0816p as=0.0528p pd=1.16u ps=0.68u
    I_MXI96_I23_XG_MN2 (XI96_I23_XG_n1 I96_gn5 VSS VSS) gpdk090_nmos1v w=0.24u l=0.1u ad=0.0528p as=0.0816p pd=0.68u ps=1.16u
    I_MXI96_I23_XG_MN0 (I96_G5_4 I96_pn5 XI96_I23_XG_n1 VSS) gpdk090_nmos1v w=0.24u l=0.1u ad=0.0528p as=0.0528p pd=0.68u ps=0.68u
    I_MXI96_I23_XG_MN1 (XI96_I23_XG_n1 I96_gn4 I96_G5_4 VSS) gpdk090_nmos1v w=0.24u l=0.1u ad=0.0816p as=0.0528p pd=1.16u ps=0.68u
    I_MXI96_I24_XG_MN2 (XI96_I24_XG_n1 I96_gn6 VSS VSS) gpdk090_nmos1v w=0.24u l=0.1u ad=0.0528p as=0.0816p pd=0.68u ps=1.16u
    I_MXI96_I24_XG_MN0 (I96_G6_5 I96_pn6 XI96_I24_XG_n1 VSS) gpdk090_nmos1v w=0.24u l=0.1u ad=0.0528p as=0.0528p pd=0.68u ps=0.68u
    I_MXI96_I24_XG_MN1 (XI96_I24_XG_n1 I96_gn5 I96_G6_5 VSS) gpdk090_nmos1v w=0.24u l=0.1u ad=0.0816p as=0.0528p pd=1.16u ps=0.68u
    I_MXI152_I36_XG_MN2 (XI152_I36_XG_n1 I152_G7_4n VSS VSS) gpdk090_nmos1v w=0.24u l=0.1u ad=0.0528p as=0.0816p pd=0.68u ps=1.16u
    I_MXI152_I36_XG_MN0 (rc7 I152_P7_4n XI152_I36_XG_n1 VSS) gpdk090_nmos1v w=0.24u l=0.1u ad=0.0528p as=0.0528p pd=0.68u ps=0.68u
    I_MXI152_I36_XG_MN1 (XI152_I36_XG_n1 I152_G3_0n rc7 VSS) gpdk090_nmos1v w=0.24u l=0.1u ad=0.0816p as=0.0528p pd=1.16u ps=0.68u
    I_MXI152_I23_XG_MN2 (XI152_I23_XG_n1 I152_gn5 VSS VSS) gpdk090_nmos1v w=0.24u l=0.1u ad=0.0528p as=0.0816p pd=0.68u ps=1.16u
    I_MXI152_I23_XG_MN0 (I152_G5_4 I152_pn5 XI152_I23_XG_n1 VSS) gpdk090_nmos1v w=0.24u l=0.1u ad=0.0528p as=0.0528p pd=0.68u ps=0.68u
    I_MXI152_I23_XG_MN1 (XI152_I23_XG_n1 I152_gn4 I152_G5_4 VSS) gpdk090_nmos1v w=0.24u l=0.1u ad=0.0816p as=0.0528p pd=1.16u ps=0.68u
    I_MXI152_I22_XG_MN2 (XI152_I22_XG_n1 I152_gn4 VSS VSS) gpdk090_nmos1v w=0.24u l=0.1u ad=0.0528p as=0.0816p pd=0.68u ps=1.16u
    I_MXI152_I22_XG_MN0 (I152_G4_3 I152_pn4 XI152_I22_XG_n1 VSS) gpdk090_nmos1v w=0.24u l=0.1u ad=0.0528p as=0.0528p pd=0.68u ps=0.68u
    I_MXI152_I22_XG_MN1 (XI152_I22_XG_n1 I152_gn3 I152_G4_3 VSS) gpdk090_nmos1v w=0.24u l=0.1u ad=0.0816p as=0.0528p pd=1.16u ps=0.68u
    I_MXI132_I17_XG_MN2 (XI132_I17_XG_n1 I132_gn0 VSS VSS) gpdk090_nmos1v w=0.24u l=0.1u ad=0.0528p as=0.0816p pd=0.68u ps=1.16u
    I_MXI132_I17_XG_MN0 (I132_G0_0 I132_pn0 XI132_I17_XG_n1 VSS) gpdk090_nmos1v w=0.24u l=0.1u ad=0.0528p as=0.0528p pd=0.68u ps=0.68u
    I_MXI132_I17_XG_MN1 (XI132_I17_XG_n1 I132_cinn I132_G0_0 VSS) gpdk090_nmos1v w=0.24u l=0.1u ad=0.0816p as=0.0528p pd=1.16u ps=0.68u
    I_MXI152_I34_XG_MN2 (XI152_I34_XG_n1 I152_G5_2n VSS VSS) gpdk090_nmos1v w=0.24u l=0.1u ad=0.0528p as=0.0816p pd=0.68u ps=1.16u
    I_MXI152_I34_XG_MN0 (I152_G5_0 I152_P5_2n XI152_I34_XG_n1 VSS) gpdk090_nmos1v w=0.24u l=0.1u ad=0.0528p as=0.0528p pd=0.68u ps=0.68u
    I_MXI152_I34_XG_MN1 (XI152_I34_XG_n1 I152_G1_0n I152_G5_0 VSS) gpdk090_nmos1v w=0.24u l=0.1u ad=0.0816p as=0.0528p pd=1.16u ps=0.68u
    I_MXI152_I21_XG_MN2 (XI152_I21_XG_n1 I152_gn3 VSS VSS) gpdk090_nmos1v w=0.24u l=0.1u ad=0.0528p as=0.0816p pd=0.68u ps=1.16u
    I_MXI152_I21_XG_MN0 (I152_G3_2 I152_pn3 XI152_I21_XG_n1 VSS) gpdk090_nmos1v w=0.24u l=0.1u ad=0.0528p as=0.0528p pd=0.68u ps=0.68u
    I_MXI152_I21_XG_MN1 (XI152_I21_XG_n1 I152_gn2 I152_G3_2 VSS) gpdk090_nmos1v w=0.24u l=0.1u ad=0.0816p as=0.0528p pd=1.16u ps=0.68u
    I_MXI84_I17_XG_MN2 (XI84_I17_XG_n1 I84_gn0 VSS VSS) gpdk090_nmos1v w=0.24u l=0.1u ad=0.0528p as=0.0816p pd=0.68u ps=1.16u
    I_MXI84_I17_XG_MN0 (I84_G0_0 I84_pn0 XI84_I17_XG_n1 VSS) gpdk090_nmos1v w=0.24u l=0.1u ad=0.0528p as=0.0528p pd=0.68u ps=0.68u
    I_MXI84_I17_XG_MN1 (XI84_I17_XG_n1 I84_cinn I84_G0_0 VSS) gpdk090_nmos1v w=0.24u l=0.1u ad=0.0816p as=0.0528p pd=1.16u ps=0.68u
    I_MXI84_I32_XG_MN2 (XI84_I32_XG_n1 I84_G4_1n VSS VSS) gpdk090_nmos1v w=0.24u l=0.1u ad=0.0528p as=0.0816p pd=0.68u ps=1.16u
    I_MXI84_I32_XG_MN0 (I84_G4_0 I84_P4_1n XI84_I32_XG_n1 VSS) gpdk090_nmos1v w=0.24u l=0.1u ad=0.0528p as=0.0528p pd=0.68u ps=0.68u
    I_MXI84_I32_XG_MN1 (XI84_I32_XG_n1 I84_G0_0n I84_G4_0 VSS) gpdk090_nmos1v w=0.24u l=0.1u ad=0.0816p as=0.0528p pd=1.16u ps=0.68u
    I_MXI84_I35_XG_MN2 (XI84_I35_XG_n1 I84_G6_3n VSS VSS) gpdk090_nmos1v w=0.24u l=0.1u ad=0.0528p as=0.0816p pd=0.68u ps=1.16u
    I_MXI84_I35_XG_MN0 (c3_7 I84_P6_3n XI84_I35_XG_n1 VSS) gpdk090_nmos1v w=0.24u l=0.1u ad=0.0528p as=0.0528p pd=0.68u ps=0.68u
    I_MXI84_I35_XG_MN1 (XI84_I35_XG_n1 I84_G2_0n c3_7 VSS) gpdk090_nmos1v w=0.24u l=0.1u ad=0.0816p as=0.0528p pd=1.16u ps=0.68u
    I_MXI152_I32_XG_MN2 (XI152_I32_XG_n1 I152_G4_1n VSS VSS) gpdk090_nmos1v w=0.24u l=0.1u ad=0.0528p as=0.0816p pd=0.68u ps=1.16u
    I_MXI152_I32_XG_MN0 (I152_G4_0 I152_P4_1n XI152_I32_XG_n1 VSS) gpdk090_nmos1v w=0.24u l=0.1u ad=0.0528p as=0.0528p pd=0.68u ps=0.68u
    I_MXI152_I32_XG_MN1 (XI152_I32_XG_n1 I152_G0_0n I152_G4_0 VSS) gpdk090_nmos1v w=0.24u l=0.1u ad=0.0816p as=0.0528p pd=1.16u ps=0.68u
    I_MXI152_I20_XG_MN2 (XI152_I20_XG_n1 I152_gn2 VSS VSS) gpdk090_nmos1v w=0.24u l=0.1u ad=0.0528p as=0.0816p pd=0.68u ps=1.16u
    I_MXI152_I20_XG_MN0 (I152_G2_1 I152_pn2 XI152_I20_XG_n1 VSS) gpdk090_nmos1v w=0.24u l=0.1u ad=0.0528p as=0.0528p pd=0.68u ps=0.68u
    I_MXI152_I20_XG_MN1 (XI152_I20_XG_n1 I152_gn1 I152_G2_1 VSS) gpdk090_nmos1v w=0.24u l=0.1u ad=0.0816p as=0.0528p pd=1.16u ps=0.68u
    I_MXI152_I19_XG_MN2 (XI152_I19_XG_n1 I152_gn1 VSS VSS) gpdk090_nmos1v w=0.24u l=0.1u ad=0.0528p as=0.0816p pd=0.68u ps=1.16u
    I_MXI152_I19_XG_MN0 (I152_G1_0 I152_pn1 XI152_I19_XG_n1 VSS) gpdk090_nmos1v w=0.24u l=0.1u ad=0.0528p as=0.0528p pd=0.68u ps=0.68u
    I_MXI152_I19_XG_MN1 (XI152_I19_XG_n1 I152_G0_0n I152_G1_0 VSS) gpdk090_nmos1v w=0.24u l=0.1u ad=0.0816p as=0.0528p pd=1.16u ps=0.68u
    I_MXI152_I17_XG_MN2 (XI152_I17_XG_n1 I152_gn0 VSS VSS) gpdk090_nmos1v w=0.24u l=0.1u ad=0.0528p as=0.0816p pd=0.68u ps=1.16u
    I_MXI152_I17_XG_MN0 (I152_G0_0 I152_pn0 XI152_I17_XG_n1 VSS) gpdk090_nmos1v w=0.24u l=0.1u ad=0.0528p as=0.0528p pd=0.68u ps=0.68u
    I_MXI152_I17_XG_MN1 (XI152_I17_XG_n1 I152_cinn I152_G0_0 VSS) gpdk090_nmos1v w=0.24u l=0.1u ad=0.0816p as=0.0528p pd=1.16u ps=0.68u
    I_MXI84_I19_XG_MN2 (XI84_I19_XG_n1 I84_gn1 VSS VSS) gpdk090_nmos1v w=0.24u l=0.1u ad=0.0528p as=0.0816p pd=0.68u ps=1.16u
    I_MXI84_I19_XG_MN0 (I84_G1_0 I84_pn1 XI84_I19_XG_n1 VSS) gpdk090_nmos1v w=0.24u l=0.1u ad=0.0528p as=0.0528p pd=0.68u ps=0.68u
    I_MXI84_I19_XG_MN1 (XI84_I19_XG_n1 I84_G0_0n I84_G1_0 VSS) gpdk090_nmos1v w=0.24u l=0.1u ad=0.0816p as=0.0528p pd=1.16u ps=0.68u
    I_MXI84_I20_XG_MN2 (XI84_I20_XG_n1 I84_gn2 VSS VSS) gpdk090_nmos1v w=0.24u l=0.1u ad=0.0528p as=0.0816p pd=0.68u ps=1.16u
    I_MXI84_I20_XG_MN0 (I84_G2_1 I84_pn2 XI84_I20_XG_n1 VSS) gpdk090_nmos1v w=0.24u l=0.1u ad=0.0528p as=0.0528p pd=0.68u ps=0.68u
    I_MXI84_I20_XG_MN1 (XI84_I20_XG_n1 I84_gn1 I84_G2_1 VSS) gpdk090_nmos1v w=0.24u l=0.1u ad=0.0816p as=0.0528p pd=1.16u ps=0.68u
    I_MXI152_I35_XG_MN2 (XI152_I35_XG_n1 I152_G6_3n VSS VSS) gpdk090_nmos1v w=0.24u l=0.1u ad=0.0528p as=0.0816p pd=0.68u ps=1.16u
    I_MXI152_I35_XG_MN0 (rc6 I152_P6_3n XI152_I35_XG_n1 VSS) gpdk090_nmos1v w=0.24u l=0.1u ad=0.0528p as=0.0528p pd=0.68u ps=0.68u
    I_MXI152_I35_XG_MN1 (XI152_I35_XG_n1 I152_G2_0n rc6 VSS) gpdk090_nmos1v w=0.24u l=0.1u ad=0.0816p as=0.0528p pd=1.16u ps=0.68u
    I_MXI72_I17_XG_MN2 (XI72_I17_XG_n1 I72_gn0 VSS VSS) gpdk090_nmos1v w=0.24u l=0.1u ad=0.0528p as=0.0816p pd=0.68u ps=1.16u
    I_MXI72_I17_XG_MN0 (I72_G0_0 I72_pn0 XI72_I17_XG_n1 VSS) gpdk090_nmos1v w=0.24u l=0.1u ad=0.0528p as=0.0528p pd=0.68u ps=0.68u
    I_MXI72_I17_XG_MN1 (XI72_I17_XG_n1 I72_cinn I72_G0_0 VSS) gpdk090_nmos1v w=0.24u l=0.1u ad=0.0816p as=0.0528p pd=1.16u ps=0.68u
    I_MXI84_I21_XG_MN2 (XI84_I21_XG_n1 I84_gn3 VSS VSS) gpdk090_nmos1v w=0.24u l=0.1u ad=0.0528p as=0.0816p pd=0.68u ps=1.16u
    I_MXI84_I21_XG_MN0 (I84_G3_2 I84_pn3 XI84_I21_XG_n1 VSS) gpdk090_nmos1v w=0.24u l=0.1u ad=0.0528p as=0.0528p pd=0.68u ps=0.68u
    I_MXI84_I21_XG_MN1 (XI84_I21_XG_n1 I84_gn2 I84_G3_2 VSS) gpdk090_nmos1v w=0.24u l=0.1u ad=0.0816p as=0.0528p pd=1.16u ps=0.68u
    I_MXI84_I22_XG_MN2 (XI84_I22_XG_n1 I84_gn4 VSS VSS) gpdk090_nmos1v w=0.24u l=0.1u ad=0.0528p as=0.0816p pd=0.68u ps=1.16u
    I_MXI84_I22_XG_MN0 (I84_G4_3 I84_pn4 XI84_I22_XG_n1 VSS) gpdk090_nmos1v w=0.24u l=0.1u ad=0.0528p as=0.0528p pd=0.68u ps=0.68u
    I_MXI84_I22_XG_MN1 (XI84_I22_XG_n1 I84_gn3 I84_G4_3 VSS) gpdk090_nmos1v w=0.24u l=0.1u ad=0.0816p as=0.0528p pd=1.16u ps=0.68u
    I_MXI84_I34_XG_MN2 (XI84_I34_XG_n1 I84_G5_2n VSS VSS) gpdk090_nmos1v w=0.24u l=0.1u ad=0.0528p as=0.0816p pd=0.68u ps=1.16u
    I_MXI84_I34_XG_MN0 (I84_G5_0 I84_P5_2n XI84_I34_XG_n1 VSS) gpdk090_nmos1v w=0.24u l=0.1u ad=0.0528p as=0.0528p pd=0.68u ps=0.68u
    I_MXI84_I34_XG_MN1 (XI84_I34_XG_n1 I84_G1_0n I84_G5_0 VSS) gpdk090_nmos1v w=0.24u l=0.1u ad=0.0816p as=0.0528p pd=1.16u ps=0.68u
    I_MXI60_I17_XG_MN2 (XI60_I17_XG_n1 I60_gn0 VSS VSS) gpdk090_nmos1v w=0.24u l=0.1u ad=0.0528p as=0.0816p pd=0.68u ps=1.16u
    I_MXI60_I17_XG_MN0 (I60_G0_0 I60_pn0 XI60_I17_XG_n1 VSS) gpdk090_nmos1v w=0.24u l=0.1u ad=0.0528p as=0.0528p pd=0.68u ps=0.68u
    I_MXI60_I17_XG_MN1 (XI60_I17_XG_n1 I60_cinn I60_G0_0 VSS) gpdk090_nmos1v w=0.24u l=0.1u ad=0.0816p as=0.0528p pd=1.16u ps=0.68u
    I_MXI84_I23_XG_MN2 (XI84_I23_XG_n1 I84_gn5 VSS VSS) gpdk090_nmos1v w=0.24u l=0.1u ad=0.0528p as=0.0816p pd=0.68u ps=1.16u
    I_MXI84_I23_XG_MN0 (I84_G5_4 I84_pn5 XI84_I23_XG_n1 VSS) gpdk090_nmos1v w=0.24u l=0.1u ad=0.0528p as=0.0528p pd=0.68u ps=0.68u
    I_MXI84_I23_XG_MN1 (XI84_I23_XG_n1 I84_gn4 I84_G5_4 VSS) gpdk090_nmos1v w=0.24u l=0.1u ad=0.0816p as=0.0528p pd=1.16u ps=0.68u
    I_MXI84_I36_XG_MN2 (XI84_I36_XG_n1 I84_G7_4n VSS VSS) gpdk090_nmos1v w=0.24u l=0.1u ad=0.0528p as=0.0816p pd=0.68u ps=1.16u
    I_MXI84_I36_XG_MN0 (c3_8 I84_P7_4n XI84_I36_XG_n1 VSS) gpdk090_nmos1v w=0.24u l=0.1u ad=0.0528p as=0.0528p pd=0.68u ps=0.68u
    I_MXI84_I36_XG_MN1 (XI84_I36_XG_n1 I84_G3_0n c3_8 VSS) gpdk090_nmos1v w=0.24u l=0.1u ad=0.0816p as=0.0528p pd=1.16u ps=0.68u
    I_MXI48_I20_XG_MN2 (XI48_I20_XG_n1 I48_gn2 VSS VSS) gpdk090_nmos1v w=0.24u l=0.1u ad=0.0528p as=0.0816p pd=0.68u ps=1.16u
    I_MXI48_I20_XG_MN0 (I48_G2_1 I48_pn2 XI48_I20_XG_n1 VSS) gpdk090_nmos1v w=0.24u l=0.1u ad=0.0528p as=0.0528p pd=0.68u ps=0.68u
    I_MXI48_I20_XG_MN1 (XI48_I20_XG_n1 I48_gn1 I48_G2_1 VSS) gpdk090_nmos1v w=0.24u l=0.1u ad=0.0816p as=0.0528p pd=1.16u ps=0.68u
    I_MXI48_I17_XG_MN2 (XI48_I17_XG_n1 I48_gn0 VSS VSS) gpdk090_nmos1v w=0.24u l=0.1u ad=0.0528p as=0.0816p pd=0.68u ps=1.16u
    I_MXI48_I17_XG_MN0 (I48_G0_0 I48_pn0 XI48_I17_XG_n1 VSS) gpdk090_nmos1v w=0.24u l=0.1u ad=0.0528p as=0.0528p pd=0.68u ps=0.68u
    I_MXI48_I17_XG_MN1 (XI48_I17_XG_n1 I48_cinn I48_G0_0 VSS) gpdk090_nmos1v w=0.24u l=0.1u ad=0.0816p as=0.0528p pd=1.16u ps=0.68u
    I_MXI72_I20_XG_MN2 (XI72_I20_XG_n1 I72_gn2 VSS VSS) gpdk090_nmos1v w=0.24u l=0.1u ad=0.0528p as=0.0816p pd=0.68u ps=1.16u
    I_MXI72_I20_XG_MN0 (I72_G2_1 I72_pn2 XI72_I20_XG_n1 VSS) gpdk090_nmos1v w=0.24u l=0.1u ad=0.0528p as=0.0528p pd=0.68u ps=0.68u
    I_MXI72_I20_XG_MN1 (XI72_I20_XG_n1 I72_gn1 I72_G2_1 VSS) gpdk090_nmos1v w=0.24u l=0.1u ad=0.0816p as=0.0528p pd=1.16u ps=0.68u
    I_MXI72_I19_XG_MN2 (XI72_I19_XG_n1 I72_gn1 VSS VSS) gpdk090_nmos1v w=0.24u l=0.1u ad=0.0528p as=0.0816p pd=0.68u ps=1.16u
    I_MXI72_I19_XG_MN0 (I72_G1_0 I72_pn1 XI72_I19_XG_n1 VSS) gpdk090_nmos1v w=0.24u l=0.1u ad=0.0528p as=0.0528p pd=0.68u ps=0.68u
    I_MXI72_I19_XG_MN1 (XI72_I19_XG_n1 I72_G0_0n I72_G1_0 VSS) gpdk090_nmos1v w=0.24u l=0.1u ad=0.0816p as=0.0528p pd=1.16u ps=0.68u
    I_MXI84_I24_XG_MN2 (XI84_I24_XG_n1 I84_gn6 VSS VSS) gpdk090_nmos1v w=0.24u l=0.1u ad=0.0528p as=0.0816p pd=0.68u ps=1.16u
    I_MXI84_I24_XG_MN0 (I84_G6_5 I84_pn6 XI84_I24_XG_n1 VSS) gpdk090_nmos1v w=0.24u l=0.1u ad=0.0528p as=0.0528p pd=0.68u ps=0.68u
    I_MXI84_I24_XG_MN1 (XI84_I24_XG_n1 I84_gn5 I84_G6_5 VSS) gpdk090_nmos1v w=0.24u l=0.1u ad=0.0816p as=0.0528p pd=1.16u ps=0.68u
    I_MXI84_I25_XG_MN2 (XI84_I25_XG_n1 I84_gn7 VSS VSS) gpdk090_nmos1v w=0.24u l=0.1u ad=0.0528p as=0.0816p pd=0.68u ps=1.16u
    I_MXI84_I25_XG_MN0 (I84_G7_6 I84_pn7 XI84_I25_XG_n1 VSS) gpdk090_nmos1v w=0.24u l=0.1u ad=0.0528p as=0.0528p pd=0.68u ps=0.68u
    I_MXI84_I25_XG_MN1 (XI84_I25_XG_n1 I84_gn6 I84_G7_6 VSS) gpdk090_nmos1v w=0.24u l=0.1u ad=0.0816p as=0.0528p pd=1.16u ps=0.68u
    I_MXI48_I22_XG_MN2 (XI48_I22_XG_n1 I48_gn4 VSS VSS) gpdk090_nmos1v w=0.24u l=0.1u ad=0.0528p as=0.0816p pd=0.68u ps=1.16u
    I_MXI48_I22_XG_MN0 (I48_G4_3 I48_pn4 XI48_I22_XG_n1 VSS) gpdk090_nmos1v w=0.24u l=0.1u ad=0.0528p as=0.0528p pd=0.68u ps=0.68u
    I_MXI48_I22_XG_MN1 (XI48_I22_XG_n1 I48_gn3 I48_G4_3 VSS) gpdk090_nmos1v w=0.24u l=0.1u ad=0.0816p as=0.0528p pd=1.16u ps=0.68u
    I_MXI48_I21_XG_MN2 (XI48_I21_XG_n1 I48_gn3 VSS VSS) gpdk090_nmos1v w=0.24u l=0.1u ad=0.0528p as=0.0816p pd=0.68u ps=1.16u
    I_MXI48_I21_XG_MN0 (I48_G3_2 I48_pn3 XI48_I21_XG_n1 VSS) gpdk090_nmos1v w=0.24u l=0.1u ad=0.0528p as=0.0528p pd=0.68u ps=0.68u
    I_MXI48_I21_XG_MN1 (XI48_I21_XG_n1 I48_gn2 I48_G3_2 VSS) gpdk090_nmos1v w=0.24u l=0.1u ad=0.0816p as=0.0528p pd=1.16u ps=0.68u
    I_MXI48_I32_XG_MN2 (XI48_I32_XG_n1 I48_G4_1n VSS VSS) gpdk090_nmos1v w=0.24u l=0.1u ad=0.0528p as=0.0816p pd=0.68u ps=1.16u
    I_MXI48_I32_XG_MN0 (I48_G4_0 I48_P4_1n XI48_I32_XG_n1 VSS) gpdk090_nmos1v w=0.24u l=0.1u ad=0.0528p as=0.0528p pd=0.68u ps=0.68u
    I_MXI48_I32_XG_MN1 (XI48_I32_XG_n1 I48_G0_0n I48_G4_0 VSS) gpdk090_nmos1v w=0.24u l=0.1u ad=0.0816p as=0.0528p pd=1.16u ps=0.68u
    I_MXI48_I19_XG_MN2 (XI48_I19_XG_n1 I48_gn1 VSS VSS) gpdk090_nmos1v w=0.24u l=0.1u ad=0.0528p as=0.0816p pd=0.68u ps=1.16u
    I_MXI48_I19_XG_MN0 (I48_G1_0 I48_pn1 XI48_I19_XG_n1 VSS) gpdk090_nmos1v w=0.24u l=0.1u ad=0.0528p as=0.0528p pd=0.68u ps=0.68u
    I_MXI48_I19_XG_MN1 (XI48_I19_XG_n1 I48_G0_0n I48_G1_0 VSS) gpdk090_nmos1v w=0.24u l=0.1u ad=0.0816p as=0.0528p pd=1.16u ps=0.68u
    I_MXI60_I20_XG_MN2 (XI60_I20_XG_n1 I60_gn2 VSS VSS) gpdk090_nmos1v w=0.24u l=0.1u ad=0.0528p as=0.0816p pd=0.68u ps=1.16u
    I_MXI60_I20_XG_MN0 (I60_G2_1 I60_pn2 XI60_I20_XG_n1 VSS) gpdk090_nmos1v w=0.24u l=0.1u ad=0.0528p as=0.0528p pd=0.68u ps=0.68u
    I_MXI60_I20_XG_MN1 (XI60_I20_XG_n1 I60_gn1 I60_G2_1 VSS) gpdk090_nmos1v w=0.24u l=0.1u ad=0.0816p as=0.0528p pd=1.16u ps=0.68u
    I_MXI60_I19_XG_MN2 (XI60_I19_XG_n1 I60_gn1 VSS VSS) gpdk090_nmos1v w=0.24u l=0.1u ad=0.0528p as=0.0816p pd=0.68u ps=1.16u
    I_MXI60_I19_XG_MN0 (I60_G1_0 I60_pn1 XI60_I19_XG_n1 VSS) gpdk090_nmos1v w=0.24u l=0.1u ad=0.0528p as=0.0528p pd=0.68u ps=0.68u
    I_MXI60_I19_XG_MN1 (XI60_I19_XG_n1 I60_G0_0n I60_G1_0 VSS) gpdk090_nmos1v w=0.24u l=0.1u ad=0.0816p as=0.0528p pd=1.16u ps=0.68u
    I_MXI72_I21_XG_MN2 (XI72_I21_XG_n1 I72_gn3 VSS VSS) gpdk090_nmos1v w=0.24u l=0.1u ad=0.0528p as=0.0816p pd=0.68u ps=1.16u
    I_MXI72_I21_XG_MN0 (I72_G3_2 I72_pn3 XI72_I21_XG_n1 VSS) gpdk090_nmos1v w=0.24u l=0.1u ad=0.0528p as=0.0528p pd=0.68u ps=0.68u
    I_MXI72_I21_XG_MN1 (XI72_I21_XG_n1 I72_gn2 I72_G3_2 VSS) gpdk090_nmos1v w=0.24u l=0.1u ad=0.0816p as=0.0528p pd=1.16u ps=0.68u
    I_MXI72_I32_XG_MN2 (XI72_I32_XG_n1 I72_G4_1n VSS VSS) gpdk090_nmos1v w=0.24u l=0.1u ad=0.0528p as=0.0816p pd=0.68u ps=1.16u
    I_MXI72_I32_XG_MN0 (I72_G4_0 I72_P4_1n XI72_I32_XG_n1 VSS) gpdk090_nmos1v w=0.24u l=0.1u ad=0.0528p as=0.0528p pd=0.68u ps=0.68u
    I_MXI72_I32_XG_MN1 (XI72_I32_XG_n1 I72_G0_0n I72_G4_0 VSS) gpdk090_nmos1v w=0.24u l=0.1u ad=0.0816p as=0.0528p pd=1.16u ps=0.68u
    I_MXI48_I23_XG_MN2 (XI48_I23_XG_n1 I48_gn5 VSS VSS) gpdk090_nmos1v w=0.24u l=0.1u ad=0.0528p as=0.0816p pd=0.68u ps=1.16u
    I_MXI48_I23_XG_MN0 (I48_G5_4 I48_pn5 XI48_I23_XG_n1 VSS) gpdk090_nmos1v w=0.24u l=0.1u ad=0.0528p as=0.0528p pd=0.68u ps=0.68u
    I_MXI48_I23_XG_MN1 (XI48_I23_XG_n1 I48_gn4 I48_G5_4 VSS) gpdk090_nmos1v w=0.24u l=0.1u ad=0.0816p as=0.0528p pd=1.16u ps=0.68u
    I_MXI48_I24_XG_MN2 (XI48_I24_XG_n1 I48_gn6 VSS VSS) gpdk090_nmos1v w=0.24u l=0.1u ad=0.0528p as=0.0816p pd=0.68u ps=1.16u
    I_MXI48_I24_XG_MN0 (I48_G6_5 I48_pn6 XI48_I24_XG_n1 VSS) gpdk090_nmos1v w=0.24u l=0.1u ad=0.0528p as=0.0528p pd=0.68u ps=0.68u
    I_MXI48_I24_XG_MN1 (XI48_I24_XG_n1 I48_gn5 I48_G6_5 VSS) gpdk090_nmos1v w=0.24u l=0.1u ad=0.0816p as=0.0528p pd=1.16u ps=0.68u
    I_MXI48_I35_XG_MN2 (XI48_I35_XG_n1 I48_G6_3n VSS VSS) gpdk090_nmos1v w=0.24u l=0.1u ad=0.0528p as=0.0816p pd=0.68u ps=1.16u
    I_MXI48_I35_XG_MN0 (c0_7 I48_P6_3n XI48_I35_XG_n1 VSS) gpdk090_nmos1v w=0.24u l=0.1u ad=0.0528p as=0.0528p pd=0.68u ps=0.68u
    I_MXI48_I35_XG_MN1 (XI48_I35_XG_n1 I48_G2_0n c0_7 VSS) gpdk090_nmos1v w=0.24u l=0.1u ad=0.0816p as=0.0528p pd=1.16u ps=0.68u
    I_MXI60_I21_XG_MN2 (XI60_I21_XG_n1 I60_gn3 VSS VSS) gpdk090_nmos1v w=0.24u l=0.1u ad=0.0528p as=0.0816p pd=0.68u ps=1.16u
    I_MXI60_I21_XG_MN0 (I60_G3_2 I60_pn3 XI60_I21_XG_n1 VSS) gpdk090_nmos1v w=0.24u l=0.1u ad=0.0528p as=0.0528p pd=0.68u ps=0.68u
    I_MXI60_I21_XG_MN1 (XI60_I21_XG_n1 I60_gn2 I60_G3_2 VSS) gpdk090_nmos1v w=0.24u l=0.1u ad=0.0816p as=0.0528p pd=1.16u ps=0.68u
    I_MXI60_I22_XG_MN2 (XI60_I22_XG_n1 I60_gn4 VSS VSS) gpdk090_nmos1v w=0.24u l=0.1u ad=0.0528p as=0.0816p pd=0.68u ps=1.16u
    I_MXI60_I22_XG_MN0 (I60_G4_3 I60_pn4 XI60_I22_XG_n1 VSS) gpdk090_nmos1v w=0.24u l=0.1u ad=0.0528p as=0.0528p pd=0.68u ps=0.68u
    I_MXI60_I22_XG_MN1 (XI60_I22_XG_n1 I60_gn3 I60_G4_3 VSS) gpdk090_nmos1v w=0.24u l=0.1u ad=0.0816p as=0.0528p pd=1.16u ps=0.68u
    I_MXI60_I32_XG_MN2 (XI60_I32_XG_n1 I60_G4_1n VSS VSS) gpdk090_nmos1v w=0.24u l=0.1u ad=0.0528p as=0.0816p pd=0.68u ps=1.16u
    I_MXI60_I32_XG_MN0 (I60_G4_0 I60_P4_1n XI60_I32_XG_n1 VSS) gpdk090_nmos1v w=0.24u l=0.1u ad=0.0528p as=0.0528p pd=0.68u ps=0.68u
    I_MXI60_I32_XG_MN1 (XI60_I32_XG_n1 I60_G0_0n I60_G4_0 VSS) gpdk090_nmos1v w=0.24u l=0.1u ad=0.0816p as=0.0528p pd=1.16u ps=0.68u
    I_MXI72_I23_XG_MN2 (XI72_I23_XG_n1 I72_gn5 VSS VSS) gpdk090_nmos1v w=0.24u l=0.1u ad=0.0528p as=0.0816p pd=0.68u ps=1.16u
    I_MXI72_I23_XG_MN0 (I72_G5_4 I72_pn5 XI72_I23_XG_n1 VSS) gpdk090_nmos1v w=0.24u l=0.1u ad=0.0528p as=0.0528p pd=0.68u ps=0.68u
    I_MXI72_I23_XG_MN1 (XI72_I23_XG_n1 I72_gn4 I72_G5_4 VSS) gpdk090_nmos1v w=0.24u l=0.1u ad=0.0816p as=0.0528p pd=1.16u ps=0.68u
    I_MXI72_I22_XG_MN2 (XI72_I22_XG_n1 I72_gn4 VSS VSS) gpdk090_nmos1v w=0.24u l=0.1u ad=0.0528p as=0.0816p pd=0.68u ps=1.16u
    I_MXI72_I22_XG_MN0 (I72_G4_3 I72_pn4 XI72_I22_XG_n1 VSS) gpdk090_nmos1v w=0.24u l=0.1u ad=0.0528p as=0.0528p pd=0.68u ps=0.68u
    I_MXI72_I22_XG_MN1 (XI72_I22_XG_n1 I72_gn3 I72_G4_3 VSS) gpdk090_nmos1v w=0.24u l=0.1u ad=0.0816p as=0.0528p pd=1.16u ps=0.68u
    I_MXI72_I34_XG_MN2 (XI72_I34_XG_n1 I72_G5_2n VSS VSS) gpdk090_nmos1v w=0.24u l=0.1u ad=0.0528p as=0.0816p pd=0.68u ps=1.16u
    I_MXI72_I34_XG_MN0 (I72_G5_0 I72_P5_2n XI72_I34_XG_n1 VSS) gpdk090_nmos1v w=0.24u l=0.1u ad=0.0528p as=0.0528p pd=0.68u ps=0.68u
    I_MXI72_I34_XG_MN1 (XI72_I34_XG_n1 I72_G1_0n I72_G5_0 VSS) gpdk090_nmos1v w=0.24u l=0.1u ad=0.0816p as=0.0528p pd=1.16u ps=0.68u
    I_MXI48_I25_XG_MN2 (XI48_I25_XG_n1 I48_gn7 VSS VSS) gpdk090_nmos1v w=0.24u l=0.1u ad=0.0528p as=0.0816p pd=0.68u ps=1.16u
    I_MXI48_I25_XG_MN0 (I48_G7_6 I48_pn7 XI48_I25_XG_n1 VSS) gpdk090_nmos1v w=0.24u l=0.1u ad=0.0528p as=0.0528p pd=0.68u ps=0.68u
    I_MXI48_I25_XG_MN1 (XI48_I25_XG_n1 I48_gn6 I48_G7_6 VSS) gpdk090_nmos1v w=0.24u l=0.1u ad=0.0816p as=0.0528p pd=1.16u ps=0.68u
    I_MXI48_I36_XG_MN2 (XI48_I36_XG_n1 I48_G7_4n VSS VSS) gpdk090_nmos1v w=0.24u l=0.1u ad=0.0528p as=0.0816p pd=0.68u ps=1.16u
    I_MXI48_I36_XG_MN0 (c0_8 I48_P7_4n XI48_I36_XG_n1 VSS) gpdk090_nmos1v w=0.24u l=0.1u ad=0.0528p as=0.0528p pd=0.68u ps=0.68u
    I_MXI48_I36_XG_MN1 (XI48_I36_XG_n1 I48_G3_0n c0_8 VSS) gpdk090_nmos1v w=0.24u l=0.1u ad=0.0816p as=0.0528p pd=1.16u ps=0.68u
    I_MXI48_I34_XG_MN2 (XI48_I34_XG_n1 I48_G5_2n VSS VSS) gpdk090_nmos1v w=0.24u l=0.1u ad=0.0528p as=0.0816p pd=0.68u ps=1.16u
    I_MXI48_I34_XG_MN0 (I48_G5_0 I48_P5_2n XI48_I34_XG_n1 VSS) gpdk090_nmos1v w=0.24u l=0.1u ad=0.0528p as=0.0528p pd=0.68u ps=0.68u
    I_MXI48_I34_XG_MN1 (XI48_I34_XG_n1 I48_G1_0n I48_G5_0 VSS) gpdk090_nmos1v w=0.24u l=0.1u ad=0.0816p as=0.0528p pd=1.16u ps=0.68u
    I_MXI60_I24_XG_MN2 (XI60_I24_XG_n1 I60_gn6 VSS VSS) gpdk090_nmos1v w=0.24u l=0.1u ad=0.0528p as=0.0816p pd=0.68u ps=1.16u
    I_MXI60_I24_XG_MN0 (I60_G6_5 I60_pn6 XI60_I24_XG_n1 VSS) gpdk090_nmos1v w=0.24u l=0.1u ad=0.0528p as=0.0528p pd=0.68u ps=0.68u
    I_MXI60_I24_XG_MN1 (XI60_I24_XG_n1 I60_gn5 I60_G6_5 VSS) gpdk090_nmos1v w=0.24u l=0.1u ad=0.0816p as=0.0528p pd=1.16u ps=0.68u
    I_MXI60_I23_XG_MN2 (XI60_I23_XG_n1 I60_gn5 VSS VSS) gpdk090_nmos1v w=0.24u l=0.1u ad=0.0528p as=0.0816p pd=0.68u ps=1.16u
    I_MXI60_I23_XG_MN0 (I60_G5_4 I60_pn5 XI60_I23_XG_n1 VSS) gpdk090_nmos1v w=0.24u l=0.1u ad=0.0528p as=0.0528p pd=0.68u ps=0.68u
    I_MXI60_I23_XG_MN1 (XI60_I23_XG_n1 I60_gn4 I60_G5_4 VSS) gpdk090_nmos1v w=0.24u l=0.1u ad=0.0816p as=0.0528p pd=1.16u ps=0.68u
    I_MXI60_I34_XG_MN2 (XI60_I34_XG_n1 I60_G5_2n VSS VSS) gpdk090_nmos1v w=0.24u l=0.1u ad=0.0528p as=0.0816p pd=0.68u ps=1.16u
    I_MXI60_I34_XG_MN0 (I60_G5_0 I60_P5_2n XI60_I34_XG_n1 VSS) gpdk090_nmos1v w=0.24u l=0.1u ad=0.0528p as=0.0528p pd=0.68u ps=0.68u
    I_MXI60_I34_XG_MN1 (XI60_I34_XG_n1 I60_G1_0n I60_G5_0 VSS) gpdk090_nmos1v w=0.24u l=0.1u ad=0.0816p as=0.0528p pd=1.16u ps=0.68u
    I_MXI60_I35_XG_MN2 (XI60_I35_XG_n1 I60_G6_3n VSS VSS) gpdk090_nmos1v w=0.24u l=0.1u ad=0.0528p as=0.0816p pd=0.68u ps=1.16u
    I_MXI60_I35_XG_MN0 (c1_7 I60_P6_3n XI60_I35_XG_n1 VSS) gpdk090_nmos1v w=0.24u l=0.1u ad=0.0528p as=0.0528p pd=0.68u ps=0.68u
    I_MXI60_I35_XG_MN1 (XI60_I35_XG_n1 I60_G2_0n c1_7 VSS) gpdk090_nmos1v w=0.24u l=0.1u ad=0.0816p as=0.0528p pd=1.16u ps=0.68u
    I_MXI72_I24_XG_MN2 (XI72_I24_XG_n1 I72_gn6 VSS VSS) gpdk090_nmos1v w=0.24u l=0.1u ad=0.0528p as=0.0816p pd=0.68u ps=1.16u
    I_MXI72_I24_XG_MN0 (I72_G6_5 I72_pn6 XI72_I24_XG_n1 VSS) gpdk090_nmos1v w=0.24u l=0.1u ad=0.0528p as=0.0528p pd=0.68u ps=0.68u
    I_MXI72_I24_XG_MN1 (XI72_I24_XG_n1 I72_gn5 I72_G6_5 VSS) gpdk090_nmos1v w=0.24u l=0.1u ad=0.0816p as=0.0528p pd=1.16u ps=0.68u
    I_MXI72_I35_XG_MN2 (XI72_I35_XG_n1 I72_G6_3n VSS VSS) gpdk090_nmos1v w=0.24u l=0.1u ad=0.0528p as=0.0816p pd=0.68u ps=1.16u
    I_MXI72_I35_XG_MN0 (c2_7 I72_P6_3n XI72_I35_XG_n1 VSS) gpdk090_nmos1v w=0.24u l=0.1u ad=0.0528p as=0.0528p pd=0.68u ps=0.68u
    I_MXI72_I35_XG_MN1 (XI72_I35_XG_n1 I72_G2_0n c2_7 VSS) gpdk090_nmos1v w=0.24u l=0.1u ad=0.0816p as=0.0528p pd=1.16u ps=0.68u
    I_MXI60_I25_XG_MN2 (XI60_I25_XG_n1 I60_gn7 VSS VSS) gpdk090_nmos1v w=0.24u l=0.1u ad=0.0528p as=0.0816p pd=0.68u ps=1.16u
    I_MXI60_I25_XG_MN0 (I60_G7_6 I60_pn7 XI60_I25_XG_n1 VSS) gpdk090_nmos1v w=0.24u l=0.1u ad=0.0528p as=0.0528p pd=0.68u ps=0.68u
    I_MXI60_I25_XG_MN1 (XI60_I25_XG_n1 I60_gn6 I60_G7_6 VSS) gpdk090_nmos1v w=0.24u l=0.1u ad=0.0816p as=0.0528p pd=1.16u ps=0.68u
    I_MXI60_I36_XG_MN2 (XI60_I36_XG_n1 I60_G7_4n VSS VSS) gpdk090_nmos1v w=0.24u l=0.1u ad=0.0528p as=0.0816p pd=0.68u ps=1.16u
    I_MXI60_I36_XG_MN0 (c1_8 I60_P7_4n XI60_I36_XG_n1 VSS) gpdk090_nmos1v w=0.24u l=0.1u ad=0.0528p as=0.0528p pd=0.68u ps=0.68u
    I_MXI60_I36_XG_MN1 (XI60_I36_XG_n1 I60_G3_0n c1_8 VSS) gpdk090_nmos1v w=0.24u l=0.1u ad=0.0816p as=0.0528p pd=1.16u ps=0.68u
    I_MXI72_I25_XG_MN2 (XI72_I25_XG_n1 I72_gn7 VSS VSS) gpdk090_nmos1v w=0.24u l=0.1u ad=0.0528p as=0.0816p pd=0.68u ps=1.16u
    I_MXI72_I25_XG_MN0 (I72_G7_6 I72_pn7 XI72_I25_XG_n1 VSS) gpdk090_nmos1v w=0.24u l=0.1u ad=0.0528p as=0.0528p pd=0.68u ps=0.68u
    I_MXI72_I25_XG_MN1 (XI72_I25_XG_n1 I72_gn6 I72_G7_6 VSS) gpdk090_nmos1v w=0.24u l=0.1u ad=0.0816p as=0.0528p pd=1.16u ps=0.68u
    I_MXI72_I36_XG_MN2 (XI72_I36_XG_n1 I72_G7_4n VSS VSS) gpdk090_nmos1v w=0.24u l=0.1u ad=0.0528p as=0.0816p pd=0.68u ps=1.16u
    I_MXI72_I36_XG_MN0 (c2_8 I72_P7_4n XI72_I36_XG_n1 VSS) gpdk090_nmos1v w=0.24u l=0.1u ad=0.0528p as=0.0528p pd=0.68u ps=0.68u
    I_MXI72_I36_XG_MN1 (XI72_I36_XG_n1 I72_G3_0n c2_8 VSS) gpdk090_nmos1v w=0.24u l=0.1u ad=0.0816p as=0.0528p pd=1.16u ps=0.68u
    I_MXI132_I7_MN1 (XI132_I7_n1 b7_7 VSS VSS) gpdk090_nmos1v w=0.24u l=0.1u ad=0.0528p as=0.0816p pd=0.68u ps=1.16u
    I_MXI132_I7_MN0 (I132_gn7 p6_6 XI132_I7_n1 VSS) gpdk090_nmos1v w=0.24u l=0.1u ad=0.0816p as=0.0528p pd=1.16u ps=0.68u
    I_MXI132_I5_MN1 (XI132_I5_n1 b7_5 VSS VSS) gpdk090_nmos1v w=0.24u l=0.1u ad=0.0528p as=0.0816p pd=0.68u ps=1.16u
    I_MXI132_I5_MN0 (I132_gn5 p6_4 XI132_I5_n1 VSS) gpdk090_nmos1v w=0.24u l=0.1u ad=0.0816p as=0.0528p pd=1.16u ps=0.68u
    I_MXI120_I31_XP_MN1 (XI120_I31_XP_n1 I120_P5_4 VSS VSS) gpdk090_nmos1v w=0.24u l=0.1u ad=0.0528p as=0.0816p pd=0.68u ps=1.16u
    I_MXI120_I31_XP_MN0 (I120_P7_4n I120_P7_6 XI120_I31_XP_n1 VSS) gpdk090_nmos1v w=0.24u l=0.1u ad=0.0816p as=0.0528p pd=1.16u ps=0.68u
    I_MXI120_I7_MN1 (XI120_I7_n1 b6_7 VSS VSS) gpdk090_nmos1v w=0.24u l=0.1u ad=0.0528p as=0.0816p pd=0.68u ps=1.16u
    I_MXI120_I7_MN0 (I120_gn7 p5_6 XI120_I7_n1 VSS) gpdk090_nmos1v w=0.24u l=0.1u ad=0.0816p as=0.0528p pd=1.16u ps=0.68u
    I_MXI108_I29_XP_MN1 (XI108_I29_XP_n1 I108_P3_2 VSS VSS) gpdk090_nmos1v w=0.24u l=0.1u ad=0.0528p as=0.0816p pd=0.68u ps=1.16u
    I_MXI108_I29_XP_MN0 (I108_P5_2n I108_P5_4 XI108_I29_XP_n1 VSS) gpdk090_nmos1v w=0.24u l=0.1u ad=0.0816p as=0.0528p pd=1.16u ps=0.68u
    I_MXI108_I7_MN1 (XI108_I7_n1 b5_7 VSS VSS) gpdk090_nmos1v w=0.24u l=0.1u ad=0.0528p as=0.0816p pd=0.68u ps=1.16u
    I_MXI108_I7_MN0 (I108_gn7 p4_6 XI108_I7_n1 VSS) gpdk090_nmos1v w=0.24u l=0.1u ad=0.0816p as=0.0528p pd=1.16u ps=0.68u
    I_MXI132_I6_MN1 (XI132_I6_n1 b7_6 VSS VSS) gpdk090_nmos1v w=0.24u l=0.1u ad=0.0528p as=0.0816p pd=0.68u ps=1.16u
    I_MXI132_I6_MN0 (I132_gn6 p6_5 XI132_I6_n1 VSS) gpdk090_nmos1v w=0.24u l=0.1u ad=0.0816p as=0.0528p pd=1.16u ps=0.68u
    I_MXI120_I30_XP_MN1 (XI120_I30_XP_n1 I120_P4_3 VSS VSS) gpdk090_nmos1v w=0.24u l=0.1u ad=0.0528p as=0.0816p pd=0.68u ps=1.16u
    I_MXI120_I30_XP_MN0 (I120_P6_3n I120_P6_5 XI120_I30_XP_n1 VSS) gpdk090_nmos1v w=0.24u l=0.1u ad=0.0816p as=0.0528p pd=1.16u ps=0.68u
    I_MXI120_I29_XP_MN1 (XI120_I29_XP_n1 I120_P3_2 VSS VSS) gpdk090_nmos1v w=0.24u l=0.1u ad=0.0528p as=0.0816p pd=0.68u ps=1.16u
    I_MXI120_I29_XP_MN0 (I120_P5_2n I120_P5_4 XI120_I29_XP_n1 VSS) gpdk090_nmos1v w=0.24u l=0.1u ad=0.0816p as=0.0528p pd=1.16u ps=0.68u
    I_MXI120_I5_MN1 (XI120_I5_n1 b6_5 VSS VSS) gpdk090_nmos1v w=0.24u l=0.1u ad=0.0528p as=0.0816p pd=0.68u ps=1.16u
    I_MXI120_I5_MN0 (I120_gn5 p5_4 XI120_I5_n1 VSS) gpdk090_nmos1v w=0.24u l=0.1u ad=0.0816p as=0.0528p pd=1.16u ps=0.68u
    I_MXI120_I6_MN1 (XI120_I6_n1 b6_6 VSS VSS) gpdk090_nmos1v w=0.24u l=0.1u ad=0.0528p as=0.0816p pd=0.68u ps=1.16u
    I_MXI120_I6_MN0 (I120_gn6 p5_5 XI120_I6_n1 VSS) gpdk090_nmos1v w=0.24u l=0.1u ad=0.0816p as=0.0528p pd=1.16u ps=0.68u
    I_MXI108_I30_XP_MN1 (XI108_I30_XP_n1 I108_P4_3 VSS VSS) gpdk090_nmos1v w=0.24u l=0.1u ad=0.0528p as=0.0816p pd=0.68u ps=1.16u
    I_MXI108_I30_XP_MN0 (I108_P6_3n I108_P6_5 XI108_I30_XP_n1 VSS) gpdk090_nmos1v w=0.24u l=0.1u ad=0.0816p as=0.0528p pd=1.16u ps=0.68u
    I_MXI108_I31_XP_MN1 (XI108_I31_XP_n1 I108_P5_4 VSS VSS) gpdk090_nmos1v w=0.24u l=0.1u ad=0.0528p as=0.0816p pd=0.68u ps=1.16u
    I_MXI108_I31_XP_MN0 (I108_P7_4n I108_P7_6 XI108_I31_XP_n1 VSS) gpdk090_nmos1v w=0.24u l=0.1u ad=0.0816p as=0.0528p pd=1.16u ps=0.68u
    I_MXI108_I5_MN1 (XI108_I5_n1 b5_5 VSS VSS) gpdk090_nmos1v w=0.24u l=0.1u ad=0.0528p as=0.0816p pd=0.68u ps=1.16u
    I_MXI108_I5_MN0 (I108_gn5 p4_4 XI108_I5_n1 VSS) gpdk090_nmos1v w=0.24u l=0.1u ad=0.0816p as=0.0528p pd=1.16u ps=0.68u
    I_MXI108_I6_MN1 (XI108_I6_n1 b5_6 VSS VSS) gpdk090_nmos1v w=0.24u l=0.1u ad=0.0528p as=0.0816p pd=0.68u ps=1.16u
    I_MXI108_I6_MN0 (I108_gn6 p4_5 XI108_I6_n1 VSS) gpdk090_nmos1v w=0.24u l=0.1u ad=0.0816p as=0.0528p pd=1.16u ps=0.68u
    I_MXI132_I31_XP_MN1 (XI132_I31_XP_n1 I132_P5_4 VSS VSS) gpdk090_nmos1v w=0.24u l=0.1u ad=0.0528p as=0.0816p pd=0.68u ps=1.16u
    I_MXI132_I31_XP_MN0 (I132_P7_4n I132_P7_6 XI132_I31_XP_n1 VSS) gpdk090_nmos1v w=0.24u l=0.1u ad=0.0816p as=0.0528p pd=1.16u ps=0.68u
    I_MXI132_I4_MN1 (XI132_I4_n1 b7_4 VSS VSS) gpdk090_nmos1v w=0.24u l=0.1u ad=0.0528p as=0.0816p pd=0.68u ps=1.16u
    I_MXI132_I4_MN0 (I132_gn4 p6_3 XI132_I4_n1 VSS) gpdk090_nmos1v w=0.24u l=0.1u ad=0.0816p as=0.0528p pd=1.16u ps=0.68u
    I_MXI120_I28_XP_MN1 (XI120_I28_XP_n1 I120_P2_1 VSS VSS) gpdk090_nmos1v w=0.24u l=0.1u ad=0.0528p as=0.0816p pd=0.68u ps=1.16u
    I_MXI120_I28_XP_MN0 (I120_P4_1n I120_P4_3 XI120_I28_XP_n1 VSS) gpdk090_nmos1v w=0.24u l=0.1u ad=0.0816p as=0.0528p pd=1.16u ps=0.68u
    I_MXI120_I3_MN1 (XI120_I3_n1 b6_3 VSS VSS) gpdk090_nmos1v w=0.24u l=0.1u ad=0.0528p as=0.0816p pd=0.68u ps=1.16u
    I_MXI120_I3_MN0 (I120_gn3 p5_2 XI120_I3_n1 VSS) gpdk090_nmos1v w=0.24u l=0.1u ad=0.0816p as=0.0528p pd=1.16u ps=0.68u
    I_MXI120_I4_MN1 (XI120_I4_n1 b6_4 VSS VSS) gpdk090_nmos1v w=0.24u l=0.1u ad=0.0528p as=0.0816p pd=0.68u ps=1.16u
    I_MXI120_I4_MN0 (I120_gn4 p5_3 XI120_I4_n1 VSS) gpdk090_nmos1v w=0.24u l=0.1u ad=0.0816p as=0.0528p pd=1.16u ps=0.68u
    I_MXI108_I28_XP_MN1 (XI108_I28_XP_n1 I108_P2_1 VSS VSS) gpdk090_nmos1v w=0.24u l=0.1u ad=0.0528p as=0.0816p pd=0.68u ps=1.16u
    I_MXI108_I28_XP_MN0 (I108_P4_1n I108_P4_3 XI108_I28_XP_n1 VSS) gpdk090_nmos1v w=0.24u l=0.1u ad=0.0816p as=0.0528p pd=1.16u ps=0.68u
    I_MXI108_I3_MN1 (XI108_I3_n1 b5_3 VSS VSS) gpdk090_nmos1v w=0.24u l=0.1u ad=0.0528p as=0.0816p pd=0.68u ps=1.16u
    I_MXI108_I3_MN0 (I108_gn3 p4_2 XI108_I3_n1 VSS) gpdk090_nmos1v w=0.24u l=0.1u ad=0.0816p as=0.0528p pd=1.16u ps=0.68u
    I_MXI108_I4_MN1 (XI108_I4_n1 b5_4 VSS VSS) gpdk090_nmos1v w=0.24u l=0.1u ad=0.0528p as=0.0816p pd=0.68u ps=1.16u
    I_MXI108_I4_MN0 (I108_gn4 p4_3 XI108_I4_n1 VSS) gpdk090_nmos1v w=0.24u l=0.1u ad=0.0816p as=0.0528p pd=1.16u ps=0.68u
    I_MXI152_I7_MN1 (XI152_I7_n1 dm7 VSS VSS) gpdk090_nmos1v w=0.24u l=0.1u ad=0.0528p as=0.0816p pd=0.68u ps=1.16u
    I_MXI152_I7_MN0 (I152_gn7 p7_7 XI152_I7_n1 VSS) gpdk090_nmos1v w=0.24u l=0.1u ad=0.0816p as=0.0528p pd=1.16u ps=0.68u
    I_MXI132_I29_XP_MN1 (XI132_I29_XP_n1 I132_P3_2 VSS VSS) gpdk090_nmos1v w=0.24u l=0.1u ad=0.0528p as=0.0816p pd=0.68u ps=1.16u
    I_MXI132_I29_XP_MN0 (I132_P5_2n I132_P5_4 XI132_I29_XP_n1 VSS) gpdk090_nmos1v w=0.24u l=0.1u ad=0.0816p as=0.0528p pd=1.16u ps=0.68u
    I_MXI132_I30_XP_MN1 (XI132_I30_XP_n1 I132_P4_3 VSS VSS) gpdk090_nmos1v w=0.24u l=0.1u ad=0.0528p as=0.0816p pd=0.68u ps=1.16u
    I_MXI132_I30_XP_MN0 (I132_P6_3n I132_P6_5 XI132_I30_XP_n1 VSS) gpdk090_nmos1v w=0.24u l=0.1u ad=0.0816p as=0.0528p pd=1.16u ps=0.68u
    I_MXI132_I3_MN1 (XI132_I3_n1 b7_3 VSS VSS) gpdk090_nmos1v w=0.24u l=0.1u ad=0.0528p as=0.0816p pd=0.68u ps=1.16u
    I_MXI132_I3_MN0 (I132_gn3 p6_2 XI132_I3_n1 VSS) gpdk090_nmos1v w=0.24u l=0.1u ad=0.0816p as=0.0528p pd=1.16u ps=0.68u
    I_MXI120_I1_MN1 (XI120_I1_n1 b6_1 VSS VSS) gpdk090_nmos1v w=0.24u l=0.1u ad=0.0528p as=0.0816p pd=0.68u ps=1.16u
    I_MXI120_I1_MN0 (I120_gn1 p5_0 XI120_I1_n1 VSS) gpdk090_nmos1v w=0.24u l=0.1u ad=0.0816p as=0.0528p pd=1.16u ps=0.68u
    I_MXI120_I2_MN1 (XI120_I2_n1 b6_2 VSS VSS) gpdk090_nmos1v w=0.24u l=0.1u ad=0.0528p as=0.0816p pd=0.68u ps=1.16u
    I_MXI120_I2_MN0 (I120_gn2 p5_1 XI120_I2_n1 VSS) gpdk090_nmos1v w=0.24u l=0.1u ad=0.0816p as=0.0528p pd=1.16u ps=0.68u
    I_MXI108_I2_MN1 (XI108_I2_n1 b5_2 VSS VSS) gpdk090_nmos1v w=0.24u l=0.1u ad=0.0528p as=0.0816p pd=0.68u ps=1.16u
    I_MXI108_I2_MN0 (I108_gn2 p4_1 XI108_I2_n1 VSS) gpdk090_nmos1v w=0.24u l=0.1u ad=0.0816p as=0.0528p pd=1.16u ps=0.68u
    I_MXI96_I29_XP_MN1 (XI96_I29_XP_n1 I96_P3_2 VSS VSS) gpdk090_nmos1v w=0.24u l=0.1u ad=0.0528p as=0.0816p pd=0.68u ps=1.16u
    I_MXI96_I29_XP_MN0 (I96_P5_2n I96_P5_4 XI96_I29_XP_n1 VSS) gpdk090_nmos1v w=0.24u l=0.1u ad=0.0816p as=0.0528p pd=1.16u ps=0.68u
    I_MXI96_I31_XP_MN1 (XI96_I31_XP_n1 I96_P5_4 VSS VSS) gpdk090_nmos1v w=0.24u l=0.1u ad=0.0528p as=0.0816p pd=0.68u ps=1.16u
    I_MXI96_I31_XP_MN0 (I96_P7_4n I96_P7_6 XI96_I31_XP_n1 VSS) gpdk090_nmos1v w=0.24u l=0.1u ad=0.0816p as=0.0528p pd=1.16u ps=0.68u
    I_MXI148_MN1 (XI148_n1 p7_8 VSS VSS) gpdk090_nmos1v w=0.24u l=0.1u ad=0.0528p as=0.0816p pd=0.68u ps=1.16u
    I_MXI148_MN0 (dmn6 dd6 XI148_n1 VSS) gpdk090_nmos1v w=0.24u l=0.1u ad=0.0816p as=0.0528p pd=1.16u ps=0.68u
    I_MXI150_MN1 (XI150_n1 p7_8 VSS VSS) gpdk090_nmos1v w=0.24u l=0.1u ad=0.0528p as=0.0816p pd=0.68u ps=1.16u
    I_MXI150_MN0 (dmn7 dd7 XI150_n1 VSS) gpdk090_nmos1v w=0.24u l=0.1u ad=0.0816p as=0.0528p pd=1.16u ps=0.68u
    I_MXI132_I28_XP_MN1 (XI132_I28_XP_n1 I132_P2_1 VSS VSS) gpdk090_nmos1v w=0.24u l=0.1u ad=0.0528p as=0.0816p pd=0.68u ps=1.16u
    I_MXI132_I28_XP_MN0 (I132_P4_1n I132_P4_3 XI132_I28_XP_n1 VSS) gpdk090_nmos1v w=0.24u l=0.1u ad=0.0816p as=0.0528p pd=1.16u ps=0.68u
    I_MXI132_I2_MN1 (XI132_I2_n1 b7_2 VSS VSS) gpdk090_nmos1v w=0.24u l=0.1u ad=0.0528p as=0.0816p pd=0.68u ps=1.16u
    I_MXI132_I2_MN0 (I132_gn2 p6_1 XI132_I2_n1 VSS) gpdk090_nmos1v w=0.24u l=0.1u ad=0.0816p as=0.0528p pd=1.16u ps=0.68u
    I_MXI120_I0_MN1 (XI120_I0_n1 b6_0 VSS VSS) gpdk090_nmos1v w=0.24u l=0.1u ad=0.0528p as=0.0816p pd=0.68u ps=1.16u
    I_MXI120_I0_MN0 (I120_gn0 aa1 XI120_I0_n1 VSS) gpdk090_nmos1v w=0.24u l=0.1u ad=0.0816p as=0.0528p pd=1.16u ps=0.68u
    I_MXI108_I0_MN1 (XI108_I0_n1 b5_0 VSS VSS) gpdk090_nmos1v w=0.24u l=0.1u ad=0.0528p as=0.0816p pd=0.68u ps=1.16u
    I_MXI108_I0_MN0 (I108_gn0 aa2 XI108_I0_n1 VSS) gpdk090_nmos1v w=0.24u l=0.1u ad=0.0816p as=0.0528p pd=1.16u ps=0.68u
    I_MXI108_I1_MN1 (XI108_I1_n1 b5_1 VSS VSS) gpdk090_nmos1v w=0.24u l=0.1u ad=0.0528p as=0.0816p pd=0.68u ps=1.16u
    I_MXI108_I1_MN0 (I108_gn1 p4_0 XI108_I1_n1 VSS) gpdk090_nmos1v w=0.24u l=0.1u ad=0.0816p as=0.0528p pd=1.16u ps=0.68u
    I_MXI96_I28_XP_MN1 (XI96_I28_XP_n1 I96_P2_1 VSS VSS) gpdk090_nmos1v w=0.24u l=0.1u ad=0.0528p as=0.0816p pd=0.68u ps=1.16u
    I_MXI96_I28_XP_MN0 (I96_P4_1n I96_P4_3 XI96_I28_XP_n1 VSS) gpdk090_nmos1v w=0.24u l=0.1u ad=0.0816p as=0.0528p pd=1.16u ps=0.68u
    I_MXI96_I30_XP_MN1 (XI96_I30_XP_n1 I96_P4_3 VSS VSS) gpdk090_nmos1v w=0.24u l=0.1u ad=0.0528p as=0.0816p pd=0.68u ps=1.16u
    I_MXI96_I30_XP_MN0 (I96_P6_3n I96_P6_5 XI96_I30_XP_n1 VSS) gpdk090_nmos1v w=0.24u l=0.1u ad=0.0816p as=0.0528p pd=1.16u ps=0.68u
    I_MXI96_I7_MN1 (XI96_I7_n1 b4_7 VSS VSS) gpdk090_nmos1v w=0.24u l=0.1u ad=0.0528p as=0.0816p pd=0.68u ps=1.16u
    I_MXI96_I7_MN0 (I96_gn7 p3_6 XI96_I7_n1 VSS) gpdk090_nmos1v w=0.24u l=0.1u ad=0.0816p as=0.0528p pd=1.16u ps=0.68u
    I_MXI152_I6_MN1 (XI152_I6_n1 dm6 VSS VSS) gpdk090_nmos1v w=0.24u l=0.1u ad=0.0528p as=0.0816p pd=0.68u ps=1.16u
    I_MXI152_I6_MN0 (I152_gn6 p7_6 XI152_I6_n1 VSS) gpdk090_nmos1v w=0.24u l=0.1u ad=0.0816p as=0.0528p pd=1.16u ps=0.68u
    I_MXI152_I5_MN1 (XI152_I5_n1 dm5 VSS VSS) gpdk090_nmos1v w=0.24u l=0.1u ad=0.0528p as=0.0816p pd=0.68u ps=1.16u
    I_MXI152_I5_MN0 (I152_gn5 p7_5 XI152_I5_n1 VSS) gpdk090_nmos1v w=0.24u l=0.1u ad=0.0816p as=0.0528p pd=1.16u ps=0.68u
    I_MXI152_I4_MN1 (XI152_I4_n1 dm4 VSS VSS) gpdk090_nmos1v w=0.24u l=0.1u ad=0.0528p as=0.0816p pd=0.68u ps=1.16u
    I_MXI152_I4_MN0 (I152_gn4 p7_4 XI152_I4_n1 VSS) gpdk090_nmos1v w=0.24u l=0.1u ad=0.0816p as=0.0528p pd=1.16u ps=0.68u
    I_MXI146_MN1 (XI146_n1 p7_8 VSS VSS) gpdk090_nmos1v w=0.24u l=0.1u ad=0.0528p as=0.0816p pd=0.68u ps=1.16u
    I_MXI146_MN0 (dmn5 dd5 XI146_n1 VSS) gpdk090_nmos1v w=0.24u l=0.1u ad=0.0816p as=0.0528p pd=1.16u ps=0.68u
    I_MXI144_MN1 (XI144_n1 p7_8 VSS VSS) gpdk090_nmos1v w=0.24u l=0.1u ad=0.0528p as=0.0816p pd=0.68u ps=1.16u
    I_MXI144_MN0 (dmn4 dd4 XI144_n1 VSS) gpdk090_nmos1v w=0.24u l=0.1u ad=0.0816p as=0.0528p pd=1.16u ps=0.68u
    I_MXI132_I1_MN1 (XI132_I1_n1 b7_1 VSS VSS) gpdk090_nmos1v w=0.24u l=0.1u ad=0.0528p as=0.0816p pd=0.68u ps=1.16u
    I_MXI132_I1_MN0 (I132_gn1 p6_0 XI132_I1_n1 VSS) gpdk090_nmos1v w=0.24u l=0.1u ad=0.0816p as=0.0528p pd=1.16u ps=0.68u
    I_MXI132_I0_MN1 (XI132_I0_n1 b7_0 VSS VSS) gpdk090_nmos1v w=0.24u l=0.1u ad=0.0528p as=0.0816p pd=0.68u ps=1.16u
    I_MXI132_I0_MN0 (I132_gn0 A_0 XI132_I0_n1 VSS) gpdk090_nmos1v w=0.24u l=0.1u ad=0.0816p as=0.0528p pd=1.16u ps=0.68u
    I_MXI96_I0_MN1 (XI96_I0_n1 b4_0 VSS VSS) gpdk090_nmos1v w=0.24u l=0.1u ad=0.0528p as=0.0816p pd=0.68u ps=1.16u
    I_MXI96_I0_MN0 (I96_gn0 aa3 XI96_I0_n1 VSS) gpdk090_nmos1v w=0.24u l=0.1u ad=0.0816p as=0.0528p pd=1.16u ps=0.68u
    I_MXI96_I1_MN1 (XI96_I1_n1 b4_1 VSS VSS) gpdk090_nmos1v w=0.24u l=0.1u ad=0.0528p as=0.0816p pd=0.68u ps=1.16u
    I_MXI96_I1_MN0 (I96_gn1 p3_0 XI96_I1_n1 VSS) gpdk090_nmos1v w=0.24u l=0.1u ad=0.0816p as=0.0528p pd=1.16u ps=0.68u
    I_MXI152_I31_XP_MN1 (XI152_I31_XP_n1 I152_P5_4 VSS VSS) gpdk090_nmos1v w=0.24u l=0.1u ad=0.0528p as=0.0816p pd=0.68u ps=1.16u
    I_MXI152_I31_XP_MN0 (I152_P7_4n I152_P7_6 XI152_I31_XP_n1 VSS) gpdk090_nmos1v w=0.24u l=0.1u ad=0.0816p as=0.0528p pd=1.16u ps=0.68u
    I_MXI152_I3_MN1 (XI152_I3_n1 dm3 VSS VSS) gpdk090_nmos1v w=0.24u l=0.1u ad=0.0528p as=0.0816p pd=0.68u ps=1.16u
    I_MXI152_I3_MN0 (I152_gn3 p7_3 XI152_I3_n1 VSS) gpdk090_nmos1v w=0.24u l=0.1u ad=0.0816p as=0.0528p pd=1.16u ps=0.68u
    I_MXI142_MN1 (XI142_n1 p7_8 VSS VSS) gpdk090_nmos1v w=0.24u l=0.1u ad=0.0528p as=0.0816p pd=0.68u ps=1.16u
    I_MXI142_MN0 (dmn3 dd3 XI142_n1 VSS) gpdk090_nmos1v w=0.24u l=0.1u ad=0.0816p as=0.0528p pd=1.16u ps=0.68u
    I_MXI0_MN1 (XI0_n1 A_0 VSS VSS) gpdk090_nmos1v w=0.24u l=0.1u ad=0.0528p as=0.0816p pd=0.68u ps=1.16u
    I_MXI0_MN0 (nakn1 A_7 XI0_n1 VSS) gpdk090_nmos1v w=0.24u l=0.1u ad=0.0816p as=0.0528p pd=1.16u ps=0.68u
    I_MXI96_I2_MN1 (XI96_I2_n1 b4_2 VSS VSS) gpdk090_nmos1v w=0.24u l=0.1u ad=0.0528p as=0.0816p pd=0.68u ps=1.16u
    I_MXI96_I2_MN0 (I96_gn2 p3_1 XI96_I2_n1 VSS) gpdk090_nmos1v w=0.24u l=0.1u ad=0.0816p as=0.0528p pd=1.16u ps=0.68u
    I_MXI96_I3_MN1 (XI96_I3_n1 b4_3 VSS VSS) gpdk090_nmos1v w=0.24u l=0.1u ad=0.0528p as=0.0816p pd=0.68u ps=1.16u
    I_MXI96_I3_MN0 (I96_gn3 p3_2 XI96_I3_n1 VSS) gpdk090_nmos1v w=0.24u l=0.1u ad=0.0816p as=0.0528p pd=1.16u ps=0.68u
    I_MXI96_I4_MN1 (XI96_I4_n1 b4_4 VSS VSS) gpdk090_nmos1v w=0.24u l=0.1u ad=0.0528p as=0.0816p pd=0.68u ps=1.16u
    I_MXI96_I4_MN0 (I96_gn4 p3_3 XI96_I4_n1 VSS) gpdk090_nmos1v w=0.24u l=0.1u ad=0.0816p as=0.0528p pd=1.16u ps=0.68u
    I_MXI96_I5_MN1 (XI96_I5_n1 b4_5 VSS VSS) gpdk090_nmos1v w=0.24u l=0.1u ad=0.0528p as=0.0816p pd=0.68u ps=1.16u
    I_MXI96_I5_MN0 (I96_gn5 p3_4 XI96_I5_n1 VSS) gpdk090_nmos1v w=0.24u l=0.1u ad=0.0816p as=0.0528p pd=1.16u ps=0.68u
    I_MXI96_I6_MN1 (XI96_I6_n1 b4_6 VSS VSS) gpdk090_nmos1v w=0.24u l=0.1u ad=0.0528p as=0.0816p pd=0.68u ps=1.16u
    I_MXI96_I6_MN0 (I96_gn6 p3_5 XI96_I6_n1 VSS) gpdk090_nmos1v w=0.24u l=0.1u ad=0.0816p as=0.0528p pd=1.16u ps=0.68u
    I_MXI152_I29_XP_MN1 (XI152_I29_XP_n1 I152_P3_2 VSS VSS) gpdk090_nmos1v w=0.24u l=0.1u ad=0.0528p as=0.0816p pd=0.68u ps=1.16u
    I_MXI152_I29_XP_MN0 (I152_P5_2n I152_P5_4 XI152_I29_XP_n1 VSS) gpdk090_nmos1v w=0.24u l=0.1u ad=0.0816p as=0.0528p pd=1.16u ps=0.68u
    I_MXI152_I2_MN1 (XI152_I2_n1 dm2 VSS VSS) gpdk090_nmos1v w=0.24u l=0.1u ad=0.0528p as=0.0816p pd=0.68u ps=1.16u
    I_MXI152_I2_MN0 (I152_gn2 p7_2 XI152_I2_n1 VSS) gpdk090_nmos1v w=0.24u l=0.1u ad=0.0816p as=0.0528p pd=1.16u ps=0.68u
    I_MXI152_I0_MN1 (XI152_I0_n1 dm0 VSS VSS) gpdk090_nmos1v w=0.24u l=0.1u ad=0.0528p as=0.0816p pd=0.68u ps=1.16u
    I_MXI152_I0_MN0 (I152_gn0 p7_0 XI152_I0_n1 VSS) gpdk090_nmos1v w=0.24u l=0.1u ad=0.0816p as=0.0528p pd=1.16u ps=0.68u
    I_MXI138_MN1 (XI138_n1 p7_8 VSS VSS) gpdk090_nmos1v w=0.24u l=0.1u ad=0.0528p as=0.0816p pd=0.68u ps=1.16u
    I_MXI138_MN0 (dmn1 dd1 XI138_n1 VSS) gpdk090_nmos1v w=0.24u l=0.1u ad=0.0816p as=0.0528p pd=1.16u ps=0.68u
    I_MXI140_MN1 (XI140_n1 p7_8 VSS VSS) gpdk090_nmos1v w=0.24u l=0.1u ad=0.0528p as=0.0816p pd=0.68u ps=1.16u
    I_MXI140_MN0 (dmn2 dd2 XI140_n1 VSS) gpdk090_nmos1v w=0.24u l=0.1u ad=0.0816p as=0.0528p pd=1.16u ps=0.68u
    I_MXI136_MN1 (XI136_n1 p7_8 VSS VSS) gpdk090_nmos1v w=0.24u l=0.1u ad=0.0528p as=0.0816p pd=0.68u ps=1.16u
    I_MXI136_MN0 (dmn0 B_0 XI136_n1 VSS) gpdk090_nmos1v w=0.24u l=0.1u ad=0.0816p as=0.0528p pd=1.16u ps=0.68u
    I_MXI154_MN1 (XI154_n1 Q_0 VSS VSS) gpdk090_nmos1v w=0.24u l=0.1u ad=0.0528p as=0.0816p pd=0.68u ps=1.16u
    I_MXI154_MN0 (nqkn1 sq XI154_n1 VSS) gpdk090_nmos1v w=0.24u l=0.1u ad=0.0816p as=0.0528p pd=1.16u ps=0.68u
    I_MXI84_I0_MN1 (XI84_I0_n1 b3_0 VSS VSS) gpdk090_nmos1v w=0.24u l=0.1u ad=0.0528p as=0.0816p pd=0.68u ps=1.16u
    I_MXI84_I0_MN0 (I84_gn0 aa4 XI84_I0_n1 VSS) gpdk090_nmos1v w=0.24u l=0.1u ad=0.0816p as=0.0528p pd=1.16u ps=0.68u
    I_MXI84_I28_XP_MN1 (XI84_I28_XP_n1 I84_P2_1 VSS VSS) gpdk090_nmos1v w=0.24u l=0.1u ad=0.0528p as=0.0816p pd=0.68u ps=1.16u
    I_MXI84_I28_XP_MN0 (I84_P4_1n I84_P4_3 XI84_I28_XP_n1 VSS) gpdk090_nmos1v w=0.24u l=0.1u ad=0.0816p as=0.0528p pd=1.16u ps=0.68u
    I_MXI152_I30_XP_MN1 (XI152_I30_XP_n1 I152_P4_3 VSS VSS) gpdk090_nmos1v w=0.24u l=0.1u ad=0.0528p as=0.0816p pd=0.68u ps=1.16u
    I_MXI152_I30_XP_MN0 (I152_P6_3n I152_P6_5 XI152_I30_XP_n1 VSS) gpdk090_nmos1v w=0.24u l=0.1u ad=0.0816p as=0.0528p pd=1.16u ps=0.68u
    I_MXI152_I28_XP_MN1 (XI152_I28_XP_n1 I152_P2_1 VSS VSS) gpdk090_nmos1v w=0.24u l=0.1u ad=0.0528p as=0.0816p pd=0.68u ps=1.16u
    I_MXI152_I28_XP_MN0 (I152_P4_1n I152_P4_3 XI152_I28_XP_n1 VSS) gpdk090_nmos1v w=0.24u l=0.1u ad=0.0816p as=0.0528p pd=1.16u ps=0.68u
    I_MXI152_I1_MN1 (XI152_I1_n1 dm1 VSS VSS) gpdk090_nmos1v w=0.24u l=0.1u ad=0.0528p as=0.0816p pd=0.68u ps=1.16u
    I_MXI152_I1_MN0 (I152_gn1 p7_1 XI152_I1_n1 VSS) gpdk090_nmos1v w=0.24u l=0.1u ad=0.0816p as=0.0528p pd=1.16u ps=0.68u
    I_MXI20_MN1 (XI20_n1 B_0 VSS VSS) gpdk090_nmos1v w=0.24u l=0.1u ad=0.0528p as=0.0816p pd=0.68u ps=1.16u
    I_MXI20_MN0 (nbkn1 B_7 XI20_n1 VSS) gpdk090_nmos1v w=0.24u l=0.1u ad=0.0816p as=0.0528p pd=1.16u ps=0.68u
    I_MXI84_I1_MN1 (XI84_I1_n1 b3_1 VSS VSS) gpdk090_nmos1v w=0.24u l=0.1u ad=0.0528p as=0.0816p pd=0.68u ps=1.16u
    I_MXI84_I1_MN0 (I84_gn1 p2_0 XI84_I1_n1 VSS) gpdk090_nmos1v w=0.24u l=0.1u ad=0.0816p as=0.0528p pd=1.16u ps=0.68u
    I_MXI84_I30_XP_MN1 (XI84_I30_XP_n1 I84_P4_3 VSS VSS) gpdk090_nmos1v w=0.24u l=0.1u ad=0.0528p as=0.0816p pd=0.68u ps=1.16u
    I_MXI84_I30_XP_MN0 (I84_P6_3n I84_P6_5 XI84_I30_XP_n1 VSS) gpdk090_nmos1v w=0.24u l=0.1u ad=0.0816p as=0.0528p pd=1.16u ps=0.68u
    I_MXI199_MN1 (XI199_n1 z1_3 VSS VSS) gpdk090_nmos1v w=0.24u l=0.1u ad=0.0528p as=0.0816p pd=0.68u ps=1.16u
    I_MXI199_MN0 (z2_1 z1_2 XI199_n1 VSS) gpdk090_nmos1v w=0.24u l=0.1u ad=0.0816p as=0.0528p pd=1.16u ps=0.68u
    I_MXI198_MN1 (XI198_n1 z1_1 VSS VSS) gpdk090_nmos1v w=0.24u l=0.1u ad=0.0528p as=0.0816p pd=0.68u ps=1.16u
    I_MXI198_MN0 (z2_0 z1_0 XI198_n1 VSS) gpdk090_nmos1v w=0.24u l=0.1u ad=0.0816p as=0.0528p pd=1.16u ps=0.68u
    I_MXI202_MN1 (XI202_n1 sqn VSS VSS) gpdk090_nmos1v w=0.24u l=0.1u ad=0.0528p as=0.0816p pd=0.68u ps=1.16u
    I_MXI202_MN0 (vn Q_7 XI202_n1 VSS) gpdk090_nmos1v w=0.24u l=0.1u ad=0.0816p as=0.0528p pd=1.16u ps=0.68u
    I_MXI72_I0_MN1 (XI72_I0_n1 b2_0 VSS VSS) gpdk090_nmos1v w=0.24u l=0.1u ad=0.0528p as=0.0816p pd=0.68u ps=1.16u
    I_MXI72_I0_MN0 (I72_gn0 aa5 XI72_I0_n1 VSS) gpdk090_nmos1v w=0.24u l=0.1u ad=0.0816p as=0.0528p pd=1.16u ps=0.68u
    I_MXI84_I2_MN1 (XI84_I2_n1 b3_2 VSS VSS) gpdk090_nmos1v w=0.24u l=0.1u ad=0.0528p as=0.0816p pd=0.68u ps=1.16u
    I_MXI84_I2_MN0 (I84_gn2 p2_1 XI84_I2_n1 VSS) gpdk090_nmos1v w=0.24u l=0.1u ad=0.0816p as=0.0528p pd=1.16u ps=0.68u
    I_MXI84_I29_XP_MN1 (XI84_I29_XP_n1 I84_P3_2 VSS VSS) gpdk090_nmos1v w=0.24u l=0.1u ad=0.0528p as=0.0816p pd=0.68u ps=1.16u
    I_MXI84_I29_XP_MN0 (I84_P5_2n I84_P5_4 XI84_I29_XP_n1 VSS) gpdk090_nmos1v w=0.24u l=0.1u ad=0.0816p as=0.0528p pd=1.16u ps=0.68u
    I_MXI174_MN1 (XI174_n1 R_0 VSS VSS) gpdk090_nmos1v w=0.24u l=0.1u ad=0.0528p as=0.0816p pd=0.68u ps=1.16u
    I_MXI174_MN0 (nrkn1 A_7 XI174_n1 VSS) gpdk090_nmos1v w=0.24u l=0.1u ad=0.0816p as=0.0528p pd=1.16u ps=0.68u
    I_MXI48_I0_MN1 (XI48_I0_n1 b0_0 VSS VSS) gpdk090_nmos1v w=0.24u l=0.1u ad=0.0528p as=0.0816p pd=0.68u ps=1.16u
    I_MXI48_I0_MN0 (I48_gn0 aa7 XI48_I0_n1 VSS) gpdk090_nmos1v w=0.24u l=0.1u ad=0.0816p as=0.0528p pd=1.16u ps=0.68u
    I_MXI60_I0_MN1 (XI60_I0_n1 b1_0 VSS VSS) gpdk090_nmos1v w=0.24u l=0.1u ad=0.0528p as=0.0816p pd=0.68u ps=1.16u
    I_MXI60_I0_MN0 (I60_gn0 aa6 XI60_I0_n1 VSS) gpdk090_nmos1v w=0.24u l=0.1u ad=0.0816p as=0.0528p pd=1.16u ps=0.68u
    I_MXI72_I1_MN1 (XI72_I1_n1 b2_1 VSS VSS) gpdk090_nmos1v w=0.24u l=0.1u ad=0.0528p as=0.0816p pd=0.68u ps=1.16u
    I_MXI72_I1_MN0 (I72_gn1 p1_0 XI72_I1_n1 VSS) gpdk090_nmos1v w=0.24u l=0.1u ad=0.0816p as=0.0528p pd=1.16u ps=0.68u
    I_MXI84_I3_MN1 (XI84_I3_n1 b3_3 VSS VSS) gpdk090_nmos1v w=0.24u l=0.1u ad=0.0528p as=0.0816p pd=0.68u ps=1.16u
    I_MXI84_I3_MN0 (I84_gn3 p2_2 XI84_I3_n1 VSS) gpdk090_nmos1v w=0.24u l=0.1u ad=0.0816p as=0.0528p pd=1.16u ps=0.68u
    I_MXI84_I4_MN1 (XI84_I4_n1 b3_4 VSS VSS) gpdk090_nmos1v w=0.24u l=0.1u ad=0.0528p as=0.0816p pd=0.68u ps=1.16u
    I_MXI84_I4_MN0 (I84_gn4 p2_3 XI84_I4_n1 VSS) gpdk090_nmos1v w=0.24u l=0.1u ad=0.0816p as=0.0528p pd=1.16u ps=0.68u
    I_MXI84_I31_XP_MN1 (XI84_I31_XP_n1 I84_P5_4 VSS VSS) gpdk090_nmos1v w=0.24u l=0.1u ad=0.0528p as=0.0816p pd=0.68u ps=1.16u
    I_MXI84_I31_XP_MN0 (I84_P7_4n I84_P7_6 XI84_I31_XP_n1 VSS) gpdk090_nmos1v w=0.24u l=0.1u ad=0.0816p as=0.0528p pd=1.16u ps=0.68u
    I_MXI48_I3_MN1 (XI48_I3_n1 b0_3 VSS VSS) gpdk090_nmos1v w=0.24u l=0.1u ad=0.0528p as=0.0816p pd=0.68u ps=1.16u
    I_MXI48_I3_MN0 (I48_gn3 VSS XI48_I3_n1 VSS) gpdk090_nmos1v w=0.24u l=0.1u ad=0.0816p as=0.0528p pd=1.16u ps=0.68u
    I_MXI48_I2_MN1 (XI48_I2_n1 b0_2 VSS VSS) gpdk090_nmos1v w=0.24u l=0.1u ad=0.0528p as=0.0816p pd=0.68u ps=1.16u
    I_MXI48_I2_MN0 (I48_gn2 VSS XI48_I2_n1 VSS) gpdk090_nmos1v w=0.24u l=0.1u ad=0.0816p as=0.0528p pd=1.16u ps=0.68u
    I_MXI48_I1_MN1 (XI48_I1_n1 b0_1 VSS VSS) gpdk090_nmos1v w=0.24u l=0.1u ad=0.0528p as=0.0816p pd=0.68u ps=1.16u
    I_MXI48_I1_MN0 (I48_gn1 VSS XI48_I1_n1 VSS) gpdk090_nmos1v w=0.24u l=0.1u ad=0.0816p as=0.0528p pd=1.16u ps=0.68u
    I_MXI60_I1_MN1 (XI60_I1_n1 b1_1 VSS VSS) gpdk090_nmos1v w=0.24u l=0.1u ad=0.0528p as=0.0816p pd=0.68u ps=1.16u
    I_MXI60_I1_MN0 (I60_gn1 p0_0 XI60_I1_n1 VSS) gpdk090_nmos1v w=0.24u l=0.1u ad=0.0816p as=0.0528p pd=1.16u ps=0.68u
    I_MXI72_I2_MN1 (XI72_I2_n1 b2_2 VSS VSS) gpdk090_nmos1v w=0.24u l=0.1u ad=0.0528p as=0.0816p pd=0.68u ps=1.16u
    I_MXI72_I2_MN0 (I72_gn2 p1_1 XI72_I2_n1 VSS) gpdk090_nmos1v w=0.24u l=0.1u ad=0.0816p as=0.0528p pd=1.16u ps=0.68u
    I_MXI84_I5_MN1 (XI84_I5_n1 b3_5 VSS VSS) gpdk090_nmos1v w=0.24u l=0.1u ad=0.0528p as=0.0816p pd=0.68u ps=1.16u
    I_MXI84_I5_MN0 (I84_gn5 p2_4 XI84_I5_n1 VSS) gpdk090_nmos1v w=0.24u l=0.1u ad=0.0816p as=0.0528p pd=1.16u ps=0.68u
    I_MXI48_I4_MN1 (XI48_I4_n1 b0_4 VSS VSS) gpdk090_nmos1v w=0.24u l=0.1u ad=0.0528p as=0.0816p pd=0.68u ps=1.16u
    I_MXI48_I4_MN0 (I48_gn4 VSS XI48_I4_n1 VSS) gpdk090_nmos1v w=0.24u l=0.1u ad=0.0816p as=0.0528p pd=1.16u ps=0.68u
    I_MXI48_I28_XP_MN1 (XI48_I28_XP_n1 I48_P2_1 VSS VSS) gpdk090_nmos1v w=0.24u l=0.1u ad=0.0528p as=0.0816p pd=0.68u ps=1.16u
    I_MXI48_I28_XP_MN0 (I48_P4_1n I48_P4_3 XI48_I28_XP_n1 VSS) gpdk090_nmos1v w=0.24u l=0.1u ad=0.0816p as=0.0528p pd=1.16u ps=0.68u
    I_MXI60_I3_MN1 (XI60_I3_n1 b1_3 VSS VSS) gpdk090_nmos1v w=0.24u l=0.1u ad=0.0528p as=0.0816p pd=0.68u ps=1.16u
    I_MXI60_I3_MN0 (I60_gn3 p0_2 XI60_I3_n1 VSS) gpdk090_nmos1v w=0.24u l=0.1u ad=0.0816p as=0.0528p pd=1.16u ps=0.68u
    I_MXI60_I2_MN1 (XI60_I2_n1 b1_2 VSS VSS) gpdk090_nmos1v w=0.24u l=0.1u ad=0.0528p as=0.0816p pd=0.68u ps=1.16u
    I_MXI60_I2_MN0 (I60_gn2 p0_1 XI60_I2_n1 VSS) gpdk090_nmos1v w=0.24u l=0.1u ad=0.0816p as=0.0528p pd=1.16u ps=0.68u
    I_MXI72_I3_MN1 (XI72_I3_n1 b2_3 VSS VSS) gpdk090_nmos1v w=0.24u l=0.1u ad=0.0528p as=0.0816p pd=0.68u ps=1.16u
    I_MXI72_I3_MN0 (I72_gn3 p1_2 XI72_I3_n1 VSS) gpdk090_nmos1v w=0.24u l=0.1u ad=0.0816p as=0.0528p pd=1.16u ps=0.68u
    I_MXI72_I28_XP_MN1 (XI72_I28_XP_n1 I72_P2_1 VSS VSS) gpdk090_nmos1v w=0.24u l=0.1u ad=0.0528p as=0.0816p pd=0.68u ps=1.16u
    I_MXI72_I28_XP_MN0 (I72_P4_1n I72_P4_3 XI72_I28_XP_n1 VSS) gpdk090_nmos1v w=0.24u l=0.1u ad=0.0816p as=0.0528p pd=1.16u ps=0.68u
    I_MXI84_I6_MN1 (XI84_I6_n1 b3_6 VSS VSS) gpdk090_nmos1v w=0.24u l=0.1u ad=0.0528p as=0.0816p pd=0.68u ps=1.16u
    I_MXI84_I6_MN0 (I84_gn6 p2_5 XI84_I6_n1 VSS) gpdk090_nmos1v w=0.24u l=0.1u ad=0.0816p as=0.0528p pd=1.16u ps=0.68u
    I_MXI48_I5_MN1 (XI48_I5_n1 b0_5 VSS VSS) gpdk090_nmos1v w=0.24u l=0.1u ad=0.0528p as=0.0816p pd=0.68u ps=1.16u
    I_MXI48_I5_MN0 (I48_gn5 VSS XI48_I5_n1 VSS) gpdk090_nmos1v w=0.24u l=0.1u ad=0.0816p as=0.0528p pd=1.16u ps=0.68u
    I_MXI48_I30_XP_MN1 (XI48_I30_XP_n1 I48_P4_3 VSS VSS) gpdk090_nmos1v w=0.24u l=0.1u ad=0.0528p as=0.0816p pd=0.68u ps=1.16u
    I_MXI48_I30_XP_MN0 (I48_P6_3n I48_P6_5 XI48_I30_XP_n1 VSS) gpdk090_nmos1v w=0.24u l=0.1u ad=0.0816p as=0.0528p pd=1.16u ps=0.68u
    I_MXI48_I29_XP_MN1 (XI48_I29_XP_n1 I48_P3_2 VSS VSS) gpdk090_nmos1v w=0.24u l=0.1u ad=0.0528p as=0.0816p pd=0.68u ps=1.16u
    I_MXI48_I29_XP_MN0 (I48_P5_2n I48_P5_4 XI48_I29_XP_n1 VSS) gpdk090_nmos1v w=0.24u l=0.1u ad=0.0816p as=0.0528p pd=1.16u ps=0.68u
    I_MXI60_I4_MN1 (XI60_I4_n1 b1_4 VSS VSS) gpdk090_nmos1v w=0.24u l=0.1u ad=0.0528p as=0.0816p pd=0.68u ps=1.16u
    I_MXI60_I4_MN0 (I60_gn4 p0_3 XI60_I4_n1 VSS) gpdk090_nmos1v w=0.24u l=0.1u ad=0.0816p as=0.0528p pd=1.16u ps=0.68u
    I_MXI60_I28_XP_MN1 (XI60_I28_XP_n1 I60_P2_1 VSS VSS) gpdk090_nmos1v w=0.24u l=0.1u ad=0.0528p as=0.0816p pd=0.68u ps=1.16u
    I_MXI60_I28_XP_MN0 (I60_P4_1n I60_P4_3 XI60_I28_XP_n1 VSS) gpdk090_nmos1v w=0.24u l=0.1u ad=0.0816p as=0.0528p pd=1.16u ps=0.68u
    I_MXI72_I4_MN1 (XI72_I4_n1 b2_4 VSS VSS) gpdk090_nmos1v w=0.24u l=0.1u ad=0.0528p as=0.0816p pd=0.68u ps=1.16u
    I_MXI72_I4_MN0 (I72_gn4 p1_3 XI72_I4_n1 VSS) gpdk090_nmos1v w=0.24u l=0.1u ad=0.0816p as=0.0528p pd=1.16u ps=0.68u
    I_MXI72_I30_XP_MN1 (XI72_I30_XP_n1 I72_P4_3 VSS VSS) gpdk090_nmos1v w=0.24u l=0.1u ad=0.0528p as=0.0816p pd=0.68u ps=1.16u
    I_MXI72_I30_XP_MN0 (I72_P6_3n I72_P6_5 XI72_I30_XP_n1 VSS) gpdk090_nmos1v w=0.24u l=0.1u ad=0.0816p as=0.0528p pd=1.16u ps=0.68u
    I_MXI72_I29_XP_MN1 (XI72_I29_XP_n1 I72_P3_2 VSS VSS) gpdk090_nmos1v w=0.24u l=0.1u ad=0.0528p as=0.0816p pd=0.68u ps=1.16u
    I_MXI72_I29_XP_MN0 (I72_P5_2n I72_P5_4 XI72_I29_XP_n1 VSS) gpdk090_nmos1v w=0.24u l=0.1u ad=0.0816p as=0.0528p pd=1.16u ps=0.68u
    I_MXI84_I7_MN1 (XI84_I7_n1 b3_7 VSS VSS) gpdk090_nmos1v w=0.24u l=0.1u ad=0.0528p as=0.0816p pd=0.68u ps=1.16u
    I_MXI84_I7_MN0 (I84_gn7 p2_6 XI84_I7_n1 VSS) gpdk090_nmos1v w=0.24u l=0.1u ad=0.0816p as=0.0528p pd=1.16u ps=0.68u
    I_MXI48_I6_MN1 (XI48_I6_n1 b0_6 VSS VSS) gpdk090_nmos1v w=0.24u l=0.1u ad=0.0528p as=0.0816p pd=0.68u ps=1.16u
    I_MXI48_I6_MN0 (I48_gn6 VSS XI48_I6_n1 VSS) gpdk090_nmos1v w=0.24u l=0.1u ad=0.0816p as=0.0528p pd=1.16u ps=0.68u
    I_MXI48_I31_XP_MN1 (XI48_I31_XP_n1 I48_P5_4 VSS VSS) gpdk090_nmos1v w=0.24u l=0.1u ad=0.0528p as=0.0816p pd=0.68u ps=1.16u
    I_MXI48_I31_XP_MN0 (I48_P7_4n I48_P7_6 XI48_I31_XP_n1 VSS) gpdk090_nmos1v w=0.24u l=0.1u ad=0.0816p as=0.0528p pd=1.16u ps=0.68u
    I_MXI60_I6_MN1 (XI60_I6_n1 b1_6 VSS VSS) gpdk090_nmos1v w=0.24u l=0.1u ad=0.0528p as=0.0816p pd=0.68u ps=1.16u
    I_MXI60_I6_MN0 (I60_gn6 p0_5 XI60_I6_n1 VSS) gpdk090_nmos1v w=0.24u l=0.1u ad=0.0816p as=0.0528p pd=1.16u ps=0.68u
    I_MXI60_I5_MN1 (XI60_I5_n1 b1_5 VSS VSS) gpdk090_nmos1v w=0.24u l=0.1u ad=0.0528p as=0.0816p pd=0.68u ps=1.16u
    I_MXI60_I5_MN0 (I60_gn5 p0_4 XI60_I5_n1 VSS) gpdk090_nmos1v w=0.24u l=0.1u ad=0.0816p as=0.0528p pd=1.16u ps=0.68u
    I_MXI60_I29_XP_MN1 (XI60_I29_XP_n1 I60_P3_2 VSS VSS) gpdk090_nmos1v w=0.24u l=0.1u ad=0.0528p as=0.0816p pd=0.68u ps=1.16u
    I_MXI60_I29_XP_MN0 (I60_P5_2n I60_P5_4 XI60_I29_XP_n1 VSS) gpdk090_nmos1v w=0.24u l=0.1u ad=0.0816p as=0.0528p pd=1.16u ps=0.68u
    I_MXI60_I31_XP_MN1 (XI60_I31_XP_n1 I60_P5_4 VSS VSS) gpdk090_nmos1v w=0.24u l=0.1u ad=0.0528p as=0.0816p pd=0.68u ps=1.16u
    I_MXI60_I31_XP_MN0 (I60_P7_4n I60_P7_6 XI60_I31_XP_n1 VSS) gpdk090_nmos1v w=0.24u l=0.1u ad=0.0816p as=0.0528p pd=1.16u ps=0.68u
    I_MXI60_I30_XP_MN1 (XI60_I30_XP_n1 I60_P4_3 VSS VSS) gpdk090_nmos1v w=0.24u l=0.1u ad=0.0528p as=0.0816p pd=0.68u ps=1.16u
    I_MXI60_I30_XP_MN0 (I60_P6_3n I60_P6_5 XI60_I30_XP_n1 VSS) gpdk090_nmos1v w=0.24u l=0.1u ad=0.0816p as=0.0528p pd=1.16u ps=0.68u
    I_MXI72_I5_MN1 (XI72_I5_n1 b2_5 VSS VSS) gpdk090_nmos1v w=0.24u l=0.1u ad=0.0528p as=0.0816p pd=0.68u ps=1.16u
    I_MXI72_I5_MN0 (I72_gn5 p1_4 XI72_I5_n1 VSS) gpdk090_nmos1v w=0.24u l=0.1u ad=0.0816p as=0.0528p pd=1.16u ps=0.68u
    I_MXI48_I7_MN1 (XI48_I7_n1 b0_7 VSS VSS) gpdk090_nmos1v w=0.24u l=0.1u ad=0.0528p as=0.0816p pd=0.68u ps=1.16u
    I_MXI48_I7_MN0 (I48_gn7 VSS XI48_I7_n1 VSS) gpdk090_nmos1v w=0.24u l=0.1u ad=0.0816p as=0.0528p pd=1.16u ps=0.68u
    I_MXI60_I7_MN1 (XI60_I7_n1 b1_7 VSS VSS) gpdk090_nmos1v w=0.24u l=0.1u ad=0.0528p as=0.0816p pd=0.68u ps=1.16u
    I_MXI60_I7_MN0 (I60_gn7 p0_6 XI60_I7_n1 VSS) gpdk090_nmos1v w=0.24u l=0.1u ad=0.0816p as=0.0528p pd=1.16u ps=0.68u
    I_MXI72_I6_MN1 (XI72_I6_n1 b2_6 VSS VSS) gpdk090_nmos1v w=0.24u l=0.1u ad=0.0528p as=0.0816p pd=0.68u ps=1.16u
    I_MXI72_I6_MN0 (I72_gn6 p1_5 XI72_I6_n1 VSS) gpdk090_nmos1v w=0.24u l=0.1u ad=0.0816p as=0.0528p pd=1.16u ps=0.68u
    I_MXI72_I7_MN1 (XI72_I7_n1 b2_7 VSS VSS) gpdk090_nmos1v w=0.24u l=0.1u ad=0.0528p as=0.0816p pd=0.68u ps=1.16u
    I_MXI72_I7_MN0 (I72_gn7 p1_6 XI72_I7_n1 VSS) gpdk090_nmos1v w=0.24u l=0.1u ad=0.0816p as=0.0528p pd=1.16u ps=0.68u
    I_MXI72_I31_XP_MN1 (XI72_I31_XP_n1 I72_P5_4 VSS VSS) gpdk090_nmos1v w=0.24u l=0.1u ad=0.0528p as=0.0816p pd=0.68u ps=1.16u
    I_MXI72_I31_XP_MN0 (I72_P7_4n I72_P7_6 XI72_I31_XP_n1 VSS) gpdk090_nmos1v w=0.24u l=0.1u ad=0.0816p as=0.0528p pd=1.16u ps=0.68u
    I_MXI120_I25_XP_MN0 (I120_P7_6 I120_pn7 VSS VSS) gpdk090_nmos1v w=0.12u l=0.1u ad=0.0408p as=0.0696p pd=0.68u ps=1.16u
    I_MXI120_I25_XP_MN1 (VSS I120_pn6 I120_P7_6 VSS) gpdk090_nmos1v w=0.12u l=0.1u ad=0.0696p as=0.0408p pd=1.16u ps=0.68u
    I_MXI108_I25_XP_MN0 (I108_P7_6 I108_pn7 VSS VSS) gpdk090_nmos1v w=0.12u l=0.1u ad=0.0408p as=0.0696p pd=0.68u ps=1.16u
    I_MXI108_I25_XP_MN1 (VSS I108_pn6 I108_P7_6 VSS) gpdk090_nmos1v w=0.12u l=0.1u ad=0.0696p as=0.0408p pd=1.16u ps=0.68u
    I_MXI120_I24_XP_MN0 (I120_P6_5 I120_pn6 VSS VSS) gpdk090_nmos1v w=0.12u l=0.1u ad=0.0408p as=0.0696p pd=0.68u ps=1.16u
    I_MXI120_I24_XP_MN1 (VSS I120_pn5 I120_P6_5 VSS) gpdk090_nmos1v w=0.12u l=0.1u ad=0.0696p as=0.0408p pd=1.16u ps=0.68u
    I_MXI120_I23_XP_MN0 (I120_P5_4 I120_pn5 VSS VSS) gpdk090_nmos1v w=0.12u l=0.1u ad=0.0408p as=0.0696p pd=0.68u ps=1.16u
    I_MXI120_I23_XP_MN1 (VSS I120_pn4 I120_P5_4 VSS) gpdk090_nmos1v w=0.12u l=0.1u ad=0.0696p as=0.0408p pd=1.16u ps=0.68u
    I_MXI108_I24_XP_MN0 (I108_P6_5 I108_pn6 VSS VSS) gpdk090_nmos1v w=0.12u l=0.1u ad=0.0408p as=0.0696p pd=0.68u ps=1.16u
    I_MXI108_I24_XP_MN1 (VSS I108_pn5 I108_P6_5 VSS) gpdk090_nmos1v w=0.12u l=0.1u ad=0.0696p as=0.0408p pd=1.16u ps=0.68u
    I_MXI108_I23_XP_MN0 (I108_P5_4 I108_pn5 VSS VSS) gpdk090_nmos1v w=0.12u l=0.1u ad=0.0408p as=0.0696p pd=0.68u ps=1.16u
    I_MXI108_I23_XP_MN1 (VSS I108_pn4 I108_P5_4 VSS) gpdk090_nmos1v w=0.12u l=0.1u ad=0.0696p as=0.0408p pd=1.16u ps=0.68u
    I_MXI132_I25_XP_MN0 (I132_P7_6 I132_pn7 VSS VSS) gpdk090_nmos1v w=0.12u l=0.1u ad=0.0408p as=0.0696p pd=0.68u ps=1.16u
    I_MXI132_I25_XP_MN1 (VSS I132_pn6 I132_P7_6 VSS) gpdk090_nmos1v w=0.12u l=0.1u ad=0.0696p as=0.0408p pd=1.16u ps=0.68u
    I_MXI132_I23_XP_MN0 (I132_P5_4 I132_pn5 VSS VSS) gpdk090_nmos1v w=0.12u l=0.1u ad=0.0408p as=0.0696p pd=0.68u ps=1.16u
    I_MXI132_I23_XP_MN1 (VSS I132_pn4 I132_P5_4 VSS) gpdk090_nmos1v w=0.12u l=0.1u ad=0.0696p as=0.0408p pd=1.16u ps=0.68u
    I_MXI132_I24_XP_MN0 (I132_P6_5 I132_pn6 VSS VSS) gpdk090_nmos1v w=0.12u l=0.1u ad=0.0408p as=0.0696p pd=0.68u ps=1.16u
    I_MXI132_I24_XP_MN1 (VSS I132_pn5 I132_P6_5 VSS) gpdk090_nmos1v w=0.12u l=0.1u ad=0.0696p as=0.0408p pd=1.16u ps=0.68u
    I_MXI120_I20_XP_MN0 (I120_P2_1 I120_pn2 VSS VSS) gpdk090_nmos1v w=0.12u l=0.1u ad=0.0408p as=0.0696p pd=0.68u ps=1.16u
    I_MXI120_I20_XP_MN1 (VSS I120_pn1 I120_P2_1 VSS) gpdk090_nmos1v w=0.12u l=0.1u ad=0.0696p as=0.0408p pd=1.16u ps=0.68u
    I_MXI120_I22_XP_MN0 (I120_P4_3 I120_pn4 VSS VSS) gpdk090_nmos1v w=0.12u l=0.1u ad=0.0408p as=0.0696p pd=0.68u ps=1.16u
    I_MXI120_I22_XP_MN1 (VSS I120_pn3 I120_P4_3 VSS) gpdk090_nmos1v w=0.12u l=0.1u ad=0.0696p as=0.0408p pd=1.16u ps=0.68u
    I_MXI120_I21_XP_MN0 (I120_P3_2 I120_pn3 VSS VSS) gpdk090_nmos1v w=0.12u l=0.1u ad=0.0408p as=0.0696p pd=0.68u ps=1.16u
    I_MXI120_I21_XP_MN1 (VSS I120_pn2 I120_P3_2 VSS) gpdk090_nmos1v w=0.12u l=0.1u ad=0.0696p as=0.0408p pd=1.16u ps=0.68u
    I_MXI108_I20_XP_MN0 (I108_P2_1 I108_pn2 VSS VSS) gpdk090_nmos1v w=0.12u l=0.1u ad=0.0408p as=0.0696p pd=0.68u ps=1.16u
    I_MXI108_I20_XP_MN1 (VSS I108_pn1 I108_P2_1 VSS) gpdk090_nmos1v w=0.12u l=0.1u ad=0.0696p as=0.0408p pd=1.16u ps=0.68u
    I_MXI108_I21_XP_MN0 (I108_P3_2 I108_pn3 VSS VSS) gpdk090_nmos1v w=0.12u l=0.1u ad=0.0408p as=0.0696p pd=0.68u ps=1.16u
    I_MXI108_I21_XP_MN1 (VSS I108_pn2 I108_P3_2 VSS) gpdk090_nmos1v w=0.12u l=0.1u ad=0.0696p as=0.0408p pd=1.16u ps=0.68u
    I_MXI108_I22_XP_MN0 (I108_P4_3 I108_pn4 VSS VSS) gpdk090_nmos1v w=0.12u l=0.1u ad=0.0408p as=0.0696p pd=0.68u ps=1.16u
    I_MXI108_I22_XP_MN1 (VSS I108_pn3 I108_P4_3 VSS) gpdk090_nmos1v w=0.12u l=0.1u ad=0.0696p as=0.0408p pd=1.16u ps=0.68u
    I_MXI132_I21_XP_MN0 (I132_P3_2 I132_pn3 VSS VSS) gpdk090_nmos1v w=0.12u l=0.1u ad=0.0408p as=0.0696p pd=0.68u ps=1.16u
    I_MXI132_I21_XP_MN1 (VSS I132_pn2 I132_P3_2 VSS) gpdk090_nmos1v w=0.12u l=0.1u ad=0.0696p as=0.0408p pd=1.16u ps=0.68u
    I_MXI132_I22_XP_MN0 (I132_P4_3 I132_pn4 VSS VSS) gpdk090_nmos1v w=0.12u l=0.1u ad=0.0408p as=0.0696p pd=0.68u ps=1.16u
    I_MXI132_I22_XP_MN1 (VSS I132_pn3 I132_P4_3 VSS) gpdk090_nmos1v w=0.12u l=0.1u ad=0.0696p as=0.0408p pd=1.16u ps=0.68u
    I_MXI96_I21_XP_MN0 (I96_P3_2 I96_pn3 VSS VSS) gpdk090_nmos1v w=0.12u l=0.1u ad=0.0408p as=0.0696p pd=0.68u ps=1.16u
    I_MXI96_I21_XP_MN1 (VSS I96_pn2 I96_P3_2 VSS) gpdk090_nmos1v w=0.12u l=0.1u ad=0.0696p as=0.0408p pd=1.16u ps=0.68u
    I_MXI96_I23_XP_MN0 (I96_P5_4 I96_pn5 VSS VSS) gpdk090_nmos1v w=0.12u l=0.1u ad=0.0408p as=0.0696p pd=0.68u ps=1.16u
    I_MXI96_I23_XP_MN1 (VSS I96_pn4 I96_P5_4 VSS) gpdk090_nmos1v w=0.12u l=0.1u ad=0.0696p as=0.0408p pd=1.16u ps=0.68u
    I_MXI96_I20_XP_MN0 (I96_P2_1 I96_pn2 VSS VSS) gpdk090_nmos1v w=0.12u l=0.1u ad=0.0408p as=0.0696p pd=0.68u ps=1.16u
    I_MXI96_I20_XP_MN1 (VSS I96_pn1 I96_P2_1 VSS) gpdk090_nmos1v w=0.12u l=0.1u ad=0.0696p as=0.0408p pd=1.16u ps=0.68u
    I_MXI96_I22_XP_MN0 (I96_P4_3 I96_pn4 VSS VSS) gpdk090_nmos1v w=0.12u l=0.1u ad=0.0408p as=0.0696p pd=0.68u ps=1.16u
    I_MXI96_I22_XP_MN1 (VSS I96_pn3 I96_P4_3 VSS) gpdk090_nmos1v w=0.12u l=0.1u ad=0.0696p as=0.0408p pd=1.16u ps=0.68u
    I_MXI96_I25_XP_MN0 (I96_P7_6 I96_pn7 VSS VSS) gpdk090_nmos1v w=0.12u l=0.1u ad=0.0408p as=0.0696p pd=0.68u ps=1.16u
    I_MXI96_I25_XP_MN1 (VSS I96_pn6 I96_P7_6 VSS) gpdk090_nmos1v w=0.12u l=0.1u ad=0.0696p as=0.0408p pd=1.16u ps=0.68u
    I_MXI132_I20_XP_MN0 (I132_P2_1 I132_pn2 VSS VSS) gpdk090_nmos1v w=0.12u l=0.1u ad=0.0408p as=0.0696p pd=0.68u ps=1.16u
    I_MXI132_I20_XP_MN1 (VSS I132_pn1 I132_P2_1 VSS) gpdk090_nmos1v w=0.12u l=0.1u ad=0.0696p as=0.0408p pd=1.16u ps=0.68u
    I_MXI96_I24_XP_MN0 (I96_P6_5 I96_pn6 VSS VSS) gpdk090_nmos1v w=0.12u l=0.1u ad=0.0408p as=0.0696p pd=0.68u ps=1.16u
    I_MXI96_I24_XP_MN1 (VSS I96_pn5 I96_P6_5 VSS) gpdk090_nmos1v w=0.12u l=0.1u ad=0.0696p as=0.0408p pd=1.16u ps=0.68u
    I_MXI152_I25_XP_MN0 (I152_P7_6 I152_pn7 VSS VSS) gpdk090_nmos1v w=0.12u l=0.1u ad=0.0408p as=0.0696p pd=0.68u ps=1.16u
    I_MXI152_I25_XP_MN1 (VSS I152_pn6 I152_P7_6 VSS) gpdk090_nmos1v w=0.12u l=0.1u ad=0.0696p as=0.0408p pd=1.16u ps=0.68u
    I_MXI152_I23_XP_MN0 (I152_P5_4 I152_pn5 VSS VSS) gpdk090_nmos1v w=0.12u l=0.1u ad=0.0408p as=0.0696p pd=0.68u ps=1.16u
    I_MXI152_I23_XP_MN1 (VSS I152_pn4 I152_P5_4 VSS) gpdk090_nmos1v w=0.12u l=0.1u ad=0.0696p as=0.0408p pd=1.16u ps=0.68u
    I_MXI152_I22_XP_MN0 (I152_P4_3 I152_pn4 VSS VSS) gpdk090_nmos1v w=0.12u l=0.1u ad=0.0408p as=0.0696p pd=0.68u ps=1.16u
    I_MXI152_I22_XP_MN1 (VSS I152_pn3 I152_P4_3 VSS) gpdk090_nmos1v w=0.12u l=0.1u ad=0.0696p as=0.0408p pd=1.16u ps=0.68u
    I_MXI152_I21_XP_MN0 (I152_P3_2 I152_pn3 VSS VSS) gpdk090_nmos1v w=0.12u l=0.1u ad=0.0408p as=0.0696p pd=0.68u ps=1.16u
    I_MXI152_I21_XP_MN1 (VSS I152_pn2 I152_P3_2 VSS) gpdk090_nmos1v w=0.12u l=0.1u ad=0.0696p as=0.0408p pd=1.16u ps=0.68u
    I_MXI152_I24_XP_MN0 (I152_P6_5 I152_pn6 VSS VSS) gpdk090_nmos1v w=0.12u l=0.1u ad=0.0408p as=0.0696p pd=0.68u ps=1.16u
    I_MXI152_I24_XP_MN1 (VSS I152_pn5 I152_P6_5 VSS) gpdk090_nmos1v w=0.12u l=0.1u ad=0.0696p as=0.0408p pd=1.16u ps=0.68u
    I_MXI197_MN0 (z1_3 B_6 VSS VSS) gpdk090_nmos1v w=0.12u l=0.1u ad=0.0408p as=0.0696p pd=0.68u ps=1.16u
    I_MXI197_MN1 (VSS B_7 z1_3 VSS) gpdk090_nmos1v w=0.12u l=0.1u ad=0.0696p as=0.0408p pd=1.16u ps=0.68u
    I_MXI194_MN0 (z1_0 B_0 VSS VSS) gpdk090_nmos1v w=0.12u l=0.1u ad=0.0408p as=0.0696p pd=0.68u ps=1.16u
    I_MXI194_MN1 (VSS B_1 z1_0 VSS) gpdk090_nmos1v w=0.12u l=0.1u ad=0.0696p as=0.0408p pd=1.16u ps=0.68u
    I_MXI84_I22_XP_MN0 (I84_P4_3 I84_pn4 VSS VSS) gpdk090_nmos1v w=0.12u l=0.1u ad=0.0408p as=0.0696p pd=0.68u ps=1.16u
    I_MXI84_I22_XP_MN1 (VSS I84_pn3 I84_P4_3 VSS) gpdk090_nmos1v w=0.12u l=0.1u ad=0.0696p as=0.0408p pd=1.16u ps=0.68u
    I_MXI84_I20_XP_MN0 (I84_P2_1 I84_pn2 VSS VSS) gpdk090_nmos1v w=0.12u l=0.1u ad=0.0408p as=0.0696p pd=0.68u ps=1.16u
    I_MXI84_I20_XP_MN1 (VSS I84_pn1 I84_P2_1 VSS) gpdk090_nmos1v w=0.12u l=0.1u ad=0.0696p as=0.0408p pd=1.16u ps=0.68u
    I_MXI84_I24_XP_MN0 (I84_P6_5 I84_pn6 VSS VSS) gpdk090_nmos1v w=0.12u l=0.1u ad=0.0408p as=0.0696p pd=0.68u ps=1.16u
    I_MXI84_I24_XP_MN1 (VSS I84_pn5 I84_P6_5 VSS) gpdk090_nmos1v w=0.12u l=0.1u ad=0.0696p as=0.0408p pd=1.16u ps=0.68u
    I_MXI152_I20_XP_MN0 (I152_P2_1 I152_pn2 VSS VSS) gpdk090_nmos1v w=0.12u l=0.1u ad=0.0408p as=0.0696p pd=0.68u ps=1.16u
    I_MXI152_I20_XP_MN1 (VSS I152_pn1 I152_P2_1 VSS) gpdk090_nmos1v w=0.12u l=0.1u ad=0.0696p as=0.0408p pd=1.16u ps=0.68u
    I_MXI196_MN0 (z1_2 B_4 VSS VSS) gpdk090_nmos1v w=0.12u l=0.1u ad=0.0408p as=0.0696p pd=0.68u ps=1.16u
    I_MXI196_MN1 (VSS B_5 z1_2 VSS) gpdk090_nmos1v w=0.12u l=0.1u ad=0.0696p as=0.0408p pd=1.16u ps=0.68u
    I_MXI195_MN0 (z1_1 B_2 VSS VSS) gpdk090_nmos1v w=0.12u l=0.1u ad=0.0408p as=0.0696p pd=0.68u ps=1.16u
    I_MXI195_MN1 (VSS B_3 z1_1 VSS) gpdk090_nmos1v w=0.12u l=0.1u ad=0.0696p as=0.0408p pd=1.16u ps=0.68u
    I_MXI200_MN0 (DZ z2_0 VSS VSS) gpdk090_nmos1v w=0.12u l=0.1u ad=0.0408p as=0.0696p pd=0.68u ps=1.16u
    I_MXI200_MN1 (VSS z2_1 DZ VSS) gpdk090_nmos1v w=0.12u l=0.1u ad=0.0696p as=0.0408p pd=1.16u ps=0.68u
    I_MXI203_MN0 (V vn VSS VSS) gpdk090_nmos1v w=0.12u l=0.1u ad=0.0408p as=0.0696p pd=0.68u ps=1.16u
    I_MXI203_MN1 (VSS DZ V VSS) gpdk090_nmos1v w=0.12u l=0.1u ad=0.0696p as=0.0408p pd=1.16u ps=0.68u
    I_MXI84_I21_XP_MN0 (I84_P3_2 I84_pn3 VSS VSS) gpdk090_nmos1v w=0.12u l=0.1u ad=0.0408p as=0.0696p pd=0.68u ps=1.16u
    I_MXI84_I21_XP_MN1 (VSS I84_pn2 I84_P3_2 VSS) gpdk090_nmos1v w=0.12u l=0.1u ad=0.0696p as=0.0408p pd=1.16u ps=0.68u
    I_MXI84_I23_XP_MN0 (I84_P5_4 I84_pn5 VSS VSS) gpdk090_nmos1v w=0.12u l=0.1u ad=0.0408p as=0.0696p pd=0.68u ps=1.16u
    I_MXI84_I23_XP_MN1 (VSS I84_pn4 I84_P5_4 VSS) gpdk090_nmos1v w=0.12u l=0.1u ad=0.0696p as=0.0408p pd=1.16u ps=0.68u
    I_MXI84_I25_XP_MN0 (I84_P7_6 I84_pn7 VSS VSS) gpdk090_nmos1v w=0.12u l=0.1u ad=0.0408p as=0.0696p pd=0.68u ps=1.16u
    I_MXI84_I25_XP_MN1 (VSS I84_pn6 I84_P7_6 VSS) gpdk090_nmos1v w=0.12u l=0.1u ad=0.0696p as=0.0408p pd=1.16u ps=0.68u
    I_MXI72_I20_XP_MN0 (I72_P2_1 I72_pn2 VSS VSS) gpdk090_nmos1v w=0.12u l=0.1u ad=0.0408p as=0.0696p pd=0.68u ps=1.16u
    I_MXI72_I20_XP_MN1 (VSS I72_pn1 I72_P2_1 VSS) gpdk090_nmos1v w=0.12u l=0.1u ad=0.0696p as=0.0408p pd=1.16u ps=0.68u
    I_MXI48_I22_XP_MN0 (I48_P4_3 I48_pn4 VSS VSS) gpdk090_nmos1v w=0.12u l=0.1u ad=0.0408p as=0.0696p pd=0.68u ps=1.16u
    I_MXI48_I22_XP_MN1 (VSS I48_pn3 I48_P4_3 VSS) gpdk090_nmos1v w=0.12u l=0.1u ad=0.0696p as=0.0408p pd=1.16u ps=0.68u
    I_MXI48_I20_XP_MN0 (I48_P2_1 I48_pn2 VSS VSS) gpdk090_nmos1v w=0.12u l=0.1u ad=0.0408p as=0.0696p pd=0.68u ps=1.16u
    I_MXI48_I20_XP_MN1 (VSS I48_pn1 I48_P2_1 VSS) gpdk090_nmos1v w=0.12u l=0.1u ad=0.0696p as=0.0408p pd=1.16u ps=0.68u
    I_MXI60_I20_XP_MN0 (I60_P2_1 I60_pn2 VSS VSS) gpdk090_nmos1v w=0.12u l=0.1u ad=0.0408p as=0.0696p pd=0.68u ps=1.16u
    I_MXI60_I20_XP_MN1 (VSS I60_pn1 I60_P2_1 VSS) gpdk090_nmos1v w=0.12u l=0.1u ad=0.0696p as=0.0408p pd=1.16u ps=0.68u
    I_MXI72_I21_XP_MN0 (I72_P3_2 I72_pn3 VSS VSS) gpdk090_nmos1v w=0.12u l=0.1u ad=0.0408p as=0.0696p pd=0.68u ps=1.16u
    I_MXI72_I21_XP_MN1 (VSS I72_pn2 I72_P3_2 VSS) gpdk090_nmos1v w=0.12u l=0.1u ad=0.0696p as=0.0408p pd=1.16u ps=0.68u
    I_MXI72_I22_XP_MN0 (I72_P4_3 I72_pn4 VSS VSS) gpdk090_nmos1v w=0.12u l=0.1u ad=0.0408p as=0.0696p pd=0.68u ps=1.16u
    I_MXI72_I22_XP_MN1 (VSS I72_pn3 I72_P4_3 VSS) gpdk090_nmos1v w=0.12u l=0.1u ad=0.0696p as=0.0408p pd=1.16u ps=0.68u
    I_MXI48_I24_XP_MN0 (I48_P6_5 I48_pn6 VSS VSS) gpdk090_nmos1v w=0.12u l=0.1u ad=0.0408p as=0.0696p pd=0.68u ps=1.16u
    I_MXI48_I24_XP_MN1 (VSS I48_pn5 I48_P6_5 VSS) gpdk090_nmos1v w=0.12u l=0.1u ad=0.0696p as=0.0408p pd=1.16u ps=0.68u
    I_MXI48_I21_XP_MN0 (I48_P3_2 I48_pn3 VSS VSS) gpdk090_nmos1v w=0.12u l=0.1u ad=0.0408p as=0.0696p pd=0.68u ps=1.16u
    I_MXI48_I21_XP_MN1 (VSS I48_pn2 I48_P3_2 VSS) gpdk090_nmos1v w=0.12u l=0.1u ad=0.0696p as=0.0408p pd=1.16u ps=0.68u
    I_MXI48_I23_XP_MN0 (I48_P5_4 I48_pn5 VSS VSS) gpdk090_nmos1v w=0.12u l=0.1u ad=0.0408p as=0.0696p pd=0.68u ps=1.16u
    I_MXI48_I23_XP_MN1 (VSS I48_pn4 I48_P5_4 VSS) gpdk090_nmos1v w=0.12u l=0.1u ad=0.0696p as=0.0408p pd=1.16u ps=0.68u
    I_MXI60_I21_XP_MN0 (I60_P3_2 I60_pn3 VSS VSS) gpdk090_nmos1v w=0.12u l=0.1u ad=0.0408p as=0.0696p pd=0.68u ps=1.16u
    I_MXI60_I21_XP_MN1 (VSS I60_pn2 I60_P3_2 VSS) gpdk090_nmos1v w=0.12u l=0.1u ad=0.0696p as=0.0408p pd=1.16u ps=0.68u
    I_MXI60_I22_XP_MN0 (I60_P4_3 I60_pn4 VSS VSS) gpdk090_nmos1v w=0.12u l=0.1u ad=0.0408p as=0.0696p pd=0.68u ps=1.16u
    I_MXI60_I22_XP_MN1 (VSS I60_pn3 I60_P4_3 VSS) gpdk090_nmos1v w=0.12u l=0.1u ad=0.0696p as=0.0408p pd=1.16u ps=0.68u
    I_MXI72_I23_XP_MN0 (I72_P5_4 I72_pn5 VSS VSS) gpdk090_nmos1v w=0.12u l=0.1u ad=0.0408p as=0.0696p pd=0.68u ps=1.16u
    I_MXI72_I23_XP_MN1 (VSS I72_pn4 I72_P5_4 VSS) gpdk090_nmos1v w=0.12u l=0.1u ad=0.0696p as=0.0408p pd=1.16u ps=0.68u
    I_MXI48_I25_XP_MN0 (I48_P7_6 I48_pn7 VSS VSS) gpdk090_nmos1v w=0.12u l=0.1u ad=0.0408p as=0.0696p pd=0.68u ps=1.16u
    I_MXI48_I25_XP_MN1 (VSS I48_pn6 I48_P7_6 VSS) gpdk090_nmos1v w=0.12u l=0.1u ad=0.0696p as=0.0408p pd=1.16u ps=0.68u
    I_MXI60_I23_XP_MN0 (I60_P5_4 I60_pn5 VSS VSS) gpdk090_nmos1v w=0.12u l=0.1u ad=0.0408p as=0.0696p pd=0.68u ps=1.16u
    I_MXI60_I23_XP_MN1 (VSS I60_pn4 I60_P5_4 VSS) gpdk090_nmos1v w=0.12u l=0.1u ad=0.0696p as=0.0408p pd=1.16u ps=0.68u
    I_MXI60_I24_XP_MN0 (I60_P6_5 I60_pn6 VSS VSS) gpdk090_nmos1v w=0.12u l=0.1u ad=0.0408p as=0.0696p pd=0.68u ps=1.16u
    I_MXI60_I24_XP_MN1 (VSS I60_pn5 I60_P6_5 VSS) gpdk090_nmos1v w=0.12u l=0.1u ad=0.0696p as=0.0408p pd=1.16u ps=0.68u
    I_MXI72_I24_XP_MN0 (I72_P6_5 I72_pn6 VSS VSS) gpdk090_nmos1v w=0.12u l=0.1u ad=0.0408p as=0.0696p pd=0.68u ps=1.16u
    I_MXI72_I24_XP_MN1 (VSS I72_pn5 I72_P6_5 VSS) gpdk090_nmos1v w=0.12u l=0.1u ad=0.0696p as=0.0408p pd=1.16u ps=0.68u
    I_MXI72_I25_XP_MN0 (I72_P7_6 I72_pn7 VSS VSS) gpdk090_nmos1v w=0.12u l=0.1u ad=0.0408p as=0.0696p pd=0.68u ps=1.16u
    I_MXI72_I25_XP_MN1 (VSS I72_pn6 I72_P7_6 VSS) gpdk090_nmos1v w=0.12u l=0.1u ad=0.0696p as=0.0408p pd=1.16u ps=0.68u
    I_MXI60_I25_XP_MN0 (I60_P7_6 I60_pn7 VSS VSS) gpdk090_nmos1v w=0.12u l=0.1u ad=0.0408p as=0.0696p pd=0.68u ps=1.16u
    I_MXI60_I25_XP_MN1 (VSS I60_pn6 I60_P7_6 VSS) gpdk090_nmos1v w=0.12u l=0.1u ad=0.0696p as=0.0408p pd=1.16u ps=0.68u
    I_MXI108_I33_MN0 (I108_G1_0n I108_G1_0 VSS VSS) gpdk090_nmos1v w=0.12u l=0.1u ad=0.0696p as=0.0696p pd=1.16u ps=1.16u
    I_MXI120_I33_MN0 (I120_G1_0n I120_G1_0 VSS VSS) gpdk090_nmos1v w=0.12u l=0.1u ad=0.0696p as=0.0696p pd=1.16u ps=1.16u
    I_MXI132_I33_MN0 (I132_G1_0n I132_G1_0 VSS VSS) gpdk090_nmos1v w=0.12u l=0.1u ad=0.0696p as=0.0696p pd=1.16u ps=1.16u
    I_MXI120_I18_MN0 (I120_G0_0n I120_G0_0 VSS VSS) gpdk090_nmos1v w=0.12u l=0.1u ad=0.0696p as=0.0696p pd=1.16u ps=1.16u
    I_MXI108_I18_MN0 (I108_G0_0n I108_G0_0 VSS VSS) gpdk090_nmos1v w=0.12u l=0.1u ad=0.0696p as=0.0696p pd=1.16u ps=1.16u
    I_MXI96_I33_MN0 (I96_G1_0n I96_G1_0 VSS VSS) gpdk090_nmos1v w=0.12u l=0.1u ad=0.0696p as=0.0696p pd=1.16u ps=1.16u
    I_MXI149_MN0 (dm6 dmn6 VSS VSS) gpdk090_nmos1v w=0.12u l=0.1u ad=0.0696p as=0.0696p pd=1.16u ps=1.16u
    I_MXI151_MN0 (dm7 dmn7 VSS VSS) gpdk090_nmos1v w=0.12u l=0.1u ad=0.0696p as=0.0696p pd=1.16u ps=1.16u
    I_MXI120_I16_MN0 (I120_cinn qu2 VSS VSS) gpdk090_nmos1v w=0.12u l=0.1u ad=0.0696p as=0.0696p pd=1.16u ps=1.16u
    I_MXI108_I16_MN0 (I108_cinn qu3 VSS VSS) gpdk090_nmos1v w=0.12u l=0.1u ad=0.0696p as=0.0696p pd=1.16u ps=1.16u
    I_MXI96_I18_MN0 (I96_G0_0n I96_G0_0 VSS VSS) gpdk090_nmos1v w=0.12u l=0.1u ad=0.0696p as=0.0696p pd=1.16u ps=1.16u
    I_MXI147_MN0 (dm5 dmn5 VSS VSS) gpdk090_nmos1v w=0.12u l=0.1u ad=0.0696p as=0.0696p pd=1.16u ps=1.16u
    I_MXI145_MN0 (dm4 dmn4 VSS VSS) gpdk090_nmos1v w=0.12u l=0.1u ad=0.0696p as=0.0696p pd=1.16u ps=1.16u
    I_MXI132_I18_MN0 (I132_G0_0n I132_G0_0 VSS VSS) gpdk090_nmos1v w=0.12u l=0.1u ad=0.0696p as=0.0696p pd=1.16u ps=1.16u
    I_MXI132_I16_MN0 (I132_cinn qu1 VSS VSS) gpdk090_nmos1v w=0.12u l=0.1u ad=0.0696p as=0.0696p pd=1.16u ps=1.16u
    I_MXI5_MN0 (nak2 nakn2 VSS VSS) gpdk090_nmos1v w=0.12u l=0.1u ad=0.0696p as=0.0696p pd=1.16u ps=1.16u
    I_MXI96_I16_MN0 (I96_cinn qu4 VSS VSS) gpdk090_nmos1v w=0.12u l=0.1u ad=0.0696p as=0.0696p pd=1.16u ps=1.16u
    I_MXI143_MN0 (dm3 dmn3 VSS VSS) gpdk090_nmos1v w=0.12u l=0.1u ad=0.0696p as=0.0696p pd=1.16u ps=1.16u
    I_MXI2_MN0 (nak1 nakn1 VSS VSS) gpdk090_nmos1v w=0.12u l=0.1u ad=0.0696p as=0.0696p pd=1.16u ps=1.16u
    I_MXI8_MN0 (nak3 nakn3 VSS VSS) gpdk090_nmos1v w=0.12u l=0.1u ad=0.0696p as=0.0696p pd=1.16u ps=1.16u
    I_MXI11_MN0 (nak4 nakn4 VSS VSS) gpdk090_nmos1v w=0.12u l=0.1u ad=0.0696p as=0.0696p pd=1.16u ps=1.16u
    I_MXI152_I33_MN0 (I152_G1_0n I152_G1_0 VSS VSS) gpdk090_nmos1v w=0.12u l=0.1u ad=0.0696p as=0.0696p pd=1.16u ps=1.16u
    I_MXI141_MN0 (dm2 dmn2 VSS VSS) gpdk090_nmos1v w=0.12u l=0.1u ad=0.0696p as=0.0696p pd=1.16u ps=1.16u
    I_MXI139_MN0 (dm1 dmn1 VSS VSS) gpdk090_nmos1v w=0.12u l=0.1u ad=0.0696p as=0.0696p pd=1.16u ps=1.16u
    I_MXI137_MN0 (dm0 dmn0 VSS VSS) gpdk090_nmos1v w=0.12u l=0.1u ad=0.0696p as=0.0696p pd=1.16u ps=1.16u
    I_MXI135_MN0 (Q_0 p7_8 VSS VSS) gpdk090_nmos1v w=0.12u l=0.1u ad=0.0696p as=0.0696p pd=1.16u ps=1.16u
    I_MXI156_MN0 (nqk1 nqkn1 VSS VSS) gpdk090_nmos1v w=0.12u l=0.1u ad=0.0696p as=0.0696p pd=1.16u ps=1.16u
    I_MXI159_MN0 (nqk2 nqkn2 VSS VSS) gpdk090_nmos1v w=0.12u l=0.1u ad=0.0696p as=0.0696p pd=1.16u ps=1.16u
    I_MXI162_MN0 (nqk3 nqkn3 VSS VSS) gpdk090_nmos1v w=0.12u l=0.1u ad=0.0696p as=0.0696p pd=1.16u ps=1.16u
    I_MXI165_MN0 (nqk4 nqkn4 VSS VSS) gpdk090_nmos1v w=0.12u l=0.1u ad=0.0696p as=0.0696p pd=1.16u ps=1.16u
    I_MXI168_MN0 (nqk5 nqkn5 VSS VSS) gpdk090_nmos1v w=0.12u l=0.1u ad=0.0696p as=0.0696p pd=1.16u ps=1.16u
    I_MXI84_I16_MN0 (I84_cinn qu5 VSS VSS) gpdk090_nmos1v w=0.12u l=0.1u ad=0.0696p as=0.0696p pd=1.16u ps=1.16u
    I_MXI84_I18_MN0 (I84_G0_0n I84_G0_0 VSS VSS) gpdk090_nmos1v w=0.12u l=0.1u ad=0.0696p as=0.0696p pd=1.16u ps=1.16u
    I_MXI152_I18_MN0 (I152_G0_0n I152_G0_0 VSS VSS) gpdk090_nmos1v w=0.12u l=0.1u ad=0.0696p as=0.0696p pd=1.16u ps=1.16u
    I_MXI152_I16_MN0 (I152_cinn VSS VSS VSS) gpdk090_nmos1v w=0.12u l=0.1u ad=0.0696p as=0.0696p pd=1.16u ps=1.16u
    I_MXI34_MN0 (nbk5 nbkn5 VSS VSS) gpdk090_nmos1v w=0.12u l=0.1u ad=0.0696p as=0.0696p pd=1.16u ps=1.16u
    I_MXI37_MN0 (nbk6 nbkn6 VSS VSS) gpdk090_nmos1v w=0.12u l=0.1u ad=0.0696p as=0.0696p pd=1.16u ps=1.16u
    I_MXI22_MN0 (nbk1 nbkn1 VSS VSS) gpdk090_nmos1v w=0.12u l=0.1u ad=0.0696p as=0.0696p pd=1.16u ps=1.16u
    I_MXI201_MN0 (sqn sq VSS VSS) gpdk090_nmos1v w=0.12u l=0.1u ad=0.0696p as=0.0696p pd=1.16u ps=1.16u
    I_MXI171_MN0 (nqk6 nqkn6 VSS VSS) gpdk090_nmos1v w=0.12u l=0.1u ad=0.0696p as=0.0696p pd=1.16u ps=1.16u
    I_MXI28_MN0 (nbk3 nbkn3 VSS VSS) gpdk090_nmos1v w=0.12u l=0.1u ad=0.0696p as=0.0696p pd=1.16u ps=1.16u
    I_MXI31_MN0 (nbk4 nbkn4 VSS VSS) gpdk090_nmos1v w=0.12u l=0.1u ad=0.0696p as=0.0696p pd=1.16u ps=1.16u
    I_MXI17_MN0 (nak6 nakn6 VSS VSS) gpdk090_nmos1v w=0.12u l=0.1u ad=0.0696p as=0.0696p pd=1.16u ps=1.16u
    I_MXI14_MN0 (nak5 nakn5 VSS VSS) gpdk090_nmos1v w=0.12u l=0.1u ad=0.0696p as=0.0696p pd=1.16u ps=1.16u
    I_MXI72_I16_MN0 (I72_cinn qu6 VSS VSS) gpdk090_nmos1v w=0.12u l=0.1u ad=0.0696p as=0.0696p pd=1.16u ps=1.16u
    I_MXI84_I33_MN0 (I84_G1_0n I84_G1_0 VSS VSS) gpdk090_nmos1v w=0.12u l=0.1u ad=0.0696p as=0.0696p pd=1.16u ps=1.16u
    I_MXI191_MN0 (nrk6 nrkn6 VSS VSS) gpdk090_nmos1v w=0.12u l=0.1u ad=0.0696p as=0.0696p pd=1.16u ps=1.16u
    I_MXI185_MN0 (nrk4 nrkn4 VSS VSS) gpdk090_nmos1v w=0.12u l=0.1u ad=0.0696p as=0.0696p pd=1.16u ps=1.16u
    I_MXI182_MN0 (nrk3 nrkn3 VSS VSS) gpdk090_nmos1v w=0.12u l=0.1u ad=0.0696p as=0.0696p pd=1.16u ps=1.16u
    I_MXI179_MN0 (nrk2 nrkn2 VSS VSS) gpdk090_nmos1v w=0.12u l=0.1u ad=0.0696p as=0.0696p pd=1.16u ps=1.16u
    I_MXI176_MN0 (nrk1 nrkn1 VSS VSS) gpdk090_nmos1v w=0.12u l=0.1u ad=0.0696p as=0.0696p pd=1.16u ps=1.16u
    I_MXI25_MN0 (nbk2 nbkn2 VSS VSS) gpdk090_nmos1v w=0.12u l=0.1u ad=0.0696p as=0.0696p pd=1.16u ps=1.16u
    I_MXI188_MN0 (nrk5 nrkn5 VSS VSS) gpdk090_nmos1v w=0.12u l=0.1u ad=0.0696p as=0.0696p pd=1.16u ps=1.16u
    I_MXI48_I16_MN0 (I48_cinn VDD VSS VSS) gpdk090_nmos1v w=0.12u l=0.1u ad=0.0696p as=0.0696p pd=1.16u ps=1.16u
    I_MXI60_I16_MN0 (I60_cinn qu7 VSS VSS) gpdk090_nmos1v w=0.12u l=0.1u ad=0.0696p as=0.0696p pd=1.16u ps=1.16u
    I_MXI72_I18_MN0 (I72_G0_0n I72_G0_0 VSS VSS) gpdk090_nmos1v w=0.12u l=0.1u ad=0.0696p as=0.0696p pd=1.16u ps=1.16u
    I_MXI48_I18_MN0 (I48_G0_0n I48_G0_0 VSS VSS) gpdk090_nmos1v w=0.12u l=0.1u ad=0.0696p as=0.0696p pd=1.16u ps=1.16u
    I_MXI60_I18_MN0 (I60_G0_0n I60_G0_0 VSS VSS) gpdk090_nmos1v w=0.12u l=0.1u ad=0.0696p as=0.0696p pd=1.16u ps=1.16u
    I_MXI48_I33_MN0 (I48_G1_0n I48_G1_0 VSS VSS) gpdk090_nmos1v w=0.12u l=0.1u ad=0.0696p as=0.0696p pd=1.16u ps=1.16u
    I_MXI72_I33_MN0 (I72_G1_0n I72_G1_0 VSS VSS) gpdk090_nmos1v w=0.12u l=0.1u ad=0.0696p as=0.0696p pd=1.16u ps=1.16u
    I_MXI60_I33_MN0 (I60_G1_0n I60_G1_0 VSS VSS) gpdk090_nmos1v w=0.12u l=0.1u ad=0.0696p as=0.0696p pd=1.16u ps=1.16u
    I_MXI131_MN1 (XI131_Bn qu1 VSS VSS) gpdk090_nmos1v w=0.12u l=0.1u ad=0.0696p as=0.0696p pd=1.16u ps=1.16u
    I_MXI131_MN5 (XI131_n2 XI131_Bn VSS VSS) gpdk090_nmos1v w=0.24u l=0.1u ad=0.0528p as=0.0816p pd=0.68u ps=1.16u
    I_MXI131_MN4 (b7_7 XI131_An XI131_n2 VSS) gpdk090_nmos1v w=0.24u l=0.1u ad=0.0528p as=0.0528p pd=0.68u ps=0.68u
    I_MXI131_MN2 (XI131_n1 dd7 b7_7 VSS) gpdk090_nmos1v w=0.24u l=0.1u ad=0.0528p as=0.0528p pd=0.68u ps=0.68u
    I_MXI131_MN3 (VSS qu1 XI131_n1 VSS) gpdk090_nmos1v w=0.24u l=0.1u ad=0.0816p as=0.0528p pd=1.16u ps=0.68u
    I_MXI131_MN0 (XI131_An dd7 VSS VSS) gpdk090_nmos1v w=0.12u l=0.1u ad=0.0696p as=0.0696p pd=1.16u ps=1.16u
    I_MXI130_MN1 (XI130_Bn qu1 VSS VSS) gpdk090_nmos1v w=0.12u l=0.1u ad=0.0696p as=0.0696p pd=1.16u ps=1.16u
    I_MXI130_MN5 (XI130_n2 XI130_Bn VSS VSS) gpdk090_nmos1v w=0.24u l=0.1u ad=0.0528p as=0.0816p pd=0.68u ps=1.16u
    I_MXI130_MN4 (b7_6 XI130_An XI130_n2 VSS) gpdk090_nmos1v w=0.24u l=0.1u ad=0.0528p as=0.0528p pd=0.68u ps=0.68u
    I_MXI130_MN2 (XI130_n1 dd6 b7_6 VSS) gpdk090_nmos1v w=0.24u l=0.1u ad=0.0528p as=0.0528p pd=0.68u ps=0.68u
    I_MXI130_MN3 (VSS qu1 XI130_n1 VSS) gpdk090_nmos1v w=0.24u l=0.1u ad=0.0816p as=0.0528p pd=1.16u ps=0.68u
    I_MXI130_MN0 (XI130_An dd6 VSS VSS) gpdk090_nmos1v w=0.12u l=0.1u ad=0.0696p as=0.0696p pd=1.16u ps=1.16u
    I_MXI120_I41_MN1 (XI120_I41_Bn I120_G3_0n VSS VSS) gpdk090_nmos1v w=0.12u l=0.1u ad=0.0696p as=0.0696p pd=1.16u ps=1.16u
    I_MXI120_I41_MN5 (XI120_I41_n2 XI120_I41_Bn VSS VSS) gpdk090_nmos1v w=0.24u l=0.1u ad=0.0528p as=0.0816p pd=0.68u ps=1.16u
    I_MXI120_I41_MN4 (p6_4 XI120_I41_An XI120_I41_n2 VSS) gpdk090_nmos1v w=0.24u l=0.1u ad=0.0528p as=0.0528p pd=0.68u ps=0.68u
    I_MXI120_I41_MN2 (XI120_I41_n1 I120_pn4 p6_4 VSS) gpdk090_nmos1v w=0.24u l=0.1u ad=0.0528p as=0.0528p pd=0.68u ps=0.68u
    I_MXI120_I41_MN3 (VSS I120_G3_0n XI120_I41_n1 VSS) gpdk090_nmos1v w=0.24u l=0.1u ad=0.0816p as=0.0528p pd=1.16u ps=0.68u
    I_MXI120_I41_MN0 (XI120_I41_An I120_pn4 VSS VSS) gpdk090_nmos1v w=0.12u l=0.1u ad=0.0696p as=0.0696p pd=1.16u ps=1.16u
    I_MXI122_MN1 (XI122_Bn c6_8 VSS VSS) gpdk090_nmos1v w=0.12u l=0.1u ad=0.0696p as=0.0696p pd=1.16u ps=1.16u
    I_MXI122_MN5 (XI122_n2 XI122_Bn VSS VSS) gpdk090_nmos1v w=0.24u l=0.1u ad=0.0528p as=0.0816p pd=0.68u ps=1.16u
    I_MXI122_MN4 (p6_8 XI122_An XI122_n2 VSS) gpdk090_nmos1v w=0.24u l=0.1u ad=0.0528p as=0.0528p pd=0.68u ps=0.68u
    I_MXI122_MN2 (XI122_n1 h6 p6_8 VSS) gpdk090_nmos1v w=0.24u l=0.1u ad=0.0528p as=0.0528p pd=0.68u ps=0.68u
    I_MXI122_MN3 (VSS c6_8 XI122_n1 VSS) gpdk090_nmos1v w=0.24u l=0.1u ad=0.0816p as=0.0528p pd=1.16u ps=0.68u
    I_MXI122_MN0 (XI122_An h6 VSS VSS) gpdk090_nmos1v w=0.12u l=0.1u ad=0.0696p as=0.0696p pd=1.16u ps=1.16u
    I_MXI119_MN1 (XI119_Bn qu2 VSS VSS) gpdk090_nmos1v w=0.12u l=0.1u ad=0.0696p as=0.0696p pd=1.16u ps=1.16u
    I_MXI119_MN5 (XI119_n2 XI119_Bn VSS VSS) gpdk090_nmos1v w=0.24u l=0.1u ad=0.0528p as=0.0816p pd=0.68u ps=1.16u
    I_MXI119_MN4 (b6_7 XI119_An XI119_n2 VSS) gpdk090_nmos1v w=0.24u l=0.1u ad=0.0528p as=0.0528p pd=0.68u ps=0.68u
    I_MXI119_MN2 (XI119_n1 dd7 b6_7 VSS) gpdk090_nmos1v w=0.24u l=0.1u ad=0.0528p as=0.0528p pd=0.68u ps=0.68u
    I_MXI119_MN3 (VSS qu2 XI119_n1 VSS) gpdk090_nmos1v w=0.24u l=0.1u ad=0.0816p as=0.0528p pd=1.16u ps=0.68u
    I_MXI119_MN0 (XI119_An dd7 VSS VSS) gpdk090_nmos1v w=0.12u l=0.1u ad=0.0696p as=0.0696p pd=1.16u ps=1.16u
    I_MXI121_MN1 (XI121_Bn qu2 VSS VSS) gpdk090_nmos1v w=0.12u l=0.1u ad=0.0696p as=0.0696p pd=1.16u ps=1.16u
    I_MXI121_MN5 (XI121_n2 XI121_Bn VSS VSS) gpdk090_nmos1v w=0.24u l=0.1u ad=0.0528p as=0.0816p pd=0.68u ps=1.16u
    I_MXI121_MN4 (h6 XI121_An XI121_n2 VSS) gpdk090_nmos1v w=0.24u l=0.1u ad=0.0528p as=0.0528p pd=0.68u ps=0.68u
    I_MXI121_MN2 (XI121_n1 p5_7 h6 VSS) gpdk090_nmos1v w=0.24u l=0.1u ad=0.0528p as=0.0528p pd=0.68u ps=0.68u
    I_MXI121_MN3 (VSS qu2 XI121_n1 VSS) gpdk090_nmos1v w=0.24u l=0.1u ad=0.0816p as=0.0528p pd=1.16u ps=0.68u
    I_MXI121_MN0 (XI121_An p5_7 VSS VSS) gpdk090_nmos1v w=0.12u l=0.1u ad=0.0696p as=0.0696p pd=1.16u ps=1.16u
    I_MXI110_MN1 (XI110_Bn c5_8 VSS VSS) gpdk090_nmos1v w=0.12u l=0.1u ad=0.0696p as=0.0696p pd=1.16u ps=1.16u
    I_MXI110_MN5 (XI110_n2 XI110_Bn VSS VSS) gpdk090_nmos1v w=0.24u l=0.1u ad=0.0528p as=0.0816p pd=0.68u ps=1.16u
    I_MXI110_MN4 (p5_8 XI110_An XI110_n2 VSS) gpdk090_nmos1v w=0.24u l=0.1u ad=0.0528p as=0.0528p pd=0.68u ps=0.68u
    I_MXI110_MN2 (XI110_n1 h5 p5_8 VSS) gpdk090_nmos1v w=0.24u l=0.1u ad=0.0528p as=0.0528p pd=0.68u ps=0.68u
    I_MXI110_MN3 (VSS c5_8 XI110_n1 VSS) gpdk090_nmos1v w=0.24u l=0.1u ad=0.0816p as=0.0528p pd=1.16u ps=0.68u
    I_MXI110_MN0 (XI110_An h5 VSS VSS) gpdk090_nmos1v w=0.12u l=0.1u ad=0.0696p as=0.0696p pd=1.16u ps=1.16u
    I_MXI107_MN1 (XI107_Bn qu3 VSS VSS) gpdk090_nmos1v w=0.12u l=0.1u ad=0.0696p as=0.0696p pd=1.16u ps=1.16u
    I_MXI107_MN5 (XI107_n2 XI107_Bn VSS VSS) gpdk090_nmos1v w=0.24u l=0.1u ad=0.0528p as=0.0816p pd=0.68u ps=1.16u
    I_MXI107_MN4 (b5_7 XI107_An XI107_n2 VSS) gpdk090_nmos1v w=0.24u l=0.1u ad=0.0528p as=0.0528p pd=0.68u ps=0.68u
    I_MXI107_MN2 (XI107_n1 dd7 b5_7 VSS) gpdk090_nmos1v w=0.24u l=0.1u ad=0.0528p as=0.0528p pd=0.68u ps=0.68u
    I_MXI107_MN3 (VSS qu3 XI107_n1 VSS) gpdk090_nmos1v w=0.24u l=0.1u ad=0.0816p as=0.0528p pd=1.16u ps=0.68u
    I_MXI107_MN0 (XI107_An dd7 VSS VSS) gpdk090_nmos1v w=0.12u l=0.1u ad=0.0696p as=0.0696p pd=1.16u ps=1.16u
    I_MXI133_MN1 (XI133_Bn qu1 VSS VSS) gpdk090_nmos1v w=0.12u l=0.1u ad=0.0696p as=0.0696p pd=1.16u ps=1.16u
    I_MXI133_MN5 (XI133_n2 XI133_Bn VSS VSS) gpdk090_nmos1v w=0.24u l=0.1u ad=0.0528p as=0.0816p pd=0.68u ps=1.16u
    I_MXI133_MN4 (h7 XI133_An XI133_n2 VSS) gpdk090_nmos1v w=0.24u l=0.1u ad=0.0528p as=0.0528p pd=0.68u ps=0.68u
    I_MXI133_MN2 (XI133_n1 p6_7 h7 VSS) gpdk090_nmos1v w=0.24u l=0.1u ad=0.0528p as=0.0528p pd=0.68u ps=0.68u
    I_MXI133_MN3 (VSS qu1 XI133_n1 VSS) gpdk090_nmos1v w=0.24u l=0.1u ad=0.0816p as=0.0528p pd=1.16u ps=0.68u
    I_MXI133_MN0 (XI133_An p6_7 VSS VSS) gpdk090_nmos1v w=0.12u l=0.1u ad=0.0696p as=0.0696p pd=1.16u ps=1.16u
    I_MXI129_MN1 (XI129_Bn qu1 VSS VSS) gpdk090_nmos1v w=0.12u l=0.1u ad=0.0696p as=0.0696p pd=1.16u ps=1.16u
    I_MXI129_MN5 (XI129_n2 XI129_Bn VSS VSS) gpdk090_nmos1v w=0.24u l=0.1u ad=0.0528p as=0.0816p pd=0.68u ps=1.16u
    I_MXI129_MN4 (b7_5 XI129_An XI129_n2 VSS) gpdk090_nmos1v w=0.24u l=0.1u ad=0.0528p as=0.0528p pd=0.68u ps=0.68u
    I_MXI129_MN2 (XI129_n1 dd5 b7_5 VSS) gpdk090_nmos1v w=0.24u l=0.1u ad=0.0528p as=0.0528p pd=0.68u ps=0.68u
    I_MXI129_MN3 (VSS qu1 XI129_n1 VSS) gpdk090_nmos1v w=0.24u l=0.1u ad=0.0816p as=0.0528p pd=1.16u ps=0.68u
    I_MXI129_MN0 (XI129_An dd5 VSS VSS) gpdk090_nmos1v w=0.12u l=0.1u ad=0.0696p as=0.0696p pd=1.16u ps=1.16u
    I_MXI118_MN1 (XI118_Bn qu2 VSS VSS) gpdk090_nmos1v w=0.12u l=0.1u ad=0.0696p as=0.0696p pd=1.16u ps=1.16u
    I_MXI118_MN5 (XI118_n2 XI118_Bn VSS VSS) gpdk090_nmos1v w=0.24u l=0.1u ad=0.0528p as=0.0816p pd=0.68u ps=1.16u
    I_MXI118_MN4 (b6_6 XI118_An XI118_n2 VSS) gpdk090_nmos1v w=0.24u l=0.1u ad=0.0528p as=0.0528p pd=0.68u ps=0.68u
    I_MXI118_MN2 (XI118_n1 dd6 b6_6 VSS) gpdk090_nmos1v w=0.24u l=0.1u ad=0.0528p as=0.0528p pd=0.68u ps=0.68u
    I_MXI118_MN3 (VSS qu2 XI118_n1 VSS) gpdk090_nmos1v w=0.24u l=0.1u ad=0.0816p as=0.0528p pd=1.16u ps=0.68u
    I_MXI118_MN0 (XI118_An dd6 VSS VSS) gpdk090_nmos1v w=0.12u l=0.1u ad=0.0696p as=0.0696p pd=1.16u ps=1.16u
    I_MXI108_I41_MN1 (XI108_I41_Bn I108_G3_0n VSS VSS) gpdk090_nmos1v w=0.12u l=0.1u ad=0.0696p as=0.0696p pd=1.16u ps=1.16u
    I_MXI108_I41_MN5 (XI108_I41_n2 XI108_I41_Bn VSS VSS) gpdk090_nmos1v w=0.24u l=0.1u ad=0.0528p as=0.0816p pd=0.68u ps=1.16u
    I_MXI108_I41_MN4 (p5_4 XI108_I41_An XI108_I41_n2 VSS) gpdk090_nmos1v w=0.24u l=0.1u ad=0.0528p as=0.0528p pd=0.68u ps=0.68u
    I_MXI108_I41_MN2 (XI108_I41_n1 I108_pn4 p5_4 VSS) gpdk090_nmos1v w=0.24u l=0.1u ad=0.0528p as=0.0528p pd=0.68u ps=0.68u
    I_MXI108_I41_MN3 (VSS I108_G3_0n XI108_I41_n1 VSS) gpdk090_nmos1v w=0.24u l=0.1u ad=0.0816p as=0.0528p pd=1.16u ps=0.68u
    I_MXI108_I41_MN0 (XI108_I41_An I108_pn4 VSS VSS) gpdk090_nmos1v w=0.12u l=0.1u ad=0.0696p as=0.0696p pd=1.16u ps=1.16u
    I_MXI109_MN1 (XI109_Bn qu3 VSS VSS) gpdk090_nmos1v w=0.12u l=0.1u ad=0.0696p as=0.0696p pd=1.16u ps=1.16u
    I_MXI109_MN5 (XI109_n2 XI109_Bn VSS VSS) gpdk090_nmos1v w=0.24u l=0.1u ad=0.0528p as=0.0816p pd=0.68u ps=1.16u
    I_MXI109_MN4 (h5 XI109_An XI109_n2 VSS) gpdk090_nmos1v w=0.24u l=0.1u ad=0.0528p as=0.0528p pd=0.68u ps=0.68u
    I_MXI109_MN2 (XI109_n1 p4_7 h5 VSS) gpdk090_nmos1v w=0.24u l=0.1u ad=0.0528p as=0.0528p pd=0.68u ps=0.68u
    I_MXI109_MN3 (VSS qu3 XI109_n1 VSS) gpdk090_nmos1v w=0.24u l=0.1u ad=0.0816p as=0.0528p pd=1.16u ps=0.68u
    I_MXI109_MN0 (XI109_An p4_7 VSS VSS) gpdk090_nmos1v w=0.12u l=0.1u ad=0.0696p as=0.0696p pd=1.16u ps=1.16u
    I_MXI106_MN1 (XI106_Bn qu3 VSS VSS) gpdk090_nmos1v w=0.12u l=0.1u ad=0.0696p as=0.0696p pd=1.16u ps=1.16u
    I_MXI106_MN5 (XI106_n2 XI106_Bn VSS VSS) gpdk090_nmos1v w=0.24u l=0.1u ad=0.0528p as=0.0816p pd=0.68u ps=1.16u
    I_MXI106_MN4 (b5_6 XI106_An XI106_n2 VSS) gpdk090_nmos1v w=0.24u l=0.1u ad=0.0528p as=0.0528p pd=0.68u ps=0.68u
    I_MXI106_MN2 (XI106_n1 dd6 b5_6 VSS) gpdk090_nmos1v w=0.24u l=0.1u ad=0.0528p as=0.0528p pd=0.68u ps=0.68u
    I_MXI106_MN3 (VSS qu3 XI106_n1 VSS) gpdk090_nmos1v w=0.24u l=0.1u ad=0.0816p as=0.0528p pd=1.16u ps=0.68u
    I_MXI106_MN0 (XI106_An dd6 VSS VSS) gpdk090_nmos1v w=0.12u l=0.1u ad=0.0696p as=0.0696p pd=1.16u ps=1.16u
    I_MXI134_MN1 (XI134_Bn c7_8 VSS VSS) gpdk090_nmos1v w=0.12u l=0.1u ad=0.0696p as=0.0696p pd=1.16u ps=1.16u
    I_MXI134_MN5 (XI134_n2 XI134_Bn VSS VSS) gpdk090_nmos1v w=0.24u l=0.1u ad=0.0528p as=0.0816p pd=0.68u ps=1.16u
    I_MXI134_MN4 (p7_8 XI134_An XI134_n2 VSS) gpdk090_nmos1v w=0.24u l=0.1u ad=0.0528p as=0.0528p pd=0.68u ps=0.68u
    I_MXI134_MN2 (XI134_n1 h7 p7_8 VSS) gpdk090_nmos1v w=0.24u l=0.1u ad=0.0528p as=0.0528p pd=0.68u ps=0.68u
    I_MXI134_MN3 (VSS c7_8 XI134_n1 VSS) gpdk090_nmos1v w=0.24u l=0.1u ad=0.0816p as=0.0528p pd=1.16u ps=0.68u
    I_MXI134_MN0 (XI134_An h7 VSS VSS) gpdk090_nmos1v w=0.12u l=0.1u ad=0.0696p as=0.0696p pd=1.16u ps=1.16u
    I_MXI120_I40_MN1 (XI120_I40_Bn I120_G2_0n VSS VSS) gpdk090_nmos1v w=0.12u l=0.1u ad=0.0696p as=0.0696p pd=1.16u ps=1.16u
    I_MXI120_I40_MN5 (XI120_I40_n2 XI120_I40_Bn VSS VSS) gpdk090_nmos1v w=0.24u l=0.1u ad=0.0528p as=0.0816p pd=0.68u ps=1.16u
    I_MXI120_I40_MN4 (p6_3 XI120_I40_An XI120_I40_n2 VSS) gpdk090_nmos1v w=0.24u l=0.1u ad=0.0528p as=0.0528p pd=0.68u ps=0.68u
    I_MXI120_I40_MN2 (XI120_I40_n1 I120_pn3 p6_3 VSS) gpdk090_nmos1v w=0.24u l=0.1u ad=0.0528p as=0.0528p pd=0.68u ps=0.68u
    I_MXI120_I40_MN3 (VSS I120_G2_0n XI120_I40_n1 VSS) gpdk090_nmos1v w=0.24u l=0.1u ad=0.0816p as=0.0528p pd=1.16u ps=0.68u
    I_MXI120_I40_MN0 (XI120_I40_An I120_pn3 VSS VSS) gpdk090_nmos1v w=0.12u l=0.1u ad=0.0696p as=0.0696p pd=1.16u ps=1.16u
    I_MXI128_MN1 (XI128_Bn qu1 VSS VSS) gpdk090_nmos1v w=0.12u l=0.1u ad=0.0696p as=0.0696p pd=1.16u ps=1.16u
    I_MXI128_MN5 (XI128_n2 XI128_Bn VSS VSS) gpdk090_nmos1v w=0.24u l=0.1u ad=0.0528p as=0.0816p pd=0.68u ps=1.16u
    I_MXI128_MN4 (b7_4 XI128_An XI128_n2 VSS) gpdk090_nmos1v w=0.24u l=0.1u ad=0.0528p as=0.0528p pd=0.68u ps=0.68u
    I_MXI128_MN2 (XI128_n1 dd4 b7_4 VSS) gpdk090_nmos1v w=0.24u l=0.1u ad=0.0528p as=0.0528p pd=0.68u ps=0.68u
    I_MXI128_MN3 (VSS qu1 XI128_n1 VSS) gpdk090_nmos1v w=0.24u l=0.1u ad=0.0816p as=0.0528p pd=1.16u ps=0.68u
    I_MXI128_MN0 (XI128_An dd4 VSS VSS) gpdk090_nmos1v w=0.12u l=0.1u ad=0.0696p as=0.0696p pd=1.16u ps=1.16u
    I_MXI117_MN1 (XI117_Bn qu2 VSS VSS) gpdk090_nmos1v w=0.12u l=0.1u ad=0.0696p as=0.0696p pd=1.16u ps=1.16u
    I_MXI117_MN5 (XI117_n2 XI117_Bn VSS VSS) gpdk090_nmos1v w=0.24u l=0.1u ad=0.0528p as=0.0816p pd=0.68u ps=1.16u
    I_MXI117_MN4 (b6_5 XI117_An XI117_n2 VSS) gpdk090_nmos1v w=0.24u l=0.1u ad=0.0528p as=0.0528p pd=0.68u ps=0.68u
    I_MXI117_MN2 (XI117_n1 dd5 b6_5 VSS) gpdk090_nmos1v w=0.24u l=0.1u ad=0.0528p as=0.0528p pd=0.68u ps=0.68u
    I_MXI117_MN3 (VSS qu2 XI117_n1 VSS) gpdk090_nmos1v w=0.24u l=0.1u ad=0.0816p as=0.0528p pd=1.16u ps=0.68u
    I_MXI117_MN0 (XI117_An dd5 VSS VSS) gpdk090_nmos1v w=0.12u l=0.1u ad=0.0696p as=0.0696p pd=1.16u ps=1.16u
    I_MXI108_I40_MN1 (XI108_I40_Bn I108_G2_0n VSS VSS) gpdk090_nmos1v w=0.12u l=0.1u ad=0.0696p as=0.0696p pd=1.16u ps=1.16u
    I_MXI108_I40_MN5 (XI108_I40_n2 XI108_I40_Bn VSS VSS) gpdk090_nmos1v w=0.24u l=0.1u ad=0.0528p as=0.0816p pd=0.68u ps=1.16u
    I_MXI108_I40_MN4 (p5_3 XI108_I40_An XI108_I40_n2 VSS) gpdk090_nmos1v w=0.24u l=0.1u ad=0.0528p as=0.0528p pd=0.68u ps=0.68u
    I_MXI108_I40_MN2 (XI108_I40_n1 I108_pn3 p5_3 VSS) gpdk090_nmos1v w=0.24u l=0.1u ad=0.0528p as=0.0528p pd=0.68u ps=0.68u
    I_MXI108_I40_MN3 (VSS I108_G2_0n XI108_I40_n1 VSS) gpdk090_nmos1v w=0.24u l=0.1u ad=0.0816p as=0.0528p pd=1.16u ps=0.68u
    I_MXI108_I40_MN0 (XI108_I40_An I108_pn3 VSS VSS) gpdk090_nmos1v w=0.12u l=0.1u ad=0.0696p as=0.0696p pd=1.16u ps=1.16u
    I_MXI104_MN1 (XI104_Bn qu3 VSS VSS) gpdk090_nmos1v w=0.12u l=0.1u ad=0.0696p as=0.0696p pd=1.16u ps=1.16u
    I_MXI104_MN5 (XI104_n2 XI104_Bn VSS VSS) gpdk090_nmos1v w=0.24u l=0.1u ad=0.0528p as=0.0816p pd=0.68u ps=1.16u
    I_MXI104_MN4 (b5_4 XI104_An XI104_n2 VSS) gpdk090_nmos1v w=0.24u l=0.1u ad=0.0528p as=0.0528p pd=0.68u ps=0.68u
    I_MXI104_MN2 (XI104_n1 dd4 b5_4 VSS) gpdk090_nmos1v w=0.24u l=0.1u ad=0.0528p as=0.0528p pd=0.68u ps=0.68u
    I_MXI104_MN3 (VSS qu3 XI104_n1 VSS) gpdk090_nmos1v w=0.24u l=0.1u ad=0.0816p as=0.0528p pd=1.16u ps=0.68u
    I_MXI104_MN0 (XI104_An dd4 VSS VSS) gpdk090_nmos1v w=0.12u l=0.1u ad=0.0696p as=0.0696p pd=1.16u ps=1.16u
    I_MXI96_I41_MN1 (XI96_I41_Bn I96_G3_0n VSS VSS) gpdk090_nmos1v w=0.12u l=0.1u ad=0.0696p as=0.0696p pd=1.16u ps=1.16u
    I_MXI96_I41_MN5 (XI96_I41_n2 XI96_I41_Bn VSS VSS) gpdk090_nmos1v w=0.24u l=0.1u ad=0.0528p as=0.0816p pd=0.68u ps=1.16u
    I_MXI96_I41_MN4 (p4_4 XI96_I41_An XI96_I41_n2 VSS) gpdk090_nmos1v w=0.24u l=0.1u ad=0.0528p as=0.0528p pd=0.68u ps=0.68u
    I_MXI96_I41_MN2 (XI96_I41_n1 I96_pn4 p4_4 VSS) gpdk090_nmos1v w=0.24u l=0.1u ad=0.0528p as=0.0528p pd=0.68u ps=0.68u
    I_MXI96_I41_MN3 (VSS I96_G3_0n XI96_I41_n1 VSS) gpdk090_nmos1v w=0.24u l=0.1u ad=0.0816p as=0.0528p pd=1.16u ps=0.68u
    I_MXI96_I41_MN0 (XI96_I41_An I96_pn4 VSS VSS) gpdk090_nmos1v w=0.12u l=0.1u ad=0.0696p as=0.0696p pd=1.16u ps=1.16u
    I_MXI105_MN1 (XI105_Bn qu3 VSS VSS) gpdk090_nmos1v w=0.12u l=0.1u ad=0.0696p as=0.0696p pd=1.16u ps=1.16u
    I_MXI105_MN5 (XI105_n2 XI105_Bn VSS VSS) gpdk090_nmos1v w=0.24u l=0.1u ad=0.0528p as=0.0816p pd=0.68u ps=1.16u
    I_MXI105_MN4 (b5_5 XI105_An XI105_n2 VSS) gpdk090_nmos1v w=0.24u l=0.1u ad=0.0528p as=0.0528p pd=0.68u ps=0.68u
    I_MXI105_MN2 (XI105_n1 dd5 b5_5 VSS) gpdk090_nmos1v w=0.24u l=0.1u ad=0.0528p as=0.0528p pd=0.68u ps=0.68u
    I_MXI105_MN3 (VSS qu3 XI105_n1 VSS) gpdk090_nmos1v w=0.24u l=0.1u ad=0.0816p as=0.0528p pd=1.16u ps=0.68u
    I_MXI105_MN0 (XI105_An dd5 VSS VSS) gpdk090_nmos1v w=0.12u l=0.1u ad=0.0696p as=0.0696p pd=1.16u ps=1.16u
    I_MXI98_MN1 (XI98_Bn c4_8 VSS VSS) gpdk090_nmos1v w=0.12u l=0.1u ad=0.0696p as=0.0696p pd=1.16u ps=1.16u
    I_MXI98_MN5 (XI98_n2 XI98_Bn VSS VSS) gpdk090_nmos1v w=0.24u l=0.1u ad=0.0528p as=0.0816p pd=0.68u ps=1.16u
    I_MXI98_MN4 (p4_8 XI98_An XI98_n2 VSS) gpdk090_nmos1v w=0.24u l=0.1u ad=0.0528p as=0.0528p pd=0.68u ps=0.68u
    I_MXI98_MN2 (XI98_n1 h4 p4_8 VSS) gpdk090_nmos1v w=0.24u l=0.1u ad=0.0528p as=0.0528p pd=0.68u ps=0.68u
    I_MXI98_MN3 (VSS c4_8 XI98_n1 VSS) gpdk090_nmos1v w=0.24u l=0.1u ad=0.0816p as=0.0528p pd=1.16u ps=0.68u
    I_MXI98_MN0 (XI98_An h4 VSS VSS) gpdk090_nmos1v w=0.12u l=0.1u ad=0.0696p as=0.0696p pd=1.16u ps=1.16u
    I_MXI127_MN1 (XI127_Bn qu1 VSS VSS) gpdk090_nmos1v w=0.12u l=0.1u ad=0.0696p as=0.0696p pd=1.16u ps=1.16u
    I_MXI127_MN5 (XI127_n2 XI127_Bn VSS VSS) gpdk090_nmos1v w=0.24u l=0.1u ad=0.0528p as=0.0816p pd=0.68u ps=1.16u
    I_MXI127_MN4 (b7_3 XI127_An XI127_n2 VSS) gpdk090_nmos1v w=0.24u l=0.1u ad=0.0528p as=0.0528p pd=0.68u ps=0.68u
    I_MXI127_MN2 (XI127_n1 dd3 b7_3 VSS) gpdk090_nmos1v w=0.24u l=0.1u ad=0.0528p as=0.0528p pd=0.68u ps=0.68u
    I_MXI127_MN3 (VSS qu1 XI127_n1 VSS) gpdk090_nmos1v w=0.24u l=0.1u ad=0.0816p as=0.0528p pd=1.16u ps=0.68u
    I_MXI127_MN0 (XI127_An dd3 VSS VSS) gpdk090_nmos1v w=0.12u l=0.1u ad=0.0696p as=0.0696p pd=1.16u ps=1.16u
    I_MXI115_MN1 (XI115_Bn qu2 VSS VSS) gpdk090_nmos1v w=0.12u l=0.1u ad=0.0696p as=0.0696p pd=1.16u ps=1.16u
    I_MXI115_MN5 (XI115_n2 XI115_Bn VSS VSS) gpdk090_nmos1v w=0.24u l=0.1u ad=0.0528p as=0.0816p pd=0.68u ps=1.16u
    I_MXI115_MN4 (b6_3 XI115_An XI115_n2 VSS) gpdk090_nmos1v w=0.24u l=0.1u ad=0.0528p as=0.0528p pd=0.68u ps=0.68u
    I_MXI115_MN2 (XI115_n1 dd3 b6_3 VSS) gpdk090_nmos1v w=0.24u l=0.1u ad=0.0528p as=0.0528p pd=0.68u ps=0.68u
    I_MXI115_MN3 (VSS qu2 XI115_n1 VSS) gpdk090_nmos1v w=0.24u l=0.1u ad=0.0816p as=0.0528p pd=1.16u ps=0.68u
    I_MXI115_MN0 (XI115_An dd3 VSS VSS) gpdk090_nmos1v w=0.12u l=0.1u ad=0.0696p as=0.0696p pd=1.16u ps=1.16u
    I_MXI116_MN1 (XI116_Bn qu2 VSS VSS) gpdk090_nmos1v w=0.12u l=0.1u ad=0.0696p as=0.0696p pd=1.16u ps=1.16u
    I_MXI116_MN5 (XI116_n2 XI116_Bn VSS VSS) gpdk090_nmos1v w=0.24u l=0.1u ad=0.0528p as=0.0816p pd=0.68u ps=1.16u
    I_MXI116_MN4 (b6_4 XI116_An XI116_n2 VSS) gpdk090_nmos1v w=0.24u l=0.1u ad=0.0528p as=0.0528p pd=0.68u ps=0.68u
    I_MXI116_MN2 (XI116_n1 dd4 b6_4 VSS) gpdk090_nmos1v w=0.24u l=0.1u ad=0.0528p as=0.0528p pd=0.68u ps=0.68u
    I_MXI116_MN3 (VSS qu2 XI116_n1 VSS) gpdk090_nmos1v w=0.24u l=0.1u ad=0.0816p as=0.0528p pd=1.16u ps=0.68u
    I_MXI116_MN0 (XI116_An dd4 VSS VSS) gpdk090_nmos1v w=0.12u l=0.1u ad=0.0696p as=0.0696p pd=1.16u ps=1.16u
    I_MXI103_MN1 (XI103_Bn qu3 VSS VSS) gpdk090_nmos1v w=0.12u l=0.1u ad=0.0696p as=0.0696p pd=1.16u ps=1.16u
    I_MXI103_MN5 (XI103_n2 XI103_Bn VSS VSS) gpdk090_nmos1v w=0.24u l=0.1u ad=0.0528p as=0.0816p pd=0.68u ps=1.16u
    I_MXI103_MN4 (b5_3 XI103_An XI103_n2 VSS) gpdk090_nmos1v w=0.24u l=0.1u ad=0.0528p as=0.0528p pd=0.68u ps=0.68u
    I_MXI103_MN2 (XI103_n1 dd3 b5_3 VSS) gpdk090_nmos1v w=0.24u l=0.1u ad=0.0528p as=0.0528p pd=0.68u ps=0.68u
    I_MXI103_MN3 (VSS qu3 XI103_n1 VSS) gpdk090_nmos1v w=0.24u l=0.1u ad=0.0816p as=0.0528p pd=1.16u ps=0.68u
    I_MXI103_MN0 (XI103_An dd3 VSS VSS) gpdk090_nmos1v w=0.12u l=0.1u ad=0.0696p as=0.0696p pd=1.16u ps=1.16u
    I_MXI96_I40_MN1 (XI96_I40_Bn I96_G2_0n VSS VSS) gpdk090_nmos1v w=0.12u l=0.1u ad=0.0696p as=0.0696p pd=1.16u ps=1.16u
    I_MXI96_I40_MN5 (XI96_I40_n2 XI96_I40_Bn VSS VSS) gpdk090_nmos1v w=0.24u l=0.1u ad=0.0528p as=0.0816p pd=0.68u ps=1.16u
    I_MXI96_I40_MN4 (p4_3 XI96_I40_An XI96_I40_n2 VSS) gpdk090_nmos1v w=0.24u l=0.1u ad=0.0528p as=0.0528p pd=0.68u ps=0.68u
    I_MXI96_I40_MN2 (XI96_I40_n1 I96_pn3 p4_3 VSS) gpdk090_nmos1v w=0.24u l=0.1u ad=0.0528p as=0.0528p pd=0.68u ps=0.68u
    I_MXI96_I40_MN3 (VSS I96_G2_0n XI96_I40_n1 VSS) gpdk090_nmos1v w=0.24u l=0.1u ad=0.0816p as=0.0528p pd=1.16u ps=0.68u
    I_MXI96_I40_MN0 (XI96_I40_An I96_pn3 VSS VSS) gpdk090_nmos1v w=0.12u l=0.1u ad=0.0696p as=0.0696p pd=1.16u ps=1.16u
    I_MXI132_I41_MN1 (XI132_I41_Bn I132_G3_0n VSS VSS) gpdk090_nmos1v w=0.12u l=0.1u ad=0.0696p as=0.0696p pd=1.16u ps=1.16u
    I_MXI132_I41_MN5 (XI132_I41_n2 XI132_I41_Bn VSS VSS) gpdk090_nmos1v w=0.24u l=0.1u ad=0.0528p as=0.0816p pd=0.68u ps=1.16u
    I_MXI132_I41_MN4 (p7_4 XI132_I41_An XI132_I41_n2 VSS) gpdk090_nmos1v w=0.24u l=0.1u ad=0.0528p as=0.0528p pd=0.68u ps=0.68u
    I_MXI132_I41_MN2 (XI132_I41_n1 I132_pn4 p7_4 VSS) gpdk090_nmos1v w=0.24u l=0.1u ad=0.0528p as=0.0528p pd=0.68u ps=0.68u
    I_MXI132_I41_MN3 (VSS I132_G3_0n XI132_I41_n1 VSS) gpdk090_nmos1v w=0.24u l=0.1u ad=0.0816p as=0.0528p pd=1.16u ps=0.68u
    I_MXI132_I41_MN0 (XI132_I41_An I132_pn4 VSS VSS) gpdk090_nmos1v w=0.12u l=0.1u ad=0.0696p as=0.0696p pd=1.16u ps=1.16u
    I_MXI132_I40_MN1 (XI132_I40_Bn I132_G2_0n VSS VSS) gpdk090_nmos1v w=0.12u l=0.1u ad=0.0696p as=0.0696p pd=1.16u ps=1.16u
    I_MXI132_I40_MN5 (XI132_I40_n2 XI132_I40_Bn VSS VSS) gpdk090_nmos1v w=0.24u l=0.1u ad=0.0528p as=0.0816p pd=0.68u ps=1.16u
    I_MXI132_I40_MN4 (p7_3 XI132_I40_An XI132_I40_n2 VSS) gpdk090_nmos1v w=0.24u l=0.1u ad=0.0528p as=0.0528p pd=0.68u ps=0.68u
    I_MXI132_I40_MN2 (XI132_I40_n1 I132_pn3 p7_3 VSS) gpdk090_nmos1v w=0.24u l=0.1u ad=0.0528p as=0.0528p pd=0.68u ps=0.68u
    I_MXI132_I40_MN3 (VSS I132_G2_0n XI132_I40_n1 VSS) gpdk090_nmos1v w=0.24u l=0.1u ad=0.0816p as=0.0528p pd=1.16u ps=0.68u
    I_MXI132_I40_MN0 (XI132_I40_An I132_pn3 VSS VSS) gpdk090_nmos1v w=0.12u l=0.1u ad=0.0696p as=0.0696p pd=1.16u ps=1.16u
    I_MXI126_MN1 (XI126_Bn qu1 VSS VSS) gpdk090_nmos1v w=0.12u l=0.1u ad=0.0696p as=0.0696p pd=1.16u ps=1.16u
    I_MXI126_MN5 (XI126_n2 XI126_Bn VSS VSS) gpdk090_nmos1v w=0.24u l=0.1u ad=0.0528p as=0.0816p pd=0.68u ps=1.16u
    I_MXI126_MN4 (b7_2 XI126_An XI126_n2 VSS) gpdk090_nmos1v w=0.24u l=0.1u ad=0.0528p as=0.0528p pd=0.68u ps=0.68u
    I_MXI126_MN2 (XI126_n1 dd2 b7_2 VSS) gpdk090_nmos1v w=0.24u l=0.1u ad=0.0528p as=0.0528p pd=0.68u ps=0.68u
    I_MXI126_MN3 (VSS qu1 XI126_n1 VSS) gpdk090_nmos1v w=0.24u l=0.1u ad=0.0816p as=0.0528p pd=1.16u ps=0.68u
    I_MXI126_MN0 (XI126_An dd2 VSS VSS) gpdk090_nmos1v w=0.12u l=0.1u ad=0.0696p as=0.0696p pd=1.16u ps=1.16u
    I_MXI113_MN1 (XI113_Bn qu2 VSS VSS) gpdk090_nmos1v w=0.12u l=0.1u ad=0.0696p as=0.0696p pd=1.16u ps=1.16u
    I_MXI113_MN5 (XI113_n2 XI113_Bn VSS VSS) gpdk090_nmos1v w=0.24u l=0.1u ad=0.0528p as=0.0816p pd=0.68u ps=1.16u
    I_MXI113_MN4 (b6_1 XI113_An XI113_n2 VSS) gpdk090_nmos1v w=0.24u l=0.1u ad=0.0528p as=0.0528p pd=0.68u ps=0.68u
    I_MXI113_MN2 (XI113_n1 dd1 b6_1 VSS) gpdk090_nmos1v w=0.24u l=0.1u ad=0.0528p as=0.0528p pd=0.68u ps=0.68u
    I_MXI113_MN3 (VSS qu2 XI113_n1 VSS) gpdk090_nmos1v w=0.24u l=0.1u ad=0.0816p as=0.0528p pd=1.16u ps=0.68u
    I_MXI113_MN0 (XI113_An dd1 VSS VSS) gpdk090_nmos1v w=0.12u l=0.1u ad=0.0696p as=0.0696p pd=1.16u ps=1.16u
    I_MXI114_MN1 (XI114_Bn qu2 VSS VSS) gpdk090_nmos1v w=0.12u l=0.1u ad=0.0696p as=0.0696p pd=1.16u ps=1.16u
    I_MXI114_MN5 (XI114_n2 XI114_Bn VSS VSS) gpdk090_nmos1v w=0.24u l=0.1u ad=0.0528p as=0.0816p pd=0.68u ps=1.16u
    I_MXI114_MN4 (b6_2 XI114_An XI114_n2 VSS) gpdk090_nmos1v w=0.24u l=0.1u ad=0.0528p as=0.0528p pd=0.68u ps=0.68u
    I_MXI114_MN2 (XI114_n1 dd2 b6_2 VSS) gpdk090_nmos1v w=0.24u l=0.1u ad=0.0528p as=0.0528p pd=0.68u ps=0.68u
    I_MXI114_MN3 (VSS qu2 XI114_n1 VSS) gpdk090_nmos1v w=0.24u l=0.1u ad=0.0816p as=0.0528p pd=1.16u ps=0.68u
    I_MXI114_MN0 (XI114_An dd2 VSS VSS) gpdk090_nmos1v w=0.12u l=0.1u ad=0.0696p as=0.0696p pd=1.16u ps=1.16u
    I_MXI101_MN1 (XI101_Bn qu3 VSS VSS) gpdk090_nmos1v w=0.12u l=0.1u ad=0.0696p as=0.0696p pd=1.16u ps=1.16u
    I_MXI101_MN5 (XI101_n2 XI101_Bn VSS VSS) gpdk090_nmos1v w=0.24u l=0.1u ad=0.0528p as=0.0816p pd=0.68u ps=1.16u
    I_MXI101_MN4 (b5_1 XI101_An XI101_n2 VSS) gpdk090_nmos1v w=0.24u l=0.1u ad=0.0528p as=0.0528p pd=0.68u ps=0.68u
    I_MXI101_MN2 (XI101_n1 dd1 b5_1 VSS) gpdk090_nmos1v w=0.24u l=0.1u ad=0.0528p as=0.0528p pd=0.68u ps=0.68u
    I_MXI101_MN3 (VSS qu3 XI101_n1 VSS) gpdk090_nmos1v w=0.24u l=0.1u ad=0.0816p as=0.0528p pd=1.16u ps=0.68u
    I_MXI101_MN0 (XI101_An dd1 VSS VSS) gpdk090_nmos1v w=0.12u l=0.1u ad=0.0696p as=0.0696p pd=1.16u ps=1.16u
    I_MXI102_MN1 (XI102_Bn qu3 VSS VSS) gpdk090_nmos1v w=0.12u l=0.1u ad=0.0696p as=0.0696p pd=1.16u ps=1.16u
    I_MXI102_MN5 (XI102_n2 XI102_Bn VSS VSS) gpdk090_nmos1v w=0.24u l=0.1u ad=0.0528p as=0.0816p pd=0.68u ps=1.16u
    I_MXI102_MN4 (b5_2 XI102_An XI102_n2 VSS) gpdk090_nmos1v w=0.24u l=0.1u ad=0.0528p as=0.0528p pd=0.68u ps=0.68u
    I_MXI102_MN2 (XI102_n1 dd2 b5_2 VSS) gpdk090_nmos1v w=0.24u l=0.1u ad=0.0528p as=0.0528p pd=0.68u ps=0.68u
    I_MXI102_MN3 (VSS qu3 XI102_n1 VSS) gpdk090_nmos1v w=0.24u l=0.1u ad=0.0816p as=0.0528p pd=1.16u ps=0.68u
    I_MXI102_MN0 (XI102_An dd2 VSS VSS) gpdk090_nmos1v w=0.12u l=0.1u ad=0.0696p as=0.0696p pd=1.16u ps=1.16u
    I_MXI125_MN1 (XI125_Bn qu1 VSS VSS) gpdk090_nmos1v w=0.12u l=0.1u ad=0.0696p as=0.0696p pd=1.16u ps=1.16u
    I_MXI125_MN5 (XI125_n2 XI125_Bn VSS VSS) gpdk090_nmos1v w=0.24u l=0.1u ad=0.0528p as=0.0816p pd=0.68u ps=1.16u
    I_MXI125_MN4 (b7_1 XI125_An XI125_n2 VSS) gpdk090_nmos1v w=0.24u l=0.1u ad=0.0528p as=0.0528p pd=0.68u ps=0.68u
    I_MXI125_MN2 (XI125_n1 dd1 b7_1 VSS) gpdk090_nmos1v w=0.24u l=0.1u ad=0.0528p as=0.0528p pd=0.68u ps=0.68u
    I_MXI125_MN3 (VSS qu1 XI125_n1 VSS) gpdk090_nmos1v w=0.24u l=0.1u ad=0.0816p as=0.0528p pd=1.16u ps=0.68u
    I_MXI125_MN0 (XI125_An dd1 VSS VSS) gpdk090_nmos1v w=0.12u l=0.1u ad=0.0696p as=0.0696p pd=1.16u ps=1.16u
    I_MXI112_MN1 (XI112_Bn qu2 VSS VSS) gpdk090_nmos1v w=0.12u l=0.1u ad=0.0696p as=0.0696p pd=1.16u ps=1.16u
    I_MXI112_MN5 (XI112_n2 XI112_Bn VSS VSS) gpdk090_nmos1v w=0.24u l=0.1u ad=0.0528p as=0.0816p pd=0.68u ps=1.16u
    I_MXI112_MN4 (b6_0 XI112_An XI112_n2 VSS) gpdk090_nmos1v w=0.24u l=0.1u ad=0.0528p as=0.0528p pd=0.68u ps=0.68u
    I_MXI112_MN2 (XI112_n1 B_0 b6_0 VSS) gpdk090_nmos1v w=0.24u l=0.1u ad=0.0528p as=0.0528p pd=0.68u ps=0.68u
    I_MXI112_MN3 (VSS qu2 XI112_n1 VSS) gpdk090_nmos1v w=0.24u l=0.1u ad=0.0816p as=0.0528p pd=1.16u ps=0.68u
    I_MXI112_MN0 (XI112_An B_0 VSS VSS) gpdk090_nmos1v w=0.12u l=0.1u ad=0.0696p as=0.0696p pd=1.16u ps=1.16u
    I_MXI100_MN1 (XI100_Bn qu3 VSS VSS) gpdk090_nmos1v w=0.12u l=0.1u ad=0.0696p as=0.0696p pd=1.16u ps=1.16u
    I_MXI100_MN5 (XI100_n2 XI100_Bn VSS VSS) gpdk090_nmos1v w=0.24u l=0.1u ad=0.0528p as=0.0816p pd=0.68u ps=1.16u
    I_MXI100_MN4 (b5_0 XI100_An XI100_n2 VSS) gpdk090_nmos1v w=0.24u l=0.1u ad=0.0528p as=0.0528p pd=0.68u ps=0.68u
    I_MXI100_MN2 (XI100_n1 B_0 b5_0 VSS) gpdk090_nmos1v w=0.24u l=0.1u ad=0.0528p as=0.0528p pd=0.68u ps=0.68u
    I_MXI100_MN3 (VSS qu3 XI100_n1 VSS) gpdk090_nmos1v w=0.24u l=0.1u ad=0.0816p as=0.0528p pd=1.16u ps=0.68u
    I_MXI100_MN0 (XI100_An B_0 VSS VSS) gpdk090_nmos1v w=0.12u l=0.1u ad=0.0696p as=0.0696p pd=1.16u ps=1.16u
    I_MXI89_MN1 (XI89_Bn qu4 VSS VSS) gpdk090_nmos1v w=0.12u l=0.1u ad=0.0696p as=0.0696p pd=1.16u ps=1.16u
    I_MXI89_MN5 (XI89_n2 XI89_Bn VSS VSS) gpdk090_nmos1v w=0.24u l=0.1u ad=0.0528p as=0.0816p pd=0.68u ps=1.16u
    I_MXI89_MN4 (b4_1 XI89_An XI89_n2 VSS) gpdk090_nmos1v w=0.24u l=0.1u ad=0.0528p as=0.0528p pd=0.68u ps=0.68u
    I_MXI89_MN2 (XI89_n1 dd1 b4_1 VSS) gpdk090_nmos1v w=0.24u l=0.1u ad=0.0528p as=0.0528p pd=0.68u ps=0.68u
    I_MXI89_MN3 (VSS qu4 XI89_n1 VSS) gpdk090_nmos1v w=0.24u l=0.1u ad=0.0816p as=0.0528p pd=1.16u ps=0.68u
    I_MXI89_MN0 (XI89_An dd1 VSS VSS) gpdk090_nmos1v w=0.12u l=0.1u ad=0.0696p as=0.0696p pd=1.16u ps=1.16u
    I_MXI95_MN1 (XI95_Bn qu4 VSS VSS) gpdk090_nmos1v w=0.12u l=0.1u ad=0.0696p as=0.0696p pd=1.16u ps=1.16u
    I_MXI95_MN5 (XI95_n2 XI95_Bn VSS VSS) gpdk090_nmos1v w=0.24u l=0.1u ad=0.0528p as=0.0816p pd=0.68u ps=1.16u
    I_MXI95_MN4 (b4_7 XI95_An XI95_n2 VSS) gpdk090_nmos1v w=0.24u l=0.1u ad=0.0528p as=0.0528p pd=0.68u ps=0.68u
    I_MXI95_MN2 (XI95_n1 dd7 b4_7 VSS) gpdk090_nmos1v w=0.24u l=0.1u ad=0.0528p as=0.0528p pd=0.68u ps=0.68u
    I_MXI95_MN3 (VSS qu4 XI95_n1 VSS) gpdk090_nmos1v w=0.24u l=0.1u ad=0.0816p as=0.0528p pd=1.16u ps=0.68u
    I_MXI95_MN0 (XI95_An dd7 VSS VSS) gpdk090_nmos1v w=0.12u l=0.1u ad=0.0696p as=0.0696p pd=1.16u ps=1.16u
    I_MXI124_MN1 (XI124_Bn qu1 VSS VSS) gpdk090_nmos1v w=0.12u l=0.1u ad=0.0696p as=0.0696p pd=1.16u ps=1.16u
    I_MXI124_MN5 (XI124_n2 XI124_Bn VSS VSS) gpdk090_nmos1v w=0.24u l=0.1u ad=0.0528p as=0.0816p pd=0.68u ps=1.16u
    I_MXI124_MN4 (b7_0 XI124_An XI124_n2 VSS) gpdk090_nmos1v w=0.24u l=0.1u ad=0.0528p as=0.0528p pd=0.68u ps=0.68u
    I_MXI124_MN2 (XI124_n1 B_0 b7_0 VSS) gpdk090_nmos1v w=0.24u l=0.1u ad=0.0528p as=0.0528p pd=0.68u ps=0.68u
    I_MXI124_MN3 (VSS qu1 XI124_n1 VSS) gpdk090_nmos1v w=0.24u l=0.1u ad=0.0816p as=0.0528p pd=1.16u ps=0.68u
    I_MXI124_MN0 (XI124_An B_0 VSS VSS) gpdk090_nmos1v w=0.12u l=0.1u ad=0.0696p as=0.0696p pd=1.16u ps=1.16u
    I_MXI88_MN1 (XI88_Bn qu4 VSS VSS) gpdk090_nmos1v w=0.12u l=0.1u ad=0.0696p as=0.0696p pd=1.16u ps=1.16u
    I_MXI88_MN5 (XI88_n2 XI88_Bn VSS VSS) gpdk090_nmos1v w=0.24u l=0.1u ad=0.0528p as=0.0816p pd=0.68u ps=1.16u
    I_MXI88_MN4 (b4_0 XI88_An XI88_n2 VSS) gpdk090_nmos1v w=0.24u l=0.1u ad=0.0528p as=0.0528p pd=0.68u ps=0.68u
    I_MXI88_MN2 (XI88_n1 B_0 b4_0 VSS) gpdk090_nmos1v w=0.24u l=0.1u ad=0.0528p as=0.0528p pd=0.68u ps=0.68u
    I_MXI88_MN3 (VSS qu4 XI88_n1 VSS) gpdk090_nmos1v w=0.24u l=0.1u ad=0.0816p as=0.0528p pd=1.16u ps=0.68u
    I_MXI88_MN0 (XI88_An B_0 VSS VSS) gpdk090_nmos1v w=0.12u l=0.1u ad=0.0696p as=0.0696p pd=1.16u ps=1.16u
    I_MXI90_MN1 (XI90_Bn qu4 VSS VSS) gpdk090_nmos1v w=0.12u l=0.1u ad=0.0696p as=0.0696p pd=1.16u ps=1.16u
    I_MXI90_MN5 (XI90_n2 XI90_Bn VSS VSS) gpdk090_nmos1v w=0.24u l=0.1u ad=0.0528p as=0.0816p pd=0.68u ps=1.16u
    I_MXI90_MN4 (b4_2 XI90_An XI90_n2 VSS) gpdk090_nmos1v w=0.24u l=0.1u ad=0.0528p as=0.0528p pd=0.68u ps=0.68u
    I_MXI90_MN2 (XI90_n1 dd2 b4_2 VSS) gpdk090_nmos1v w=0.24u l=0.1u ad=0.0528p as=0.0528p pd=0.68u ps=0.68u
    I_MXI90_MN3 (VSS qu4 XI90_n1 VSS) gpdk090_nmos1v w=0.24u l=0.1u ad=0.0816p as=0.0528p pd=1.16u ps=0.68u
    I_MXI90_MN0 (XI90_An dd2 VSS VSS) gpdk090_nmos1v w=0.12u l=0.1u ad=0.0696p as=0.0696p pd=1.16u ps=1.16u
    I_MXI91_MN1 (XI91_Bn qu4 VSS VSS) gpdk090_nmos1v w=0.12u l=0.1u ad=0.0696p as=0.0696p pd=1.16u ps=1.16u
    I_MXI91_MN5 (XI91_n2 XI91_Bn VSS VSS) gpdk090_nmos1v w=0.24u l=0.1u ad=0.0528p as=0.0816p pd=0.68u ps=1.16u
    I_MXI91_MN4 (b4_3 XI91_An XI91_n2 VSS) gpdk090_nmos1v w=0.24u l=0.1u ad=0.0528p as=0.0528p pd=0.68u ps=0.68u
    I_MXI91_MN2 (XI91_n1 dd3 b4_3 VSS) gpdk090_nmos1v w=0.24u l=0.1u ad=0.0528p as=0.0528p pd=0.68u ps=0.68u
    I_MXI91_MN3 (VSS qu4 XI91_n1 VSS) gpdk090_nmos1v w=0.24u l=0.1u ad=0.0816p as=0.0528p pd=1.16u ps=0.68u
    I_MXI91_MN0 (XI91_An dd3 VSS VSS) gpdk090_nmos1v w=0.12u l=0.1u ad=0.0696p as=0.0696p pd=1.16u ps=1.16u
    I_MXI92_MN1 (XI92_Bn qu4 VSS VSS) gpdk090_nmos1v w=0.12u l=0.1u ad=0.0696p as=0.0696p pd=1.16u ps=1.16u
    I_MXI92_MN5 (XI92_n2 XI92_Bn VSS VSS) gpdk090_nmos1v w=0.24u l=0.1u ad=0.0528p as=0.0816p pd=0.68u ps=1.16u
    I_MXI92_MN4 (b4_4 XI92_An XI92_n2 VSS) gpdk090_nmos1v w=0.24u l=0.1u ad=0.0528p as=0.0528p pd=0.68u ps=0.68u
    I_MXI92_MN2 (XI92_n1 dd4 b4_4 VSS) gpdk090_nmos1v w=0.24u l=0.1u ad=0.0528p as=0.0528p pd=0.68u ps=0.68u
    I_MXI92_MN3 (VSS qu4 XI92_n1 VSS) gpdk090_nmos1v w=0.24u l=0.1u ad=0.0816p as=0.0528p pd=1.16u ps=0.68u
    I_MXI92_MN0 (XI92_An dd4 VSS VSS) gpdk090_nmos1v w=0.12u l=0.1u ad=0.0696p as=0.0696p pd=1.16u ps=1.16u
    I_MXI94_MN1 (XI94_Bn qu4 VSS VSS) gpdk090_nmos1v w=0.12u l=0.1u ad=0.0696p as=0.0696p pd=1.16u ps=1.16u
    I_MXI94_MN5 (XI94_n2 XI94_Bn VSS VSS) gpdk090_nmos1v w=0.24u l=0.1u ad=0.0528p as=0.0816p pd=0.68u ps=1.16u
    I_MXI94_MN4 (b4_6 XI94_An XI94_n2 VSS) gpdk090_nmos1v w=0.24u l=0.1u ad=0.0528p as=0.0528p pd=0.68u ps=0.68u
    I_MXI94_MN2 (XI94_n1 dd6 b4_6 VSS) gpdk090_nmos1v w=0.24u l=0.1u ad=0.0528p as=0.0528p pd=0.68u ps=0.68u
    I_MXI94_MN3 (VSS qu4 XI94_n1 VSS) gpdk090_nmos1v w=0.24u l=0.1u ad=0.0816p as=0.0528p pd=1.16u ps=0.68u
    I_MXI94_MN0 (XI94_An dd6 VSS VSS) gpdk090_nmos1v w=0.12u l=0.1u ad=0.0696p as=0.0696p pd=1.16u ps=1.16u
    I_MXI97_MN1 (XI97_Bn qu4 VSS VSS) gpdk090_nmos1v w=0.12u l=0.1u ad=0.0696p as=0.0696p pd=1.16u ps=1.16u
    I_MXI97_MN5 (XI97_n2 XI97_Bn VSS VSS) gpdk090_nmos1v w=0.24u l=0.1u ad=0.0528p as=0.0816p pd=0.68u ps=1.16u
    I_MXI97_MN4 (h4 XI97_An XI97_n2 VSS) gpdk090_nmos1v w=0.24u l=0.1u ad=0.0528p as=0.0528p pd=0.68u ps=0.68u
    I_MXI97_MN2 (XI97_n1 p3_7 h4 VSS) gpdk090_nmos1v w=0.24u l=0.1u ad=0.0528p as=0.0528p pd=0.68u ps=0.68u
    I_MXI97_MN3 (VSS qu4 XI97_n1 VSS) gpdk090_nmos1v w=0.24u l=0.1u ad=0.0816p as=0.0528p pd=1.16u ps=0.68u
    I_MXI97_MN0 (XI97_An p3_7 VSS VSS) gpdk090_nmos1v w=0.12u l=0.1u ad=0.0696p as=0.0696p pd=1.16u ps=1.16u
    I_MXI152_I41_MN1 (XI152_I41_Bn I152_G3_0n VSS VSS) gpdk090_nmos1v w=0.12u l=0.1u ad=0.0696p as=0.0696p pd=1.16u ps=1.16u
    I_MXI152_I41_MN5 (XI152_I41_n2 XI152_I41_Bn VSS VSS) gpdk090_nmos1v w=0.24u l=0.1u ad=0.0528p as=0.0816p pd=0.68u ps=1.16u
    I_MXI152_I41_MN4 (ru4 XI152_I41_An XI152_I41_n2 VSS) gpdk090_nmos1v w=0.24u l=0.1u ad=0.0528p as=0.0528p pd=0.68u ps=0.68u
    I_MXI152_I41_MN2 (XI152_I41_n1 I152_pn4 ru4 VSS) gpdk090_nmos1v w=0.24u l=0.1u ad=0.0528p as=0.0528p pd=0.68u ps=0.68u
    I_MXI152_I41_MN3 (VSS I152_G3_0n XI152_I41_n1 VSS) gpdk090_nmos1v w=0.24u l=0.1u ad=0.0816p as=0.0528p pd=1.16u ps=0.68u
    I_MXI152_I41_MN0 (XI152_I41_An I152_pn4 VSS VSS) gpdk090_nmos1v w=0.12u l=0.1u ad=0.0696p as=0.0696p pd=1.16u ps=1.16u
    I_MXI153_MN1 (XI153_Bn B_7 VSS VSS) gpdk090_nmos1v w=0.12u l=0.1u ad=0.0696p as=0.0696p pd=1.16u ps=1.16u
    I_MXI153_MN5 (XI153_n2 XI153_Bn VSS VSS) gpdk090_nmos1v w=0.24u l=0.1u ad=0.0528p as=0.0816p pd=0.68u ps=1.16u
    I_MXI153_MN4 (sq XI153_An XI153_n2 VSS) gpdk090_nmos1v w=0.24u l=0.1u ad=0.0528p as=0.0528p pd=0.68u ps=0.68u
    I_MXI153_MN2 (XI153_n1 A_7 sq VSS) gpdk090_nmos1v w=0.24u l=0.1u ad=0.0528p as=0.0528p pd=0.68u ps=0.68u
    I_MXI153_MN3 (VSS B_7 XI153_n1 VSS) gpdk090_nmos1v w=0.24u l=0.1u ad=0.0816p as=0.0528p pd=1.16u ps=0.68u
    I_MXI153_MN0 (XI153_An A_7 VSS VSS) gpdk090_nmos1v w=0.12u l=0.1u ad=0.0696p as=0.0696p pd=1.16u ps=1.16u
    I_MXI76_MN1 (XI76_Bn qu5 VSS VSS) gpdk090_nmos1v w=0.12u l=0.1u ad=0.0696p as=0.0696p pd=1.16u ps=1.16u
    I_MXI76_MN5 (XI76_n2 XI76_Bn VSS VSS) gpdk090_nmos1v w=0.24u l=0.1u ad=0.0528p as=0.0816p pd=0.68u ps=1.16u
    I_MXI76_MN4 (b3_0 XI76_An XI76_n2 VSS) gpdk090_nmos1v w=0.24u l=0.1u ad=0.0528p as=0.0528p pd=0.68u ps=0.68u
    I_MXI76_MN2 (XI76_n1 B_0 b3_0 VSS) gpdk090_nmos1v w=0.24u l=0.1u ad=0.0528p as=0.0528p pd=0.68u ps=0.68u
    I_MXI76_MN3 (VSS qu5 XI76_n1 VSS) gpdk090_nmos1v w=0.24u l=0.1u ad=0.0816p as=0.0528p pd=1.16u ps=0.68u
    I_MXI76_MN0 (XI76_An B_0 VSS VSS) gpdk090_nmos1v w=0.12u l=0.1u ad=0.0696p as=0.0696p pd=1.16u ps=1.16u
    I_MXI84_I40_MN1 (XI84_I40_Bn I84_G2_0n VSS VSS) gpdk090_nmos1v w=0.12u l=0.1u ad=0.0696p as=0.0696p pd=1.16u ps=1.16u
    I_MXI84_I40_MN5 (XI84_I40_n2 XI84_I40_Bn VSS VSS) gpdk090_nmos1v w=0.24u l=0.1u ad=0.0528p as=0.0816p pd=0.68u ps=1.16u
    I_MXI84_I40_MN4 (p3_3 XI84_I40_An XI84_I40_n2 VSS) gpdk090_nmos1v w=0.24u l=0.1u ad=0.0528p as=0.0528p pd=0.68u ps=0.68u
    I_MXI84_I40_MN2 (XI84_I40_n1 I84_pn3 p3_3 VSS) gpdk090_nmos1v w=0.24u l=0.1u ad=0.0528p as=0.0528p pd=0.68u ps=0.68u
    I_MXI84_I40_MN3 (VSS I84_G2_0n XI84_I40_n1 VSS) gpdk090_nmos1v w=0.24u l=0.1u ad=0.0816p as=0.0528p pd=1.16u ps=0.68u
    I_MXI84_I40_MN0 (XI84_I40_An I84_pn3 VSS VSS) gpdk090_nmos1v w=0.12u l=0.1u ad=0.0696p as=0.0696p pd=1.16u ps=1.16u
    I_MXI93_MN1 (XI93_Bn qu4 VSS VSS) gpdk090_nmos1v w=0.12u l=0.1u ad=0.0696p as=0.0696p pd=1.16u ps=1.16u
    I_MXI93_MN5 (XI93_n2 XI93_Bn VSS VSS) gpdk090_nmos1v w=0.24u l=0.1u ad=0.0528p as=0.0816p pd=0.68u ps=1.16u
    I_MXI93_MN4 (b4_5 XI93_An XI93_n2 VSS) gpdk090_nmos1v w=0.24u l=0.1u ad=0.0528p as=0.0528p pd=0.68u ps=0.68u
    I_MXI93_MN2 (XI93_n1 dd5 b4_5 VSS) gpdk090_nmos1v w=0.24u l=0.1u ad=0.0528p as=0.0528p pd=0.68u ps=0.68u
    I_MXI93_MN3 (VSS qu4 XI93_n1 VSS) gpdk090_nmos1v w=0.24u l=0.1u ad=0.0816p as=0.0528p pd=1.16u ps=0.68u
    I_MXI93_MN0 (XI93_An dd5 VSS VSS) gpdk090_nmos1v w=0.12u l=0.1u ad=0.0696p as=0.0696p pd=1.16u ps=1.16u
    I_MXI64_MN1 (XI64_Bn qu6 VSS VSS) gpdk090_nmos1v w=0.12u l=0.1u ad=0.0696p as=0.0696p pd=1.16u ps=1.16u
    I_MXI64_MN5 (XI64_n2 XI64_Bn VSS VSS) gpdk090_nmos1v w=0.24u l=0.1u ad=0.0528p as=0.0816p pd=0.68u ps=1.16u
    I_MXI64_MN4 (b2_0 XI64_An XI64_n2 VSS) gpdk090_nmos1v w=0.24u l=0.1u ad=0.0528p as=0.0528p pd=0.68u ps=0.68u
    I_MXI64_MN2 (XI64_n1 B_0 b2_0 VSS) gpdk090_nmos1v w=0.24u l=0.1u ad=0.0528p as=0.0528p pd=0.68u ps=0.68u
    I_MXI64_MN3 (VSS qu6 XI64_n1 VSS) gpdk090_nmos1v w=0.24u l=0.1u ad=0.0816p as=0.0528p pd=1.16u ps=0.68u
    I_MXI64_MN0 (XI64_An B_0 VSS VSS) gpdk090_nmos1v w=0.12u l=0.1u ad=0.0696p as=0.0696p pd=1.16u ps=1.16u
    I_MXI77_MN1 (XI77_Bn qu5 VSS VSS) gpdk090_nmos1v w=0.12u l=0.1u ad=0.0696p as=0.0696p pd=1.16u ps=1.16u
    I_MXI77_MN5 (XI77_n2 XI77_Bn VSS VSS) gpdk090_nmos1v w=0.24u l=0.1u ad=0.0528p as=0.0816p pd=0.68u ps=1.16u
    I_MXI77_MN4 (b3_1 XI77_An XI77_n2 VSS) gpdk090_nmos1v w=0.24u l=0.1u ad=0.0528p as=0.0528p pd=0.68u ps=0.68u
    I_MXI77_MN2 (XI77_n1 dd1 b3_1 VSS) gpdk090_nmos1v w=0.24u l=0.1u ad=0.0528p as=0.0528p pd=0.68u ps=0.68u
    I_MXI77_MN3 (VSS qu5 XI77_n1 VSS) gpdk090_nmos1v w=0.24u l=0.1u ad=0.0816p as=0.0528p pd=1.16u ps=0.68u
    I_MXI77_MN0 (XI77_An dd1 VSS VSS) gpdk090_nmos1v w=0.12u l=0.1u ad=0.0696p as=0.0696p pd=1.16u ps=1.16u
    I_MXI152_I40_MN1 (XI152_I40_Bn I152_G2_0n VSS VSS) gpdk090_nmos1v w=0.12u l=0.1u ad=0.0696p as=0.0696p pd=1.16u ps=1.16u
    I_MXI152_I40_MN5 (XI152_I40_n2 XI152_I40_Bn VSS VSS) gpdk090_nmos1v w=0.24u l=0.1u ad=0.0528p as=0.0816p pd=0.68u ps=1.16u
    I_MXI152_I40_MN4 (ru3 XI152_I40_An XI152_I40_n2 VSS) gpdk090_nmos1v w=0.24u l=0.1u ad=0.0528p as=0.0528p pd=0.68u ps=0.68u
    I_MXI152_I40_MN2 (XI152_I40_n1 I152_pn3 ru3 VSS) gpdk090_nmos1v w=0.24u l=0.1u ad=0.0528p as=0.0528p pd=0.68u ps=0.68u
    I_MXI152_I40_MN3 (VSS I152_G2_0n XI152_I40_n1 VSS) gpdk090_nmos1v w=0.24u l=0.1u ad=0.0816p as=0.0528p pd=1.16u ps=0.68u
    I_MXI152_I40_MN0 (XI152_I40_An I152_pn3 VSS VSS) gpdk090_nmos1v w=0.12u l=0.1u ad=0.0696p as=0.0696p pd=1.16u ps=1.16u
    I_MXI40_MN1 (XI40_Bn VDD VSS VSS) gpdk090_nmos1v w=0.12u l=0.1u ad=0.0696p as=0.0696p pd=1.16u ps=1.16u
    I_MXI40_MN5 (XI40_n2 XI40_Bn VSS VSS) gpdk090_nmos1v w=0.24u l=0.1u ad=0.0528p as=0.0816p pd=0.68u ps=1.16u
    I_MXI40_MN4 (b0_0 XI40_An XI40_n2 VSS) gpdk090_nmos1v w=0.24u l=0.1u ad=0.0528p as=0.0528p pd=0.68u ps=0.68u
    I_MXI40_MN2 (XI40_n1 B_0 b0_0 VSS) gpdk090_nmos1v w=0.24u l=0.1u ad=0.0528p as=0.0528p pd=0.68u ps=0.68u
    I_MXI40_MN3 (VSS VDD XI40_n1 VSS) gpdk090_nmos1v w=0.24u l=0.1u ad=0.0816p as=0.0528p pd=1.16u ps=0.68u
    I_MXI40_MN0 (XI40_An B_0 VSS VSS) gpdk090_nmos1v w=0.12u l=0.1u ad=0.0696p as=0.0696p pd=1.16u ps=1.16u
    I_MXI52_MN1 (XI52_Bn qu7 VSS VSS) gpdk090_nmos1v w=0.12u l=0.1u ad=0.0696p as=0.0696p pd=1.16u ps=1.16u
    I_MXI52_MN5 (XI52_n2 XI52_Bn VSS VSS) gpdk090_nmos1v w=0.24u l=0.1u ad=0.0528p as=0.0816p pd=0.68u ps=1.16u
    I_MXI52_MN4 (b1_0 XI52_An XI52_n2 VSS) gpdk090_nmos1v w=0.24u l=0.1u ad=0.0528p as=0.0528p pd=0.68u ps=0.68u
    I_MXI52_MN2 (XI52_n1 B_0 b1_0 VSS) gpdk090_nmos1v w=0.24u l=0.1u ad=0.0528p as=0.0528p pd=0.68u ps=0.68u
    I_MXI52_MN3 (VSS qu7 XI52_n1 VSS) gpdk090_nmos1v w=0.24u l=0.1u ad=0.0816p as=0.0528p pd=1.16u ps=0.68u
    I_MXI52_MN0 (XI52_An B_0 VSS VSS) gpdk090_nmos1v w=0.12u l=0.1u ad=0.0696p as=0.0696p pd=1.16u ps=1.16u
    I_MXI78_MN1 (XI78_Bn qu5 VSS VSS) gpdk090_nmos1v w=0.12u l=0.1u ad=0.0696p as=0.0696p pd=1.16u ps=1.16u
    I_MXI78_MN5 (XI78_n2 XI78_Bn VSS VSS) gpdk090_nmos1v w=0.24u l=0.1u ad=0.0528p as=0.0816p pd=0.68u ps=1.16u
    I_MXI78_MN4 (b3_2 XI78_An XI78_n2 VSS) gpdk090_nmos1v w=0.24u l=0.1u ad=0.0528p as=0.0528p pd=0.68u ps=0.68u
    I_MXI78_MN2 (XI78_n1 dd2 b3_2 VSS) gpdk090_nmos1v w=0.24u l=0.1u ad=0.0528p as=0.0528p pd=0.68u ps=0.68u
    I_MXI78_MN3 (VSS qu5 XI78_n1 VSS) gpdk090_nmos1v w=0.24u l=0.1u ad=0.0816p as=0.0528p pd=1.16u ps=0.68u
    I_MXI78_MN0 (XI78_An dd2 VSS VSS) gpdk090_nmos1v w=0.12u l=0.1u ad=0.0696p as=0.0696p pd=1.16u ps=1.16u
    I_MXI84_I41_MN1 (XI84_I41_Bn I84_G3_0n VSS VSS) gpdk090_nmos1v w=0.12u l=0.1u ad=0.0696p as=0.0696p pd=1.16u ps=1.16u
    I_MXI84_I41_MN5 (XI84_I41_n2 XI84_I41_Bn VSS VSS) gpdk090_nmos1v w=0.24u l=0.1u ad=0.0528p as=0.0816p pd=0.68u ps=1.16u
    I_MXI84_I41_MN4 (p3_4 XI84_I41_An XI84_I41_n2 VSS) gpdk090_nmos1v w=0.24u l=0.1u ad=0.0528p as=0.0528p pd=0.68u ps=0.68u
    I_MXI84_I41_MN2 (XI84_I41_n1 I84_pn4 p3_4 VSS) gpdk090_nmos1v w=0.24u l=0.1u ad=0.0528p as=0.0528p pd=0.68u ps=0.68u
    I_MXI84_I41_MN3 (VSS I84_G3_0n XI84_I41_n1 VSS) gpdk090_nmos1v w=0.24u l=0.1u ad=0.0816p as=0.0528p pd=1.16u ps=0.68u
    I_MXI84_I41_MN0 (XI84_I41_An I84_pn4 VSS VSS) gpdk090_nmos1v w=0.12u l=0.1u ad=0.0696p as=0.0696p pd=1.16u ps=1.16u
    I_MXI43_MN1 (XI43_Bn VDD VSS VSS) gpdk090_nmos1v w=0.12u l=0.1u ad=0.0696p as=0.0696p pd=1.16u ps=1.16u
    I_MXI43_MN5 (XI43_n2 XI43_Bn VSS VSS) gpdk090_nmos1v w=0.24u l=0.1u ad=0.0528p as=0.0816p pd=0.68u ps=1.16u
    I_MXI43_MN4 (b0_3 XI43_An XI43_n2 VSS) gpdk090_nmos1v w=0.24u l=0.1u ad=0.0528p as=0.0528p pd=0.68u ps=0.68u
    I_MXI43_MN2 (XI43_n1 dd3 b0_3 VSS) gpdk090_nmos1v w=0.24u l=0.1u ad=0.0528p as=0.0528p pd=0.68u ps=0.68u
    I_MXI43_MN3 (VSS VDD XI43_n1 VSS) gpdk090_nmos1v w=0.24u l=0.1u ad=0.0816p as=0.0528p pd=1.16u ps=0.68u
    I_MXI43_MN0 (XI43_An dd3 VSS VSS) gpdk090_nmos1v w=0.12u l=0.1u ad=0.0696p as=0.0696p pd=1.16u ps=1.16u
    I_MXI42_MN1 (XI42_Bn VDD VSS VSS) gpdk090_nmos1v w=0.12u l=0.1u ad=0.0696p as=0.0696p pd=1.16u ps=1.16u
    I_MXI42_MN5 (XI42_n2 XI42_Bn VSS VSS) gpdk090_nmos1v w=0.24u l=0.1u ad=0.0528p as=0.0816p pd=0.68u ps=1.16u
    I_MXI42_MN4 (b0_2 XI42_An XI42_n2 VSS) gpdk090_nmos1v w=0.24u l=0.1u ad=0.0528p as=0.0528p pd=0.68u ps=0.68u
    I_MXI42_MN2 (XI42_n1 dd2 b0_2 VSS) gpdk090_nmos1v w=0.24u l=0.1u ad=0.0528p as=0.0528p pd=0.68u ps=0.68u
    I_MXI42_MN3 (VSS VDD XI42_n1 VSS) gpdk090_nmos1v w=0.24u l=0.1u ad=0.0816p as=0.0528p pd=1.16u ps=0.68u
    I_MXI42_MN0 (XI42_An dd2 VSS VSS) gpdk090_nmos1v w=0.12u l=0.1u ad=0.0696p as=0.0696p pd=1.16u ps=1.16u
    I_MXI41_MN1 (XI41_Bn VDD VSS VSS) gpdk090_nmos1v w=0.12u l=0.1u ad=0.0696p as=0.0696p pd=1.16u ps=1.16u
    I_MXI41_MN5 (XI41_n2 XI41_Bn VSS VSS) gpdk090_nmos1v w=0.24u l=0.1u ad=0.0528p as=0.0816p pd=0.68u ps=1.16u
    I_MXI41_MN4 (b0_1 XI41_An XI41_n2 VSS) gpdk090_nmos1v w=0.24u l=0.1u ad=0.0528p as=0.0528p pd=0.68u ps=0.68u
    I_MXI41_MN2 (XI41_n1 dd1 b0_1 VSS) gpdk090_nmos1v w=0.24u l=0.1u ad=0.0528p as=0.0528p pd=0.68u ps=0.68u
    I_MXI41_MN3 (VSS VDD XI41_n1 VSS) gpdk090_nmos1v w=0.24u l=0.1u ad=0.0816p as=0.0528p pd=1.16u ps=0.68u
    I_MXI41_MN0 (XI41_An dd1 VSS VSS) gpdk090_nmos1v w=0.12u l=0.1u ad=0.0696p as=0.0696p pd=1.16u ps=1.16u
    I_MXI53_MN1 (XI53_Bn qu7 VSS VSS) gpdk090_nmos1v w=0.12u l=0.1u ad=0.0696p as=0.0696p pd=1.16u ps=1.16u
    I_MXI53_MN5 (XI53_n2 XI53_Bn VSS VSS) gpdk090_nmos1v w=0.24u l=0.1u ad=0.0528p as=0.0816p pd=0.68u ps=1.16u
    I_MXI53_MN4 (b1_1 XI53_An XI53_n2 VSS) gpdk090_nmos1v w=0.24u l=0.1u ad=0.0528p as=0.0528p pd=0.68u ps=0.68u
    I_MXI53_MN2 (XI53_n1 dd1 b1_1 VSS) gpdk090_nmos1v w=0.24u l=0.1u ad=0.0528p as=0.0528p pd=0.68u ps=0.68u
    I_MXI53_MN3 (VSS qu7 XI53_n1 VSS) gpdk090_nmos1v w=0.24u l=0.1u ad=0.0816p as=0.0528p pd=1.16u ps=0.68u
    I_MXI53_MN0 (XI53_An dd1 VSS VSS) gpdk090_nmos1v w=0.12u l=0.1u ad=0.0696p as=0.0696p pd=1.16u ps=1.16u
    I_MXI65_MN1 (XI65_Bn qu6 VSS VSS) gpdk090_nmos1v w=0.12u l=0.1u ad=0.0696p as=0.0696p pd=1.16u ps=1.16u
    I_MXI65_MN5 (XI65_n2 XI65_Bn VSS VSS) gpdk090_nmos1v w=0.24u l=0.1u ad=0.0528p as=0.0816p pd=0.68u ps=1.16u
    I_MXI65_MN4 (b2_1 XI65_An XI65_n2 VSS) gpdk090_nmos1v w=0.24u l=0.1u ad=0.0528p as=0.0528p pd=0.68u ps=0.68u
    I_MXI65_MN2 (XI65_n1 dd1 b2_1 VSS) gpdk090_nmos1v w=0.24u l=0.1u ad=0.0528p as=0.0528p pd=0.68u ps=0.68u
    I_MXI65_MN3 (VSS qu6 XI65_n1 VSS) gpdk090_nmos1v w=0.24u l=0.1u ad=0.0816p as=0.0528p pd=1.16u ps=0.68u
    I_MXI65_MN0 (XI65_An dd1 VSS VSS) gpdk090_nmos1v w=0.12u l=0.1u ad=0.0696p as=0.0696p pd=1.16u ps=1.16u
    I_MXI79_MN1 (XI79_Bn qu5 VSS VSS) gpdk090_nmos1v w=0.12u l=0.1u ad=0.0696p as=0.0696p pd=1.16u ps=1.16u
    I_MXI79_MN5 (XI79_n2 XI79_Bn VSS VSS) gpdk090_nmos1v w=0.24u l=0.1u ad=0.0528p as=0.0816p pd=0.68u ps=1.16u
    I_MXI79_MN4 (b3_3 XI79_An XI79_n2 VSS) gpdk090_nmos1v w=0.24u l=0.1u ad=0.0528p as=0.0528p pd=0.68u ps=0.68u
    I_MXI79_MN2 (XI79_n1 dd3 b3_3 VSS) gpdk090_nmos1v w=0.24u l=0.1u ad=0.0528p as=0.0528p pd=0.68u ps=0.68u
    I_MXI79_MN3 (VSS qu5 XI79_n1 VSS) gpdk090_nmos1v w=0.24u l=0.1u ad=0.0816p as=0.0528p pd=1.16u ps=0.68u
    I_MXI79_MN0 (XI79_An dd3 VSS VSS) gpdk090_nmos1v w=0.12u l=0.1u ad=0.0696p as=0.0696p pd=1.16u ps=1.16u
    I_MXI80_MN1 (XI80_Bn qu5 VSS VSS) gpdk090_nmos1v w=0.12u l=0.1u ad=0.0696p as=0.0696p pd=1.16u ps=1.16u
    I_MXI80_MN5 (XI80_n2 XI80_Bn VSS VSS) gpdk090_nmos1v w=0.24u l=0.1u ad=0.0528p as=0.0816p pd=0.68u ps=1.16u
    I_MXI80_MN4 (b3_4 XI80_An XI80_n2 VSS) gpdk090_nmos1v w=0.24u l=0.1u ad=0.0528p as=0.0528p pd=0.68u ps=0.68u
    I_MXI80_MN2 (XI80_n1 dd4 b3_4 VSS) gpdk090_nmos1v w=0.24u l=0.1u ad=0.0528p as=0.0528p pd=0.68u ps=0.68u
    I_MXI80_MN3 (VSS qu5 XI80_n1 VSS) gpdk090_nmos1v w=0.24u l=0.1u ad=0.0816p as=0.0528p pd=1.16u ps=0.68u
    I_MXI80_MN0 (XI80_An dd4 VSS VSS) gpdk090_nmos1v w=0.12u l=0.1u ad=0.0696p as=0.0696p pd=1.16u ps=1.16u
    I_MXI44_MN1 (XI44_Bn VDD VSS VSS) gpdk090_nmos1v w=0.12u l=0.1u ad=0.0696p as=0.0696p pd=1.16u ps=1.16u
    I_MXI44_MN5 (XI44_n2 XI44_Bn VSS VSS) gpdk090_nmos1v w=0.24u l=0.1u ad=0.0528p as=0.0816p pd=0.68u ps=1.16u
    I_MXI44_MN4 (b0_4 XI44_An XI44_n2 VSS) gpdk090_nmos1v w=0.24u l=0.1u ad=0.0528p as=0.0528p pd=0.68u ps=0.68u
    I_MXI44_MN2 (XI44_n1 dd4 b0_4 VSS) gpdk090_nmos1v w=0.24u l=0.1u ad=0.0528p as=0.0528p pd=0.68u ps=0.68u
    I_MXI44_MN3 (VSS VDD XI44_n1 VSS) gpdk090_nmos1v w=0.24u l=0.1u ad=0.0816p as=0.0528p pd=1.16u ps=0.68u
    I_MXI44_MN0 (XI44_An dd4 VSS VSS) gpdk090_nmos1v w=0.12u l=0.1u ad=0.0696p as=0.0696p pd=1.16u ps=1.16u
    I_MXI55_MN1 (XI55_Bn qu7 VSS VSS) gpdk090_nmos1v w=0.12u l=0.1u ad=0.0696p as=0.0696p pd=1.16u ps=1.16u
    I_MXI55_MN5 (XI55_n2 XI55_Bn VSS VSS) gpdk090_nmos1v w=0.24u l=0.1u ad=0.0528p as=0.0816p pd=0.68u ps=1.16u
    I_MXI55_MN4 (b1_3 XI55_An XI55_n2 VSS) gpdk090_nmos1v w=0.24u l=0.1u ad=0.0528p as=0.0528p pd=0.68u ps=0.68u
    I_MXI55_MN2 (XI55_n1 dd3 b1_3 VSS) gpdk090_nmos1v w=0.24u l=0.1u ad=0.0528p as=0.0528p pd=0.68u ps=0.68u
    I_MXI55_MN3 (VSS qu7 XI55_n1 VSS) gpdk090_nmos1v w=0.24u l=0.1u ad=0.0816p as=0.0528p pd=1.16u ps=0.68u
    I_MXI55_MN0 (XI55_An dd3 VSS VSS) gpdk090_nmos1v w=0.12u l=0.1u ad=0.0696p as=0.0696p pd=1.16u ps=1.16u
    I_MXI54_MN1 (XI54_Bn qu7 VSS VSS) gpdk090_nmos1v w=0.12u l=0.1u ad=0.0696p as=0.0696p pd=1.16u ps=1.16u
    I_MXI54_MN5 (XI54_n2 XI54_Bn VSS VSS) gpdk090_nmos1v w=0.24u l=0.1u ad=0.0528p as=0.0816p pd=0.68u ps=1.16u
    I_MXI54_MN4 (b1_2 XI54_An XI54_n2 VSS) gpdk090_nmos1v w=0.24u l=0.1u ad=0.0528p as=0.0528p pd=0.68u ps=0.68u
    I_MXI54_MN2 (XI54_n1 dd2 b1_2 VSS) gpdk090_nmos1v w=0.24u l=0.1u ad=0.0528p as=0.0528p pd=0.68u ps=0.68u
    I_MXI54_MN3 (VSS qu7 XI54_n1 VSS) gpdk090_nmos1v w=0.24u l=0.1u ad=0.0816p as=0.0528p pd=1.16u ps=0.68u
    I_MXI54_MN0 (XI54_An dd2 VSS VSS) gpdk090_nmos1v w=0.12u l=0.1u ad=0.0696p as=0.0696p pd=1.16u ps=1.16u
    I_MXI67_MN1 (XI67_Bn qu6 VSS VSS) gpdk090_nmos1v w=0.12u l=0.1u ad=0.0696p as=0.0696p pd=1.16u ps=1.16u
    I_MXI67_MN5 (XI67_n2 XI67_Bn VSS VSS) gpdk090_nmos1v w=0.24u l=0.1u ad=0.0528p as=0.0816p pd=0.68u ps=1.16u
    I_MXI67_MN4 (b2_3 XI67_An XI67_n2 VSS) gpdk090_nmos1v w=0.24u l=0.1u ad=0.0528p as=0.0528p pd=0.68u ps=0.68u
    I_MXI67_MN2 (XI67_n1 dd3 b2_3 VSS) gpdk090_nmos1v w=0.24u l=0.1u ad=0.0528p as=0.0528p pd=0.68u ps=0.68u
    I_MXI67_MN3 (VSS qu6 XI67_n1 VSS) gpdk090_nmos1v w=0.24u l=0.1u ad=0.0816p as=0.0528p pd=1.16u ps=0.68u
    I_MXI67_MN0 (XI67_An dd3 VSS VSS) gpdk090_nmos1v w=0.12u l=0.1u ad=0.0696p as=0.0696p pd=1.16u ps=1.16u
    I_MXI66_MN1 (XI66_Bn qu6 VSS VSS) gpdk090_nmos1v w=0.12u l=0.1u ad=0.0696p as=0.0696p pd=1.16u ps=1.16u
    I_MXI66_MN5 (XI66_n2 XI66_Bn VSS VSS) gpdk090_nmos1v w=0.24u l=0.1u ad=0.0528p as=0.0816p pd=0.68u ps=1.16u
    I_MXI66_MN4 (b2_2 XI66_An XI66_n2 VSS) gpdk090_nmos1v w=0.24u l=0.1u ad=0.0528p as=0.0528p pd=0.68u ps=0.68u
    I_MXI66_MN2 (XI66_n1 dd2 b2_2 VSS) gpdk090_nmos1v w=0.24u l=0.1u ad=0.0528p as=0.0528p pd=0.68u ps=0.68u
    I_MXI66_MN3 (VSS qu6 XI66_n1 VSS) gpdk090_nmos1v w=0.24u l=0.1u ad=0.0816p as=0.0528p pd=1.16u ps=0.68u
    I_MXI66_MN0 (XI66_An dd2 VSS VSS) gpdk090_nmos1v w=0.12u l=0.1u ad=0.0696p as=0.0696p pd=1.16u ps=1.16u
    I_MXI72_I40_MN1 (XI72_I40_Bn I72_G2_0n VSS VSS) gpdk090_nmos1v w=0.12u l=0.1u ad=0.0696p as=0.0696p pd=1.16u ps=1.16u
    I_MXI72_I40_MN5 (XI72_I40_n2 XI72_I40_Bn VSS VSS) gpdk090_nmos1v w=0.24u l=0.1u ad=0.0528p as=0.0816p pd=0.68u ps=1.16u
    I_MXI72_I40_MN4 (p2_3 XI72_I40_An XI72_I40_n2 VSS) gpdk090_nmos1v w=0.24u l=0.1u ad=0.0528p as=0.0528p pd=0.68u ps=0.68u
    I_MXI72_I40_MN2 (XI72_I40_n1 I72_pn3 p2_3 VSS) gpdk090_nmos1v w=0.24u l=0.1u ad=0.0528p as=0.0528p pd=0.68u ps=0.68u
    I_MXI72_I40_MN3 (VSS I72_G2_0n XI72_I40_n1 VSS) gpdk090_nmos1v w=0.24u l=0.1u ad=0.0816p as=0.0528p pd=1.16u ps=0.68u
    I_MXI72_I40_MN0 (XI72_I40_An I72_pn3 VSS VSS) gpdk090_nmos1v w=0.12u l=0.1u ad=0.0696p as=0.0696p pd=1.16u ps=1.16u
    I_MXI81_MN1 (XI81_Bn qu5 VSS VSS) gpdk090_nmos1v w=0.12u l=0.1u ad=0.0696p as=0.0696p pd=1.16u ps=1.16u
    I_MXI81_MN5 (XI81_n2 XI81_Bn VSS VSS) gpdk090_nmos1v w=0.24u l=0.1u ad=0.0528p as=0.0816p pd=0.68u ps=1.16u
    I_MXI81_MN4 (b3_5 XI81_An XI81_n2 VSS) gpdk090_nmos1v w=0.24u l=0.1u ad=0.0528p as=0.0528p pd=0.68u ps=0.68u
    I_MXI81_MN2 (XI81_n1 dd5 b3_5 VSS) gpdk090_nmos1v w=0.24u l=0.1u ad=0.0528p as=0.0528p pd=0.68u ps=0.68u
    I_MXI81_MN3 (VSS qu5 XI81_n1 VSS) gpdk090_nmos1v w=0.24u l=0.1u ad=0.0816p as=0.0528p pd=1.16u ps=0.68u
    I_MXI81_MN0 (XI81_An dd5 VSS VSS) gpdk090_nmos1v w=0.12u l=0.1u ad=0.0696p as=0.0696p pd=1.16u ps=1.16u
    I_MXI86_MN1 (XI86_Bn c3_8 VSS VSS) gpdk090_nmos1v w=0.12u l=0.1u ad=0.0696p as=0.0696p pd=1.16u ps=1.16u
    I_MXI86_MN5 (XI86_n2 XI86_Bn VSS VSS) gpdk090_nmos1v w=0.24u l=0.1u ad=0.0528p as=0.0816p pd=0.68u ps=1.16u
    I_MXI86_MN4 (p3_8 XI86_An XI86_n2 VSS) gpdk090_nmos1v w=0.24u l=0.1u ad=0.0528p as=0.0528p pd=0.68u ps=0.68u
    I_MXI86_MN2 (XI86_n1 h3 p3_8 VSS) gpdk090_nmos1v w=0.24u l=0.1u ad=0.0528p as=0.0528p pd=0.68u ps=0.68u
    I_MXI86_MN3 (VSS c3_8 XI86_n1 VSS) gpdk090_nmos1v w=0.24u l=0.1u ad=0.0816p as=0.0528p pd=1.16u ps=0.68u
    I_MXI86_MN0 (XI86_An h3 VSS VSS) gpdk090_nmos1v w=0.12u l=0.1u ad=0.0696p as=0.0696p pd=1.16u ps=1.16u
    I_MXI45_MN1 (XI45_Bn VDD VSS VSS) gpdk090_nmos1v w=0.12u l=0.1u ad=0.0696p as=0.0696p pd=1.16u ps=1.16u
    I_MXI45_MN5 (XI45_n2 XI45_Bn VSS VSS) gpdk090_nmos1v w=0.24u l=0.1u ad=0.0528p as=0.0816p pd=0.68u ps=1.16u
    I_MXI45_MN4 (b0_5 XI45_An XI45_n2 VSS) gpdk090_nmos1v w=0.24u l=0.1u ad=0.0528p as=0.0528p pd=0.68u ps=0.68u
    I_MXI45_MN2 (XI45_n1 dd5 b0_5 VSS) gpdk090_nmos1v w=0.24u l=0.1u ad=0.0528p as=0.0528p pd=0.68u ps=0.68u
    I_MXI45_MN3 (VSS VDD XI45_n1 VSS) gpdk090_nmos1v w=0.24u l=0.1u ad=0.0816p as=0.0528p pd=1.16u ps=0.68u
    I_MXI45_MN0 (XI45_An dd5 VSS VSS) gpdk090_nmos1v w=0.12u l=0.1u ad=0.0696p as=0.0696p pd=1.16u ps=1.16u
    I_MXI56_MN1 (XI56_Bn qu7 VSS VSS) gpdk090_nmos1v w=0.12u l=0.1u ad=0.0696p as=0.0696p pd=1.16u ps=1.16u
    I_MXI56_MN5 (XI56_n2 XI56_Bn VSS VSS) gpdk090_nmos1v w=0.24u l=0.1u ad=0.0528p as=0.0816p pd=0.68u ps=1.16u
    I_MXI56_MN4 (b1_4 XI56_An XI56_n2 VSS) gpdk090_nmos1v w=0.24u l=0.1u ad=0.0528p as=0.0528p pd=0.68u ps=0.68u
    I_MXI56_MN2 (XI56_n1 dd4 b1_4 VSS) gpdk090_nmos1v w=0.24u l=0.1u ad=0.0528p as=0.0528p pd=0.68u ps=0.68u
    I_MXI56_MN3 (VSS qu7 XI56_n1 VSS) gpdk090_nmos1v w=0.24u l=0.1u ad=0.0816p as=0.0528p pd=1.16u ps=0.68u
    I_MXI56_MN0 (XI56_An dd4 VSS VSS) gpdk090_nmos1v w=0.12u l=0.1u ad=0.0696p as=0.0696p pd=1.16u ps=1.16u
    I_MXI68_MN1 (XI68_Bn qu6 VSS VSS) gpdk090_nmos1v w=0.12u l=0.1u ad=0.0696p as=0.0696p pd=1.16u ps=1.16u
    I_MXI68_MN5 (XI68_n2 XI68_Bn VSS VSS) gpdk090_nmos1v w=0.24u l=0.1u ad=0.0528p as=0.0816p pd=0.68u ps=1.16u
    I_MXI68_MN4 (b2_4 XI68_An XI68_n2 VSS) gpdk090_nmos1v w=0.24u l=0.1u ad=0.0528p as=0.0528p pd=0.68u ps=0.68u
    I_MXI68_MN2 (XI68_n1 dd4 b2_4 VSS) gpdk090_nmos1v w=0.24u l=0.1u ad=0.0528p as=0.0528p pd=0.68u ps=0.68u
    I_MXI68_MN3 (VSS qu6 XI68_n1 VSS) gpdk090_nmos1v w=0.24u l=0.1u ad=0.0816p as=0.0528p pd=1.16u ps=0.68u
    I_MXI68_MN0 (XI68_An dd4 VSS VSS) gpdk090_nmos1v w=0.12u l=0.1u ad=0.0696p as=0.0696p pd=1.16u ps=1.16u
    I_MXI72_I41_MN1 (XI72_I41_Bn I72_G3_0n VSS VSS) gpdk090_nmos1v w=0.12u l=0.1u ad=0.0696p as=0.0696p pd=1.16u ps=1.16u
    I_MXI72_I41_MN5 (XI72_I41_n2 XI72_I41_Bn VSS VSS) gpdk090_nmos1v w=0.24u l=0.1u ad=0.0528p as=0.0816p pd=0.68u ps=1.16u
    I_MXI72_I41_MN4 (p2_4 XI72_I41_An XI72_I41_n2 VSS) gpdk090_nmos1v w=0.24u l=0.1u ad=0.0528p as=0.0528p pd=0.68u ps=0.68u
    I_MXI72_I41_MN2 (XI72_I41_n1 I72_pn4 p2_4 VSS) gpdk090_nmos1v w=0.24u l=0.1u ad=0.0528p as=0.0528p pd=0.68u ps=0.68u
    I_MXI72_I41_MN3 (VSS I72_G3_0n XI72_I41_n1 VSS) gpdk090_nmos1v w=0.24u l=0.1u ad=0.0816p as=0.0528p pd=1.16u ps=0.68u
    I_MXI72_I41_MN0 (XI72_I41_An I72_pn4 VSS VSS) gpdk090_nmos1v w=0.12u l=0.1u ad=0.0696p as=0.0696p pd=1.16u ps=1.16u
    I_MXI82_MN1 (XI82_Bn qu5 VSS VSS) gpdk090_nmos1v w=0.12u l=0.1u ad=0.0696p as=0.0696p pd=1.16u ps=1.16u
    I_MXI82_MN5 (XI82_n2 XI82_Bn VSS VSS) gpdk090_nmos1v w=0.24u l=0.1u ad=0.0528p as=0.0816p pd=0.68u ps=1.16u
    I_MXI82_MN4 (b3_6 XI82_An XI82_n2 VSS) gpdk090_nmos1v w=0.24u l=0.1u ad=0.0528p as=0.0528p pd=0.68u ps=0.68u
    I_MXI82_MN2 (XI82_n1 dd6 b3_6 VSS) gpdk090_nmos1v w=0.24u l=0.1u ad=0.0528p as=0.0528p pd=0.68u ps=0.68u
    I_MXI82_MN3 (VSS qu5 XI82_n1 VSS) gpdk090_nmos1v w=0.24u l=0.1u ad=0.0816p as=0.0528p pd=1.16u ps=0.68u
    I_MXI82_MN0 (XI82_An dd6 VSS VSS) gpdk090_nmos1v w=0.12u l=0.1u ad=0.0696p as=0.0696p pd=1.16u ps=1.16u
    I_MXI48_I40_MN1 (XI48_I40_Bn I48_G2_0n VSS VSS) gpdk090_nmos1v w=0.12u l=0.1u ad=0.0696p as=0.0696p pd=1.16u ps=1.16u
    I_MXI48_I40_MN5 (XI48_I40_n2 XI48_I40_Bn VSS VSS) gpdk090_nmos1v w=0.24u l=0.1u ad=0.0528p as=0.0816p pd=0.68u ps=1.16u
    I_MXI48_I40_MN4 (p0_3 XI48_I40_An XI48_I40_n2 VSS) gpdk090_nmos1v w=0.24u l=0.1u ad=0.0528p as=0.0528p pd=0.68u ps=0.68u
    I_MXI48_I40_MN2 (XI48_I40_n1 I48_pn3 p0_3 VSS) gpdk090_nmos1v w=0.24u l=0.1u ad=0.0528p as=0.0528p pd=0.68u ps=0.68u
    I_MXI48_I40_MN3 (VSS I48_G2_0n XI48_I40_n1 VSS) gpdk090_nmos1v w=0.24u l=0.1u ad=0.0816p as=0.0528p pd=1.16u ps=0.68u
    I_MXI48_I40_MN0 (XI48_I40_An I48_pn3 VSS VSS) gpdk090_nmos1v w=0.12u l=0.1u ad=0.0696p as=0.0696p pd=1.16u ps=1.16u
    I_MXI57_MN1 (XI57_Bn qu7 VSS VSS) gpdk090_nmos1v w=0.12u l=0.1u ad=0.0696p as=0.0696p pd=1.16u ps=1.16u
    I_MXI57_MN5 (XI57_n2 XI57_Bn VSS VSS) gpdk090_nmos1v w=0.24u l=0.1u ad=0.0528p as=0.0816p pd=0.68u ps=1.16u
    I_MXI57_MN4 (b1_5 XI57_An XI57_n2 VSS) gpdk090_nmos1v w=0.24u l=0.1u ad=0.0528p as=0.0528p pd=0.68u ps=0.68u
    I_MXI57_MN2 (XI57_n1 dd5 b1_5 VSS) gpdk090_nmos1v w=0.24u l=0.1u ad=0.0528p as=0.0528p pd=0.68u ps=0.68u
    I_MXI57_MN3 (VSS qu7 XI57_n1 VSS) gpdk090_nmos1v w=0.24u l=0.1u ad=0.0816p as=0.0528p pd=1.16u ps=0.68u
    I_MXI57_MN0 (XI57_An dd5 VSS VSS) gpdk090_nmos1v w=0.12u l=0.1u ad=0.0696p as=0.0696p pd=1.16u ps=1.16u
    I_MXI60_I40_MN1 (XI60_I40_Bn I60_G2_0n VSS VSS) gpdk090_nmos1v w=0.12u l=0.1u ad=0.0696p as=0.0696p pd=1.16u ps=1.16u
    I_MXI60_I40_MN5 (XI60_I40_n2 XI60_I40_Bn VSS VSS) gpdk090_nmos1v w=0.24u l=0.1u ad=0.0528p as=0.0816p pd=0.68u ps=1.16u
    I_MXI60_I40_MN4 (p1_3 XI60_I40_An XI60_I40_n2 VSS) gpdk090_nmos1v w=0.24u l=0.1u ad=0.0528p as=0.0528p pd=0.68u ps=0.68u
    I_MXI60_I40_MN2 (XI60_I40_n1 I60_pn3 p1_3 VSS) gpdk090_nmos1v w=0.24u l=0.1u ad=0.0528p as=0.0528p pd=0.68u ps=0.68u
    I_MXI60_I40_MN3 (VSS I60_G2_0n XI60_I40_n1 VSS) gpdk090_nmos1v w=0.24u l=0.1u ad=0.0816p as=0.0528p pd=1.16u ps=0.68u
    I_MXI60_I40_MN0 (XI60_I40_An I60_pn3 VSS VSS) gpdk090_nmos1v w=0.12u l=0.1u ad=0.0696p as=0.0696p pd=1.16u ps=1.16u
    I_MXI69_MN1 (XI69_Bn qu6 VSS VSS) gpdk090_nmos1v w=0.12u l=0.1u ad=0.0696p as=0.0696p pd=1.16u ps=1.16u
    I_MXI69_MN5 (XI69_n2 XI69_Bn VSS VSS) gpdk090_nmos1v w=0.24u l=0.1u ad=0.0528p as=0.0816p pd=0.68u ps=1.16u
    I_MXI69_MN4 (b2_5 XI69_An XI69_n2 VSS) gpdk090_nmos1v w=0.24u l=0.1u ad=0.0528p as=0.0528p pd=0.68u ps=0.68u
    I_MXI69_MN2 (XI69_n1 dd5 b2_5 VSS) gpdk090_nmos1v w=0.24u l=0.1u ad=0.0528p as=0.0528p pd=0.68u ps=0.68u
    I_MXI69_MN3 (VSS qu6 XI69_n1 VSS) gpdk090_nmos1v w=0.24u l=0.1u ad=0.0816p as=0.0528p pd=1.16u ps=0.68u
    I_MXI69_MN0 (XI69_An dd5 VSS VSS) gpdk090_nmos1v w=0.12u l=0.1u ad=0.0696p as=0.0696p pd=1.16u ps=1.16u
    I_MXI83_MN1 (XI83_Bn qu5 VSS VSS) gpdk090_nmos1v w=0.12u l=0.1u ad=0.0696p as=0.0696p pd=1.16u ps=1.16u
    I_MXI83_MN5 (XI83_n2 XI83_Bn VSS VSS) gpdk090_nmos1v w=0.24u l=0.1u ad=0.0528p as=0.0816p pd=0.68u ps=1.16u
    I_MXI83_MN4 (b3_7 XI83_An XI83_n2 VSS) gpdk090_nmos1v w=0.24u l=0.1u ad=0.0528p as=0.0528p pd=0.68u ps=0.68u
    I_MXI83_MN2 (XI83_n1 dd7 b3_7 VSS) gpdk090_nmos1v w=0.24u l=0.1u ad=0.0528p as=0.0528p pd=0.68u ps=0.68u
    I_MXI83_MN3 (VSS qu5 XI83_n1 VSS) gpdk090_nmos1v w=0.24u l=0.1u ad=0.0816p as=0.0528p pd=1.16u ps=0.68u
    I_MXI83_MN0 (XI83_An dd7 VSS VSS) gpdk090_nmos1v w=0.12u l=0.1u ad=0.0696p as=0.0696p pd=1.16u ps=1.16u
    I_MXI46_MN1 (XI46_Bn VDD VSS VSS) gpdk090_nmos1v w=0.12u l=0.1u ad=0.0696p as=0.0696p pd=1.16u ps=1.16u
    I_MXI46_MN5 (XI46_n2 XI46_Bn VSS VSS) gpdk090_nmos1v w=0.24u l=0.1u ad=0.0528p as=0.0816p pd=0.68u ps=1.16u
    I_MXI46_MN4 (b0_6 XI46_An XI46_n2 VSS) gpdk090_nmos1v w=0.24u l=0.1u ad=0.0528p as=0.0528p pd=0.68u ps=0.68u
    I_MXI46_MN2 (XI46_n1 dd6 b0_6 VSS) gpdk090_nmos1v w=0.24u l=0.1u ad=0.0528p as=0.0528p pd=0.68u ps=0.68u
    I_MXI46_MN3 (VSS VDD XI46_n1 VSS) gpdk090_nmos1v w=0.24u l=0.1u ad=0.0816p as=0.0528p pd=1.16u ps=0.68u
    I_MXI46_MN0 (XI46_An dd6 VSS VSS) gpdk090_nmos1v w=0.12u l=0.1u ad=0.0696p as=0.0696p pd=1.16u ps=1.16u
    I_MXI48_I41_MN1 (XI48_I41_Bn I48_G3_0n VSS VSS) gpdk090_nmos1v w=0.12u l=0.1u ad=0.0696p as=0.0696p pd=1.16u ps=1.16u
    I_MXI48_I41_MN5 (XI48_I41_n2 XI48_I41_Bn VSS VSS) gpdk090_nmos1v w=0.24u l=0.1u ad=0.0528p as=0.0816p pd=0.68u ps=1.16u
    I_MXI48_I41_MN4 (p0_4 XI48_I41_An XI48_I41_n2 VSS) gpdk090_nmos1v w=0.24u l=0.1u ad=0.0528p as=0.0528p pd=0.68u ps=0.68u
    I_MXI48_I41_MN2 (XI48_I41_n1 I48_pn4 p0_4 VSS) gpdk090_nmos1v w=0.24u l=0.1u ad=0.0528p as=0.0528p pd=0.68u ps=0.68u
    I_MXI48_I41_MN3 (VSS I48_G3_0n XI48_I41_n1 VSS) gpdk090_nmos1v w=0.24u l=0.1u ad=0.0816p as=0.0528p pd=1.16u ps=0.68u
    I_MXI48_I41_MN0 (XI48_I41_An I48_pn4 VSS VSS) gpdk090_nmos1v w=0.12u l=0.1u ad=0.0696p as=0.0696p pd=1.16u ps=1.16u
    I_MXI58_MN1 (XI58_Bn qu7 VSS VSS) gpdk090_nmos1v w=0.12u l=0.1u ad=0.0696p as=0.0696p pd=1.16u ps=1.16u
    I_MXI58_MN5 (XI58_n2 XI58_Bn VSS VSS) gpdk090_nmos1v w=0.24u l=0.1u ad=0.0528p as=0.0816p pd=0.68u ps=1.16u
    I_MXI58_MN4 (b1_6 XI58_An XI58_n2 VSS) gpdk090_nmos1v w=0.24u l=0.1u ad=0.0528p as=0.0528p pd=0.68u ps=0.68u
    I_MXI58_MN2 (XI58_n1 dd6 b1_6 VSS) gpdk090_nmos1v w=0.24u l=0.1u ad=0.0528p as=0.0528p pd=0.68u ps=0.68u
    I_MXI58_MN3 (VSS qu7 XI58_n1 VSS) gpdk090_nmos1v w=0.24u l=0.1u ad=0.0816p as=0.0528p pd=1.16u ps=0.68u
    I_MXI58_MN0 (XI58_An dd6 VSS VSS) gpdk090_nmos1v w=0.12u l=0.1u ad=0.0696p as=0.0696p pd=1.16u ps=1.16u
    I_MXI60_I41_MN1 (XI60_I41_Bn I60_G3_0n VSS VSS) gpdk090_nmos1v w=0.12u l=0.1u ad=0.0696p as=0.0696p pd=1.16u ps=1.16u
    I_MXI60_I41_MN5 (XI60_I41_n2 XI60_I41_Bn VSS VSS) gpdk090_nmos1v w=0.24u l=0.1u ad=0.0528p as=0.0816p pd=0.68u ps=1.16u
    I_MXI60_I41_MN4 (p1_4 XI60_I41_An XI60_I41_n2 VSS) gpdk090_nmos1v w=0.24u l=0.1u ad=0.0528p as=0.0528p pd=0.68u ps=0.68u
    I_MXI60_I41_MN2 (XI60_I41_n1 I60_pn4 p1_4 VSS) gpdk090_nmos1v w=0.24u l=0.1u ad=0.0528p as=0.0528p pd=0.68u ps=0.68u
    I_MXI60_I41_MN3 (VSS I60_G3_0n XI60_I41_n1 VSS) gpdk090_nmos1v w=0.24u l=0.1u ad=0.0816p as=0.0528p pd=1.16u ps=0.68u
    I_MXI60_I41_MN0 (XI60_I41_An I60_pn4 VSS VSS) gpdk090_nmos1v w=0.12u l=0.1u ad=0.0696p as=0.0696p pd=1.16u ps=1.16u
    I_MXI70_MN1 (XI70_Bn qu6 VSS VSS) gpdk090_nmos1v w=0.12u l=0.1u ad=0.0696p as=0.0696p pd=1.16u ps=1.16u
    I_MXI70_MN5 (XI70_n2 XI70_Bn VSS VSS) gpdk090_nmos1v w=0.24u l=0.1u ad=0.0528p as=0.0816p pd=0.68u ps=1.16u
    I_MXI70_MN4 (b2_6 XI70_An XI70_n2 VSS) gpdk090_nmos1v w=0.24u l=0.1u ad=0.0528p as=0.0528p pd=0.68u ps=0.68u
    I_MXI70_MN2 (XI70_n1 dd6 b2_6 VSS) gpdk090_nmos1v w=0.24u l=0.1u ad=0.0528p as=0.0528p pd=0.68u ps=0.68u
    I_MXI70_MN3 (VSS qu6 XI70_n1 VSS) gpdk090_nmos1v w=0.24u l=0.1u ad=0.0816p as=0.0528p pd=1.16u ps=0.68u
    I_MXI70_MN0 (XI70_An dd6 VSS VSS) gpdk090_nmos1v w=0.12u l=0.1u ad=0.0696p as=0.0696p pd=1.16u ps=1.16u
    I_MXI85_MN1 (XI85_Bn qu5 VSS VSS) gpdk090_nmos1v w=0.12u l=0.1u ad=0.0696p as=0.0696p pd=1.16u ps=1.16u
    I_MXI85_MN5 (XI85_n2 XI85_Bn VSS VSS) gpdk090_nmos1v w=0.24u l=0.1u ad=0.0528p as=0.0816p pd=0.68u ps=1.16u
    I_MXI85_MN4 (h3 XI85_An XI85_n2 VSS) gpdk090_nmos1v w=0.24u l=0.1u ad=0.0528p as=0.0528p pd=0.68u ps=0.68u
    I_MXI85_MN2 (XI85_n1 p2_7 h3 VSS) gpdk090_nmos1v w=0.24u l=0.1u ad=0.0528p as=0.0528p pd=0.68u ps=0.68u
    I_MXI85_MN3 (VSS qu5 XI85_n1 VSS) gpdk090_nmos1v w=0.24u l=0.1u ad=0.0816p as=0.0528p pd=1.16u ps=0.68u
    I_MXI85_MN0 (XI85_An p2_7 VSS VSS) gpdk090_nmos1v w=0.12u l=0.1u ad=0.0696p as=0.0696p pd=1.16u ps=1.16u
    I_MXI47_MN1 (XI47_Bn VDD VSS VSS) gpdk090_nmos1v w=0.12u l=0.1u ad=0.0696p as=0.0696p pd=1.16u ps=1.16u
    I_MXI47_MN5 (XI47_n2 XI47_Bn VSS VSS) gpdk090_nmos1v w=0.24u l=0.1u ad=0.0528p as=0.0816p pd=0.68u ps=1.16u
    I_MXI47_MN4 (b0_7 XI47_An XI47_n2 VSS) gpdk090_nmos1v w=0.24u l=0.1u ad=0.0528p as=0.0528p pd=0.68u ps=0.68u
    I_MXI47_MN2 (XI47_n1 dd7 b0_7 VSS) gpdk090_nmos1v w=0.24u l=0.1u ad=0.0528p as=0.0528p pd=0.68u ps=0.68u
    I_MXI47_MN3 (VSS VDD XI47_n1 VSS) gpdk090_nmos1v w=0.24u l=0.1u ad=0.0816p as=0.0528p pd=1.16u ps=0.68u
    I_MXI47_MN0 (XI47_An dd7 VSS VSS) gpdk090_nmos1v w=0.12u l=0.1u ad=0.0696p as=0.0696p pd=1.16u ps=1.16u
    I_MXI49_MN1 (XI49_Bn VDD VSS VSS) gpdk090_nmos1v w=0.12u l=0.1u ad=0.0696p as=0.0696p pd=1.16u ps=1.16u
    I_MXI49_MN5 (XI49_n2 XI49_Bn VSS VSS) gpdk090_nmos1v w=0.24u l=0.1u ad=0.0528p as=0.0816p pd=0.68u ps=1.16u
    I_MXI49_MN4 (h0 XI49_An XI49_n2 VSS) gpdk090_nmos1v w=0.24u l=0.1u ad=0.0528p as=0.0528p pd=0.68u ps=0.68u
    I_MXI49_MN2 (XI49_n1 VSS h0 VSS) gpdk090_nmos1v w=0.24u l=0.1u ad=0.0528p as=0.0528p pd=0.68u ps=0.68u
    I_MXI49_MN3 (VSS VDD XI49_n1 VSS) gpdk090_nmos1v w=0.24u l=0.1u ad=0.0816p as=0.0528p pd=1.16u ps=0.68u
    I_MXI49_MN0 (XI49_An VSS VSS VSS) gpdk090_nmos1v w=0.12u l=0.1u ad=0.0696p as=0.0696p pd=1.16u ps=1.16u
    I_MXI50_MN1 (XI50_Bn c0_8 VSS VSS) gpdk090_nmos1v w=0.12u l=0.1u ad=0.0696p as=0.0696p pd=1.16u ps=1.16u
    I_MXI50_MN5 (XI50_n2 XI50_Bn VSS VSS) gpdk090_nmos1v w=0.24u l=0.1u ad=0.0528p as=0.0816p pd=0.68u ps=1.16u
    I_MXI50_MN4 (p0_8 XI50_An XI50_n2 VSS) gpdk090_nmos1v w=0.24u l=0.1u ad=0.0528p as=0.0528p pd=0.68u ps=0.68u
    I_MXI50_MN2 (XI50_n1 h0 p0_8 VSS) gpdk090_nmos1v w=0.24u l=0.1u ad=0.0528p as=0.0528p pd=0.68u ps=0.68u
    I_MXI50_MN3 (VSS c0_8 XI50_n1 VSS) gpdk090_nmos1v w=0.24u l=0.1u ad=0.0816p as=0.0528p pd=1.16u ps=0.68u
    I_MXI50_MN0 (XI50_An h0 VSS VSS) gpdk090_nmos1v w=0.12u l=0.1u ad=0.0696p as=0.0696p pd=1.16u ps=1.16u
    I_MXI61_MN1 (XI61_Bn qu7 VSS VSS) gpdk090_nmos1v w=0.12u l=0.1u ad=0.0696p as=0.0696p pd=1.16u ps=1.16u
    I_MXI61_MN5 (XI61_n2 XI61_Bn VSS VSS) gpdk090_nmos1v w=0.24u l=0.1u ad=0.0528p as=0.0816p pd=0.68u ps=1.16u
    I_MXI61_MN4 (h1 XI61_An XI61_n2 VSS) gpdk090_nmos1v w=0.24u l=0.1u ad=0.0528p as=0.0528p pd=0.68u ps=0.68u
    I_MXI61_MN2 (XI61_n1 p0_7 h1 VSS) gpdk090_nmos1v w=0.24u l=0.1u ad=0.0528p as=0.0528p pd=0.68u ps=0.68u
    I_MXI61_MN3 (VSS qu7 XI61_n1 VSS) gpdk090_nmos1v w=0.24u l=0.1u ad=0.0816p as=0.0528p pd=1.16u ps=0.68u
    I_MXI61_MN0 (XI61_An p0_7 VSS VSS) gpdk090_nmos1v w=0.12u l=0.1u ad=0.0696p as=0.0696p pd=1.16u ps=1.16u
    I_MXI59_MN1 (XI59_Bn qu7 VSS VSS) gpdk090_nmos1v w=0.12u l=0.1u ad=0.0696p as=0.0696p pd=1.16u ps=1.16u
    I_MXI59_MN5 (XI59_n2 XI59_Bn VSS VSS) gpdk090_nmos1v w=0.24u l=0.1u ad=0.0528p as=0.0816p pd=0.68u ps=1.16u
    I_MXI59_MN4 (b1_7 XI59_An XI59_n2 VSS) gpdk090_nmos1v w=0.24u l=0.1u ad=0.0528p as=0.0528p pd=0.68u ps=0.68u
    I_MXI59_MN2 (XI59_n1 dd7 b1_7 VSS) gpdk090_nmos1v w=0.24u l=0.1u ad=0.0528p as=0.0528p pd=0.68u ps=0.68u
    I_MXI59_MN3 (VSS qu7 XI59_n1 VSS) gpdk090_nmos1v w=0.24u l=0.1u ad=0.0816p as=0.0528p pd=1.16u ps=0.68u
    I_MXI59_MN0 (XI59_An dd7 VSS VSS) gpdk090_nmos1v w=0.12u l=0.1u ad=0.0696p as=0.0696p pd=1.16u ps=1.16u
    I_MXI62_MN1 (XI62_Bn c1_8 VSS VSS) gpdk090_nmos1v w=0.12u l=0.1u ad=0.0696p as=0.0696p pd=1.16u ps=1.16u
    I_MXI62_MN5 (XI62_n2 XI62_Bn VSS VSS) gpdk090_nmos1v w=0.24u l=0.1u ad=0.0528p as=0.0816p pd=0.68u ps=1.16u
    I_MXI62_MN4 (p1_8 XI62_An XI62_n2 VSS) gpdk090_nmos1v w=0.24u l=0.1u ad=0.0528p as=0.0528p pd=0.68u ps=0.68u
    I_MXI62_MN2 (XI62_n1 h1 p1_8 VSS) gpdk090_nmos1v w=0.24u l=0.1u ad=0.0528p as=0.0528p pd=0.68u ps=0.68u
    I_MXI62_MN3 (VSS c1_8 XI62_n1 VSS) gpdk090_nmos1v w=0.24u l=0.1u ad=0.0816p as=0.0528p pd=1.16u ps=0.68u
    I_MXI62_MN0 (XI62_An h1 VSS VSS) gpdk090_nmos1v w=0.12u l=0.1u ad=0.0696p as=0.0696p pd=1.16u ps=1.16u
    I_MXI73_MN1 (XI73_Bn qu6 VSS VSS) gpdk090_nmos1v w=0.12u l=0.1u ad=0.0696p as=0.0696p pd=1.16u ps=1.16u
    I_MXI73_MN5 (XI73_n2 XI73_Bn VSS VSS) gpdk090_nmos1v w=0.24u l=0.1u ad=0.0528p as=0.0816p pd=0.68u ps=1.16u
    I_MXI73_MN4 (h2 XI73_An XI73_n2 VSS) gpdk090_nmos1v w=0.24u l=0.1u ad=0.0528p as=0.0528p pd=0.68u ps=0.68u
    I_MXI73_MN2 (XI73_n1 p1_7 h2 VSS) gpdk090_nmos1v w=0.24u l=0.1u ad=0.0528p as=0.0528p pd=0.68u ps=0.68u
    I_MXI73_MN3 (VSS qu6 XI73_n1 VSS) gpdk090_nmos1v w=0.24u l=0.1u ad=0.0816p as=0.0528p pd=1.16u ps=0.68u
    I_MXI73_MN0 (XI73_An p1_7 VSS VSS) gpdk090_nmos1v w=0.12u l=0.1u ad=0.0696p as=0.0696p pd=1.16u ps=1.16u
    I_MXI74_MN1 (XI74_Bn c2_8 VSS VSS) gpdk090_nmos1v w=0.12u l=0.1u ad=0.0696p as=0.0696p pd=1.16u ps=1.16u
    I_MXI74_MN5 (XI74_n2 XI74_Bn VSS VSS) gpdk090_nmos1v w=0.24u l=0.1u ad=0.0528p as=0.0816p pd=0.68u ps=1.16u
    I_MXI74_MN4 (p2_8 XI74_An XI74_n2 VSS) gpdk090_nmos1v w=0.24u l=0.1u ad=0.0528p as=0.0528p pd=0.68u ps=0.68u
    I_MXI74_MN2 (XI74_n1 h2 p2_8 VSS) gpdk090_nmos1v w=0.24u l=0.1u ad=0.0528p as=0.0528p pd=0.68u ps=0.68u
    I_MXI74_MN3 (VSS c2_8 XI74_n1 VSS) gpdk090_nmos1v w=0.24u l=0.1u ad=0.0816p as=0.0528p pd=1.16u ps=0.68u
    I_MXI74_MN0 (XI74_An h2 VSS VSS) gpdk090_nmos1v w=0.12u l=0.1u ad=0.0696p as=0.0696p pd=1.16u ps=1.16u
    I_MXI71_MN1 (XI71_Bn qu6 VSS VSS) gpdk090_nmos1v w=0.12u l=0.1u ad=0.0696p as=0.0696p pd=1.16u ps=1.16u
    I_MXI71_MN5 (XI71_n2 XI71_Bn VSS VSS) gpdk090_nmos1v w=0.24u l=0.1u ad=0.0528p as=0.0816p pd=0.68u ps=1.16u
    I_MXI71_MN4 (b2_7 XI71_An XI71_n2 VSS) gpdk090_nmos1v w=0.24u l=0.1u ad=0.0528p as=0.0528p pd=0.68u ps=0.68u
    I_MXI71_MN2 (XI71_n1 dd7 b2_7 VSS) gpdk090_nmos1v w=0.24u l=0.1u ad=0.0528p as=0.0528p pd=0.68u ps=0.68u
    I_MXI71_MN3 (VSS qu6 XI71_n1 VSS) gpdk090_nmos1v w=0.24u l=0.1u ad=0.0816p as=0.0528p pd=1.16u ps=0.68u
    I_MXI71_MN0 (XI71_An dd7 VSS VSS) gpdk090_nmos1v w=0.12u l=0.1u ad=0.0696p as=0.0696p pd=1.16u ps=1.16u
    I_MXI132_I15_MP1 (VDD b7_7 XI132_I15_Bn VDD) gpdk090_pmos1v w=0.24u l=0.1u ad=0.0816p as=0.0816p pd=1.16u ps=1.16u
    I_MXI132_I15_MP5 (I132_pn7 b7_7 XI132_I15_p1 VDD) gpdk090_pmos1v w=0.48u l=0.1u ad=0.1056p as=0.1632p pd=0.92u ps=1.64u
    I_MXI132_I15_MP4 (XI132_I15_p1 XI132_I15_An I132_pn7 VDD) gpdk090_pmos1v w=0.48u l=0.1u ad=0.1056p as=0.1056p pd=0.92u ps=0.92u
    I_MXI132_I15_MP2 (VDD p6_6 XI132_I15_p1 VDD) gpdk090_pmos1v w=0.48u l=0.1u ad=0.1056p as=0.1056p pd=0.92u ps=0.92u
    I_MXI132_I15_MP3 (XI132_I15_p1 XI132_I15_Bn VDD VDD) gpdk090_pmos1v w=0.48u l=0.1u ad=0.1632p as=0.1056p pd=1.64u ps=0.92u
    I_MXI132_I15_MP0 (VDD p6_6 XI132_I15_An VDD) gpdk090_pmos1v w=0.24u l=0.1u ad=0.0816p as=0.0816p pd=1.16u ps=1.16u
    I_MXI132_I13_MP1 (VDD b7_5 XI132_I13_Bn VDD) gpdk090_pmos1v w=0.24u l=0.1u ad=0.0816p as=0.0816p pd=1.16u ps=1.16u
    I_MXI132_I13_MP5 (I132_pn5 b7_5 XI132_I13_p1 VDD) gpdk090_pmos1v w=0.48u l=0.1u ad=0.1056p as=0.1632p pd=0.92u ps=1.64u
    I_MXI132_I13_MP4 (XI132_I13_p1 XI132_I13_An I132_pn5 VDD) gpdk090_pmos1v w=0.48u l=0.1u ad=0.1056p as=0.1056p pd=0.92u ps=0.92u
    I_MXI132_I13_MP2 (VDD p6_4 XI132_I13_p1 VDD) gpdk090_pmos1v w=0.48u l=0.1u ad=0.1056p as=0.1056p pd=0.92u ps=0.92u
    I_MXI132_I13_MP3 (XI132_I13_p1 XI132_I13_Bn VDD VDD) gpdk090_pmos1v w=0.48u l=0.1u ad=0.1632p as=0.1056p pd=1.64u ps=0.92u
    I_MXI132_I13_MP0 (VDD p6_4 XI132_I13_An VDD) gpdk090_pmos1v w=0.24u l=0.1u ad=0.0816p as=0.0816p pd=1.16u ps=1.16u
    I_MXI120_I44_MP1 (VDD c6_7 XI120_I44_Bn VDD) gpdk090_pmos1v w=0.24u l=0.1u ad=0.0816p as=0.0816p pd=1.16u ps=1.16u
    I_MXI120_I44_MP5 (p6_7 c6_7 XI120_I44_p1 VDD) gpdk090_pmos1v w=0.48u l=0.1u ad=0.1056p as=0.1632p pd=0.92u ps=1.64u
    I_MXI120_I44_MP4 (XI120_I44_p1 XI120_I44_An p6_7 VDD) gpdk090_pmos1v w=0.48u l=0.1u ad=0.1056p as=0.1056p pd=0.92u ps=0.92u
    I_MXI120_I44_MP2 (VDD I120_pn7 XI120_I44_p1 VDD) gpdk090_pmos1v w=0.48u l=0.1u ad=0.1056p as=0.1056p pd=0.92u ps=0.92u
    I_MXI120_I44_MP3 (XI120_I44_p1 XI120_I44_Bn VDD VDD) gpdk090_pmos1v w=0.48u l=0.1u ad=0.1632p as=0.1056p pd=1.64u ps=0.92u
    I_MXI120_I44_MP0 (VDD I120_pn7 XI120_I44_An VDD) gpdk090_pmos1v w=0.24u l=0.1u ad=0.0816p as=0.0816p pd=1.16u ps=1.16u
    I_MXI120_I43_MP1 (VDD I120_G5_0 XI120_I43_Bn VDD) gpdk090_pmos1v w=0.24u l=0.1u ad=0.0816p as=0.0816p pd=1.16u ps=1.16u
    I_MXI120_I43_MP5 (p6_6 I120_G5_0 XI120_I43_p1 VDD) gpdk090_pmos1v w=0.48u l=0.1u ad=0.1056p as=0.1632p pd=0.92u ps=1.64u
    I_MXI120_I43_MP4 (XI120_I43_p1 XI120_I43_An p6_6 VDD) gpdk090_pmos1v w=0.48u l=0.1u ad=0.1056p as=0.1056p pd=0.92u ps=0.92u
    I_MXI120_I43_MP2 (VDD I120_pn6 XI120_I43_p1 VDD) gpdk090_pmos1v w=0.48u l=0.1u ad=0.1056p as=0.1056p pd=0.92u ps=0.92u
    I_MXI120_I43_MP3 (XI120_I43_p1 XI120_I43_Bn VDD VDD) gpdk090_pmos1v w=0.48u l=0.1u ad=0.1632p as=0.1056p pd=1.64u ps=0.92u
    I_MXI120_I43_MP0 (VDD I120_pn6 XI120_I43_An VDD) gpdk090_pmos1v w=0.24u l=0.1u ad=0.0816p as=0.0816p pd=1.16u ps=1.16u
    I_MXI120_I15_MP1 (VDD b6_7 XI120_I15_Bn VDD) gpdk090_pmos1v w=0.24u l=0.1u ad=0.0816p as=0.0816p pd=1.16u ps=1.16u
    I_MXI120_I15_MP5 (I120_pn7 b6_7 XI120_I15_p1 VDD) gpdk090_pmos1v w=0.48u l=0.1u ad=0.1056p as=0.1632p pd=0.92u ps=1.64u
    I_MXI120_I15_MP4 (XI120_I15_p1 XI120_I15_An I120_pn7 VDD) gpdk090_pmos1v w=0.48u l=0.1u ad=0.1056p as=0.1056p pd=0.92u ps=0.92u
    I_MXI120_I15_MP2 (VDD p5_6 XI120_I15_p1 VDD) gpdk090_pmos1v w=0.48u l=0.1u ad=0.1056p as=0.1056p pd=0.92u ps=0.92u
    I_MXI120_I15_MP3 (XI120_I15_p1 XI120_I15_Bn VDD VDD) gpdk090_pmos1v w=0.48u l=0.1u ad=0.1632p as=0.1056p pd=1.64u ps=0.92u
    I_MXI120_I15_MP0 (VDD p5_6 XI120_I15_An VDD) gpdk090_pmos1v w=0.24u l=0.1u ad=0.0816p as=0.0816p pd=1.16u ps=1.16u
    I_MXI108_I44_MP1 (VDD c5_7 XI108_I44_Bn VDD) gpdk090_pmos1v w=0.24u l=0.1u ad=0.0816p as=0.0816p pd=1.16u ps=1.16u
    I_MXI108_I44_MP5 (p5_7 c5_7 XI108_I44_p1 VDD) gpdk090_pmos1v w=0.48u l=0.1u ad=0.1056p as=0.1632p pd=0.92u ps=1.64u
    I_MXI108_I44_MP4 (XI108_I44_p1 XI108_I44_An p5_7 VDD) gpdk090_pmos1v w=0.48u l=0.1u ad=0.1056p as=0.1056p pd=0.92u ps=0.92u
    I_MXI108_I44_MP2 (VDD I108_pn7 XI108_I44_p1 VDD) gpdk090_pmos1v w=0.48u l=0.1u ad=0.1056p as=0.1056p pd=0.92u ps=0.92u
    I_MXI108_I44_MP3 (XI108_I44_p1 XI108_I44_Bn VDD VDD) gpdk090_pmos1v w=0.48u l=0.1u ad=0.1632p as=0.1056p pd=1.64u ps=0.92u
    I_MXI108_I44_MP0 (VDD I108_pn7 XI108_I44_An VDD) gpdk090_pmos1v w=0.24u l=0.1u ad=0.0816p as=0.0816p pd=1.16u ps=1.16u
    I_MXI108_I43_MP1 (VDD I108_G5_0 XI108_I43_Bn VDD) gpdk090_pmos1v w=0.24u l=0.1u ad=0.0816p as=0.0816p pd=1.16u ps=1.16u
    I_MXI108_I43_MP5 (p5_6 I108_G5_0 XI108_I43_p1 VDD) gpdk090_pmos1v w=0.48u l=0.1u ad=0.1056p as=0.1632p pd=0.92u ps=1.64u
    I_MXI108_I43_MP4 (XI108_I43_p1 XI108_I43_An p5_6 VDD) gpdk090_pmos1v w=0.48u l=0.1u ad=0.1056p as=0.1056p pd=0.92u ps=0.92u
    I_MXI108_I43_MP2 (VDD I108_pn6 XI108_I43_p1 VDD) gpdk090_pmos1v w=0.48u l=0.1u ad=0.1056p as=0.1056p pd=0.92u ps=0.92u
    I_MXI108_I43_MP3 (XI108_I43_p1 XI108_I43_Bn VDD VDD) gpdk090_pmos1v w=0.48u l=0.1u ad=0.1632p as=0.1056p pd=1.64u ps=0.92u
    I_MXI108_I43_MP0 (VDD I108_pn6 XI108_I43_An VDD) gpdk090_pmos1v w=0.24u l=0.1u ad=0.0816p as=0.0816p pd=1.16u ps=1.16u
    I_MXI108_I15_MP1 (VDD b5_7 XI108_I15_Bn VDD) gpdk090_pmos1v w=0.24u l=0.1u ad=0.0816p as=0.0816p pd=1.16u ps=1.16u
    I_MXI108_I15_MP5 (I108_pn7 b5_7 XI108_I15_p1 VDD) gpdk090_pmos1v w=0.48u l=0.1u ad=0.1056p as=0.1632p pd=0.92u ps=1.64u
    I_MXI108_I15_MP4 (XI108_I15_p1 XI108_I15_An I108_pn7 VDD) gpdk090_pmos1v w=0.48u l=0.1u ad=0.1056p as=0.1056p pd=0.92u ps=0.92u
    I_MXI108_I15_MP2 (VDD p4_6 XI108_I15_p1 VDD) gpdk090_pmos1v w=0.48u l=0.1u ad=0.1056p as=0.1056p pd=0.92u ps=0.92u
    I_MXI108_I15_MP3 (XI108_I15_p1 XI108_I15_Bn VDD VDD) gpdk090_pmos1v w=0.48u l=0.1u ad=0.1632p as=0.1056p pd=1.64u ps=0.92u
    I_MXI108_I15_MP0 (VDD p4_6 XI108_I15_An VDD) gpdk090_pmos1v w=0.24u l=0.1u ad=0.0816p as=0.0816p pd=1.16u ps=1.16u
    I_MXI132_I14_MP1 (VDD b7_6 XI132_I14_Bn VDD) gpdk090_pmos1v w=0.24u l=0.1u ad=0.0816p as=0.0816p pd=1.16u ps=1.16u
    I_MXI132_I14_MP5 (I132_pn6 b7_6 XI132_I14_p1 VDD) gpdk090_pmos1v w=0.48u l=0.1u ad=0.1056p as=0.1632p pd=0.92u ps=1.64u
    I_MXI132_I14_MP4 (XI132_I14_p1 XI132_I14_An I132_pn6 VDD) gpdk090_pmos1v w=0.48u l=0.1u ad=0.1056p as=0.1056p pd=0.92u ps=0.92u
    I_MXI132_I14_MP2 (VDD p6_5 XI132_I14_p1 VDD) gpdk090_pmos1v w=0.48u l=0.1u ad=0.1056p as=0.1056p pd=0.92u ps=0.92u
    I_MXI132_I14_MP3 (XI132_I14_p1 XI132_I14_Bn VDD VDD) gpdk090_pmos1v w=0.48u l=0.1u ad=0.1632p as=0.1056p pd=1.64u ps=0.92u
    I_MXI132_I14_MP0 (VDD p6_5 XI132_I14_An VDD) gpdk090_pmos1v w=0.24u l=0.1u ad=0.0816p as=0.0816p pd=1.16u ps=1.16u
    I_MXI120_I42_MP1 (VDD I120_G4_0 XI120_I42_Bn VDD) gpdk090_pmos1v w=0.24u l=0.1u ad=0.0816p as=0.0816p pd=1.16u ps=1.16u
    I_MXI120_I42_MP5 (p6_5 I120_G4_0 XI120_I42_p1 VDD) gpdk090_pmos1v w=0.48u l=0.1u ad=0.1056p as=0.1632p pd=0.92u ps=1.64u
    I_MXI120_I42_MP4 (XI120_I42_p1 XI120_I42_An p6_5 VDD) gpdk090_pmos1v w=0.48u l=0.1u ad=0.1056p as=0.1056p pd=0.92u ps=0.92u
    I_MXI120_I42_MP2 (VDD I120_pn5 XI120_I42_p1 VDD) gpdk090_pmos1v w=0.48u l=0.1u ad=0.1056p as=0.1056p pd=0.92u ps=0.92u
    I_MXI120_I42_MP3 (XI120_I42_p1 XI120_I42_Bn VDD VDD) gpdk090_pmos1v w=0.48u l=0.1u ad=0.1632p as=0.1056p pd=1.64u ps=0.92u
    I_MXI120_I42_MP0 (VDD I120_pn5 XI120_I42_An VDD) gpdk090_pmos1v w=0.24u l=0.1u ad=0.0816p as=0.0816p pd=1.16u ps=1.16u
    I_MXI120_I13_MP1 (VDD b6_5 XI120_I13_Bn VDD) gpdk090_pmos1v w=0.24u l=0.1u ad=0.0816p as=0.0816p pd=1.16u ps=1.16u
    I_MXI120_I13_MP5 (I120_pn5 b6_5 XI120_I13_p1 VDD) gpdk090_pmos1v w=0.48u l=0.1u ad=0.1056p as=0.1632p pd=0.92u ps=1.64u
    I_MXI120_I13_MP4 (XI120_I13_p1 XI120_I13_An I120_pn5 VDD) gpdk090_pmos1v w=0.48u l=0.1u ad=0.1056p as=0.1056p pd=0.92u ps=0.92u
    I_MXI120_I13_MP2 (VDD p5_4 XI120_I13_p1 VDD) gpdk090_pmos1v w=0.48u l=0.1u ad=0.1056p as=0.1056p pd=0.92u ps=0.92u
    I_MXI120_I13_MP3 (XI120_I13_p1 XI120_I13_Bn VDD VDD) gpdk090_pmos1v w=0.48u l=0.1u ad=0.1632p as=0.1056p pd=1.64u ps=0.92u
    I_MXI120_I13_MP0 (VDD p5_4 XI120_I13_An VDD) gpdk090_pmos1v w=0.24u l=0.1u ad=0.0816p as=0.0816p pd=1.16u ps=1.16u
    I_MXI120_I14_MP1 (VDD b6_6 XI120_I14_Bn VDD) gpdk090_pmos1v w=0.24u l=0.1u ad=0.0816p as=0.0816p pd=1.16u ps=1.16u
    I_MXI120_I14_MP5 (I120_pn6 b6_6 XI120_I14_p1 VDD) gpdk090_pmos1v w=0.48u l=0.1u ad=0.1056p as=0.1632p pd=0.92u ps=1.64u
    I_MXI120_I14_MP4 (XI120_I14_p1 XI120_I14_An I120_pn6 VDD) gpdk090_pmos1v w=0.48u l=0.1u ad=0.1056p as=0.1056p pd=0.92u ps=0.92u
    I_MXI120_I14_MP2 (VDD p5_5 XI120_I14_p1 VDD) gpdk090_pmos1v w=0.48u l=0.1u ad=0.1056p as=0.1056p pd=0.92u ps=0.92u
    I_MXI120_I14_MP3 (XI120_I14_p1 XI120_I14_Bn VDD VDD) gpdk090_pmos1v w=0.48u l=0.1u ad=0.1632p as=0.1056p pd=1.64u ps=0.92u
    I_MXI120_I14_MP0 (VDD p5_5 XI120_I14_An VDD) gpdk090_pmos1v w=0.24u l=0.1u ad=0.0816p as=0.0816p pd=1.16u ps=1.16u
    I_MXI108_I42_MP1 (VDD I108_G4_0 XI108_I42_Bn VDD) gpdk090_pmos1v w=0.24u l=0.1u ad=0.0816p as=0.0816p pd=1.16u ps=1.16u
    I_MXI108_I42_MP5 (p5_5 I108_G4_0 XI108_I42_p1 VDD) gpdk090_pmos1v w=0.48u l=0.1u ad=0.1056p as=0.1632p pd=0.92u ps=1.64u
    I_MXI108_I42_MP4 (XI108_I42_p1 XI108_I42_An p5_5 VDD) gpdk090_pmos1v w=0.48u l=0.1u ad=0.1056p as=0.1056p pd=0.92u ps=0.92u
    I_MXI108_I42_MP2 (VDD I108_pn5 XI108_I42_p1 VDD) gpdk090_pmos1v w=0.48u l=0.1u ad=0.1056p as=0.1056p pd=0.92u ps=0.92u
    I_MXI108_I42_MP3 (XI108_I42_p1 XI108_I42_Bn VDD VDD) gpdk090_pmos1v w=0.48u l=0.1u ad=0.1632p as=0.1056p pd=1.64u ps=0.92u
    I_MXI108_I42_MP0 (VDD I108_pn5 XI108_I42_An VDD) gpdk090_pmos1v w=0.24u l=0.1u ad=0.0816p as=0.0816p pd=1.16u ps=1.16u
    I_MXI108_I14_MP1 (VDD b5_6 XI108_I14_Bn VDD) gpdk090_pmos1v w=0.24u l=0.1u ad=0.0816p as=0.0816p pd=1.16u ps=1.16u
    I_MXI108_I14_MP5 (I108_pn6 b5_6 XI108_I14_p1 VDD) gpdk090_pmos1v w=0.48u l=0.1u ad=0.1056p as=0.1632p pd=0.92u ps=1.64u
    I_MXI108_I14_MP4 (XI108_I14_p1 XI108_I14_An I108_pn6 VDD) gpdk090_pmos1v w=0.48u l=0.1u ad=0.1056p as=0.1056p pd=0.92u ps=0.92u
    I_MXI108_I14_MP2 (VDD p4_5 XI108_I14_p1 VDD) gpdk090_pmos1v w=0.48u l=0.1u ad=0.1056p as=0.1056p pd=0.92u ps=0.92u
    I_MXI108_I14_MP3 (XI108_I14_p1 XI108_I14_Bn VDD VDD) gpdk090_pmos1v w=0.48u l=0.1u ad=0.1632p as=0.1056p pd=1.64u ps=0.92u
    I_MXI108_I14_MP0 (VDD p4_5 XI108_I14_An VDD) gpdk090_pmos1v w=0.24u l=0.1u ad=0.0816p as=0.0816p pd=1.16u ps=1.16u
    I_MXI132_I43_MP1 (VDD I132_G5_0 XI132_I43_Bn VDD) gpdk090_pmos1v w=0.24u l=0.1u ad=0.0816p as=0.0816p pd=1.16u ps=1.16u
    I_MXI132_I43_MP5 (p7_6 I132_G5_0 XI132_I43_p1 VDD) gpdk090_pmos1v w=0.48u l=0.1u ad=0.1056p as=0.1632p pd=0.92u ps=1.64u
    I_MXI132_I43_MP4 (XI132_I43_p1 XI132_I43_An p7_6 VDD) gpdk090_pmos1v w=0.48u l=0.1u ad=0.1056p as=0.1056p pd=0.92u ps=0.92u
    I_MXI132_I43_MP2 (VDD I132_pn6 XI132_I43_p1 VDD) gpdk090_pmos1v w=0.48u l=0.1u ad=0.1056p as=0.1056p pd=0.92u ps=0.92u
    I_MXI132_I43_MP3 (XI132_I43_p1 XI132_I43_Bn VDD VDD) gpdk090_pmos1v w=0.48u l=0.1u ad=0.1632p as=0.1056p pd=1.64u ps=0.92u
    I_MXI132_I43_MP0 (VDD I132_pn6 XI132_I43_An VDD) gpdk090_pmos1v w=0.24u l=0.1u ad=0.0816p as=0.0816p pd=1.16u ps=1.16u
    I_MXI132_I12_MP1 (VDD b7_4 XI132_I12_Bn VDD) gpdk090_pmos1v w=0.24u l=0.1u ad=0.0816p as=0.0816p pd=1.16u ps=1.16u
    I_MXI132_I12_MP5 (I132_pn4 b7_4 XI132_I12_p1 VDD) gpdk090_pmos1v w=0.48u l=0.1u ad=0.1056p as=0.1632p pd=0.92u ps=1.64u
    I_MXI132_I12_MP4 (XI132_I12_p1 XI132_I12_An I132_pn4 VDD) gpdk090_pmos1v w=0.48u l=0.1u ad=0.1056p as=0.1056p pd=0.92u ps=0.92u
    I_MXI132_I12_MP2 (VDD p6_3 XI132_I12_p1 VDD) gpdk090_pmos1v w=0.48u l=0.1u ad=0.1056p as=0.1056p pd=0.92u ps=0.92u
    I_MXI132_I12_MP3 (XI132_I12_p1 XI132_I12_Bn VDD VDD) gpdk090_pmos1v w=0.48u l=0.1u ad=0.1632p as=0.1056p pd=1.64u ps=0.92u
    I_MXI132_I12_MP0 (VDD p6_3 XI132_I12_An VDD) gpdk090_pmos1v w=0.24u l=0.1u ad=0.0816p as=0.0816p pd=1.16u ps=1.16u
    I_MXI120_I12_MP1 (VDD b6_4 XI120_I12_Bn VDD) gpdk090_pmos1v w=0.24u l=0.1u ad=0.0816p as=0.0816p pd=1.16u ps=1.16u
    I_MXI120_I12_MP5 (I120_pn4 b6_4 XI120_I12_p1 VDD) gpdk090_pmos1v w=0.48u l=0.1u ad=0.1056p as=0.1632p pd=0.92u ps=1.64u
    I_MXI120_I12_MP4 (XI120_I12_p1 XI120_I12_An I120_pn4 VDD) gpdk090_pmos1v w=0.48u l=0.1u ad=0.1056p as=0.1056p pd=0.92u ps=0.92u
    I_MXI120_I12_MP2 (VDD p5_3 XI120_I12_p1 VDD) gpdk090_pmos1v w=0.48u l=0.1u ad=0.1056p as=0.1056p pd=0.92u ps=0.92u
    I_MXI120_I12_MP3 (XI120_I12_p1 XI120_I12_Bn VDD VDD) gpdk090_pmos1v w=0.48u l=0.1u ad=0.1632p as=0.1056p pd=1.64u ps=0.92u
    I_MXI120_I12_MP0 (VDD p5_3 XI120_I12_An VDD) gpdk090_pmos1v w=0.24u l=0.1u ad=0.0816p as=0.0816p pd=1.16u ps=1.16u
    I_MXI108_I11_MP1 (VDD b5_3 XI108_I11_Bn VDD) gpdk090_pmos1v w=0.24u l=0.1u ad=0.0816p as=0.0816p pd=1.16u ps=1.16u
    I_MXI108_I11_MP5 (I108_pn3 b5_3 XI108_I11_p1 VDD) gpdk090_pmos1v w=0.48u l=0.1u ad=0.1056p as=0.1632p pd=0.92u ps=1.64u
    I_MXI108_I11_MP4 (XI108_I11_p1 XI108_I11_An I108_pn3 VDD) gpdk090_pmos1v w=0.48u l=0.1u ad=0.1056p as=0.1056p pd=0.92u ps=0.92u
    I_MXI108_I11_MP2 (VDD p4_2 XI108_I11_p1 VDD) gpdk090_pmos1v w=0.48u l=0.1u ad=0.1056p as=0.1056p pd=0.92u ps=0.92u
    I_MXI108_I11_MP3 (XI108_I11_p1 XI108_I11_Bn VDD VDD) gpdk090_pmos1v w=0.48u l=0.1u ad=0.1632p as=0.1056p pd=1.64u ps=0.92u
    I_MXI108_I11_MP0 (VDD p4_2 XI108_I11_An VDD) gpdk090_pmos1v w=0.24u l=0.1u ad=0.0816p as=0.0816p pd=1.16u ps=1.16u
    I_MXI108_I12_MP1 (VDD b5_4 XI108_I12_Bn VDD) gpdk090_pmos1v w=0.24u l=0.1u ad=0.0816p as=0.0816p pd=1.16u ps=1.16u
    I_MXI108_I12_MP5 (I108_pn4 b5_4 XI108_I12_p1 VDD) gpdk090_pmos1v w=0.48u l=0.1u ad=0.1056p as=0.1632p pd=0.92u ps=1.64u
    I_MXI108_I12_MP4 (XI108_I12_p1 XI108_I12_An I108_pn4 VDD) gpdk090_pmos1v w=0.48u l=0.1u ad=0.1056p as=0.1056p pd=0.92u ps=0.92u
    I_MXI108_I12_MP2 (VDD p4_3 XI108_I12_p1 VDD) gpdk090_pmos1v w=0.48u l=0.1u ad=0.1056p as=0.1056p pd=0.92u ps=0.92u
    I_MXI108_I12_MP3 (XI108_I12_p1 XI108_I12_Bn VDD VDD) gpdk090_pmos1v w=0.48u l=0.1u ad=0.1632p as=0.1056p pd=1.64u ps=0.92u
    I_MXI108_I12_MP0 (VDD p4_3 XI108_I12_An VDD) gpdk090_pmos1v w=0.24u l=0.1u ad=0.0816p as=0.0816p pd=1.16u ps=1.16u
    I_MXI108_I13_MP1 (VDD b5_5 XI108_I13_Bn VDD) gpdk090_pmos1v w=0.24u l=0.1u ad=0.0816p as=0.0816p pd=1.16u ps=1.16u
    I_MXI108_I13_MP5 (I108_pn5 b5_5 XI108_I13_p1 VDD) gpdk090_pmos1v w=0.48u l=0.1u ad=0.1056p as=0.1632p pd=0.92u ps=1.64u
    I_MXI108_I13_MP4 (XI108_I13_p1 XI108_I13_An I108_pn5 VDD) gpdk090_pmos1v w=0.48u l=0.1u ad=0.1056p as=0.1056p pd=0.92u ps=0.92u
    I_MXI108_I13_MP2 (VDD p4_4 XI108_I13_p1 VDD) gpdk090_pmos1v w=0.48u l=0.1u ad=0.1056p as=0.1056p pd=0.92u ps=0.92u
    I_MXI108_I13_MP3 (XI108_I13_p1 XI108_I13_Bn VDD VDD) gpdk090_pmos1v w=0.48u l=0.1u ad=0.1632p as=0.1056p pd=1.64u ps=0.92u
    I_MXI108_I13_MP0 (VDD p4_4 XI108_I13_An VDD) gpdk090_pmos1v w=0.24u l=0.1u ad=0.0816p as=0.0816p pd=1.16u ps=1.16u
    I_MXI96_I43_MP1 (VDD I96_G5_0 XI96_I43_Bn VDD) gpdk090_pmos1v w=0.24u l=0.1u ad=0.0816p as=0.0816p pd=1.16u ps=1.16u
    I_MXI96_I43_MP5 (p4_6 I96_G5_0 XI96_I43_p1 VDD) gpdk090_pmos1v w=0.48u l=0.1u ad=0.1056p as=0.1632p pd=0.92u ps=1.64u
    I_MXI96_I43_MP4 (XI96_I43_p1 XI96_I43_An p4_6 VDD) gpdk090_pmos1v w=0.48u l=0.1u ad=0.1056p as=0.1056p pd=0.92u ps=0.92u
    I_MXI96_I43_MP2 (VDD I96_pn6 XI96_I43_p1 VDD) gpdk090_pmos1v w=0.48u l=0.1u ad=0.1056p as=0.1056p pd=0.92u ps=0.92u
    I_MXI96_I43_MP3 (XI96_I43_p1 XI96_I43_Bn VDD VDD) gpdk090_pmos1v w=0.48u l=0.1u ad=0.1632p as=0.1056p pd=1.64u ps=0.92u
    I_MXI96_I43_MP0 (VDD I96_pn6 XI96_I43_An VDD) gpdk090_pmos1v w=0.24u l=0.1u ad=0.0816p as=0.0816p pd=1.16u ps=1.16u
    I_MXI132_I44_MP1 (VDD c7_7 XI132_I44_Bn VDD) gpdk090_pmos1v w=0.24u l=0.1u ad=0.0816p as=0.0816p pd=1.16u ps=1.16u
    I_MXI132_I44_MP5 (p7_7 c7_7 XI132_I44_p1 VDD) gpdk090_pmos1v w=0.48u l=0.1u ad=0.1056p as=0.1632p pd=0.92u ps=1.64u
    I_MXI132_I44_MP4 (XI132_I44_p1 XI132_I44_An p7_7 VDD) gpdk090_pmos1v w=0.48u l=0.1u ad=0.1056p as=0.1056p pd=0.92u ps=0.92u
    I_MXI132_I44_MP2 (VDD I132_pn7 XI132_I44_p1 VDD) gpdk090_pmos1v w=0.48u l=0.1u ad=0.1056p as=0.1056p pd=0.92u ps=0.92u
    I_MXI132_I44_MP3 (XI132_I44_p1 XI132_I44_Bn VDD VDD) gpdk090_pmos1v w=0.48u l=0.1u ad=0.1632p as=0.1056p pd=1.64u ps=0.92u
    I_MXI132_I44_MP0 (VDD I132_pn7 XI132_I44_An VDD) gpdk090_pmos1v w=0.24u l=0.1u ad=0.0816p as=0.0816p pd=1.16u ps=1.16u
    I_MXI132_I11_MP1 (VDD b7_3 XI132_I11_Bn VDD) gpdk090_pmos1v w=0.24u l=0.1u ad=0.0816p as=0.0816p pd=1.16u ps=1.16u
    I_MXI132_I11_MP5 (I132_pn3 b7_3 XI132_I11_p1 VDD) gpdk090_pmos1v w=0.48u l=0.1u ad=0.1056p as=0.1632p pd=0.92u ps=1.64u
    I_MXI132_I11_MP4 (XI132_I11_p1 XI132_I11_An I132_pn3 VDD) gpdk090_pmos1v w=0.48u l=0.1u ad=0.1056p as=0.1056p pd=0.92u ps=0.92u
    I_MXI132_I11_MP2 (VDD p6_2 XI132_I11_p1 VDD) gpdk090_pmos1v w=0.48u l=0.1u ad=0.1056p as=0.1056p pd=0.92u ps=0.92u
    I_MXI132_I11_MP3 (XI132_I11_p1 XI132_I11_Bn VDD VDD) gpdk090_pmos1v w=0.48u l=0.1u ad=0.1632p as=0.1056p pd=1.64u ps=0.92u
    I_MXI132_I11_MP0 (VDD p6_2 XI132_I11_An VDD) gpdk090_pmos1v w=0.24u l=0.1u ad=0.0816p as=0.0816p pd=1.16u ps=1.16u
    I_MXI120_I39_MP1 (VDD I120_G1_0 XI120_I39_Bn VDD) gpdk090_pmos1v w=0.24u l=0.1u ad=0.0816p as=0.0816p pd=1.16u ps=1.16u
    I_MXI120_I39_MP5 (p6_2 I120_G1_0 XI120_I39_p1 VDD) gpdk090_pmos1v w=0.48u l=0.1u ad=0.1056p as=0.1632p pd=0.92u ps=1.64u
    I_MXI120_I39_MP4 (XI120_I39_p1 XI120_I39_An p6_2 VDD) gpdk090_pmos1v w=0.48u l=0.1u ad=0.1056p as=0.1056p pd=0.92u ps=0.92u
    I_MXI120_I39_MP2 (VDD I120_pn2 XI120_I39_p1 VDD) gpdk090_pmos1v w=0.48u l=0.1u ad=0.1056p as=0.1056p pd=0.92u ps=0.92u
    I_MXI120_I39_MP3 (XI120_I39_p1 XI120_I39_Bn VDD VDD) gpdk090_pmos1v w=0.48u l=0.1u ad=0.1632p as=0.1056p pd=1.64u ps=0.92u
    I_MXI120_I39_MP0 (VDD I120_pn2 XI120_I39_An VDD) gpdk090_pmos1v w=0.24u l=0.1u ad=0.0816p as=0.0816p pd=1.16u ps=1.16u
    I_MXI120_I9_MP1 (VDD b6_1 XI120_I9_Bn VDD) gpdk090_pmos1v w=0.24u l=0.1u ad=0.0816p as=0.0816p pd=1.16u ps=1.16u
    I_MXI120_I9_MP5 (I120_pn1 b6_1 XI120_I9_p1 VDD) gpdk090_pmos1v w=0.48u l=0.1u ad=0.1056p as=0.1632p pd=0.92u ps=1.64u
    I_MXI120_I9_MP4 (XI120_I9_p1 XI120_I9_An I120_pn1 VDD) gpdk090_pmos1v w=0.48u l=0.1u ad=0.1056p as=0.1056p pd=0.92u ps=0.92u
    I_MXI120_I9_MP2 (VDD p5_0 XI120_I9_p1 VDD) gpdk090_pmos1v w=0.48u l=0.1u ad=0.1056p as=0.1056p pd=0.92u ps=0.92u
    I_MXI120_I9_MP3 (XI120_I9_p1 XI120_I9_Bn VDD VDD) gpdk090_pmos1v w=0.48u l=0.1u ad=0.1632p as=0.1056p pd=1.64u ps=0.92u
    I_MXI120_I9_MP0 (VDD p5_0 XI120_I9_An VDD) gpdk090_pmos1v w=0.24u l=0.1u ad=0.0816p as=0.0816p pd=1.16u ps=1.16u
    I_MXI120_I11_MP1 (VDD b6_3 XI120_I11_Bn VDD) gpdk090_pmos1v w=0.24u l=0.1u ad=0.0816p as=0.0816p pd=1.16u ps=1.16u
    I_MXI120_I11_MP5 (I120_pn3 b6_3 XI120_I11_p1 VDD) gpdk090_pmos1v w=0.48u l=0.1u ad=0.1056p as=0.1632p pd=0.92u ps=1.64u
    I_MXI120_I11_MP4 (XI120_I11_p1 XI120_I11_An I120_pn3 VDD) gpdk090_pmos1v w=0.48u l=0.1u ad=0.1056p as=0.1056p pd=0.92u ps=0.92u
    I_MXI120_I11_MP2 (VDD p5_2 XI120_I11_p1 VDD) gpdk090_pmos1v w=0.48u l=0.1u ad=0.1056p as=0.1056p pd=0.92u ps=0.92u
    I_MXI120_I11_MP3 (XI120_I11_p1 XI120_I11_Bn VDD VDD) gpdk090_pmos1v w=0.48u l=0.1u ad=0.1632p as=0.1056p pd=1.64u ps=0.92u
    I_MXI120_I11_MP0 (VDD p5_2 XI120_I11_An VDD) gpdk090_pmos1v w=0.24u l=0.1u ad=0.0816p as=0.0816p pd=1.16u ps=1.16u
    I_MXI108_I38_MP1 (VDD I108_G0_0 XI108_I38_Bn VDD) gpdk090_pmos1v w=0.24u l=0.1u ad=0.0816p as=0.0816p pd=1.16u ps=1.16u
    I_MXI108_I38_MP5 (p5_1 I108_G0_0 XI108_I38_p1 VDD) gpdk090_pmos1v w=0.48u l=0.1u ad=0.1056p as=0.1632p pd=0.92u ps=1.64u
    I_MXI108_I38_MP4 (XI108_I38_p1 XI108_I38_An p5_1 VDD) gpdk090_pmos1v w=0.48u l=0.1u ad=0.1056p as=0.1056p pd=0.92u ps=0.92u
    I_MXI108_I38_MP2 (VDD I108_pn1 XI108_I38_p1 VDD) gpdk090_pmos1v w=0.48u l=0.1u ad=0.1056p as=0.1056p pd=0.92u ps=0.92u
    I_MXI108_I38_MP3 (XI108_I38_p1 XI108_I38_Bn VDD VDD) gpdk090_pmos1v w=0.48u l=0.1u ad=0.1632p as=0.1056p pd=1.64u ps=0.92u
    I_MXI108_I38_MP0 (VDD I108_pn1 XI108_I38_An VDD) gpdk090_pmos1v w=0.24u l=0.1u ad=0.0816p as=0.0816p pd=1.16u ps=1.16u
    I_MXI108_I9_MP1 (VDD b5_1 XI108_I9_Bn VDD) gpdk090_pmos1v w=0.24u l=0.1u ad=0.0816p as=0.0816p pd=1.16u ps=1.16u
    I_MXI108_I9_MP5 (I108_pn1 b5_1 XI108_I9_p1 VDD) gpdk090_pmos1v w=0.48u l=0.1u ad=0.1056p as=0.1632p pd=0.92u ps=1.64u
    I_MXI108_I9_MP4 (XI108_I9_p1 XI108_I9_An I108_pn1 VDD) gpdk090_pmos1v w=0.48u l=0.1u ad=0.1056p as=0.1056p pd=0.92u ps=0.92u
    I_MXI108_I9_MP2 (VDD p4_0 XI108_I9_p1 VDD) gpdk090_pmos1v w=0.48u l=0.1u ad=0.1056p as=0.1056p pd=0.92u ps=0.92u
    I_MXI108_I9_MP3 (XI108_I9_p1 XI108_I9_Bn VDD VDD) gpdk090_pmos1v w=0.48u l=0.1u ad=0.1632p as=0.1056p pd=1.64u ps=0.92u
    I_MXI108_I9_MP0 (VDD p4_0 XI108_I9_An VDD) gpdk090_pmos1v w=0.24u l=0.1u ad=0.0816p as=0.0816p pd=1.16u ps=1.16u
    I_MXI108_I39_MP1 (VDD I108_G1_0 XI108_I39_Bn VDD) gpdk090_pmos1v w=0.24u l=0.1u ad=0.0816p as=0.0816p pd=1.16u ps=1.16u
    I_MXI108_I39_MP5 (p5_2 I108_G1_0 XI108_I39_p1 VDD) gpdk090_pmos1v w=0.48u l=0.1u ad=0.1056p as=0.1632p pd=0.92u ps=1.64u
    I_MXI108_I39_MP4 (XI108_I39_p1 XI108_I39_An p5_2 VDD) gpdk090_pmos1v w=0.48u l=0.1u ad=0.1056p as=0.1056p pd=0.92u ps=0.92u
    I_MXI108_I39_MP2 (VDD I108_pn2 XI108_I39_p1 VDD) gpdk090_pmos1v w=0.48u l=0.1u ad=0.1056p as=0.1056p pd=0.92u ps=0.92u
    I_MXI108_I39_MP3 (XI108_I39_p1 XI108_I39_Bn VDD VDD) gpdk090_pmos1v w=0.48u l=0.1u ad=0.1632p as=0.1056p pd=1.64u ps=0.92u
    I_MXI108_I39_MP0 (VDD I108_pn2 XI108_I39_An VDD) gpdk090_pmos1v w=0.24u l=0.1u ad=0.0816p as=0.0816p pd=1.16u ps=1.16u
    I_MXI96_I39_MP1 (VDD I96_G1_0 XI96_I39_Bn VDD) gpdk090_pmos1v w=0.24u l=0.1u ad=0.0816p as=0.0816p pd=1.16u ps=1.16u
    I_MXI96_I39_MP5 (p4_2 I96_G1_0 XI96_I39_p1 VDD) gpdk090_pmos1v w=0.48u l=0.1u ad=0.1056p as=0.1632p pd=0.92u ps=1.64u
    I_MXI96_I39_MP4 (XI96_I39_p1 XI96_I39_An p4_2 VDD) gpdk090_pmos1v w=0.48u l=0.1u ad=0.1056p as=0.1056p pd=0.92u ps=0.92u
    I_MXI96_I39_MP2 (VDD I96_pn2 XI96_I39_p1 VDD) gpdk090_pmos1v w=0.48u l=0.1u ad=0.1056p as=0.1056p pd=0.92u ps=0.92u
    I_MXI96_I39_MP3 (XI96_I39_p1 XI96_I39_Bn VDD VDD) gpdk090_pmos1v w=0.48u l=0.1u ad=0.1632p as=0.1056p pd=1.64u ps=0.92u
    I_MXI96_I39_MP0 (VDD I96_pn2 XI96_I39_An VDD) gpdk090_pmos1v w=0.24u l=0.1u ad=0.0816p as=0.0816p pd=1.16u ps=1.16u
    I_MXI96_I42_MP1 (VDD I96_G4_0 XI96_I42_Bn VDD) gpdk090_pmos1v w=0.24u l=0.1u ad=0.0816p as=0.0816p pd=1.16u ps=1.16u
    I_MXI96_I42_MP5 (p4_5 I96_G4_0 XI96_I42_p1 VDD) gpdk090_pmos1v w=0.48u l=0.1u ad=0.1056p as=0.1632p pd=0.92u ps=1.64u
    I_MXI96_I42_MP4 (XI96_I42_p1 XI96_I42_An p4_5 VDD) gpdk090_pmos1v w=0.48u l=0.1u ad=0.1056p as=0.1056p pd=0.92u ps=0.92u
    I_MXI96_I42_MP2 (VDD I96_pn5 XI96_I42_p1 VDD) gpdk090_pmos1v w=0.48u l=0.1u ad=0.1056p as=0.1056p pd=0.92u ps=0.92u
    I_MXI96_I42_MP3 (XI96_I42_p1 XI96_I42_Bn VDD VDD) gpdk090_pmos1v w=0.48u l=0.1u ad=0.1632p as=0.1056p pd=1.64u ps=0.92u
    I_MXI96_I42_MP0 (VDD I96_pn5 XI96_I42_An VDD) gpdk090_pmos1v w=0.24u l=0.1u ad=0.0816p as=0.0816p pd=1.16u ps=1.16u
    I_MXI152_I15_MP1 (VDD dm7 XI152_I15_Bn VDD) gpdk090_pmos1v w=0.24u l=0.1u ad=0.0816p as=0.0816p pd=1.16u ps=1.16u
    I_MXI152_I15_MP5 (I152_pn7 dm7 XI152_I15_p1 VDD) gpdk090_pmos1v w=0.48u l=0.1u ad=0.1056p as=0.1632p pd=0.92u ps=1.64u
    I_MXI152_I15_MP4 (XI152_I15_p1 XI152_I15_An I152_pn7 VDD) gpdk090_pmos1v w=0.48u l=0.1u ad=0.1056p as=0.1056p pd=0.92u ps=0.92u
    I_MXI152_I15_MP2 (VDD p7_7 XI152_I15_p1 VDD) gpdk090_pmos1v w=0.48u l=0.1u ad=0.1056p as=0.1056p pd=0.92u ps=0.92u
    I_MXI152_I15_MP3 (XI152_I15_p1 XI152_I15_Bn VDD VDD) gpdk090_pmos1v w=0.48u l=0.1u ad=0.1632p as=0.1056p pd=1.64u ps=0.92u
    I_MXI152_I15_MP0 (VDD p7_7 XI152_I15_An VDD) gpdk090_pmos1v w=0.24u l=0.1u ad=0.0816p as=0.0816p pd=1.16u ps=1.16u
    I_MXI132_I42_MP1 (VDD I132_G4_0 XI132_I42_Bn VDD) gpdk090_pmos1v w=0.24u l=0.1u ad=0.0816p as=0.0816p pd=1.16u ps=1.16u
    I_MXI132_I42_MP5 (p7_5 I132_G4_0 XI132_I42_p1 VDD) gpdk090_pmos1v w=0.48u l=0.1u ad=0.1056p as=0.1632p pd=0.92u ps=1.64u
    I_MXI132_I42_MP4 (XI132_I42_p1 XI132_I42_An p7_5 VDD) gpdk090_pmos1v w=0.48u l=0.1u ad=0.1056p as=0.1056p pd=0.92u ps=0.92u
    I_MXI132_I42_MP2 (VDD I132_pn5 XI132_I42_p1 VDD) gpdk090_pmos1v w=0.48u l=0.1u ad=0.1056p as=0.1056p pd=0.92u ps=0.92u
    I_MXI132_I42_MP3 (XI132_I42_p1 XI132_I42_Bn VDD VDD) gpdk090_pmos1v w=0.48u l=0.1u ad=0.1632p as=0.1056p pd=1.64u ps=0.92u
    I_MXI132_I42_MP0 (VDD I132_pn5 XI132_I42_An VDD) gpdk090_pmos1v w=0.24u l=0.1u ad=0.0816p as=0.0816p pd=1.16u ps=1.16u
    I_MXI132_I10_MP1 (VDD b7_2 XI132_I10_Bn VDD) gpdk090_pmos1v w=0.24u l=0.1u ad=0.0816p as=0.0816p pd=1.16u ps=1.16u
    I_MXI132_I10_MP5 (I132_pn2 b7_2 XI132_I10_p1 VDD) gpdk090_pmos1v w=0.48u l=0.1u ad=0.1056p as=0.1632p pd=0.92u ps=1.64u
    I_MXI132_I10_MP4 (XI132_I10_p1 XI132_I10_An I132_pn2 VDD) gpdk090_pmos1v w=0.48u l=0.1u ad=0.1056p as=0.1056p pd=0.92u ps=0.92u
    I_MXI132_I10_MP2 (VDD p6_1 XI132_I10_p1 VDD) gpdk090_pmos1v w=0.48u l=0.1u ad=0.1056p as=0.1056p pd=0.92u ps=0.92u
    I_MXI132_I10_MP3 (XI132_I10_p1 XI132_I10_Bn VDD VDD) gpdk090_pmos1v w=0.48u l=0.1u ad=0.1632p as=0.1056p pd=1.64u ps=0.92u
    I_MXI132_I10_MP0 (VDD p6_1 XI132_I10_An VDD) gpdk090_pmos1v w=0.24u l=0.1u ad=0.0816p as=0.0816p pd=1.16u ps=1.16u
    I_MXI120_I38_MP1 (VDD I120_G0_0 XI120_I38_Bn VDD) gpdk090_pmos1v w=0.24u l=0.1u ad=0.0816p as=0.0816p pd=1.16u ps=1.16u
    I_MXI120_I38_MP5 (p6_1 I120_G0_0 XI120_I38_p1 VDD) gpdk090_pmos1v w=0.48u l=0.1u ad=0.1056p as=0.1632p pd=0.92u ps=1.64u
    I_MXI120_I38_MP4 (XI120_I38_p1 XI120_I38_An p6_1 VDD) gpdk090_pmos1v w=0.48u l=0.1u ad=0.1056p as=0.1056p pd=0.92u ps=0.92u
    I_MXI120_I38_MP2 (VDD I120_pn1 XI120_I38_p1 VDD) gpdk090_pmos1v w=0.48u l=0.1u ad=0.1056p as=0.1056p pd=0.92u ps=0.92u
    I_MXI120_I38_MP3 (XI120_I38_p1 XI120_I38_Bn VDD VDD) gpdk090_pmos1v w=0.48u l=0.1u ad=0.1632p as=0.1056p pd=1.64u ps=0.92u
    I_MXI120_I38_MP0 (VDD I120_pn1 XI120_I38_An VDD) gpdk090_pmos1v w=0.24u l=0.1u ad=0.0816p as=0.0816p pd=1.16u ps=1.16u
    I_MXI120_I10_MP1 (VDD b6_2 XI120_I10_Bn VDD) gpdk090_pmos1v w=0.24u l=0.1u ad=0.0816p as=0.0816p pd=1.16u ps=1.16u
    I_MXI120_I10_MP5 (I120_pn2 b6_2 XI120_I10_p1 VDD) gpdk090_pmos1v w=0.48u l=0.1u ad=0.1056p as=0.1632p pd=0.92u ps=1.64u
    I_MXI120_I10_MP4 (XI120_I10_p1 XI120_I10_An I120_pn2 VDD) gpdk090_pmos1v w=0.48u l=0.1u ad=0.1056p as=0.1056p pd=0.92u ps=0.92u
    I_MXI120_I10_MP2 (VDD p5_1 XI120_I10_p1 VDD) gpdk090_pmos1v w=0.48u l=0.1u ad=0.1056p as=0.1056p pd=0.92u ps=0.92u
    I_MXI120_I10_MP3 (XI120_I10_p1 XI120_I10_Bn VDD VDD) gpdk090_pmos1v w=0.48u l=0.1u ad=0.1632p as=0.1056p pd=1.64u ps=0.92u
    I_MXI120_I10_MP0 (VDD p5_1 XI120_I10_An VDD) gpdk090_pmos1v w=0.24u l=0.1u ad=0.0816p as=0.0816p pd=1.16u ps=1.16u
    I_MXI108_I37_MP1 (VDD qu3 XI108_I37_Bn VDD) gpdk090_pmos1v w=0.24u l=0.1u ad=0.0816p as=0.0816p pd=1.16u ps=1.16u
    I_MXI108_I37_MP5 (p5_0 qu3 XI108_I37_p1 VDD) gpdk090_pmos1v w=0.48u l=0.1u ad=0.1056p as=0.1632p pd=0.92u ps=1.64u
    I_MXI108_I37_MP4 (XI108_I37_p1 XI108_I37_An p5_0 VDD) gpdk090_pmos1v w=0.48u l=0.1u ad=0.1056p as=0.1056p pd=0.92u ps=0.92u
    I_MXI108_I37_MP2 (VDD I108_pn0 XI108_I37_p1 VDD) gpdk090_pmos1v w=0.48u l=0.1u ad=0.1056p as=0.1056p pd=0.92u ps=0.92u
    I_MXI108_I37_MP3 (XI108_I37_p1 XI108_I37_Bn VDD VDD) gpdk090_pmos1v w=0.48u l=0.1u ad=0.1632p as=0.1056p pd=1.64u ps=0.92u
    I_MXI108_I37_MP0 (VDD I108_pn0 XI108_I37_An VDD) gpdk090_pmos1v w=0.24u l=0.1u ad=0.0816p as=0.0816p pd=1.16u ps=1.16u
    I_MXI108_I8_MP1 (VDD b5_0 XI108_I8_Bn VDD) gpdk090_pmos1v w=0.24u l=0.1u ad=0.0816p as=0.0816p pd=1.16u ps=1.16u
    I_MXI108_I8_MP5 (I108_pn0 b5_0 XI108_I8_p1 VDD) gpdk090_pmos1v w=0.48u l=0.1u ad=0.1056p as=0.1632p pd=0.92u ps=1.64u
    I_MXI108_I8_MP4 (XI108_I8_p1 XI108_I8_An I108_pn0 VDD) gpdk090_pmos1v w=0.48u l=0.1u ad=0.1056p as=0.1056p pd=0.92u ps=0.92u
    I_MXI108_I8_MP2 (VDD aa2 XI108_I8_p1 VDD) gpdk090_pmos1v w=0.48u l=0.1u ad=0.1056p as=0.1056p pd=0.92u ps=0.92u
    I_MXI108_I8_MP3 (XI108_I8_p1 XI108_I8_Bn VDD VDD) gpdk090_pmos1v w=0.48u l=0.1u ad=0.1632p as=0.1056p pd=1.64u ps=0.92u
    I_MXI108_I8_MP0 (VDD aa2 XI108_I8_An VDD) gpdk090_pmos1v w=0.24u l=0.1u ad=0.0816p as=0.0816p pd=1.16u ps=1.16u
    I_MXI108_I10_MP1 (VDD b5_2 XI108_I10_Bn VDD) gpdk090_pmos1v w=0.24u l=0.1u ad=0.0816p as=0.0816p pd=1.16u ps=1.16u
    I_MXI108_I10_MP5 (I108_pn2 b5_2 XI108_I10_p1 VDD) gpdk090_pmos1v w=0.48u l=0.1u ad=0.1056p as=0.1632p pd=0.92u ps=1.64u
    I_MXI108_I10_MP4 (XI108_I10_p1 XI108_I10_An I108_pn2 VDD) gpdk090_pmos1v w=0.48u l=0.1u ad=0.1056p as=0.1056p pd=0.92u ps=0.92u
    I_MXI108_I10_MP2 (VDD p4_1 XI108_I10_p1 VDD) gpdk090_pmos1v w=0.48u l=0.1u ad=0.1056p as=0.1056p pd=0.92u ps=0.92u
    I_MXI108_I10_MP3 (XI108_I10_p1 XI108_I10_Bn VDD VDD) gpdk090_pmos1v w=0.48u l=0.1u ad=0.1632p as=0.1056p pd=1.64u ps=0.92u
    I_MXI108_I10_MP0 (VDD p4_1 XI108_I10_An VDD) gpdk090_pmos1v w=0.24u l=0.1u ad=0.0816p as=0.0816p pd=1.16u ps=1.16u
    I_MXI96_I38_MP1 (VDD I96_G0_0 XI96_I38_Bn VDD) gpdk090_pmos1v w=0.24u l=0.1u ad=0.0816p as=0.0816p pd=1.16u ps=1.16u
    I_MXI96_I38_MP5 (p4_1 I96_G0_0 XI96_I38_p1 VDD) gpdk090_pmos1v w=0.48u l=0.1u ad=0.1056p as=0.1632p pd=0.92u ps=1.64u
    I_MXI96_I38_MP4 (XI96_I38_p1 XI96_I38_An p4_1 VDD) gpdk090_pmos1v w=0.48u l=0.1u ad=0.1056p as=0.1056p pd=0.92u ps=0.92u
    I_MXI96_I38_MP2 (VDD I96_pn1 XI96_I38_p1 VDD) gpdk090_pmos1v w=0.48u l=0.1u ad=0.1056p as=0.1056p pd=0.92u ps=0.92u
    I_MXI96_I38_MP3 (XI96_I38_p1 XI96_I38_Bn VDD VDD) gpdk090_pmos1v w=0.48u l=0.1u ad=0.1632p as=0.1056p pd=1.64u ps=0.92u
    I_MXI96_I38_MP0 (VDD I96_pn1 XI96_I38_An VDD) gpdk090_pmos1v w=0.24u l=0.1u ad=0.0816p as=0.0816p pd=1.16u ps=1.16u
    I_MXI96_I9_MP1 (VDD b4_1 XI96_I9_Bn VDD) gpdk090_pmos1v w=0.24u l=0.1u ad=0.0816p as=0.0816p pd=1.16u ps=1.16u
    I_MXI96_I9_MP5 (I96_pn1 b4_1 XI96_I9_p1 VDD) gpdk090_pmos1v w=0.48u l=0.1u ad=0.1056p as=0.1632p pd=0.92u ps=1.64u
    I_MXI96_I9_MP4 (XI96_I9_p1 XI96_I9_An I96_pn1 VDD) gpdk090_pmos1v w=0.48u l=0.1u ad=0.1056p as=0.1056p pd=0.92u ps=0.92u
    I_MXI96_I9_MP2 (VDD p3_0 XI96_I9_p1 VDD) gpdk090_pmos1v w=0.48u l=0.1u ad=0.1056p as=0.1056p pd=0.92u ps=0.92u
    I_MXI96_I9_MP3 (XI96_I9_p1 XI96_I9_Bn VDD VDD) gpdk090_pmos1v w=0.48u l=0.1u ad=0.1632p as=0.1056p pd=1.64u ps=0.92u
    I_MXI96_I9_MP0 (VDD p3_0 XI96_I9_An VDD) gpdk090_pmos1v w=0.24u l=0.1u ad=0.0816p as=0.0816p pd=1.16u ps=1.16u
    I_MXI96_I44_MP1 (VDD c4_7 XI96_I44_Bn VDD) gpdk090_pmos1v w=0.24u l=0.1u ad=0.0816p as=0.0816p pd=1.16u ps=1.16u
    I_MXI96_I44_MP5 (p4_7 c4_7 XI96_I44_p1 VDD) gpdk090_pmos1v w=0.48u l=0.1u ad=0.1056p as=0.1632p pd=0.92u ps=1.64u
    I_MXI96_I44_MP4 (XI96_I44_p1 XI96_I44_An p4_7 VDD) gpdk090_pmos1v w=0.48u l=0.1u ad=0.1056p as=0.1056p pd=0.92u ps=0.92u
    I_MXI96_I44_MP2 (VDD I96_pn7 XI96_I44_p1 VDD) gpdk090_pmos1v w=0.48u l=0.1u ad=0.1056p as=0.1056p pd=0.92u ps=0.92u
    I_MXI96_I44_MP3 (XI96_I44_p1 XI96_I44_Bn VDD VDD) gpdk090_pmos1v w=0.48u l=0.1u ad=0.1632p as=0.1056p pd=1.64u ps=0.92u
    I_MXI96_I44_MP0 (VDD I96_pn7 XI96_I44_An VDD) gpdk090_pmos1v w=0.24u l=0.1u ad=0.0816p as=0.0816p pd=1.16u ps=1.16u
    I_MXI96_I15_MP1 (VDD b4_7 XI96_I15_Bn VDD) gpdk090_pmos1v w=0.24u l=0.1u ad=0.0816p as=0.0816p pd=1.16u ps=1.16u
    I_MXI96_I15_MP5 (I96_pn7 b4_7 XI96_I15_p1 VDD) gpdk090_pmos1v w=0.48u l=0.1u ad=0.1056p as=0.1632p pd=0.92u ps=1.64u
    I_MXI96_I15_MP4 (XI96_I15_p1 XI96_I15_An I96_pn7 VDD) gpdk090_pmos1v w=0.48u l=0.1u ad=0.1056p as=0.1056p pd=0.92u ps=0.92u
    I_MXI96_I15_MP2 (VDD p3_6 XI96_I15_p1 VDD) gpdk090_pmos1v w=0.48u l=0.1u ad=0.1056p as=0.1056p pd=0.92u ps=0.92u
    I_MXI96_I15_MP3 (XI96_I15_p1 XI96_I15_Bn VDD VDD) gpdk090_pmos1v w=0.48u l=0.1u ad=0.1632p as=0.1056p pd=1.64u ps=0.92u
    I_MXI96_I15_MP0 (VDD p3_6 XI96_I15_An VDD) gpdk090_pmos1v w=0.24u l=0.1u ad=0.0816p as=0.0816p pd=1.16u ps=1.16u
    I_MXI152_I14_MP1 (VDD dm6 XI152_I14_Bn VDD) gpdk090_pmos1v w=0.24u l=0.1u ad=0.0816p as=0.0816p pd=1.16u ps=1.16u
    I_MXI152_I14_MP5 (I152_pn6 dm6 XI152_I14_p1 VDD) gpdk090_pmos1v w=0.48u l=0.1u ad=0.1056p as=0.1632p pd=0.92u ps=1.64u
    I_MXI152_I14_MP4 (XI152_I14_p1 XI152_I14_An I152_pn6 VDD) gpdk090_pmos1v w=0.48u l=0.1u ad=0.1056p as=0.1056p pd=0.92u ps=0.92u
    I_MXI152_I14_MP2 (VDD p7_6 XI152_I14_p1 VDD) gpdk090_pmos1v w=0.48u l=0.1u ad=0.1056p as=0.1056p pd=0.92u ps=0.92u
    I_MXI152_I14_MP3 (XI152_I14_p1 XI152_I14_Bn VDD VDD) gpdk090_pmos1v w=0.48u l=0.1u ad=0.1632p as=0.1056p pd=1.64u ps=0.92u
    I_MXI152_I14_MP0 (VDD p7_6 XI152_I14_An VDD) gpdk090_pmos1v w=0.24u l=0.1u ad=0.0816p as=0.0816p pd=1.16u ps=1.16u
    I_MXI152_I13_MP1 (VDD dm5 XI152_I13_Bn VDD) gpdk090_pmos1v w=0.24u l=0.1u ad=0.0816p as=0.0816p pd=1.16u ps=1.16u
    I_MXI152_I13_MP5 (I152_pn5 dm5 XI152_I13_p1 VDD) gpdk090_pmos1v w=0.48u l=0.1u ad=0.1056p as=0.1632p pd=0.92u ps=1.64u
    I_MXI152_I13_MP4 (XI152_I13_p1 XI152_I13_An I152_pn5 VDD) gpdk090_pmos1v w=0.48u l=0.1u ad=0.1056p as=0.1056p pd=0.92u ps=0.92u
    I_MXI152_I13_MP2 (VDD p7_5 XI152_I13_p1 VDD) gpdk090_pmos1v w=0.48u l=0.1u ad=0.1056p as=0.1056p pd=0.92u ps=0.92u
    I_MXI152_I13_MP3 (XI152_I13_p1 XI152_I13_Bn VDD VDD) gpdk090_pmos1v w=0.48u l=0.1u ad=0.1632p as=0.1056p pd=1.64u ps=0.92u
    I_MXI152_I13_MP0 (VDD p7_5 XI152_I13_An VDD) gpdk090_pmos1v w=0.24u l=0.1u ad=0.0816p as=0.0816p pd=1.16u ps=1.16u
    I_MXI132_I39_MP1 (VDD I132_G1_0 XI132_I39_Bn VDD) gpdk090_pmos1v w=0.24u l=0.1u ad=0.0816p as=0.0816p pd=1.16u ps=1.16u
    I_MXI132_I39_MP5 (p7_2 I132_G1_0 XI132_I39_p1 VDD) gpdk090_pmos1v w=0.48u l=0.1u ad=0.1056p as=0.1632p pd=0.92u ps=1.64u
    I_MXI132_I39_MP4 (XI132_I39_p1 XI132_I39_An p7_2 VDD) gpdk090_pmos1v w=0.48u l=0.1u ad=0.1056p as=0.1056p pd=0.92u ps=0.92u
    I_MXI132_I39_MP2 (VDD I132_pn2 XI132_I39_p1 VDD) gpdk090_pmos1v w=0.48u l=0.1u ad=0.1056p as=0.1056p pd=0.92u ps=0.92u
    I_MXI132_I39_MP3 (XI132_I39_p1 XI132_I39_Bn VDD VDD) gpdk090_pmos1v w=0.48u l=0.1u ad=0.1632p as=0.1056p pd=1.64u ps=0.92u
    I_MXI132_I39_MP0 (VDD I132_pn2 XI132_I39_An VDD) gpdk090_pmos1v w=0.24u l=0.1u ad=0.0816p as=0.0816p pd=1.16u ps=1.16u
    I_MXI132_I9_MP1 (VDD b7_1 XI132_I9_Bn VDD) gpdk090_pmos1v w=0.24u l=0.1u ad=0.0816p as=0.0816p pd=1.16u ps=1.16u
    I_MXI132_I9_MP5 (I132_pn1 b7_1 XI132_I9_p1 VDD) gpdk090_pmos1v w=0.48u l=0.1u ad=0.1056p as=0.1632p pd=0.92u ps=1.64u
    I_MXI132_I9_MP4 (XI132_I9_p1 XI132_I9_An I132_pn1 VDD) gpdk090_pmos1v w=0.48u l=0.1u ad=0.1056p as=0.1056p pd=0.92u ps=0.92u
    I_MXI132_I9_MP2 (VDD p6_0 XI132_I9_p1 VDD) gpdk090_pmos1v w=0.48u l=0.1u ad=0.1056p as=0.1056p pd=0.92u ps=0.92u
    I_MXI132_I9_MP3 (XI132_I9_p1 XI132_I9_Bn VDD VDD) gpdk090_pmos1v w=0.48u l=0.1u ad=0.1632p as=0.1056p pd=1.64u ps=0.92u
    I_MXI132_I9_MP0 (VDD p6_0 XI132_I9_An VDD) gpdk090_pmos1v w=0.24u l=0.1u ad=0.0816p as=0.0816p pd=1.16u ps=1.16u
    I_MXI120_I37_MP1 (VDD qu2 XI120_I37_Bn VDD) gpdk090_pmos1v w=0.24u l=0.1u ad=0.0816p as=0.0816p pd=1.16u ps=1.16u
    I_MXI120_I37_MP5 (p6_0 qu2 XI120_I37_p1 VDD) gpdk090_pmos1v w=0.48u l=0.1u ad=0.1056p as=0.1632p pd=0.92u ps=1.64u
    I_MXI120_I37_MP4 (XI120_I37_p1 XI120_I37_An p6_0 VDD) gpdk090_pmos1v w=0.48u l=0.1u ad=0.1056p as=0.1056p pd=0.92u ps=0.92u
    I_MXI120_I37_MP2 (VDD I120_pn0 XI120_I37_p1 VDD) gpdk090_pmos1v w=0.48u l=0.1u ad=0.1056p as=0.1056p pd=0.92u ps=0.92u
    I_MXI120_I37_MP3 (XI120_I37_p1 XI120_I37_Bn VDD VDD) gpdk090_pmos1v w=0.48u l=0.1u ad=0.1632p as=0.1056p pd=1.64u ps=0.92u
    I_MXI120_I37_MP0 (VDD I120_pn0 XI120_I37_An VDD) gpdk090_pmos1v w=0.24u l=0.1u ad=0.0816p as=0.0816p pd=1.16u ps=1.16u
    I_MXI120_I8_MP1 (VDD b6_0 XI120_I8_Bn VDD) gpdk090_pmos1v w=0.24u l=0.1u ad=0.0816p as=0.0816p pd=1.16u ps=1.16u
    I_MXI120_I8_MP5 (I120_pn0 b6_0 XI120_I8_p1 VDD) gpdk090_pmos1v w=0.48u l=0.1u ad=0.1056p as=0.1632p pd=0.92u ps=1.64u
    I_MXI120_I8_MP4 (XI120_I8_p1 XI120_I8_An I120_pn0 VDD) gpdk090_pmos1v w=0.48u l=0.1u ad=0.1056p as=0.1056p pd=0.92u ps=0.92u
    I_MXI120_I8_MP2 (VDD aa1 XI120_I8_p1 VDD) gpdk090_pmos1v w=0.48u l=0.1u ad=0.1056p as=0.1056p pd=0.92u ps=0.92u
    I_MXI120_I8_MP3 (XI120_I8_p1 XI120_I8_Bn VDD VDD) gpdk090_pmos1v w=0.48u l=0.1u ad=0.1632p as=0.1056p pd=1.64u ps=0.92u
    I_MXI120_I8_MP0 (VDD aa1 XI120_I8_An VDD) gpdk090_pmos1v w=0.24u l=0.1u ad=0.0816p as=0.0816p pd=1.16u ps=1.16u
    I_MXI4_MP1 (VDD nakn2 XI4_Bn VDD) gpdk090_pmos1v w=0.24u l=0.1u ad=0.0816p as=0.0816p pd=1.16u ps=1.16u
    I_MXI4_MP5 (aa2 nakn2 XI4_p1 VDD) gpdk090_pmos1v w=0.48u l=0.1u ad=0.1056p as=0.1632p pd=0.92u ps=1.64u
    I_MXI4_MP4 (XI4_p1 XI4_An aa2 VDD) gpdk090_pmos1v w=0.48u l=0.1u ad=0.1056p as=0.1056p pd=0.92u ps=0.92u
    I_MXI4_MP2 (VDD A_2 XI4_p1 VDD) gpdk090_pmos1v w=0.48u l=0.1u ad=0.1056p as=0.1056p pd=0.92u ps=0.92u
    I_MXI4_MP3 (XI4_p1 XI4_Bn VDD VDD) gpdk090_pmos1v w=0.48u l=0.1u ad=0.1632p as=0.1056p pd=1.64u ps=0.92u
    I_MXI4_MP0 (VDD A_2 XI4_An VDD) gpdk090_pmos1v w=0.24u l=0.1u ad=0.0816p as=0.0816p pd=1.16u ps=1.16u
    I_MXI7_MP1 (VDD nakn3 XI7_Bn VDD) gpdk090_pmos1v w=0.24u l=0.1u ad=0.0816p as=0.0816p pd=1.16u ps=1.16u
    I_MXI7_MP5 (aa3 nakn3 XI7_p1 VDD) gpdk090_pmos1v w=0.48u l=0.1u ad=0.1056p as=0.1632p pd=0.92u ps=1.64u
    I_MXI7_MP4 (XI7_p1 XI7_An aa3 VDD) gpdk090_pmos1v w=0.48u l=0.1u ad=0.1056p as=0.1056p pd=0.92u ps=0.92u
    I_MXI7_MP2 (VDD A_3 XI7_p1 VDD) gpdk090_pmos1v w=0.48u l=0.1u ad=0.1056p as=0.1056p pd=0.92u ps=0.92u
    I_MXI7_MP3 (XI7_p1 XI7_Bn VDD VDD) gpdk090_pmos1v w=0.48u l=0.1u ad=0.1632p as=0.1056p pd=1.64u ps=0.92u
    I_MXI7_MP0 (VDD A_3 XI7_An VDD) gpdk090_pmos1v w=0.24u l=0.1u ad=0.0816p as=0.0816p pd=1.16u ps=1.16u
    I_MXI96_I37_MP1 (VDD qu4 XI96_I37_Bn VDD) gpdk090_pmos1v w=0.24u l=0.1u ad=0.0816p as=0.0816p pd=1.16u ps=1.16u
    I_MXI96_I37_MP5 (p4_0 qu4 XI96_I37_p1 VDD) gpdk090_pmos1v w=0.48u l=0.1u ad=0.1056p as=0.1632p pd=0.92u ps=1.64u
    I_MXI96_I37_MP4 (XI96_I37_p1 XI96_I37_An p4_0 VDD) gpdk090_pmos1v w=0.48u l=0.1u ad=0.1056p as=0.1056p pd=0.92u ps=0.92u
    I_MXI96_I37_MP2 (VDD I96_pn0 XI96_I37_p1 VDD) gpdk090_pmos1v w=0.48u l=0.1u ad=0.1056p as=0.1056p pd=0.92u ps=0.92u
    I_MXI96_I37_MP3 (XI96_I37_p1 XI96_I37_Bn VDD VDD) gpdk090_pmos1v w=0.48u l=0.1u ad=0.1632p as=0.1056p pd=1.64u ps=0.92u
    I_MXI96_I37_MP0 (VDD I96_pn0 XI96_I37_An VDD) gpdk090_pmos1v w=0.24u l=0.1u ad=0.0816p as=0.0816p pd=1.16u ps=1.16u
    I_MXI96_I8_MP1 (VDD b4_0 XI96_I8_Bn VDD) gpdk090_pmos1v w=0.24u l=0.1u ad=0.0816p as=0.0816p pd=1.16u ps=1.16u
    I_MXI96_I8_MP5 (I96_pn0 b4_0 XI96_I8_p1 VDD) gpdk090_pmos1v w=0.48u l=0.1u ad=0.1056p as=0.1632p pd=0.92u ps=1.64u
    I_MXI96_I8_MP4 (XI96_I8_p1 XI96_I8_An I96_pn0 VDD) gpdk090_pmos1v w=0.48u l=0.1u ad=0.1056p as=0.1056p pd=0.92u ps=0.92u
    I_MXI96_I8_MP2 (VDD aa3 XI96_I8_p1 VDD) gpdk090_pmos1v w=0.48u l=0.1u ad=0.1056p as=0.1056p pd=0.92u ps=0.92u
    I_MXI96_I8_MP3 (XI96_I8_p1 XI96_I8_Bn VDD VDD) gpdk090_pmos1v w=0.48u l=0.1u ad=0.1632p as=0.1056p pd=1.64u ps=0.92u
    I_MXI96_I8_MP0 (VDD aa3 XI96_I8_An VDD) gpdk090_pmos1v w=0.24u l=0.1u ad=0.0816p as=0.0816p pd=1.16u ps=1.16u
    I_MXI96_I10_MP1 (VDD b4_2 XI96_I10_Bn VDD) gpdk090_pmos1v w=0.24u l=0.1u ad=0.0816p as=0.0816p pd=1.16u ps=1.16u
    I_MXI96_I10_MP5 (I96_pn2 b4_2 XI96_I10_p1 VDD) gpdk090_pmos1v w=0.48u l=0.1u ad=0.1056p as=0.1632p pd=0.92u ps=1.64u
    I_MXI96_I10_MP4 (XI96_I10_p1 XI96_I10_An I96_pn2 VDD) gpdk090_pmos1v w=0.48u l=0.1u ad=0.1056p as=0.1056p pd=0.92u ps=0.92u
    I_MXI96_I10_MP2 (VDD p3_1 XI96_I10_p1 VDD) gpdk090_pmos1v w=0.48u l=0.1u ad=0.1056p as=0.1056p pd=0.92u ps=0.92u
    I_MXI96_I10_MP3 (XI96_I10_p1 XI96_I10_Bn VDD VDD) gpdk090_pmos1v w=0.48u l=0.1u ad=0.1632p as=0.1056p pd=1.64u ps=0.92u
    I_MXI96_I10_MP0 (VDD p3_1 XI96_I10_An VDD) gpdk090_pmos1v w=0.24u l=0.1u ad=0.0816p as=0.0816p pd=1.16u ps=1.16u
    I_MXI96_I14_MP1 (VDD b4_6 XI96_I14_Bn VDD) gpdk090_pmos1v w=0.24u l=0.1u ad=0.0816p as=0.0816p pd=1.16u ps=1.16u
    I_MXI96_I14_MP5 (I96_pn6 b4_6 XI96_I14_p1 VDD) gpdk090_pmos1v w=0.48u l=0.1u ad=0.1056p as=0.1632p pd=0.92u ps=1.64u
    I_MXI96_I14_MP4 (XI96_I14_p1 XI96_I14_An I96_pn6 VDD) gpdk090_pmos1v w=0.48u l=0.1u ad=0.1056p as=0.1056p pd=0.92u ps=0.92u
    I_MXI96_I14_MP2 (VDD p3_5 XI96_I14_p1 VDD) gpdk090_pmos1v w=0.48u l=0.1u ad=0.1056p as=0.1056p pd=0.92u ps=0.92u
    I_MXI96_I14_MP3 (XI96_I14_p1 XI96_I14_Bn VDD VDD) gpdk090_pmos1v w=0.48u l=0.1u ad=0.1632p as=0.1056p pd=1.64u ps=0.92u
    I_MXI96_I14_MP0 (VDD p3_5 XI96_I14_An VDD) gpdk090_pmos1v w=0.24u l=0.1u ad=0.0816p as=0.0816p pd=1.16u ps=1.16u
    I_MXI152_I12_MP1 (VDD dm4 XI152_I12_Bn VDD) gpdk090_pmos1v w=0.24u l=0.1u ad=0.0816p as=0.0816p pd=1.16u ps=1.16u
    I_MXI152_I12_MP5 (I152_pn4 dm4 XI152_I12_p1 VDD) gpdk090_pmos1v w=0.48u l=0.1u ad=0.1056p as=0.1632p pd=0.92u ps=1.64u
    I_MXI152_I12_MP4 (XI152_I12_p1 XI152_I12_An I152_pn4 VDD) gpdk090_pmos1v w=0.48u l=0.1u ad=0.1056p as=0.1056p pd=0.92u ps=0.92u
    I_MXI152_I12_MP2 (VDD p7_4 XI152_I12_p1 VDD) gpdk090_pmos1v w=0.48u l=0.1u ad=0.1056p as=0.1056p pd=0.92u ps=0.92u
    I_MXI152_I12_MP3 (XI152_I12_p1 XI152_I12_Bn VDD VDD) gpdk090_pmos1v w=0.48u l=0.1u ad=0.1632p as=0.1056p pd=1.64u ps=0.92u
    I_MXI152_I12_MP0 (VDD p7_4 XI152_I12_An VDD) gpdk090_pmos1v w=0.24u l=0.1u ad=0.0816p as=0.0816p pd=1.16u ps=1.16u
    I_MXI152_I11_MP1 (VDD dm3 XI152_I11_Bn VDD) gpdk090_pmos1v w=0.24u l=0.1u ad=0.0816p as=0.0816p pd=1.16u ps=1.16u
    I_MXI152_I11_MP5 (I152_pn3 dm3 XI152_I11_p1 VDD) gpdk090_pmos1v w=0.48u l=0.1u ad=0.1056p as=0.1632p pd=0.92u ps=1.64u
    I_MXI152_I11_MP4 (XI152_I11_p1 XI152_I11_An I152_pn3 VDD) gpdk090_pmos1v w=0.48u l=0.1u ad=0.1056p as=0.1056p pd=0.92u ps=0.92u
    I_MXI152_I11_MP2 (VDD p7_3 XI152_I11_p1 VDD) gpdk090_pmos1v w=0.48u l=0.1u ad=0.1056p as=0.1056p pd=0.92u ps=0.92u
    I_MXI152_I11_MP3 (XI152_I11_p1 XI152_I11_Bn VDD VDD) gpdk090_pmos1v w=0.48u l=0.1u ad=0.1632p as=0.1056p pd=1.64u ps=0.92u
    I_MXI152_I11_MP0 (VDD p7_3 XI152_I11_An VDD) gpdk090_pmos1v w=0.24u l=0.1u ad=0.0816p as=0.0816p pd=1.16u ps=1.16u
    I_MXI132_I38_MP1 (VDD I132_G0_0 XI132_I38_Bn VDD) gpdk090_pmos1v w=0.24u l=0.1u ad=0.0816p as=0.0816p pd=1.16u ps=1.16u
    I_MXI132_I38_MP5 (p7_1 I132_G0_0 XI132_I38_p1 VDD) gpdk090_pmos1v w=0.48u l=0.1u ad=0.1056p as=0.1632p pd=0.92u ps=1.64u
    I_MXI132_I38_MP4 (XI132_I38_p1 XI132_I38_An p7_1 VDD) gpdk090_pmos1v w=0.48u l=0.1u ad=0.1056p as=0.1056p pd=0.92u ps=0.92u
    I_MXI132_I38_MP2 (VDD I132_pn1 XI132_I38_p1 VDD) gpdk090_pmos1v w=0.48u l=0.1u ad=0.1056p as=0.1056p pd=0.92u ps=0.92u
    I_MXI132_I38_MP3 (XI132_I38_p1 XI132_I38_Bn VDD VDD) gpdk090_pmos1v w=0.48u l=0.1u ad=0.1632p as=0.1056p pd=1.64u ps=0.92u
    I_MXI132_I38_MP0 (VDD I132_pn1 XI132_I38_An VDD) gpdk090_pmos1v w=0.24u l=0.1u ad=0.0816p as=0.0816p pd=1.16u ps=1.16u
    I_MXI132_I37_MP1 (VDD qu1 XI132_I37_Bn VDD) gpdk090_pmos1v w=0.24u l=0.1u ad=0.0816p as=0.0816p pd=1.16u ps=1.16u
    I_MXI132_I37_MP5 (p7_0 qu1 XI132_I37_p1 VDD) gpdk090_pmos1v w=0.48u l=0.1u ad=0.1056p as=0.1632p pd=0.92u ps=1.64u
    I_MXI132_I37_MP4 (XI132_I37_p1 XI132_I37_An p7_0 VDD) gpdk090_pmos1v w=0.48u l=0.1u ad=0.1056p as=0.1056p pd=0.92u ps=0.92u
    I_MXI132_I37_MP2 (VDD I132_pn0 XI132_I37_p1 VDD) gpdk090_pmos1v w=0.48u l=0.1u ad=0.1056p as=0.1056p pd=0.92u ps=0.92u
    I_MXI132_I37_MP3 (XI132_I37_p1 XI132_I37_Bn VDD VDD) gpdk090_pmos1v w=0.48u l=0.1u ad=0.1632p as=0.1056p pd=1.64u ps=0.92u
    I_MXI132_I37_MP0 (VDD I132_pn0 XI132_I37_An VDD) gpdk090_pmos1v w=0.24u l=0.1u ad=0.0816p as=0.0816p pd=1.16u ps=1.16u
    I_MXI132_I8_MP1 (VDD b7_0 XI132_I8_Bn VDD) gpdk090_pmos1v w=0.24u l=0.1u ad=0.0816p as=0.0816p pd=1.16u ps=1.16u
    I_MXI132_I8_MP5 (I132_pn0 b7_0 XI132_I8_p1 VDD) gpdk090_pmos1v w=0.48u l=0.1u ad=0.1056p as=0.1632p pd=0.92u ps=1.64u
    I_MXI132_I8_MP4 (XI132_I8_p1 XI132_I8_An I132_pn0 VDD) gpdk090_pmos1v w=0.48u l=0.1u ad=0.1056p as=0.1056p pd=0.92u ps=0.92u
    I_MXI132_I8_MP2 (VDD A_0 XI132_I8_p1 VDD) gpdk090_pmos1v w=0.48u l=0.1u ad=0.1056p as=0.1056p pd=0.92u ps=0.92u
    I_MXI132_I8_MP3 (XI132_I8_p1 XI132_I8_Bn VDD VDD) gpdk090_pmos1v w=0.48u l=0.1u ad=0.1632p as=0.1056p pd=1.64u ps=0.92u
    I_MXI132_I8_MP0 (VDD A_0 XI132_I8_An VDD) gpdk090_pmos1v w=0.24u l=0.1u ad=0.0816p as=0.0816p pd=1.16u ps=1.16u
    I_MXI1_MP1 (VDD nakn1 XI1_Bn VDD) gpdk090_pmos1v w=0.24u l=0.1u ad=0.0816p as=0.0816p pd=1.16u ps=1.16u
    I_MXI1_MP5 (aa1 nakn1 XI1_p1 VDD) gpdk090_pmos1v w=0.48u l=0.1u ad=0.1056p as=0.1632p pd=0.92u ps=1.64u
    I_MXI1_MP4 (XI1_p1 XI1_An aa1 VDD) gpdk090_pmos1v w=0.48u l=0.1u ad=0.1056p as=0.1056p pd=0.92u ps=0.92u
    I_MXI1_MP2 (VDD A_1 XI1_p1 VDD) gpdk090_pmos1v w=0.48u l=0.1u ad=0.1056p as=0.1056p pd=0.92u ps=0.92u
    I_MXI1_MP3 (XI1_p1 XI1_Bn VDD VDD) gpdk090_pmos1v w=0.48u l=0.1u ad=0.1632p as=0.1056p pd=1.64u ps=0.92u
    I_MXI1_MP0 (VDD A_1 XI1_An VDD) gpdk090_pmos1v w=0.24u l=0.1u ad=0.0816p as=0.0816p pd=1.16u ps=1.16u
    I_MXI155_MP1 (VDD nqkn1 XI155_Bn VDD) gpdk090_pmos1v w=0.24u l=0.1u ad=0.0816p as=0.0816p pd=1.16u ps=1.16u
    I_MXI155_MP5 (Q_1 nqkn1 XI155_p1 VDD) gpdk090_pmos1v w=0.48u l=0.1u ad=0.1056p as=0.1632p pd=0.92u ps=1.64u
    I_MXI155_MP4 (XI155_p1 XI155_An Q_1 VDD) gpdk090_pmos1v w=0.48u l=0.1u ad=0.1056p as=0.1056p pd=0.92u ps=0.92u
    I_MXI155_MP2 (VDD qu1 XI155_p1 VDD) gpdk090_pmos1v w=0.48u l=0.1u ad=0.1056p as=0.1056p pd=0.92u ps=0.92u
    I_MXI155_MP3 (XI155_p1 XI155_Bn VDD VDD) gpdk090_pmos1v w=0.48u l=0.1u ad=0.1632p as=0.1056p pd=1.64u ps=0.92u
    I_MXI155_MP0 (VDD qu1 XI155_An VDD) gpdk090_pmos1v w=0.24u l=0.1u ad=0.0816p as=0.0816p pd=1.16u ps=1.16u
    I_MXI158_MP1 (VDD nqkn2 XI158_Bn VDD) gpdk090_pmos1v w=0.24u l=0.1u ad=0.0816p as=0.0816p pd=1.16u ps=1.16u
    I_MXI158_MP5 (Q_2 nqkn2 XI158_p1 VDD) gpdk090_pmos1v w=0.48u l=0.1u ad=0.1056p as=0.1632p pd=0.92u ps=1.64u
    I_MXI158_MP4 (XI158_p1 XI158_An Q_2 VDD) gpdk090_pmos1v w=0.48u l=0.1u ad=0.1056p as=0.1056p pd=0.92u ps=0.92u
    I_MXI158_MP2 (VDD qu2 XI158_p1 VDD) gpdk090_pmos1v w=0.48u l=0.1u ad=0.1056p as=0.1056p pd=0.92u ps=0.92u
    I_MXI158_MP3 (XI158_p1 XI158_Bn VDD VDD) gpdk090_pmos1v w=0.48u l=0.1u ad=0.1632p as=0.1056p pd=1.64u ps=0.92u
    I_MXI158_MP0 (VDD qu2 XI158_An VDD) gpdk090_pmos1v w=0.24u l=0.1u ad=0.0816p as=0.0816p pd=1.16u ps=1.16u
    I_MXI161_MP1 (VDD nqkn3 XI161_Bn VDD) gpdk090_pmos1v w=0.24u l=0.1u ad=0.0816p as=0.0816p pd=1.16u ps=1.16u
    I_MXI161_MP5 (Q_3 nqkn3 XI161_p1 VDD) gpdk090_pmos1v w=0.48u l=0.1u ad=0.1056p as=0.1632p pd=0.92u ps=1.64u
    I_MXI161_MP4 (XI161_p1 XI161_An Q_3 VDD) gpdk090_pmos1v w=0.48u l=0.1u ad=0.1056p as=0.1056p pd=0.92u ps=0.92u
    I_MXI161_MP2 (VDD qu3 XI161_p1 VDD) gpdk090_pmos1v w=0.48u l=0.1u ad=0.1056p as=0.1056p pd=0.92u ps=0.92u
    I_MXI161_MP3 (XI161_p1 XI161_Bn VDD VDD) gpdk090_pmos1v w=0.48u l=0.1u ad=0.1632p as=0.1056p pd=1.64u ps=0.92u
    I_MXI161_MP0 (VDD qu3 XI161_An VDD) gpdk090_pmos1v w=0.24u l=0.1u ad=0.0816p as=0.0816p pd=1.16u ps=1.16u
    I_MXI10_MP1 (VDD nakn4 XI10_Bn VDD) gpdk090_pmos1v w=0.24u l=0.1u ad=0.0816p as=0.0816p pd=1.16u ps=1.16u
    I_MXI10_MP5 (aa4 nakn4 XI10_p1 VDD) gpdk090_pmos1v w=0.48u l=0.1u ad=0.1056p as=0.1632p pd=0.92u ps=1.64u
    I_MXI10_MP4 (XI10_p1 XI10_An aa4 VDD) gpdk090_pmos1v w=0.48u l=0.1u ad=0.1056p as=0.1056p pd=0.92u ps=0.92u
    I_MXI10_MP2 (VDD A_4 XI10_p1 VDD) gpdk090_pmos1v w=0.48u l=0.1u ad=0.1056p as=0.1056p pd=0.92u ps=0.92u
    I_MXI10_MP3 (XI10_p1 XI10_Bn VDD VDD) gpdk090_pmos1v w=0.48u l=0.1u ad=0.1632p as=0.1056p pd=1.64u ps=0.92u
    I_MXI10_MP0 (VDD A_4 XI10_An VDD) gpdk090_pmos1v w=0.24u l=0.1u ad=0.0816p as=0.0816p pd=1.16u ps=1.16u
    I_MXI84_I8_MP1 (VDD b3_0 XI84_I8_Bn VDD) gpdk090_pmos1v w=0.24u l=0.1u ad=0.0816p as=0.0816p pd=1.16u ps=1.16u
    I_MXI84_I8_MP5 (I84_pn0 b3_0 XI84_I8_p1 VDD) gpdk090_pmos1v w=0.48u l=0.1u ad=0.1056p as=0.1632p pd=0.92u ps=1.64u
    I_MXI84_I8_MP4 (XI84_I8_p1 XI84_I8_An I84_pn0 VDD) gpdk090_pmos1v w=0.48u l=0.1u ad=0.1056p as=0.1056p pd=0.92u ps=0.92u
    I_MXI84_I8_MP2 (VDD aa4 XI84_I8_p1 VDD) gpdk090_pmos1v w=0.48u l=0.1u ad=0.1056p as=0.1056p pd=0.92u ps=0.92u
    I_MXI84_I8_MP3 (XI84_I8_p1 XI84_I8_Bn VDD VDD) gpdk090_pmos1v w=0.48u l=0.1u ad=0.1632p as=0.1056p pd=1.64u ps=0.92u
    I_MXI84_I8_MP0 (VDD aa4 XI84_I8_An VDD) gpdk090_pmos1v w=0.24u l=0.1u ad=0.0816p as=0.0816p pd=1.16u ps=1.16u
    I_MXI84_I37_MP1 (VDD qu5 XI84_I37_Bn VDD) gpdk090_pmos1v w=0.24u l=0.1u ad=0.0816p as=0.0816p pd=1.16u ps=1.16u
    I_MXI84_I37_MP5 (p3_0 qu5 XI84_I37_p1 VDD) gpdk090_pmos1v w=0.48u l=0.1u ad=0.1056p as=0.1632p pd=0.92u ps=1.64u
    I_MXI84_I37_MP4 (XI84_I37_p1 XI84_I37_An p3_0 VDD) gpdk090_pmos1v w=0.48u l=0.1u ad=0.1056p as=0.1056p pd=0.92u ps=0.92u
    I_MXI84_I37_MP2 (VDD I84_pn0 XI84_I37_p1 VDD) gpdk090_pmos1v w=0.48u l=0.1u ad=0.1056p as=0.1056p pd=0.92u ps=0.92u
    I_MXI84_I37_MP3 (XI84_I37_p1 XI84_I37_Bn VDD VDD) gpdk090_pmos1v w=0.48u l=0.1u ad=0.1632p as=0.1056p pd=1.64u ps=0.92u
    I_MXI84_I37_MP0 (VDD I84_pn0 XI84_I37_An VDD) gpdk090_pmos1v w=0.24u l=0.1u ad=0.0816p as=0.0816p pd=1.16u ps=1.16u
    I_MXI96_I11_MP1 (VDD b4_3 XI96_I11_Bn VDD) gpdk090_pmos1v w=0.24u l=0.1u ad=0.0816p as=0.0816p pd=1.16u ps=1.16u
    I_MXI96_I11_MP5 (I96_pn3 b4_3 XI96_I11_p1 VDD) gpdk090_pmos1v w=0.48u l=0.1u ad=0.1056p as=0.1632p pd=0.92u ps=1.64u
    I_MXI96_I11_MP4 (XI96_I11_p1 XI96_I11_An I96_pn3 VDD) gpdk090_pmos1v w=0.48u l=0.1u ad=0.1056p as=0.1056p pd=0.92u ps=0.92u
    I_MXI96_I11_MP2 (VDD p3_2 XI96_I11_p1 VDD) gpdk090_pmos1v w=0.48u l=0.1u ad=0.1056p as=0.1056p pd=0.92u ps=0.92u
    I_MXI96_I11_MP3 (XI96_I11_p1 XI96_I11_Bn VDD VDD) gpdk090_pmos1v w=0.48u l=0.1u ad=0.1632p as=0.1056p pd=1.64u ps=0.92u
    I_MXI96_I11_MP0 (VDD p3_2 XI96_I11_An VDD) gpdk090_pmos1v w=0.24u l=0.1u ad=0.0816p as=0.0816p pd=1.16u ps=1.16u
    I_MXI96_I12_MP1 (VDD b4_4 XI96_I12_Bn VDD) gpdk090_pmos1v w=0.24u l=0.1u ad=0.0816p as=0.0816p pd=1.16u ps=1.16u
    I_MXI96_I12_MP5 (I96_pn4 b4_4 XI96_I12_p1 VDD) gpdk090_pmos1v w=0.48u l=0.1u ad=0.1056p as=0.1632p pd=0.92u ps=1.64u
    I_MXI96_I12_MP4 (XI96_I12_p1 XI96_I12_An I96_pn4 VDD) gpdk090_pmos1v w=0.48u l=0.1u ad=0.1056p as=0.1056p pd=0.92u ps=0.92u
    I_MXI96_I12_MP2 (VDD p3_3 XI96_I12_p1 VDD) gpdk090_pmos1v w=0.48u l=0.1u ad=0.1056p as=0.1056p pd=0.92u ps=0.92u
    I_MXI96_I12_MP3 (XI96_I12_p1 XI96_I12_Bn VDD VDD) gpdk090_pmos1v w=0.48u l=0.1u ad=0.1632p as=0.1056p pd=1.64u ps=0.92u
    I_MXI96_I12_MP0 (VDD p3_3 XI96_I12_An VDD) gpdk090_pmos1v w=0.24u l=0.1u ad=0.0816p as=0.0816p pd=1.16u ps=1.16u
    I_MXI96_I13_MP1 (VDD b4_5 XI96_I13_Bn VDD) gpdk090_pmos1v w=0.24u l=0.1u ad=0.0816p as=0.0816p pd=1.16u ps=1.16u
    I_MXI96_I13_MP5 (I96_pn5 b4_5 XI96_I13_p1 VDD) gpdk090_pmos1v w=0.48u l=0.1u ad=0.1056p as=0.1632p pd=0.92u ps=1.64u
    I_MXI96_I13_MP4 (XI96_I13_p1 XI96_I13_An I96_pn5 VDD) gpdk090_pmos1v w=0.48u l=0.1u ad=0.1056p as=0.1056p pd=0.92u ps=0.92u
    I_MXI96_I13_MP2 (VDD p3_4 XI96_I13_p1 VDD) gpdk090_pmos1v w=0.48u l=0.1u ad=0.1056p as=0.1056p pd=0.92u ps=0.92u
    I_MXI96_I13_MP3 (XI96_I13_p1 XI96_I13_Bn VDD VDD) gpdk090_pmos1v w=0.48u l=0.1u ad=0.1632p as=0.1056p pd=1.64u ps=0.92u
    I_MXI96_I13_MP0 (VDD p3_4 XI96_I13_An VDD) gpdk090_pmos1v w=0.24u l=0.1u ad=0.0816p as=0.0816p pd=1.16u ps=1.16u
    I_MXI152_I10_MP1 (VDD dm2 XI152_I10_Bn VDD) gpdk090_pmos1v w=0.24u l=0.1u ad=0.0816p as=0.0816p pd=1.16u ps=1.16u
    I_MXI152_I10_MP5 (I152_pn2 dm2 XI152_I10_p1 VDD) gpdk090_pmos1v w=0.48u l=0.1u ad=0.1056p as=0.1632p pd=0.92u ps=1.64u
    I_MXI152_I10_MP4 (XI152_I10_p1 XI152_I10_An I152_pn2 VDD) gpdk090_pmos1v w=0.48u l=0.1u ad=0.1056p as=0.1056p pd=0.92u ps=0.92u
    I_MXI152_I10_MP2 (VDD p7_2 XI152_I10_p1 VDD) gpdk090_pmos1v w=0.48u l=0.1u ad=0.1056p as=0.1056p pd=0.92u ps=0.92u
    I_MXI152_I10_MP3 (XI152_I10_p1 XI152_I10_Bn VDD VDD) gpdk090_pmos1v w=0.48u l=0.1u ad=0.1632p as=0.1056p pd=1.64u ps=0.92u
    I_MXI152_I10_MP0 (VDD p7_2 XI152_I10_An VDD) gpdk090_pmos1v w=0.24u l=0.1u ad=0.0816p as=0.0816p pd=1.16u ps=1.16u
    I_MXI152_I8_MP1 (VDD dm0 XI152_I8_Bn VDD) gpdk090_pmos1v w=0.24u l=0.1u ad=0.0816p as=0.0816p pd=1.16u ps=1.16u
    I_MXI152_I8_MP5 (I152_pn0 dm0 XI152_I8_p1 VDD) gpdk090_pmos1v w=0.48u l=0.1u ad=0.1056p as=0.1632p pd=0.92u ps=1.64u
    I_MXI152_I8_MP4 (XI152_I8_p1 XI152_I8_An I152_pn0 VDD) gpdk090_pmos1v w=0.48u l=0.1u ad=0.1056p as=0.1056p pd=0.92u ps=0.92u
    I_MXI152_I8_MP2 (VDD p7_0 XI152_I8_p1 VDD) gpdk090_pmos1v w=0.48u l=0.1u ad=0.1056p as=0.1056p pd=0.92u ps=0.92u
    I_MXI152_I8_MP3 (XI152_I8_p1 XI152_I8_Bn VDD VDD) gpdk090_pmos1v w=0.48u l=0.1u ad=0.1632p as=0.1056p pd=1.64u ps=0.92u
    I_MXI152_I8_MP0 (VDD p7_0 XI152_I8_An VDD) gpdk090_pmos1v w=0.24u l=0.1u ad=0.0816p as=0.0816p pd=1.16u ps=1.16u
    I_MXI36_MP1 (VDD nbkn6 XI36_Bn VDD) gpdk090_pmos1v w=0.24u l=0.1u ad=0.0816p as=0.0816p pd=1.16u ps=1.16u
    I_MXI36_MP5 (dd6 nbkn6 XI36_p1 VDD) gpdk090_pmos1v w=0.48u l=0.1u ad=0.1056p as=0.1632p pd=0.92u ps=1.64u
    I_MXI36_MP4 (XI36_p1 XI36_An dd6 VDD) gpdk090_pmos1v w=0.48u l=0.1u ad=0.1056p as=0.1056p pd=0.92u ps=0.92u
    I_MXI36_MP2 (VDD B_6 XI36_p1 VDD) gpdk090_pmos1v w=0.48u l=0.1u ad=0.1056p as=0.1056p pd=0.92u ps=0.92u
    I_MXI36_MP3 (XI36_p1 XI36_Bn VDD VDD) gpdk090_pmos1v w=0.48u l=0.1u ad=0.1632p as=0.1056p pd=1.64u ps=0.92u
    I_MXI36_MP0 (VDD B_6 XI36_An VDD) gpdk090_pmos1v w=0.24u l=0.1u ad=0.0816p as=0.0816p pd=1.16u ps=1.16u
    I_MXI39_MP1 (VDD nbkn7 XI39_Bn VDD) gpdk090_pmos1v w=0.24u l=0.1u ad=0.0816p as=0.0816p pd=1.16u ps=1.16u
    I_MXI39_MP5 (dd7 nbkn7 XI39_p1 VDD) gpdk090_pmos1v w=0.48u l=0.1u ad=0.1056p as=0.1632p pd=0.92u ps=1.64u
    I_MXI39_MP4 (XI39_p1 XI39_An dd7 VDD) gpdk090_pmos1v w=0.48u l=0.1u ad=0.1056p as=0.1056p pd=0.92u ps=0.92u
    I_MXI39_MP2 (VDD B_7 XI39_p1 VDD) gpdk090_pmos1v w=0.48u l=0.1u ad=0.1056p as=0.1056p pd=0.92u ps=0.92u
    I_MXI39_MP3 (XI39_p1 XI39_Bn VDD VDD) gpdk090_pmos1v w=0.48u l=0.1u ad=0.1632p as=0.1056p pd=1.64u ps=0.92u
    I_MXI39_MP0 (VDD B_7 XI39_An VDD) gpdk090_pmos1v w=0.24u l=0.1u ad=0.0816p as=0.0816p pd=1.16u ps=1.16u
    I_MXI167_MP1 (VDD nqkn5 XI167_Bn VDD) gpdk090_pmos1v w=0.24u l=0.1u ad=0.0816p as=0.0816p pd=1.16u ps=1.16u
    I_MXI167_MP5 (Q_5 nqkn5 XI167_p1 VDD) gpdk090_pmos1v w=0.48u l=0.1u ad=0.1056p as=0.1632p pd=0.92u ps=1.64u
    I_MXI167_MP4 (XI167_p1 XI167_An Q_5 VDD) gpdk090_pmos1v w=0.48u l=0.1u ad=0.1056p as=0.1056p pd=0.92u ps=0.92u
    I_MXI167_MP2 (VDD qu5 XI167_p1 VDD) gpdk090_pmos1v w=0.48u l=0.1u ad=0.1056p as=0.1056p pd=0.92u ps=0.92u
    I_MXI167_MP3 (XI167_p1 XI167_Bn VDD VDD) gpdk090_pmos1v w=0.48u l=0.1u ad=0.1632p as=0.1056p pd=1.64u ps=0.92u
    I_MXI167_MP0 (VDD qu5 XI167_An VDD) gpdk090_pmos1v w=0.24u l=0.1u ad=0.0816p as=0.0816p pd=1.16u ps=1.16u
    I_MXI84_I9_MP1 (VDD b3_1 XI84_I9_Bn VDD) gpdk090_pmos1v w=0.24u l=0.1u ad=0.0816p as=0.0816p pd=1.16u ps=1.16u
    I_MXI84_I9_MP5 (I84_pn1 b3_1 XI84_I9_p1 VDD) gpdk090_pmos1v w=0.48u l=0.1u ad=0.1056p as=0.1632p pd=0.92u ps=1.64u
    I_MXI84_I9_MP4 (XI84_I9_p1 XI84_I9_An I84_pn1 VDD) gpdk090_pmos1v w=0.48u l=0.1u ad=0.1056p as=0.1056p pd=0.92u ps=0.92u
    I_MXI84_I9_MP2 (VDD p2_0 XI84_I9_p1 VDD) gpdk090_pmos1v w=0.48u l=0.1u ad=0.1056p as=0.1056p pd=0.92u ps=0.92u
    I_MXI84_I9_MP3 (XI84_I9_p1 XI84_I9_Bn VDD VDD) gpdk090_pmos1v w=0.48u l=0.1u ad=0.1632p as=0.1056p pd=1.64u ps=0.92u
    I_MXI84_I9_MP0 (VDD p2_0 XI84_I9_An VDD) gpdk090_pmos1v w=0.24u l=0.1u ad=0.0816p as=0.0816p pd=1.16u ps=1.16u
    I_MXI84_I38_MP1 (VDD I84_G0_0 XI84_I38_Bn VDD) gpdk090_pmos1v w=0.24u l=0.1u ad=0.0816p as=0.0816p pd=1.16u ps=1.16u
    I_MXI84_I38_MP5 (p3_1 I84_G0_0 XI84_I38_p1 VDD) gpdk090_pmos1v w=0.48u l=0.1u ad=0.1056p as=0.1632p pd=0.92u ps=1.64u
    I_MXI84_I38_MP4 (XI84_I38_p1 XI84_I38_An p3_1 VDD) gpdk090_pmos1v w=0.48u l=0.1u ad=0.1056p as=0.1056p pd=0.92u ps=0.92u
    I_MXI84_I38_MP2 (VDD I84_pn1 XI84_I38_p1 VDD) gpdk090_pmos1v w=0.48u l=0.1u ad=0.1056p as=0.1056p pd=0.92u ps=0.92u
    I_MXI84_I38_MP3 (XI84_I38_p1 XI84_I38_Bn VDD VDD) gpdk090_pmos1v w=0.48u l=0.1u ad=0.1632p as=0.1056p pd=1.64u ps=0.92u
    I_MXI84_I38_MP0 (VDD I84_pn1 XI84_I38_An VDD) gpdk090_pmos1v w=0.24u l=0.1u ad=0.0816p as=0.0816p pd=1.16u ps=1.16u
    I_MXI84_I42_MP1 (VDD I84_G4_0 XI84_I42_Bn VDD) gpdk090_pmos1v w=0.24u l=0.1u ad=0.0816p as=0.0816p pd=1.16u ps=1.16u
    I_MXI84_I42_MP5 (p3_5 I84_G4_0 XI84_I42_p1 VDD) gpdk090_pmos1v w=0.48u l=0.1u ad=0.1056p as=0.1632p pd=0.92u ps=1.64u
    I_MXI84_I42_MP4 (XI84_I42_p1 XI84_I42_An p3_5 VDD) gpdk090_pmos1v w=0.48u l=0.1u ad=0.1056p as=0.1056p pd=0.92u ps=0.92u
    I_MXI84_I42_MP2 (VDD I84_pn5 XI84_I42_p1 VDD) gpdk090_pmos1v w=0.48u l=0.1u ad=0.1056p as=0.1056p pd=0.92u ps=0.92u
    I_MXI84_I42_MP3 (XI84_I42_p1 XI84_I42_Bn VDD VDD) gpdk090_pmos1v w=0.48u l=0.1u ad=0.1632p as=0.1056p pd=1.64u ps=0.92u
    I_MXI84_I42_MP0 (VDD I84_pn5 XI84_I42_An VDD) gpdk090_pmos1v w=0.24u l=0.1u ad=0.0816p as=0.0816p pd=1.16u ps=1.16u
    I_MXI84_I44_MP1 (VDD c3_7 XI84_I44_Bn VDD) gpdk090_pmos1v w=0.24u l=0.1u ad=0.0816p as=0.0816p pd=1.16u ps=1.16u
    I_MXI84_I44_MP5 (p3_7 c3_7 XI84_I44_p1 VDD) gpdk090_pmos1v w=0.48u l=0.1u ad=0.1056p as=0.1632p pd=0.92u ps=1.64u
    I_MXI84_I44_MP4 (XI84_I44_p1 XI84_I44_An p3_7 VDD) gpdk090_pmos1v w=0.48u l=0.1u ad=0.1056p as=0.1056p pd=0.92u ps=0.92u
    I_MXI84_I44_MP2 (VDD I84_pn7 XI84_I44_p1 VDD) gpdk090_pmos1v w=0.48u l=0.1u ad=0.1056p as=0.1056p pd=0.92u ps=0.92u
    I_MXI84_I44_MP3 (XI84_I44_p1 XI84_I44_Bn VDD VDD) gpdk090_pmos1v w=0.48u l=0.1u ad=0.1632p as=0.1056p pd=1.64u ps=0.92u
    I_MXI84_I44_MP0 (VDD I84_pn7 XI84_I44_An VDD) gpdk090_pmos1v w=0.24u l=0.1u ad=0.0816p as=0.0816p pd=1.16u ps=1.16u
    I_MXI152_I43_MP1 (VDD I152_G5_0 XI152_I43_Bn VDD) gpdk090_pmos1v w=0.24u l=0.1u ad=0.0816p as=0.0816p pd=1.16u ps=1.16u
    I_MXI152_I43_MP5 (ru6 I152_G5_0 XI152_I43_p1 VDD) gpdk090_pmos1v w=0.48u l=0.1u ad=0.1056p as=0.1632p pd=0.92u ps=1.64u
    I_MXI152_I43_MP4 (XI152_I43_p1 XI152_I43_An ru6 VDD) gpdk090_pmos1v w=0.48u l=0.1u ad=0.1056p as=0.1056p pd=0.92u ps=0.92u
    I_MXI152_I43_MP2 (VDD I152_pn6 XI152_I43_p1 VDD) gpdk090_pmos1v w=0.48u l=0.1u ad=0.1056p as=0.1056p pd=0.92u ps=0.92u
    I_MXI152_I43_MP3 (XI152_I43_p1 XI152_I43_Bn VDD VDD) gpdk090_pmos1v w=0.48u l=0.1u ad=0.1632p as=0.1056p pd=1.64u ps=0.92u
    I_MXI152_I43_MP0 (VDD I152_pn6 XI152_I43_An VDD) gpdk090_pmos1v w=0.24u l=0.1u ad=0.0816p as=0.0816p pd=1.16u ps=1.16u
    I_MXI152_I9_MP1 (VDD dm1 XI152_I9_Bn VDD) gpdk090_pmos1v w=0.24u l=0.1u ad=0.0816p as=0.0816p pd=1.16u ps=1.16u
    I_MXI152_I9_MP5 (I152_pn1 dm1 XI152_I9_p1 VDD) gpdk090_pmos1v w=0.48u l=0.1u ad=0.1056p as=0.1632p pd=0.92u ps=1.64u
    I_MXI152_I9_MP4 (XI152_I9_p1 XI152_I9_An I152_pn1 VDD) gpdk090_pmos1v w=0.48u l=0.1u ad=0.1056p as=0.1056p pd=0.92u ps=0.92u
    I_MXI152_I9_MP2 (VDD p7_1 XI152_I9_p1 VDD) gpdk090_pmos1v w=0.48u l=0.1u ad=0.1056p as=0.1056p pd=0.92u ps=0.92u
    I_MXI152_I9_MP3 (XI152_I9_p1 XI152_I9_Bn VDD VDD) gpdk090_pmos1v w=0.48u l=0.1u ad=0.1632p as=0.1056p pd=1.64u ps=0.92u
    I_MXI152_I9_MP0 (VDD p7_1 XI152_I9_An VDD) gpdk090_pmos1v w=0.24u l=0.1u ad=0.0816p as=0.0816p pd=1.16u ps=1.16u
    I_MXI33_MP1 (VDD nbkn5 XI33_Bn VDD) gpdk090_pmos1v w=0.24u l=0.1u ad=0.0816p as=0.0816p pd=1.16u ps=1.16u
    I_MXI33_MP5 (dd5 nbkn5 XI33_p1 VDD) gpdk090_pmos1v w=0.48u l=0.1u ad=0.1056p as=0.1632p pd=0.92u ps=1.64u
    I_MXI33_MP4 (XI33_p1 XI33_An dd5 VDD) gpdk090_pmos1v w=0.48u l=0.1u ad=0.1056p as=0.1056p pd=0.92u ps=0.92u
    I_MXI33_MP2 (VDD B_5 XI33_p1 VDD) gpdk090_pmos1v w=0.48u l=0.1u ad=0.1056p as=0.1056p pd=0.92u ps=0.92u
    I_MXI33_MP3 (XI33_p1 XI33_Bn VDD VDD) gpdk090_pmos1v w=0.48u l=0.1u ad=0.1632p as=0.1056p pd=1.64u ps=0.92u
    I_MXI33_MP0 (VDD B_5 XI33_An VDD) gpdk090_pmos1v w=0.24u l=0.1u ad=0.0816p as=0.0816p pd=1.16u ps=1.16u
    I_MXI21_MP1 (VDD nbkn1 XI21_Bn VDD) gpdk090_pmos1v w=0.24u l=0.1u ad=0.0816p as=0.0816p pd=1.16u ps=1.16u
    I_MXI21_MP5 (dd1 nbkn1 XI21_p1 VDD) gpdk090_pmos1v w=0.48u l=0.1u ad=0.1056p as=0.1632p pd=0.92u ps=1.64u
    I_MXI21_MP4 (XI21_p1 XI21_An dd1 VDD) gpdk090_pmos1v w=0.48u l=0.1u ad=0.1056p as=0.1056p pd=0.92u ps=0.92u
    I_MXI21_MP2 (VDD B_1 XI21_p1 VDD) gpdk090_pmos1v w=0.48u l=0.1u ad=0.1056p as=0.1056p pd=0.92u ps=0.92u
    I_MXI21_MP3 (XI21_p1 XI21_Bn VDD VDD) gpdk090_pmos1v w=0.48u l=0.1u ad=0.1632p as=0.1056p pd=1.64u ps=0.92u
    I_MXI21_MP0 (VDD B_1 XI21_An VDD) gpdk090_pmos1v w=0.24u l=0.1u ad=0.0816p as=0.0816p pd=1.16u ps=1.16u
    I_MXI164_MP1 (VDD nqkn4 XI164_Bn VDD) gpdk090_pmos1v w=0.24u l=0.1u ad=0.0816p as=0.0816p pd=1.16u ps=1.16u
    I_MXI164_MP5 (Q_4 nqkn4 XI164_p1 VDD) gpdk090_pmos1v w=0.48u l=0.1u ad=0.1056p as=0.1632p pd=0.92u ps=1.64u
    I_MXI164_MP4 (XI164_p1 XI164_An Q_4 VDD) gpdk090_pmos1v w=0.48u l=0.1u ad=0.1056p as=0.1056p pd=0.92u ps=0.92u
    I_MXI164_MP2 (VDD qu4 XI164_p1 VDD) gpdk090_pmos1v w=0.48u l=0.1u ad=0.1056p as=0.1056p pd=0.92u ps=0.92u
    I_MXI164_MP3 (XI164_p1 XI164_Bn VDD VDD) gpdk090_pmos1v w=0.48u l=0.1u ad=0.1632p as=0.1056p pd=1.64u ps=0.92u
    I_MXI164_MP0 (VDD qu4 XI164_An VDD) gpdk090_pmos1v w=0.24u l=0.1u ad=0.0816p as=0.0816p pd=1.16u ps=1.16u
    I_MXI170_MP1 (VDD nqkn6 XI170_Bn VDD) gpdk090_pmos1v w=0.24u l=0.1u ad=0.0816p as=0.0816p pd=1.16u ps=1.16u
    I_MXI170_MP5 (Q_6 nqkn6 XI170_p1 VDD) gpdk090_pmos1v w=0.48u l=0.1u ad=0.1056p as=0.1632p pd=0.92u ps=1.64u
    I_MXI170_MP4 (XI170_p1 XI170_An Q_6 VDD) gpdk090_pmos1v w=0.48u l=0.1u ad=0.1056p as=0.1056p pd=0.92u ps=0.92u
    I_MXI170_MP2 (VDD qu6 XI170_p1 VDD) gpdk090_pmos1v w=0.48u l=0.1u ad=0.1056p as=0.1056p pd=0.92u ps=0.92u
    I_MXI170_MP3 (XI170_p1 XI170_Bn VDD VDD) gpdk090_pmos1v w=0.48u l=0.1u ad=0.1632p as=0.1056p pd=1.64u ps=0.92u
    I_MXI170_MP0 (VDD qu6 XI170_An VDD) gpdk090_pmos1v w=0.24u l=0.1u ad=0.0816p as=0.0816p pd=1.16u ps=1.16u
    I_MXI72_I37_MP1 (VDD qu6 XI72_I37_Bn VDD) gpdk090_pmos1v w=0.24u l=0.1u ad=0.0816p as=0.0816p pd=1.16u ps=1.16u
    I_MXI72_I37_MP5 (p2_0 qu6 XI72_I37_p1 VDD) gpdk090_pmos1v w=0.48u l=0.1u ad=0.1056p as=0.1632p pd=0.92u ps=1.64u
    I_MXI72_I37_MP4 (XI72_I37_p1 XI72_I37_An p2_0 VDD) gpdk090_pmos1v w=0.48u l=0.1u ad=0.1056p as=0.1056p pd=0.92u ps=0.92u
    I_MXI72_I37_MP2 (VDD I72_pn0 XI72_I37_p1 VDD) gpdk090_pmos1v w=0.48u l=0.1u ad=0.1056p as=0.1056p pd=0.92u ps=0.92u
    I_MXI72_I37_MP3 (XI72_I37_p1 XI72_I37_Bn VDD VDD) gpdk090_pmos1v w=0.48u l=0.1u ad=0.1632p as=0.1056p pd=1.64u ps=0.92u
    I_MXI72_I37_MP0 (VDD I72_pn0 XI72_I37_An VDD) gpdk090_pmos1v w=0.24u l=0.1u ad=0.0816p as=0.0816p pd=1.16u ps=1.16u
    I_MXI84_I10_MP1 (VDD b3_2 XI84_I10_Bn VDD) gpdk090_pmos1v w=0.24u l=0.1u ad=0.0816p as=0.0816p pd=1.16u ps=1.16u
    I_MXI84_I10_MP5 (I84_pn2 b3_2 XI84_I10_p1 VDD) gpdk090_pmos1v w=0.48u l=0.1u ad=0.1056p as=0.1632p pd=0.92u ps=1.64u
    I_MXI84_I10_MP4 (XI84_I10_p1 XI84_I10_An I84_pn2 VDD) gpdk090_pmos1v w=0.48u l=0.1u ad=0.1056p as=0.1056p pd=0.92u ps=0.92u
    I_MXI84_I10_MP2 (VDD p2_1 XI84_I10_p1 VDD) gpdk090_pmos1v w=0.48u l=0.1u ad=0.1056p as=0.1056p pd=0.92u ps=0.92u
    I_MXI84_I10_MP3 (XI84_I10_p1 XI84_I10_Bn VDD VDD) gpdk090_pmos1v w=0.48u l=0.1u ad=0.1632p as=0.1056p pd=1.64u ps=0.92u
    I_MXI84_I10_MP0 (VDD p2_1 XI84_I10_An VDD) gpdk090_pmos1v w=0.24u l=0.1u ad=0.0816p as=0.0816p pd=1.16u ps=1.16u
    I_MXI84_I39_MP1 (VDD I84_G1_0 XI84_I39_Bn VDD) gpdk090_pmos1v w=0.24u l=0.1u ad=0.0816p as=0.0816p pd=1.16u ps=1.16u
    I_MXI84_I39_MP5 (p3_2 I84_G1_0 XI84_I39_p1 VDD) gpdk090_pmos1v w=0.48u l=0.1u ad=0.1056p as=0.1632p pd=0.92u ps=1.64u
    I_MXI84_I39_MP4 (XI84_I39_p1 XI84_I39_An p3_2 VDD) gpdk090_pmos1v w=0.48u l=0.1u ad=0.1056p as=0.1056p pd=0.92u ps=0.92u
    I_MXI84_I39_MP2 (VDD I84_pn2 XI84_I39_p1 VDD) gpdk090_pmos1v w=0.48u l=0.1u ad=0.1056p as=0.1056p pd=0.92u ps=0.92u
    I_MXI84_I39_MP3 (XI84_I39_p1 XI84_I39_Bn VDD VDD) gpdk090_pmos1v w=0.48u l=0.1u ad=0.1632p as=0.1056p pd=1.64u ps=0.92u
    I_MXI84_I39_MP0 (VDD I84_pn2 XI84_I39_An VDD) gpdk090_pmos1v w=0.24u l=0.1u ad=0.0816p as=0.0816p pd=1.16u ps=1.16u
    I_MXI84_I43_MP1 (VDD I84_G5_0 XI84_I43_Bn VDD) gpdk090_pmos1v w=0.24u l=0.1u ad=0.0816p as=0.0816p pd=1.16u ps=1.16u
    I_MXI84_I43_MP5 (p3_6 I84_G5_0 XI84_I43_p1 VDD) gpdk090_pmos1v w=0.48u l=0.1u ad=0.1056p as=0.1632p pd=0.92u ps=1.64u
    I_MXI84_I43_MP4 (XI84_I43_p1 XI84_I43_An p3_6 VDD) gpdk090_pmos1v w=0.48u l=0.1u ad=0.1056p as=0.1056p pd=0.92u ps=0.92u
    I_MXI84_I43_MP2 (VDD I84_pn6 XI84_I43_p1 VDD) gpdk090_pmos1v w=0.48u l=0.1u ad=0.1056p as=0.1056p pd=0.92u ps=0.92u
    I_MXI84_I43_MP3 (XI84_I43_p1 XI84_I43_Bn VDD VDD) gpdk090_pmos1v w=0.48u l=0.1u ad=0.1632p as=0.1056p pd=1.64u ps=0.92u
    I_MXI84_I43_MP0 (VDD I84_pn6 XI84_I43_An VDD) gpdk090_pmos1v w=0.24u l=0.1u ad=0.0816p as=0.0816p pd=1.16u ps=1.16u
    I_MXI193_MP1 (VDD nrkn7 XI193_Bn VDD) gpdk090_pmos1v w=0.24u l=0.1u ad=0.0816p as=0.0816p pd=1.16u ps=1.16u
    I_MXI193_MP5 (R_7 nrkn7 XI193_p1 VDD) gpdk090_pmos1v w=0.48u l=0.1u ad=0.1056p as=0.1632p pd=0.92u ps=1.64u
    I_MXI193_MP4 (XI193_p1 XI193_An R_7 VDD) gpdk090_pmos1v w=0.48u l=0.1u ad=0.1056p as=0.1056p pd=0.92u ps=0.92u
    I_MXI193_MP2 (VDD ru7 XI193_p1 VDD) gpdk090_pmos1v w=0.48u l=0.1u ad=0.1056p as=0.1056p pd=0.92u ps=0.92u
    I_MXI193_MP3 (XI193_p1 XI193_Bn VDD VDD) gpdk090_pmos1v w=0.48u l=0.1u ad=0.1632p as=0.1056p pd=1.64u ps=0.92u
    I_MXI193_MP0 (VDD ru7 XI193_An VDD) gpdk090_pmos1v w=0.24u l=0.1u ad=0.0816p as=0.0816p pd=1.16u ps=1.16u
    I_MXI152_I44_MP1 (VDD rc6 XI152_I44_Bn VDD) gpdk090_pmos1v w=0.24u l=0.1u ad=0.0816p as=0.0816p pd=1.16u ps=1.16u
    I_MXI152_I44_MP5 (ru7 rc6 XI152_I44_p1 VDD) gpdk090_pmos1v w=0.48u l=0.1u ad=0.1056p as=0.1632p pd=0.92u ps=1.64u
    I_MXI152_I44_MP4 (XI152_I44_p1 XI152_I44_An ru7 VDD) gpdk090_pmos1v w=0.48u l=0.1u ad=0.1056p as=0.1056p pd=0.92u ps=0.92u
    I_MXI152_I44_MP2 (VDD I152_pn7 XI152_I44_p1 VDD) gpdk090_pmos1v w=0.48u l=0.1u ad=0.1056p as=0.1056p pd=0.92u ps=0.92u
    I_MXI152_I44_MP3 (XI152_I44_p1 XI152_I44_Bn VDD VDD) gpdk090_pmos1v w=0.48u l=0.1u ad=0.1632p as=0.1056p pd=1.64u ps=0.92u
    I_MXI152_I44_MP0 (VDD I152_pn7 XI152_I44_An VDD) gpdk090_pmos1v w=0.24u l=0.1u ad=0.0816p as=0.0816p pd=1.16u ps=1.16u
    I_MXI152_I42_MP1 (VDD I152_G4_0 XI152_I42_Bn VDD) gpdk090_pmos1v w=0.24u l=0.1u ad=0.0816p as=0.0816p pd=1.16u ps=1.16u
    I_MXI152_I42_MP5 (ru5 I152_G4_0 XI152_I42_p1 VDD) gpdk090_pmos1v w=0.48u l=0.1u ad=0.1056p as=0.1632p pd=0.92u ps=1.64u
    I_MXI152_I42_MP4 (XI152_I42_p1 XI152_I42_An ru5 VDD) gpdk090_pmos1v w=0.48u l=0.1u ad=0.1056p as=0.1056p pd=0.92u ps=0.92u
    I_MXI152_I42_MP2 (VDD I152_pn5 XI152_I42_p1 VDD) gpdk090_pmos1v w=0.48u l=0.1u ad=0.1056p as=0.1056p pd=0.92u ps=0.92u
    I_MXI152_I42_MP3 (XI152_I42_p1 XI152_I42_Bn VDD VDD) gpdk090_pmos1v w=0.48u l=0.1u ad=0.1632p as=0.1056p pd=1.64u ps=0.92u
    I_MXI152_I42_MP0 (VDD I152_pn5 XI152_I42_An VDD) gpdk090_pmos1v w=0.24u l=0.1u ad=0.0816p as=0.0816p pd=1.16u ps=1.16u
    I_MXI152_I39_MP1 (VDD I152_G1_0 XI152_I39_Bn VDD) gpdk090_pmos1v w=0.24u l=0.1u ad=0.0816p as=0.0816p pd=1.16u ps=1.16u
    I_MXI152_I39_MP5 (ru2 I152_G1_0 XI152_I39_p1 VDD) gpdk090_pmos1v w=0.48u l=0.1u ad=0.1056p as=0.1632p pd=0.92u ps=1.64u
    I_MXI152_I39_MP4 (XI152_I39_p1 XI152_I39_An ru2 VDD) gpdk090_pmos1v w=0.48u l=0.1u ad=0.1056p as=0.1056p pd=0.92u ps=0.92u
    I_MXI152_I39_MP2 (VDD I152_pn2 XI152_I39_p1 VDD) gpdk090_pmos1v w=0.48u l=0.1u ad=0.1056p as=0.1056p pd=0.92u ps=0.92u
    I_MXI152_I39_MP3 (XI152_I39_p1 XI152_I39_Bn VDD VDD) gpdk090_pmos1v w=0.48u l=0.1u ad=0.1632p as=0.1056p pd=1.64u ps=0.92u
    I_MXI152_I39_MP0 (VDD I152_pn2 XI152_I39_An VDD) gpdk090_pmos1v w=0.24u l=0.1u ad=0.0816p as=0.0816p pd=1.16u ps=1.16u
    I_MXI152_I38_MP1 (VDD I152_G0_0 XI152_I38_Bn VDD) gpdk090_pmos1v w=0.24u l=0.1u ad=0.0816p as=0.0816p pd=1.16u ps=1.16u
    I_MXI152_I38_MP5 (ru1 I152_G0_0 XI152_I38_p1 VDD) gpdk090_pmos1v w=0.48u l=0.1u ad=0.1056p as=0.1632p pd=0.92u ps=1.64u
    I_MXI152_I38_MP4 (XI152_I38_p1 XI152_I38_An ru1 VDD) gpdk090_pmos1v w=0.48u l=0.1u ad=0.1056p as=0.1056p pd=0.92u ps=0.92u
    I_MXI152_I38_MP2 (VDD I152_pn1 XI152_I38_p1 VDD) gpdk090_pmos1v w=0.48u l=0.1u ad=0.1056p as=0.1056p pd=0.92u ps=0.92u
    I_MXI152_I38_MP3 (XI152_I38_p1 XI152_I38_Bn VDD VDD) gpdk090_pmos1v w=0.48u l=0.1u ad=0.1632p as=0.1056p pd=1.64u ps=0.92u
    I_MXI152_I38_MP0 (VDD I152_pn1 XI152_I38_An VDD) gpdk090_pmos1v w=0.24u l=0.1u ad=0.0816p as=0.0816p pd=1.16u ps=1.16u
    I_MXI175_MP1 (VDD nrkn1 XI175_Bn VDD) gpdk090_pmos1v w=0.24u l=0.1u ad=0.0816p as=0.0816p pd=1.16u ps=1.16u
    I_MXI175_MP5 (R_1 nrkn1 XI175_p1 VDD) gpdk090_pmos1v w=0.48u l=0.1u ad=0.1056p as=0.1632p pd=0.92u ps=1.64u
    I_MXI175_MP4 (XI175_p1 XI175_An R_1 VDD) gpdk090_pmos1v w=0.48u l=0.1u ad=0.1056p as=0.1056p pd=0.92u ps=0.92u
    I_MXI175_MP2 (VDD ru1 XI175_p1 VDD) gpdk090_pmos1v w=0.48u l=0.1u ad=0.1056p as=0.1056p pd=0.92u ps=0.92u
    I_MXI175_MP3 (XI175_p1 XI175_Bn VDD VDD) gpdk090_pmos1v w=0.48u l=0.1u ad=0.1632p as=0.1056p pd=1.64u ps=0.92u
    I_MXI175_MP0 (VDD ru1 XI175_An VDD) gpdk090_pmos1v w=0.24u l=0.1u ad=0.0816p as=0.0816p pd=1.16u ps=1.16u
    I_MXI152_I37_MP1 (VDD VSS XI152_I37_Bn VDD) gpdk090_pmos1v w=0.24u l=0.1u ad=0.0816p as=0.0816p pd=1.16u ps=1.16u
    I_MXI152_I37_MP5 (R_0 VSS XI152_I37_p1 VDD) gpdk090_pmos1v w=0.48u l=0.1u ad=0.1056p as=0.1632p pd=0.92u ps=1.64u
    I_MXI152_I37_MP4 (XI152_I37_p1 XI152_I37_An R_0 VDD) gpdk090_pmos1v w=0.48u l=0.1u ad=0.1056p as=0.1056p pd=0.92u ps=0.92u
    I_MXI152_I37_MP2 (VDD I152_pn0 XI152_I37_p1 VDD) gpdk090_pmos1v w=0.48u l=0.1u ad=0.1056p as=0.1056p pd=0.92u ps=0.92u
    I_MXI152_I37_MP3 (XI152_I37_p1 XI152_I37_Bn VDD VDD) gpdk090_pmos1v w=0.48u l=0.1u ad=0.1632p as=0.1056p pd=1.64u ps=0.92u
    I_MXI152_I37_MP0 (VDD I152_pn0 XI152_I37_An VDD) gpdk090_pmos1v w=0.24u l=0.1u ad=0.0816p as=0.0816p pd=1.16u ps=1.16u
    I_MXI24_MP1 (VDD nbkn2 XI24_Bn VDD) gpdk090_pmos1v w=0.24u l=0.1u ad=0.0816p as=0.0816p pd=1.16u ps=1.16u
    I_MXI24_MP5 (dd2 nbkn2 XI24_p1 VDD) gpdk090_pmos1v w=0.48u l=0.1u ad=0.1056p as=0.1632p pd=0.92u ps=1.64u
    I_MXI24_MP4 (XI24_p1 XI24_An dd2 VDD) gpdk090_pmos1v w=0.48u l=0.1u ad=0.1056p as=0.1056p pd=0.92u ps=0.92u
    I_MXI24_MP2 (VDD B_2 XI24_p1 VDD) gpdk090_pmos1v w=0.48u l=0.1u ad=0.1056p as=0.1056p pd=0.92u ps=0.92u
    I_MXI24_MP3 (XI24_p1 XI24_Bn VDD VDD) gpdk090_pmos1v w=0.48u l=0.1u ad=0.1632p as=0.1056p pd=1.64u ps=0.92u
    I_MXI24_MP0 (VDD B_2 XI24_An VDD) gpdk090_pmos1v w=0.24u l=0.1u ad=0.0816p as=0.0816p pd=1.16u ps=1.16u
    I_MXI173_MP1 (VDD nqkn7 XI173_Bn VDD) gpdk090_pmos1v w=0.24u l=0.1u ad=0.0816p as=0.0816p pd=1.16u ps=1.16u
    I_MXI173_MP5 (Q_7 nqkn7 XI173_p1 VDD) gpdk090_pmos1v w=0.48u l=0.1u ad=0.1056p as=0.1632p pd=0.92u ps=1.64u
    I_MXI173_MP4 (XI173_p1 XI173_An Q_7 VDD) gpdk090_pmos1v w=0.48u l=0.1u ad=0.1056p as=0.1056p pd=0.92u ps=0.92u
    I_MXI173_MP2 (VDD qu7 XI173_p1 VDD) gpdk090_pmos1v w=0.48u l=0.1u ad=0.1056p as=0.1056p pd=0.92u ps=0.92u
    I_MXI173_MP3 (XI173_p1 XI173_Bn VDD VDD) gpdk090_pmos1v w=0.48u l=0.1u ad=0.1632p as=0.1056p pd=1.64u ps=0.92u
    I_MXI173_MP0 (VDD qu7 XI173_An VDD) gpdk090_pmos1v w=0.24u l=0.1u ad=0.0816p as=0.0816p pd=1.16u ps=1.16u
    I_MXI13_MP1 (VDD nakn5 XI13_Bn VDD) gpdk090_pmos1v w=0.24u l=0.1u ad=0.0816p as=0.0816p pd=1.16u ps=1.16u
    I_MXI13_MP5 (aa5 nakn5 XI13_p1 VDD) gpdk090_pmos1v w=0.48u l=0.1u ad=0.1056p as=0.1632p pd=0.92u ps=1.64u
    I_MXI13_MP4 (XI13_p1 XI13_An aa5 VDD) gpdk090_pmos1v w=0.48u l=0.1u ad=0.1056p as=0.1056p pd=0.92u ps=0.92u
    I_MXI13_MP2 (VDD A_5 XI13_p1 VDD) gpdk090_pmos1v w=0.48u l=0.1u ad=0.1056p as=0.1056p pd=0.92u ps=0.92u
    I_MXI13_MP3 (XI13_p1 XI13_Bn VDD VDD) gpdk090_pmos1v w=0.48u l=0.1u ad=0.1632p as=0.1056p pd=1.64u ps=0.92u
    I_MXI13_MP0 (VDD A_5 XI13_An VDD) gpdk090_pmos1v w=0.24u l=0.1u ad=0.0816p as=0.0816p pd=1.16u ps=1.16u
    I_MXI72_I8_MP1 (VDD b2_0 XI72_I8_Bn VDD) gpdk090_pmos1v w=0.24u l=0.1u ad=0.0816p as=0.0816p pd=1.16u ps=1.16u
    I_MXI72_I8_MP5 (I72_pn0 b2_0 XI72_I8_p1 VDD) gpdk090_pmos1v w=0.48u l=0.1u ad=0.1056p as=0.1632p pd=0.92u ps=1.64u
    I_MXI72_I8_MP4 (XI72_I8_p1 XI72_I8_An I72_pn0 VDD) gpdk090_pmos1v w=0.48u l=0.1u ad=0.1056p as=0.1056p pd=0.92u ps=0.92u
    I_MXI72_I8_MP2 (VDD aa5 XI72_I8_p1 VDD) gpdk090_pmos1v w=0.48u l=0.1u ad=0.1056p as=0.1056p pd=0.92u ps=0.92u
    I_MXI72_I8_MP3 (XI72_I8_p1 XI72_I8_Bn VDD VDD) gpdk090_pmos1v w=0.48u l=0.1u ad=0.1632p as=0.1056p pd=1.64u ps=0.92u
    I_MXI72_I8_MP0 (VDD aa5 XI72_I8_An VDD) gpdk090_pmos1v w=0.24u l=0.1u ad=0.0816p as=0.0816p pd=1.16u ps=1.16u
    I_MXI72_I38_MP1 (VDD I72_G0_0 XI72_I38_Bn VDD) gpdk090_pmos1v w=0.24u l=0.1u ad=0.0816p as=0.0816p pd=1.16u ps=1.16u
    I_MXI72_I38_MP5 (p2_1 I72_G0_0 XI72_I38_p1 VDD) gpdk090_pmos1v w=0.48u l=0.1u ad=0.1056p as=0.1632p pd=0.92u ps=1.64u
    I_MXI72_I38_MP4 (XI72_I38_p1 XI72_I38_An p2_1 VDD) gpdk090_pmos1v w=0.48u l=0.1u ad=0.1056p as=0.1056p pd=0.92u ps=0.92u
    I_MXI72_I38_MP2 (VDD I72_pn1 XI72_I38_p1 VDD) gpdk090_pmos1v w=0.48u l=0.1u ad=0.1056p as=0.1056p pd=0.92u ps=0.92u
    I_MXI72_I38_MP3 (XI72_I38_p1 XI72_I38_Bn VDD VDD) gpdk090_pmos1v w=0.48u l=0.1u ad=0.1632p as=0.1056p pd=1.64u ps=0.92u
    I_MXI72_I38_MP0 (VDD I72_pn1 XI72_I38_An VDD) gpdk090_pmos1v w=0.24u l=0.1u ad=0.0816p as=0.0816p pd=1.16u ps=1.16u
    I_MXI84_I11_MP1 (VDD b3_3 XI84_I11_Bn VDD) gpdk090_pmos1v w=0.24u l=0.1u ad=0.0816p as=0.0816p pd=1.16u ps=1.16u
    I_MXI84_I11_MP5 (I84_pn3 b3_3 XI84_I11_p1 VDD) gpdk090_pmos1v w=0.48u l=0.1u ad=0.1056p as=0.1632p pd=0.92u ps=1.64u
    I_MXI84_I11_MP4 (XI84_I11_p1 XI84_I11_An I84_pn3 VDD) gpdk090_pmos1v w=0.48u l=0.1u ad=0.1056p as=0.1056p pd=0.92u ps=0.92u
    I_MXI84_I11_MP2 (VDD p2_2 XI84_I11_p1 VDD) gpdk090_pmos1v w=0.48u l=0.1u ad=0.1056p as=0.1056p pd=0.92u ps=0.92u
    I_MXI84_I11_MP3 (XI84_I11_p1 XI84_I11_Bn VDD VDD) gpdk090_pmos1v w=0.48u l=0.1u ad=0.1632p as=0.1056p pd=1.64u ps=0.92u
    I_MXI84_I11_MP0 (VDD p2_2 XI84_I11_An VDD) gpdk090_pmos1v w=0.24u l=0.1u ad=0.0816p as=0.0816p pd=1.16u ps=1.16u
    I_MXI190_MP1 (VDD nrkn6 XI190_Bn VDD) gpdk090_pmos1v w=0.24u l=0.1u ad=0.0816p as=0.0816p pd=1.16u ps=1.16u
    I_MXI190_MP5 (R_6 nrkn6 XI190_p1 VDD) gpdk090_pmos1v w=0.48u l=0.1u ad=0.1056p as=0.1632p pd=0.92u ps=1.64u
    I_MXI190_MP4 (XI190_p1 XI190_An R_6 VDD) gpdk090_pmos1v w=0.48u l=0.1u ad=0.1056p as=0.1056p pd=0.92u ps=0.92u
    I_MXI190_MP2 (VDD ru6 XI190_p1 VDD) gpdk090_pmos1v w=0.48u l=0.1u ad=0.1056p as=0.1056p pd=0.92u ps=0.92u
    I_MXI190_MP3 (XI190_p1 XI190_Bn VDD VDD) gpdk090_pmos1v w=0.48u l=0.1u ad=0.1632p as=0.1056p pd=1.64u ps=0.92u
    I_MXI190_MP0 (VDD ru6 XI190_An VDD) gpdk090_pmos1v w=0.24u l=0.1u ad=0.0816p as=0.0816p pd=1.16u ps=1.16u
    I_MXI184_MP1 (VDD nrkn4 XI184_Bn VDD) gpdk090_pmos1v w=0.24u l=0.1u ad=0.0816p as=0.0816p pd=1.16u ps=1.16u
    I_MXI184_MP5 (R_4 nrkn4 XI184_p1 VDD) gpdk090_pmos1v w=0.48u l=0.1u ad=0.1056p as=0.1632p pd=0.92u ps=1.64u
    I_MXI184_MP4 (XI184_p1 XI184_An R_4 VDD) gpdk090_pmos1v w=0.48u l=0.1u ad=0.1056p as=0.1056p pd=0.92u ps=0.92u
    I_MXI184_MP2 (VDD ru4 XI184_p1 VDD) gpdk090_pmos1v w=0.48u l=0.1u ad=0.1056p as=0.1056p pd=0.92u ps=0.92u
    I_MXI184_MP3 (XI184_p1 XI184_Bn VDD VDD) gpdk090_pmos1v w=0.48u l=0.1u ad=0.1632p as=0.1056p pd=1.64u ps=0.92u
    I_MXI184_MP0 (VDD ru4 XI184_An VDD) gpdk090_pmos1v w=0.24u l=0.1u ad=0.0816p as=0.0816p pd=1.16u ps=1.16u
    I_MXI178_MP1 (VDD nrkn2 XI178_Bn VDD) gpdk090_pmos1v w=0.24u l=0.1u ad=0.0816p as=0.0816p pd=1.16u ps=1.16u
    I_MXI178_MP5 (R_2 nrkn2 XI178_p1 VDD) gpdk090_pmos1v w=0.48u l=0.1u ad=0.1056p as=0.1632p pd=0.92u ps=1.64u
    I_MXI178_MP4 (XI178_p1 XI178_An R_2 VDD) gpdk090_pmos1v w=0.48u l=0.1u ad=0.1056p as=0.1056p pd=0.92u ps=0.92u
    I_MXI178_MP2 (VDD ru2 XI178_p1 VDD) gpdk090_pmos1v w=0.48u l=0.1u ad=0.1056p as=0.1056p pd=0.92u ps=0.92u
    I_MXI178_MP3 (XI178_p1 XI178_Bn VDD VDD) gpdk090_pmos1v w=0.48u l=0.1u ad=0.1632p as=0.1056p pd=1.64u ps=0.92u
    I_MXI178_MP0 (VDD ru2 XI178_An VDD) gpdk090_pmos1v w=0.24u l=0.1u ad=0.0816p as=0.0816p pd=1.16u ps=1.16u
    I_MXI27_MP1 (VDD nbkn3 XI27_Bn VDD) gpdk090_pmos1v w=0.24u l=0.1u ad=0.0816p as=0.0816p pd=1.16u ps=1.16u
    I_MXI27_MP5 (dd3 nbkn3 XI27_p1 VDD) gpdk090_pmos1v w=0.48u l=0.1u ad=0.1056p as=0.1632p pd=0.92u ps=1.64u
    I_MXI27_MP4 (XI27_p1 XI27_An dd3 VDD) gpdk090_pmos1v w=0.48u l=0.1u ad=0.1056p as=0.1056p pd=0.92u ps=0.92u
    I_MXI27_MP2 (VDD B_3 XI27_p1 VDD) gpdk090_pmos1v w=0.48u l=0.1u ad=0.1056p as=0.1056p pd=0.92u ps=0.92u
    I_MXI27_MP3 (XI27_p1 XI27_Bn VDD VDD) gpdk090_pmos1v w=0.48u l=0.1u ad=0.1632p as=0.1056p pd=1.64u ps=0.92u
    I_MXI27_MP0 (VDD B_3 XI27_An VDD) gpdk090_pmos1v w=0.24u l=0.1u ad=0.0816p as=0.0816p pd=1.16u ps=1.16u
    I_MXI30_MP1 (VDD nbkn4 XI30_Bn VDD) gpdk090_pmos1v w=0.24u l=0.1u ad=0.0816p as=0.0816p pd=1.16u ps=1.16u
    I_MXI30_MP5 (dd4 nbkn4 XI30_p1 VDD) gpdk090_pmos1v w=0.48u l=0.1u ad=0.1056p as=0.1632p pd=0.92u ps=1.64u
    I_MXI30_MP4 (XI30_p1 XI30_An dd4 VDD) gpdk090_pmos1v w=0.48u l=0.1u ad=0.1056p as=0.1056p pd=0.92u ps=0.92u
    I_MXI30_MP2 (VDD B_4 XI30_p1 VDD) gpdk090_pmos1v w=0.48u l=0.1u ad=0.1056p as=0.1056p pd=0.92u ps=0.92u
    I_MXI30_MP3 (XI30_p1 XI30_Bn VDD VDD) gpdk090_pmos1v w=0.48u l=0.1u ad=0.1632p as=0.1056p pd=1.64u ps=0.92u
    I_MXI30_MP0 (VDD B_4 XI30_An VDD) gpdk090_pmos1v w=0.24u l=0.1u ad=0.0816p as=0.0816p pd=1.16u ps=1.16u
    I_MXI48_I8_MP1 (VDD b0_0 XI48_I8_Bn VDD) gpdk090_pmos1v w=0.24u l=0.1u ad=0.0816p as=0.0816p pd=1.16u ps=1.16u
    I_MXI48_I8_MP5 (I48_pn0 b0_0 XI48_I8_p1 VDD) gpdk090_pmos1v w=0.48u l=0.1u ad=0.1056p as=0.1632p pd=0.92u ps=1.64u
    I_MXI48_I8_MP4 (XI48_I8_p1 XI48_I8_An I48_pn0 VDD) gpdk090_pmos1v w=0.48u l=0.1u ad=0.1056p as=0.1056p pd=0.92u ps=0.92u
    I_MXI48_I8_MP2 (VDD aa7 XI48_I8_p1 VDD) gpdk090_pmos1v w=0.48u l=0.1u ad=0.1056p as=0.1056p pd=0.92u ps=0.92u
    I_MXI48_I8_MP3 (XI48_I8_p1 XI48_I8_Bn VDD VDD) gpdk090_pmos1v w=0.48u l=0.1u ad=0.1632p as=0.1056p pd=1.64u ps=0.92u
    I_MXI48_I8_MP0 (VDD aa7 XI48_I8_An VDD) gpdk090_pmos1v w=0.24u l=0.1u ad=0.0816p as=0.0816p pd=1.16u ps=1.16u
    I_MXI19_MP1 (VDD nakn7 XI19_Bn VDD) gpdk090_pmos1v w=0.24u l=0.1u ad=0.0816p as=0.0816p pd=1.16u ps=1.16u
    I_MXI19_MP5 (aa7 nakn7 XI19_p1 VDD) gpdk090_pmos1v w=0.48u l=0.1u ad=0.1056p as=0.1632p pd=0.92u ps=1.64u
    I_MXI19_MP4 (XI19_p1 XI19_An aa7 VDD) gpdk090_pmos1v w=0.48u l=0.1u ad=0.1056p as=0.1056p pd=0.92u ps=0.92u
    I_MXI19_MP2 (VDD A_7 XI19_p1 VDD) gpdk090_pmos1v w=0.48u l=0.1u ad=0.1056p as=0.1056p pd=0.92u ps=0.92u
    I_MXI19_MP3 (XI19_p1 XI19_Bn VDD VDD) gpdk090_pmos1v w=0.48u l=0.1u ad=0.1632p as=0.1056p pd=1.64u ps=0.92u
    I_MXI19_MP0 (VDD A_7 XI19_An VDD) gpdk090_pmos1v w=0.24u l=0.1u ad=0.0816p as=0.0816p pd=1.16u ps=1.16u
    I_MXI16_MP1 (VDD nakn6 XI16_Bn VDD) gpdk090_pmos1v w=0.24u l=0.1u ad=0.0816p as=0.0816p pd=1.16u ps=1.16u
    I_MXI16_MP5 (aa6 nakn6 XI16_p1 VDD) gpdk090_pmos1v w=0.48u l=0.1u ad=0.1056p as=0.1632p pd=0.92u ps=1.64u
    I_MXI16_MP4 (XI16_p1 XI16_An aa6 VDD) gpdk090_pmos1v w=0.48u l=0.1u ad=0.1056p as=0.1056p pd=0.92u ps=0.92u
    I_MXI16_MP2 (VDD A_6 XI16_p1 VDD) gpdk090_pmos1v w=0.48u l=0.1u ad=0.1056p as=0.1056p pd=0.92u ps=0.92u
    I_MXI16_MP3 (XI16_p1 XI16_Bn VDD VDD) gpdk090_pmos1v w=0.48u l=0.1u ad=0.1632p as=0.1056p pd=1.64u ps=0.92u
    I_MXI16_MP0 (VDD A_6 XI16_An VDD) gpdk090_pmos1v w=0.24u l=0.1u ad=0.0816p as=0.0816p pd=1.16u ps=1.16u
    I_MXI60_I37_MP1 (VDD qu7 XI60_I37_Bn VDD) gpdk090_pmos1v w=0.24u l=0.1u ad=0.0816p as=0.0816p pd=1.16u ps=1.16u
    I_MXI60_I37_MP5 (p1_0 qu7 XI60_I37_p1 VDD) gpdk090_pmos1v w=0.48u l=0.1u ad=0.1056p as=0.1632p pd=0.92u ps=1.64u
    I_MXI60_I37_MP4 (XI60_I37_p1 XI60_I37_An p1_0 VDD) gpdk090_pmos1v w=0.48u l=0.1u ad=0.1056p as=0.1056p pd=0.92u ps=0.92u
    I_MXI60_I37_MP2 (VDD I60_pn0 XI60_I37_p1 VDD) gpdk090_pmos1v w=0.48u l=0.1u ad=0.1056p as=0.1056p pd=0.92u ps=0.92u
    I_MXI60_I37_MP3 (XI60_I37_p1 XI60_I37_Bn VDD VDD) gpdk090_pmos1v w=0.48u l=0.1u ad=0.1632p as=0.1056p pd=1.64u ps=0.92u
    I_MXI60_I37_MP0 (VDD I60_pn0 XI60_I37_An VDD) gpdk090_pmos1v w=0.24u l=0.1u ad=0.0816p as=0.0816p pd=1.16u ps=1.16u
    I_MXI60_I8_MP1 (VDD b1_0 XI60_I8_Bn VDD) gpdk090_pmos1v w=0.24u l=0.1u ad=0.0816p as=0.0816p pd=1.16u ps=1.16u
    I_MXI60_I8_MP5 (I60_pn0 b1_0 XI60_I8_p1 VDD) gpdk090_pmos1v w=0.48u l=0.1u ad=0.1056p as=0.1632p pd=0.92u ps=1.64u
    I_MXI60_I8_MP4 (XI60_I8_p1 XI60_I8_An I60_pn0 VDD) gpdk090_pmos1v w=0.48u l=0.1u ad=0.1056p as=0.1056p pd=0.92u ps=0.92u
    I_MXI60_I8_MP2 (VDD aa6 XI60_I8_p1 VDD) gpdk090_pmos1v w=0.48u l=0.1u ad=0.1056p as=0.1056p pd=0.92u ps=0.92u
    I_MXI60_I8_MP3 (XI60_I8_p1 XI60_I8_Bn VDD VDD) gpdk090_pmos1v w=0.48u l=0.1u ad=0.1632p as=0.1056p pd=1.64u ps=0.92u
    I_MXI60_I8_MP0 (VDD aa6 XI60_I8_An VDD) gpdk090_pmos1v w=0.24u l=0.1u ad=0.0816p as=0.0816p pd=1.16u ps=1.16u
    I_MXI72_I9_MP1 (VDD b2_1 XI72_I9_Bn VDD) gpdk090_pmos1v w=0.24u l=0.1u ad=0.0816p as=0.0816p pd=1.16u ps=1.16u
    I_MXI72_I9_MP5 (I72_pn1 b2_1 XI72_I9_p1 VDD) gpdk090_pmos1v w=0.48u l=0.1u ad=0.1056p as=0.1632p pd=0.92u ps=1.64u
    I_MXI72_I9_MP4 (XI72_I9_p1 XI72_I9_An I72_pn1 VDD) gpdk090_pmos1v w=0.48u l=0.1u ad=0.1056p as=0.1056p pd=0.92u ps=0.92u
    I_MXI72_I9_MP2 (VDD p1_0 XI72_I9_p1 VDD) gpdk090_pmos1v w=0.48u l=0.1u ad=0.1056p as=0.1056p pd=0.92u ps=0.92u
    I_MXI72_I9_MP3 (XI72_I9_p1 XI72_I9_Bn VDD VDD) gpdk090_pmos1v w=0.48u l=0.1u ad=0.1632p as=0.1056p pd=1.64u ps=0.92u
    I_MXI72_I9_MP0 (VDD p1_0 XI72_I9_An VDD) gpdk090_pmos1v w=0.24u l=0.1u ad=0.0816p as=0.0816p pd=1.16u ps=1.16u
    I_MXI84_I12_MP1 (VDD b3_4 XI84_I12_Bn VDD) gpdk090_pmos1v w=0.24u l=0.1u ad=0.0816p as=0.0816p pd=1.16u ps=1.16u
    I_MXI84_I12_MP5 (I84_pn4 b3_4 XI84_I12_p1 VDD) gpdk090_pmos1v w=0.48u l=0.1u ad=0.1056p as=0.1632p pd=0.92u ps=1.64u
    I_MXI84_I12_MP4 (XI84_I12_p1 XI84_I12_An I84_pn4 VDD) gpdk090_pmos1v w=0.48u l=0.1u ad=0.1056p as=0.1056p pd=0.92u ps=0.92u
    I_MXI84_I12_MP2 (VDD p2_3 XI84_I12_p1 VDD) gpdk090_pmos1v w=0.48u l=0.1u ad=0.1056p as=0.1056p pd=0.92u ps=0.92u
    I_MXI84_I12_MP3 (XI84_I12_p1 XI84_I12_Bn VDD VDD) gpdk090_pmos1v w=0.48u l=0.1u ad=0.1632p as=0.1056p pd=1.64u ps=0.92u
    I_MXI84_I12_MP0 (VDD p2_3 XI84_I12_An VDD) gpdk090_pmos1v w=0.24u l=0.1u ad=0.0816p as=0.0816p pd=1.16u ps=1.16u
    I_MXI187_MP1 (VDD nrkn5 XI187_Bn VDD) gpdk090_pmos1v w=0.24u l=0.1u ad=0.0816p as=0.0816p pd=1.16u ps=1.16u
    I_MXI187_MP5 (R_5 nrkn5 XI187_p1 VDD) gpdk090_pmos1v w=0.48u l=0.1u ad=0.1056p as=0.1632p pd=0.92u ps=1.64u
    I_MXI187_MP4 (XI187_p1 XI187_An R_5 VDD) gpdk090_pmos1v w=0.48u l=0.1u ad=0.1056p as=0.1056p pd=0.92u ps=0.92u
    I_MXI187_MP2 (VDD ru5 XI187_p1 VDD) gpdk090_pmos1v w=0.48u l=0.1u ad=0.1056p as=0.1056p pd=0.92u ps=0.92u
    I_MXI187_MP3 (XI187_p1 XI187_Bn VDD VDD) gpdk090_pmos1v w=0.48u l=0.1u ad=0.1632p as=0.1056p pd=1.64u ps=0.92u
    I_MXI187_MP0 (VDD ru5 XI187_An VDD) gpdk090_pmos1v w=0.24u l=0.1u ad=0.0816p as=0.0816p pd=1.16u ps=1.16u
    I_MXI181_MP1 (VDD nrkn3 XI181_Bn VDD) gpdk090_pmos1v w=0.24u l=0.1u ad=0.0816p as=0.0816p pd=1.16u ps=1.16u
    I_MXI181_MP5 (R_3 nrkn3 XI181_p1 VDD) gpdk090_pmos1v w=0.48u l=0.1u ad=0.1056p as=0.1632p pd=0.92u ps=1.64u
    I_MXI181_MP4 (XI181_p1 XI181_An R_3 VDD) gpdk090_pmos1v w=0.48u l=0.1u ad=0.1056p as=0.1056p pd=0.92u ps=0.92u
    I_MXI181_MP2 (VDD ru3 XI181_p1 VDD) gpdk090_pmos1v w=0.48u l=0.1u ad=0.1056p as=0.1056p pd=0.92u ps=0.92u
    I_MXI181_MP3 (XI181_p1 XI181_Bn VDD VDD) gpdk090_pmos1v w=0.48u l=0.1u ad=0.1632p as=0.1056p pd=1.64u ps=0.92u
    I_MXI181_MP0 (VDD ru3 XI181_An VDD) gpdk090_pmos1v w=0.24u l=0.1u ad=0.0816p as=0.0816p pd=1.16u ps=1.16u
    I_MXI48_I11_MP1 (VDD b0_3 XI48_I11_Bn VDD) gpdk090_pmos1v w=0.24u l=0.1u ad=0.0816p as=0.0816p pd=1.16u ps=1.16u
    I_MXI48_I11_MP5 (I48_pn3 b0_3 XI48_I11_p1 VDD) gpdk090_pmos1v w=0.48u l=0.1u ad=0.1056p as=0.1632p pd=0.92u ps=1.64u
    I_MXI48_I11_MP4 (XI48_I11_p1 XI48_I11_An I48_pn3 VDD) gpdk090_pmos1v w=0.48u l=0.1u ad=0.1056p as=0.1056p pd=0.92u ps=0.92u
    I_MXI48_I11_MP2 (VDD VSS XI48_I11_p1 VDD) gpdk090_pmos1v w=0.48u l=0.1u ad=0.1056p as=0.1056p pd=0.92u ps=0.92u
    I_MXI48_I11_MP3 (XI48_I11_p1 XI48_I11_Bn VDD VDD) gpdk090_pmos1v w=0.48u l=0.1u ad=0.1632p as=0.1056p pd=1.64u ps=0.92u
    I_MXI48_I11_MP0 (VDD VSS XI48_I11_An VDD) gpdk090_pmos1v w=0.24u l=0.1u ad=0.0816p as=0.0816p pd=1.16u ps=1.16u
    I_MXI48_I10_MP1 (VDD b0_2 XI48_I10_Bn VDD) gpdk090_pmos1v w=0.24u l=0.1u ad=0.0816p as=0.0816p pd=1.16u ps=1.16u
    I_MXI48_I10_MP5 (I48_pn2 b0_2 XI48_I10_p1 VDD) gpdk090_pmos1v w=0.48u l=0.1u ad=0.1056p as=0.1632p pd=0.92u ps=1.64u
    I_MXI48_I10_MP4 (XI48_I10_p1 XI48_I10_An I48_pn2 VDD) gpdk090_pmos1v w=0.48u l=0.1u ad=0.1056p as=0.1056p pd=0.92u ps=0.92u
    I_MXI48_I10_MP2 (VDD VSS XI48_I10_p1 VDD) gpdk090_pmos1v w=0.48u l=0.1u ad=0.1056p as=0.1056p pd=0.92u ps=0.92u
    I_MXI48_I10_MP3 (XI48_I10_p1 XI48_I10_Bn VDD VDD) gpdk090_pmos1v w=0.48u l=0.1u ad=0.1632p as=0.1056p pd=1.64u ps=0.92u
    I_MXI48_I10_MP0 (VDD VSS XI48_I10_An VDD) gpdk090_pmos1v w=0.24u l=0.1u ad=0.0816p as=0.0816p pd=1.16u ps=1.16u
    I_MXI48_I9_MP1 (VDD b0_1 XI48_I9_Bn VDD) gpdk090_pmos1v w=0.24u l=0.1u ad=0.0816p as=0.0816p pd=1.16u ps=1.16u
    I_MXI48_I9_MP5 (I48_pn1 b0_1 XI48_I9_p1 VDD) gpdk090_pmos1v w=0.48u l=0.1u ad=0.1056p as=0.1632p pd=0.92u ps=1.64u
    I_MXI48_I9_MP4 (XI48_I9_p1 XI48_I9_An I48_pn1 VDD) gpdk090_pmos1v w=0.48u l=0.1u ad=0.1056p as=0.1056p pd=0.92u ps=0.92u
    I_MXI48_I9_MP2 (VDD VSS XI48_I9_p1 VDD) gpdk090_pmos1v w=0.48u l=0.1u ad=0.1056p as=0.1056p pd=0.92u ps=0.92u
    I_MXI48_I9_MP3 (XI48_I9_p1 XI48_I9_Bn VDD VDD) gpdk090_pmos1v w=0.48u l=0.1u ad=0.1632p as=0.1056p pd=1.64u ps=0.92u
    I_MXI48_I9_MP0 (VDD VSS XI48_I9_An VDD) gpdk090_pmos1v w=0.24u l=0.1u ad=0.0816p as=0.0816p pd=1.16u ps=1.16u
    I_MXI48_I37_MP1 (VDD VDD XI48_I37_Bn VDD) gpdk090_pmos1v w=0.24u l=0.1u ad=0.0816p as=0.0816p pd=1.16u ps=1.16u
    I_MXI48_I37_MP5 (p0_0 VDD XI48_I37_p1 VDD) gpdk090_pmos1v w=0.48u l=0.1u ad=0.1056p as=0.1632p pd=0.92u ps=1.64u
    I_MXI48_I37_MP4 (XI48_I37_p1 XI48_I37_An p0_0 VDD) gpdk090_pmos1v w=0.48u l=0.1u ad=0.1056p as=0.1056p pd=0.92u ps=0.92u
    I_MXI48_I37_MP2 (VDD I48_pn0 XI48_I37_p1 VDD) gpdk090_pmos1v w=0.48u l=0.1u ad=0.1056p as=0.1056p pd=0.92u ps=0.92u
    I_MXI48_I37_MP3 (XI48_I37_p1 XI48_I37_Bn VDD VDD) gpdk090_pmos1v w=0.48u l=0.1u ad=0.1632p as=0.1056p pd=1.64u ps=0.92u
    I_MXI48_I37_MP0 (VDD I48_pn0 XI48_I37_An VDD) gpdk090_pmos1v w=0.24u l=0.1u ad=0.0816p as=0.0816p pd=1.16u ps=1.16u
    I_MXI60_I9_MP1 (VDD b1_1 XI60_I9_Bn VDD) gpdk090_pmos1v w=0.24u l=0.1u ad=0.0816p as=0.0816p pd=1.16u ps=1.16u
    I_MXI60_I9_MP5 (I60_pn1 b1_1 XI60_I9_p1 VDD) gpdk090_pmos1v w=0.48u l=0.1u ad=0.1056p as=0.1632p pd=0.92u ps=1.64u
    I_MXI60_I9_MP4 (XI60_I9_p1 XI60_I9_An I60_pn1 VDD) gpdk090_pmos1v w=0.48u l=0.1u ad=0.1056p as=0.1056p pd=0.92u ps=0.92u
    I_MXI60_I9_MP2 (VDD p0_0 XI60_I9_p1 VDD) gpdk090_pmos1v w=0.48u l=0.1u ad=0.1056p as=0.1056p pd=0.92u ps=0.92u
    I_MXI60_I9_MP3 (XI60_I9_p1 XI60_I9_Bn VDD VDD) gpdk090_pmos1v w=0.48u l=0.1u ad=0.1632p as=0.1056p pd=1.64u ps=0.92u
    I_MXI60_I9_MP0 (VDD p0_0 XI60_I9_An VDD) gpdk090_pmos1v w=0.24u l=0.1u ad=0.0816p as=0.0816p pd=1.16u ps=1.16u
    I_MXI60_I38_MP1 (VDD I60_G0_0 XI60_I38_Bn VDD) gpdk090_pmos1v w=0.24u l=0.1u ad=0.0816p as=0.0816p pd=1.16u ps=1.16u
    I_MXI60_I38_MP5 (p1_1 I60_G0_0 XI60_I38_p1 VDD) gpdk090_pmos1v w=0.48u l=0.1u ad=0.1056p as=0.1632p pd=0.92u ps=1.64u
    I_MXI60_I38_MP4 (XI60_I38_p1 XI60_I38_An p1_1 VDD) gpdk090_pmos1v w=0.48u l=0.1u ad=0.1056p as=0.1056p pd=0.92u ps=0.92u
    I_MXI60_I38_MP2 (VDD I60_pn1 XI60_I38_p1 VDD) gpdk090_pmos1v w=0.48u l=0.1u ad=0.1056p as=0.1056p pd=0.92u ps=0.92u
    I_MXI60_I38_MP3 (XI60_I38_p1 XI60_I38_Bn VDD VDD) gpdk090_pmos1v w=0.48u l=0.1u ad=0.1632p as=0.1056p pd=1.64u ps=0.92u
    I_MXI60_I38_MP0 (VDD I60_pn1 XI60_I38_An VDD) gpdk090_pmos1v w=0.24u l=0.1u ad=0.0816p as=0.0816p pd=1.16u ps=1.16u
    I_MXI72_I10_MP1 (VDD b2_2 XI72_I10_Bn VDD) gpdk090_pmos1v w=0.24u l=0.1u ad=0.0816p as=0.0816p pd=1.16u ps=1.16u
    I_MXI72_I10_MP5 (I72_pn2 b2_2 XI72_I10_p1 VDD) gpdk090_pmos1v w=0.48u l=0.1u ad=0.1056p as=0.1632p pd=0.92u ps=1.64u
    I_MXI72_I10_MP4 (XI72_I10_p1 XI72_I10_An I72_pn2 VDD) gpdk090_pmos1v w=0.48u l=0.1u ad=0.1056p as=0.1056p pd=0.92u ps=0.92u
    I_MXI72_I10_MP2 (VDD p1_1 XI72_I10_p1 VDD) gpdk090_pmos1v w=0.48u l=0.1u ad=0.1056p as=0.1056p pd=0.92u ps=0.92u
    I_MXI72_I10_MP3 (XI72_I10_p1 XI72_I10_Bn VDD VDD) gpdk090_pmos1v w=0.48u l=0.1u ad=0.1632p as=0.1056p pd=1.64u ps=0.92u
    I_MXI72_I10_MP0 (VDD p1_1 XI72_I10_An VDD) gpdk090_pmos1v w=0.24u l=0.1u ad=0.0816p as=0.0816p pd=1.16u ps=1.16u
    I_MXI72_I39_MP1 (VDD I72_G1_0 XI72_I39_Bn VDD) gpdk090_pmos1v w=0.24u l=0.1u ad=0.0816p as=0.0816p pd=1.16u ps=1.16u
    I_MXI72_I39_MP5 (p2_2 I72_G1_0 XI72_I39_p1 VDD) gpdk090_pmos1v w=0.48u l=0.1u ad=0.1056p as=0.1632p pd=0.92u ps=1.64u
    I_MXI72_I39_MP4 (XI72_I39_p1 XI72_I39_An p2_2 VDD) gpdk090_pmos1v w=0.48u l=0.1u ad=0.1056p as=0.1056p pd=0.92u ps=0.92u
    I_MXI72_I39_MP2 (VDD I72_pn2 XI72_I39_p1 VDD) gpdk090_pmos1v w=0.48u l=0.1u ad=0.1056p as=0.1056p pd=0.92u ps=0.92u
    I_MXI72_I39_MP3 (XI72_I39_p1 XI72_I39_Bn VDD VDD) gpdk090_pmos1v w=0.48u l=0.1u ad=0.1632p as=0.1056p pd=1.64u ps=0.92u
    I_MXI72_I39_MP0 (VDD I72_pn2 XI72_I39_An VDD) gpdk090_pmos1v w=0.24u l=0.1u ad=0.0816p as=0.0816p pd=1.16u ps=1.16u
    I_MXI84_I13_MP1 (VDD b3_5 XI84_I13_Bn VDD) gpdk090_pmos1v w=0.24u l=0.1u ad=0.0816p as=0.0816p pd=1.16u ps=1.16u
    I_MXI84_I13_MP5 (I84_pn5 b3_5 XI84_I13_p1 VDD) gpdk090_pmos1v w=0.48u l=0.1u ad=0.1056p as=0.1632p pd=0.92u ps=1.64u
    I_MXI84_I13_MP4 (XI84_I13_p1 XI84_I13_An I84_pn5 VDD) gpdk090_pmos1v w=0.48u l=0.1u ad=0.1056p as=0.1056p pd=0.92u ps=0.92u
    I_MXI84_I13_MP2 (VDD p2_4 XI84_I13_p1 VDD) gpdk090_pmos1v w=0.48u l=0.1u ad=0.1056p as=0.1056p pd=0.92u ps=0.92u
    I_MXI84_I13_MP3 (XI84_I13_p1 XI84_I13_Bn VDD VDD) gpdk090_pmos1v w=0.48u l=0.1u ad=0.1632p as=0.1056p pd=1.64u ps=0.92u
    I_MXI84_I13_MP0 (VDD p2_4 XI84_I13_An VDD) gpdk090_pmos1v w=0.24u l=0.1u ad=0.0816p as=0.0816p pd=1.16u ps=1.16u
    I_MXI48_I12_MP1 (VDD b0_4 XI48_I12_Bn VDD) gpdk090_pmos1v w=0.24u l=0.1u ad=0.0816p as=0.0816p pd=1.16u ps=1.16u
    I_MXI48_I12_MP5 (I48_pn4 b0_4 XI48_I12_p1 VDD) gpdk090_pmos1v w=0.48u l=0.1u ad=0.1056p as=0.1632p pd=0.92u ps=1.64u
    I_MXI48_I12_MP4 (XI48_I12_p1 XI48_I12_An I48_pn4 VDD) gpdk090_pmos1v w=0.48u l=0.1u ad=0.1056p as=0.1056p pd=0.92u ps=0.92u
    I_MXI48_I12_MP2 (VDD VSS XI48_I12_p1 VDD) gpdk090_pmos1v w=0.48u l=0.1u ad=0.1056p as=0.1056p pd=0.92u ps=0.92u
    I_MXI48_I12_MP3 (XI48_I12_p1 XI48_I12_Bn VDD VDD) gpdk090_pmos1v w=0.48u l=0.1u ad=0.1632p as=0.1056p pd=1.64u ps=0.92u
    I_MXI48_I12_MP0 (VDD VSS XI48_I12_An VDD) gpdk090_pmos1v w=0.24u l=0.1u ad=0.0816p as=0.0816p pd=1.16u ps=1.16u
    I_MXI48_I38_MP1 (VDD I48_G0_0 XI48_I38_Bn VDD) gpdk090_pmos1v w=0.24u l=0.1u ad=0.0816p as=0.0816p pd=1.16u ps=1.16u
    I_MXI48_I38_MP5 (p0_1 I48_G0_0 XI48_I38_p1 VDD) gpdk090_pmos1v w=0.48u l=0.1u ad=0.1056p as=0.1632p pd=0.92u ps=1.64u
    I_MXI48_I38_MP4 (XI48_I38_p1 XI48_I38_An p0_1 VDD) gpdk090_pmos1v w=0.48u l=0.1u ad=0.1056p as=0.1056p pd=0.92u ps=0.92u
    I_MXI48_I38_MP2 (VDD I48_pn1 XI48_I38_p1 VDD) gpdk090_pmos1v w=0.48u l=0.1u ad=0.1056p as=0.1056p pd=0.92u ps=0.92u
    I_MXI48_I38_MP3 (XI48_I38_p1 XI48_I38_Bn VDD VDD) gpdk090_pmos1v w=0.48u l=0.1u ad=0.1632p as=0.1056p pd=1.64u ps=0.92u
    I_MXI48_I38_MP0 (VDD I48_pn1 XI48_I38_An VDD) gpdk090_pmos1v w=0.24u l=0.1u ad=0.0816p as=0.0816p pd=1.16u ps=1.16u
    I_MXI60_I11_MP1 (VDD b1_3 XI60_I11_Bn VDD) gpdk090_pmos1v w=0.24u l=0.1u ad=0.0816p as=0.0816p pd=1.16u ps=1.16u
    I_MXI60_I11_MP5 (I60_pn3 b1_3 XI60_I11_p1 VDD) gpdk090_pmos1v w=0.48u l=0.1u ad=0.1056p as=0.1632p pd=0.92u ps=1.64u
    I_MXI60_I11_MP4 (XI60_I11_p1 XI60_I11_An I60_pn3 VDD) gpdk090_pmos1v w=0.48u l=0.1u ad=0.1056p as=0.1056p pd=0.92u ps=0.92u
    I_MXI60_I11_MP2 (VDD p0_2 XI60_I11_p1 VDD) gpdk090_pmos1v w=0.48u l=0.1u ad=0.1056p as=0.1056p pd=0.92u ps=0.92u
    I_MXI60_I11_MP3 (XI60_I11_p1 XI60_I11_Bn VDD VDD) gpdk090_pmos1v w=0.48u l=0.1u ad=0.1632p as=0.1056p pd=1.64u ps=0.92u
    I_MXI60_I11_MP0 (VDD p0_2 XI60_I11_An VDD) gpdk090_pmos1v w=0.24u l=0.1u ad=0.0816p as=0.0816p pd=1.16u ps=1.16u
    I_MXI60_I10_MP1 (VDD b1_2 XI60_I10_Bn VDD) gpdk090_pmos1v w=0.24u l=0.1u ad=0.0816p as=0.0816p pd=1.16u ps=1.16u
    I_MXI60_I10_MP5 (I60_pn2 b1_2 XI60_I10_p1 VDD) gpdk090_pmos1v w=0.48u l=0.1u ad=0.1056p as=0.1632p pd=0.92u ps=1.64u
    I_MXI60_I10_MP4 (XI60_I10_p1 XI60_I10_An I60_pn2 VDD) gpdk090_pmos1v w=0.48u l=0.1u ad=0.1056p as=0.1056p pd=0.92u ps=0.92u
    I_MXI60_I10_MP2 (VDD p0_1 XI60_I10_p1 VDD) gpdk090_pmos1v w=0.48u l=0.1u ad=0.1056p as=0.1056p pd=0.92u ps=0.92u
    I_MXI60_I10_MP3 (XI60_I10_p1 XI60_I10_Bn VDD VDD) gpdk090_pmos1v w=0.48u l=0.1u ad=0.1632p as=0.1056p pd=1.64u ps=0.92u
    I_MXI60_I10_MP0 (VDD p0_1 XI60_I10_An VDD) gpdk090_pmos1v w=0.24u l=0.1u ad=0.0816p as=0.0816p pd=1.16u ps=1.16u
    I_MXI60_I39_MP1 (VDD I60_G1_0 XI60_I39_Bn VDD) gpdk090_pmos1v w=0.24u l=0.1u ad=0.0816p as=0.0816p pd=1.16u ps=1.16u
    I_MXI60_I39_MP5 (p1_2 I60_G1_0 XI60_I39_p1 VDD) gpdk090_pmos1v w=0.48u l=0.1u ad=0.1056p as=0.1632p pd=0.92u ps=1.64u
    I_MXI60_I39_MP4 (XI60_I39_p1 XI60_I39_An p1_2 VDD) gpdk090_pmos1v w=0.48u l=0.1u ad=0.1056p as=0.1056p pd=0.92u ps=0.92u
    I_MXI60_I39_MP2 (VDD I60_pn2 XI60_I39_p1 VDD) gpdk090_pmos1v w=0.48u l=0.1u ad=0.1056p as=0.1056p pd=0.92u ps=0.92u
    I_MXI60_I39_MP3 (XI60_I39_p1 XI60_I39_Bn VDD VDD) gpdk090_pmos1v w=0.48u l=0.1u ad=0.1632p as=0.1056p pd=1.64u ps=0.92u
    I_MXI60_I39_MP0 (VDD I60_pn2 XI60_I39_An VDD) gpdk090_pmos1v w=0.24u l=0.1u ad=0.0816p as=0.0816p pd=1.16u ps=1.16u
    I_MXI72_I11_MP1 (VDD b2_3 XI72_I11_Bn VDD) gpdk090_pmos1v w=0.24u l=0.1u ad=0.0816p as=0.0816p pd=1.16u ps=1.16u
    I_MXI72_I11_MP5 (I72_pn3 b2_3 XI72_I11_p1 VDD) gpdk090_pmos1v w=0.48u l=0.1u ad=0.1056p as=0.1632p pd=0.92u ps=1.64u
    I_MXI72_I11_MP4 (XI72_I11_p1 XI72_I11_An I72_pn3 VDD) gpdk090_pmos1v w=0.48u l=0.1u ad=0.1056p as=0.1056p pd=0.92u ps=0.92u
    I_MXI72_I11_MP2 (VDD p1_2 XI72_I11_p1 VDD) gpdk090_pmos1v w=0.48u l=0.1u ad=0.1056p as=0.1056p pd=0.92u ps=0.92u
    I_MXI72_I11_MP3 (XI72_I11_p1 XI72_I11_Bn VDD VDD) gpdk090_pmos1v w=0.48u l=0.1u ad=0.1632p as=0.1056p pd=1.64u ps=0.92u
    I_MXI72_I11_MP0 (VDD p1_2 XI72_I11_An VDD) gpdk090_pmos1v w=0.24u l=0.1u ad=0.0816p as=0.0816p pd=1.16u ps=1.16u
    I_MXI72_I12_MP1 (VDD b2_4 XI72_I12_Bn VDD) gpdk090_pmos1v w=0.24u l=0.1u ad=0.0816p as=0.0816p pd=1.16u ps=1.16u
    I_MXI72_I12_MP5 (I72_pn4 b2_4 XI72_I12_p1 VDD) gpdk090_pmos1v w=0.48u l=0.1u ad=0.1056p as=0.1632p pd=0.92u ps=1.64u
    I_MXI72_I12_MP4 (XI72_I12_p1 XI72_I12_An I72_pn4 VDD) gpdk090_pmos1v w=0.48u l=0.1u ad=0.1056p as=0.1056p pd=0.92u ps=0.92u
    I_MXI72_I12_MP2 (VDD p1_3 XI72_I12_p1 VDD) gpdk090_pmos1v w=0.48u l=0.1u ad=0.1056p as=0.1056p pd=0.92u ps=0.92u
    I_MXI72_I12_MP3 (XI72_I12_p1 XI72_I12_Bn VDD VDD) gpdk090_pmos1v w=0.48u l=0.1u ad=0.1632p as=0.1056p pd=1.64u ps=0.92u
    I_MXI72_I12_MP0 (VDD p1_3 XI72_I12_An VDD) gpdk090_pmos1v w=0.24u l=0.1u ad=0.0816p as=0.0816p pd=1.16u ps=1.16u
    I_MXI72_I42_MP1 (VDD I72_G4_0 XI72_I42_Bn VDD) gpdk090_pmos1v w=0.24u l=0.1u ad=0.0816p as=0.0816p pd=1.16u ps=1.16u
    I_MXI72_I42_MP5 (p2_5 I72_G4_0 XI72_I42_p1 VDD) gpdk090_pmos1v w=0.48u l=0.1u ad=0.1056p as=0.1632p pd=0.92u ps=1.64u
    I_MXI72_I42_MP4 (XI72_I42_p1 XI72_I42_An p2_5 VDD) gpdk090_pmos1v w=0.48u l=0.1u ad=0.1056p as=0.1056p pd=0.92u ps=0.92u
    I_MXI72_I42_MP2 (VDD I72_pn5 XI72_I42_p1 VDD) gpdk090_pmos1v w=0.48u l=0.1u ad=0.1056p as=0.1056p pd=0.92u ps=0.92u
    I_MXI72_I42_MP3 (XI72_I42_p1 XI72_I42_Bn VDD VDD) gpdk090_pmos1v w=0.48u l=0.1u ad=0.1632p as=0.1056p pd=1.64u ps=0.92u
    I_MXI72_I42_MP0 (VDD I72_pn5 XI72_I42_An VDD) gpdk090_pmos1v w=0.24u l=0.1u ad=0.0816p as=0.0816p pd=1.16u ps=1.16u
    I_MXI84_I14_MP1 (VDD b3_6 XI84_I14_Bn VDD) gpdk090_pmos1v w=0.24u l=0.1u ad=0.0816p as=0.0816p pd=1.16u ps=1.16u
    I_MXI84_I14_MP5 (I84_pn6 b3_6 XI84_I14_p1 VDD) gpdk090_pmos1v w=0.48u l=0.1u ad=0.1056p as=0.1632p pd=0.92u ps=1.64u
    I_MXI84_I14_MP4 (XI84_I14_p1 XI84_I14_An I84_pn6 VDD) gpdk090_pmos1v w=0.48u l=0.1u ad=0.1056p as=0.1056p pd=0.92u ps=0.92u
    I_MXI84_I14_MP2 (VDD p2_5 XI84_I14_p1 VDD) gpdk090_pmos1v w=0.48u l=0.1u ad=0.1056p as=0.1056p pd=0.92u ps=0.92u
    I_MXI84_I14_MP3 (XI84_I14_p1 XI84_I14_Bn VDD VDD) gpdk090_pmos1v w=0.48u l=0.1u ad=0.1632p as=0.1056p pd=1.64u ps=0.92u
    I_MXI84_I14_MP0 (VDD p2_5 XI84_I14_An VDD) gpdk090_pmos1v w=0.24u l=0.1u ad=0.0816p as=0.0816p pd=1.16u ps=1.16u
    I_MXI84_I15_MP1 (VDD b3_7 XI84_I15_Bn VDD) gpdk090_pmos1v w=0.24u l=0.1u ad=0.0816p as=0.0816p pd=1.16u ps=1.16u
    I_MXI84_I15_MP5 (I84_pn7 b3_7 XI84_I15_p1 VDD) gpdk090_pmos1v w=0.48u l=0.1u ad=0.1056p as=0.1632p pd=0.92u ps=1.64u
    I_MXI84_I15_MP4 (XI84_I15_p1 XI84_I15_An I84_pn7 VDD) gpdk090_pmos1v w=0.48u l=0.1u ad=0.1056p as=0.1056p pd=0.92u ps=0.92u
    I_MXI84_I15_MP2 (VDD p2_6 XI84_I15_p1 VDD) gpdk090_pmos1v w=0.48u l=0.1u ad=0.1056p as=0.1056p pd=0.92u ps=0.92u
    I_MXI84_I15_MP3 (XI84_I15_p1 XI84_I15_Bn VDD VDD) gpdk090_pmos1v w=0.48u l=0.1u ad=0.1632p as=0.1056p pd=1.64u ps=0.92u
    I_MXI84_I15_MP0 (VDD p2_6 XI84_I15_An VDD) gpdk090_pmos1v w=0.24u l=0.1u ad=0.0816p as=0.0816p pd=1.16u ps=1.16u
    I_MXI48_I13_MP1 (VDD b0_5 XI48_I13_Bn VDD) gpdk090_pmos1v w=0.24u l=0.1u ad=0.0816p as=0.0816p pd=1.16u ps=1.16u
    I_MXI48_I13_MP5 (I48_pn5 b0_5 XI48_I13_p1 VDD) gpdk090_pmos1v w=0.48u l=0.1u ad=0.1056p as=0.1632p pd=0.92u ps=1.64u
    I_MXI48_I13_MP4 (XI48_I13_p1 XI48_I13_An I48_pn5 VDD) gpdk090_pmos1v w=0.48u l=0.1u ad=0.1056p as=0.1056p pd=0.92u ps=0.92u
    I_MXI48_I13_MP2 (VDD VSS XI48_I13_p1 VDD) gpdk090_pmos1v w=0.48u l=0.1u ad=0.1056p as=0.1056p pd=0.92u ps=0.92u
    I_MXI48_I13_MP3 (XI48_I13_p1 XI48_I13_Bn VDD VDD) gpdk090_pmos1v w=0.48u l=0.1u ad=0.1632p as=0.1056p pd=1.64u ps=0.92u
    I_MXI48_I13_MP0 (VDD VSS XI48_I13_An VDD) gpdk090_pmos1v w=0.24u l=0.1u ad=0.0816p as=0.0816p pd=1.16u ps=1.16u
    I_MXI48_I42_MP1 (VDD I48_G4_0 XI48_I42_Bn VDD) gpdk090_pmos1v w=0.24u l=0.1u ad=0.0816p as=0.0816p pd=1.16u ps=1.16u
    I_MXI48_I42_MP5 (p0_5 I48_G4_0 XI48_I42_p1 VDD) gpdk090_pmos1v w=0.48u l=0.1u ad=0.1056p as=0.1632p pd=0.92u ps=1.64u
    I_MXI48_I42_MP4 (XI48_I42_p1 XI48_I42_An p0_5 VDD) gpdk090_pmos1v w=0.48u l=0.1u ad=0.1056p as=0.1056p pd=0.92u ps=0.92u
    I_MXI48_I42_MP2 (VDD I48_pn5 XI48_I42_p1 VDD) gpdk090_pmos1v w=0.48u l=0.1u ad=0.1056p as=0.1056p pd=0.92u ps=0.92u
    I_MXI48_I42_MP3 (XI48_I42_p1 XI48_I42_Bn VDD VDD) gpdk090_pmos1v w=0.48u l=0.1u ad=0.1632p as=0.1056p pd=1.64u ps=0.92u
    I_MXI48_I42_MP0 (VDD I48_pn5 XI48_I42_An VDD) gpdk090_pmos1v w=0.24u l=0.1u ad=0.0816p as=0.0816p pd=1.16u ps=1.16u
    I_MXI48_I39_MP1 (VDD I48_G1_0 XI48_I39_Bn VDD) gpdk090_pmos1v w=0.24u l=0.1u ad=0.0816p as=0.0816p pd=1.16u ps=1.16u
    I_MXI48_I39_MP5 (p0_2 I48_G1_0 XI48_I39_p1 VDD) gpdk090_pmos1v w=0.48u l=0.1u ad=0.1056p as=0.1632p pd=0.92u ps=1.64u
    I_MXI48_I39_MP4 (XI48_I39_p1 XI48_I39_An p0_2 VDD) gpdk090_pmos1v w=0.48u l=0.1u ad=0.1056p as=0.1056p pd=0.92u ps=0.92u
    I_MXI48_I39_MP2 (VDD I48_pn2 XI48_I39_p1 VDD) gpdk090_pmos1v w=0.48u l=0.1u ad=0.1056p as=0.1056p pd=0.92u ps=0.92u
    I_MXI48_I39_MP3 (XI48_I39_p1 XI48_I39_Bn VDD VDD) gpdk090_pmos1v w=0.48u l=0.1u ad=0.1632p as=0.1056p pd=1.64u ps=0.92u
    I_MXI48_I39_MP0 (VDD I48_pn2 XI48_I39_An VDD) gpdk090_pmos1v w=0.24u l=0.1u ad=0.0816p as=0.0816p pd=1.16u ps=1.16u
    I_MXI60_I12_MP1 (VDD b1_4 XI60_I12_Bn VDD) gpdk090_pmos1v w=0.24u l=0.1u ad=0.0816p as=0.0816p pd=1.16u ps=1.16u
    I_MXI60_I12_MP5 (I60_pn4 b1_4 XI60_I12_p1 VDD) gpdk090_pmos1v w=0.48u l=0.1u ad=0.1056p as=0.1632p pd=0.92u ps=1.64u
    I_MXI60_I12_MP4 (XI60_I12_p1 XI60_I12_An I60_pn4 VDD) gpdk090_pmos1v w=0.48u l=0.1u ad=0.1056p as=0.1056p pd=0.92u ps=0.92u
    I_MXI60_I12_MP2 (VDD p0_3 XI60_I12_p1 VDD) gpdk090_pmos1v w=0.48u l=0.1u ad=0.1056p as=0.1056p pd=0.92u ps=0.92u
    I_MXI60_I12_MP3 (XI60_I12_p1 XI60_I12_Bn VDD VDD) gpdk090_pmos1v w=0.48u l=0.1u ad=0.1632p as=0.1056p pd=1.64u ps=0.92u
    I_MXI60_I12_MP0 (VDD p0_3 XI60_I12_An VDD) gpdk090_pmos1v w=0.24u l=0.1u ad=0.0816p as=0.0816p pd=1.16u ps=1.16u
    I_MXI48_I14_MP1 (VDD b0_6 XI48_I14_Bn VDD) gpdk090_pmos1v w=0.24u l=0.1u ad=0.0816p as=0.0816p pd=1.16u ps=1.16u
    I_MXI48_I14_MP5 (I48_pn6 b0_6 XI48_I14_p1 VDD) gpdk090_pmos1v w=0.48u l=0.1u ad=0.1056p as=0.1632p pd=0.92u ps=1.64u
    I_MXI48_I14_MP4 (XI48_I14_p1 XI48_I14_An I48_pn6 VDD) gpdk090_pmos1v w=0.48u l=0.1u ad=0.1056p as=0.1056p pd=0.92u ps=0.92u
    I_MXI48_I14_MP2 (VDD VSS XI48_I14_p1 VDD) gpdk090_pmos1v w=0.48u l=0.1u ad=0.1056p as=0.1056p pd=0.92u ps=0.92u
    I_MXI48_I14_MP3 (XI48_I14_p1 XI48_I14_Bn VDD VDD) gpdk090_pmos1v w=0.48u l=0.1u ad=0.1632p as=0.1056p pd=1.64u ps=0.92u
    I_MXI48_I14_MP0 (VDD VSS XI48_I14_An VDD) gpdk090_pmos1v w=0.24u l=0.1u ad=0.0816p as=0.0816p pd=1.16u ps=1.16u
    I_MXI48_I43_MP1 (VDD I48_G5_0 XI48_I43_Bn VDD) gpdk090_pmos1v w=0.24u l=0.1u ad=0.0816p as=0.0816p pd=1.16u ps=1.16u
    I_MXI48_I43_MP5 (p0_6 I48_G5_0 XI48_I43_p1 VDD) gpdk090_pmos1v w=0.48u l=0.1u ad=0.1056p as=0.1632p pd=0.92u ps=1.64u
    I_MXI48_I43_MP4 (XI48_I43_p1 XI48_I43_An p0_6 VDD) gpdk090_pmos1v w=0.48u l=0.1u ad=0.1056p as=0.1056p pd=0.92u ps=0.92u
    I_MXI48_I43_MP2 (VDD I48_pn6 XI48_I43_p1 VDD) gpdk090_pmos1v w=0.48u l=0.1u ad=0.1056p as=0.1056p pd=0.92u ps=0.92u
    I_MXI48_I43_MP3 (XI48_I43_p1 XI48_I43_Bn VDD VDD) gpdk090_pmos1v w=0.48u l=0.1u ad=0.1632p as=0.1056p pd=1.64u ps=0.92u
    I_MXI48_I43_MP0 (VDD I48_pn6 XI48_I43_An VDD) gpdk090_pmos1v w=0.24u l=0.1u ad=0.0816p as=0.0816p pd=1.16u ps=1.16u
    I_MXI60_I13_MP1 (VDD b1_5 XI60_I13_Bn VDD) gpdk090_pmos1v w=0.24u l=0.1u ad=0.0816p as=0.0816p pd=1.16u ps=1.16u
    I_MXI60_I13_MP5 (I60_pn5 b1_5 XI60_I13_p1 VDD) gpdk090_pmos1v w=0.48u l=0.1u ad=0.1056p as=0.1632p pd=0.92u ps=1.64u
    I_MXI60_I13_MP4 (XI60_I13_p1 XI60_I13_An I60_pn5 VDD) gpdk090_pmos1v w=0.48u l=0.1u ad=0.1056p as=0.1056p pd=0.92u ps=0.92u
    I_MXI60_I13_MP2 (VDD p0_4 XI60_I13_p1 VDD) gpdk090_pmos1v w=0.48u l=0.1u ad=0.1056p as=0.1056p pd=0.92u ps=0.92u
    I_MXI60_I13_MP3 (XI60_I13_p1 XI60_I13_Bn VDD VDD) gpdk090_pmos1v w=0.48u l=0.1u ad=0.1632p as=0.1056p pd=1.64u ps=0.92u
    I_MXI60_I13_MP0 (VDD p0_4 XI60_I13_An VDD) gpdk090_pmos1v w=0.24u l=0.1u ad=0.0816p as=0.0816p pd=1.16u ps=1.16u
    I_MXI72_I13_MP1 (VDD b2_5 XI72_I13_Bn VDD) gpdk090_pmos1v w=0.24u l=0.1u ad=0.0816p as=0.0816p pd=1.16u ps=1.16u
    I_MXI72_I13_MP5 (I72_pn5 b2_5 XI72_I13_p1 VDD) gpdk090_pmos1v w=0.48u l=0.1u ad=0.1056p as=0.1632p pd=0.92u ps=1.64u
    I_MXI72_I13_MP4 (XI72_I13_p1 XI72_I13_An I72_pn5 VDD) gpdk090_pmos1v w=0.48u l=0.1u ad=0.1056p as=0.1056p pd=0.92u ps=0.92u
    I_MXI72_I13_MP2 (VDD p1_4 XI72_I13_p1 VDD) gpdk090_pmos1v w=0.48u l=0.1u ad=0.1056p as=0.1056p pd=0.92u ps=0.92u
    I_MXI72_I13_MP3 (XI72_I13_p1 XI72_I13_Bn VDD VDD) gpdk090_pmos1v w=0.48u l=0.1u ad=0.1632p as=0.1056p pd=1.64u ps=0.92u
    I_MXI72_I13_MP0 (VDD p1_4 XI72_I13_An VDD) gpdk090_pmos1v w=0.24u l=0.1u ad=0.0816p as=0.0816p pd=1.16u ps=1.16u
    I_MXI72_I14_MP1 (VDD b2_6 XI72_I14_Bn VDD) gpdk090_pmos1v w=0.24u l=0.1u ad=0.0816p as=0.0816p pd=1.16u ps=1.16u
    I_MXI72_I14_MP5 (I72_pn6 b2_6 XI72_I14_p1 VDD) gpdk090_pmos1v w=0.48u l=0.1u ad=0.1056p as=0.1632p pd=0.92u ps=1.64u
    I_MXI72_I14_MP4 (XI72_I14_p1 XI72_I14_An I72_pn6 VDD) gpdk090_pmos1v w=0.48u l=0.1u ad=0.1056p as=0.1056p pd=0.92u ps=0.92u
    I_MXI72_I14_MP2 (VDD p1_5 XI72_I14_p1 VDD) gpdk090_pmos1v w=0.48u l=0.1u ad=0.1056p as=0.1056p pd=0.92u ps=0.92u
    I_MXI72_I14_MP3 (XI72_I14_p1 XI72_I14_Bn VDD VDD) gpdk090_pmos1v w=0.48u l=0.1u ad=0.1632p as=0.1056p pd=1.64u ps=0.92u
    I_MXI72_I14_MP0 (VDD p1_5 XI72_I14_An VDD) gpdk090_pmos1v w=0.24u l=0.1u ad=0.0816p as=0.0816p pd=1.16u ps=1.16u
    I_MXI72_I44_MP1 (VDD c2_7 XI72_I44_Bn VDD) gpdk090_pmos1v w=0.24u l=0.1u ad=0.0816p as=0.0816p pd=1.16u ps=1.16u
    I_MXI72_I44_MP5 (p2_7 c2_7 XI72_I44_p1 VDD) gpdk090_pmos1v w=0.48u l=0.1u ad=0.1056p as=0.1632p pd=0.92u ps=1.64u
    I_MXI72_I44_MP4 (XI72_I44_p1 XI72_I44_An p2_7 VDD) gpdk090_pmos1v w=0.48u l=0.1u ad=0.1056p as=0.1056p pd=0.92u ps=0.92u
    I_MXI72_I44_MP2 (VDD I72_pn7 XI72_I44_p1 VDD) gpdk090_pmos1v w=0.48u l=0.1u ad=0.1056p as=0.1056p pd=0.92u ps=0.92u
    I_MXI72_I44_MP3 (XI72_I44_p1 XI72_I44_Bn VDD VDD) gpdk090_pmos1v w=0.48u l=0.1u ad=0.1632p as=0.1056p pd=1.64u ps=0.92u
    I_MXI72_I44_MP0 (VDD I72_pn7 XI72_I44_An VDD) gpdk090_pmos1v w=0.24u l=0.1u ad=0.0816p as=0.0816p pd=1.16u ps=1.16u
    I_MXI72_I43_MP1 (VDD I72_G5_0 XI72_I43_Bn VDD) gpdk090_pmos1v w=0.24u l=0.1u ad=0.0816p as=0.0816p pd=1.16u ps=1.16u
    I_MXI72_I43_MP5 (p2_6 I72_G5_0 XI72_I43_p1 VDD) gpdk090_pmos1v w=0.48u l=0.1u ad=0.1056p as=0.1632p pd=0.92u ps=1.64u
    I_MXI72_I43_MP4 (XI72_I43_p1 XI72_I43_An p2_6 VDD) gpdk090_pmos1v w=0.48u l=0.1u ad=0.1056p as=0.1056p pd=0.92u ps=0.92u
    I_MXI72_I43_MP2 (VDD I72_pn6 XI72_I43_p1 VDD) gpdk090_pmos1v w=0.48u l=0.1u ad=0.1056p as=0.1056p pd=0.92u ps=0.92u
    I_MXI72_I43_MP3 (XI72_I43_p1 XI72_I43_Bn VDD VDD) gpdk090_pmos1v w=0.48u l=0.1u ad=0.1632p as=0.1056p pd=1.64u ps=0.92u
    I_MXI72_I43_MP0 (VDD I72_pn6 XI72_I43_An VDD) gpdk090_pmos1v w=0.24u l=0.1u ad=0.0816p as=0.0816p pd=1.16u ps=1.16u
    I_MXI48_I15_MP1 (VDD b0_7 XI48_I15_Bn VDD) gpdk090_pmos1v w=0.24u l=0.1u ad=0.0816p as=0.0816p pd=1.16u ps=1.16u
    I_MXI48_I15_MP5 (I48_pn7 b0_7 XI48_I15_p1 VDD) gpdk090_pmos1v w=0.48u l=0.1u ad=0.1056p as=0.1632p pd=0.92u ps=1.64u
    I_MXI48_I15_MP4 (XI48_I15_p1 XI48_I15_An I48_pn7 VDD) gpdk090_pmos1v w=0.48u l=0.1u ad=0.1056p as=0.1056p pd=0.92u ps=0.92u
    I_MXI48_I15_MP2 (VDD VSS XI48_I15_p1 VDD) gpdk090_pmos1v w=0.48u l=0.1u ad=0.1056p as=0.1056p pd=0.92u ps=0.92u
    I_MXI48_I15_MP3 (XI48_I15_p1 XI48_I15_Bn VDD VDD) gpdk090_pmos1v w=0.48u l=0.1u ad=0.1632p as=0.1056p pd=1.64u ps=0.92u
    I_MXI48_I15_MP0 (VDD VSS XI48_I15_An VDD) gpdk090_pmos1v w=0.24u l=0.1u ad=0.0816p as=0.0816p pd=1.16u ps=1.16u
    I_MXI48_I44_MP1 (VDD c0_7 XI48_I44_Bn VDD) gpdk090_pmos1v w=0.24u l=0.1u ad=0.0816p as=0.0816p pd=1.16u ps=1.16u
    I_MXI48_I44_MP5 (p0_7 c0_7 XI48_I44_p1 VDD) gpdk090_pmos1v w=0.48u l=0.1u ad=0.1056p as=0.1632p pd=0.92u ps=1.64u
    I_MXI48_I44_MP4 (XI48_I44_p1 XI48_I44_An p0_7 VDD) gpdk090_pmos1v w=0.48u l=0.1u ad=0.1056p as=0.1056p pd=0.92u ps=0.92u
    I_MXI48_I44_MP2 (VDD I48_pn7 XI48_I44_p1 VDD) gpdk090_pmos1v w=0.48u l=0.1u ad=0.1056p as=0.1056p pd=0.92u ps=0.92u
    I_MXI48_I44_MP3 (XI48_I44_p1 XI48_I44_Bn VDD VDD) gpdk090_pmos1v w=0.48u l=0.1u ad=0.1632p as=0.1056p pd=1.64u ps=0.92u
    I_MXI48_I44_MP0 (VDD I48_pn7 XI48_I44_An VDD) gpdk090_pmos1v w=0.24u l=0.1u ad=0.0816p as=0.0816p pd=1.16u ps=1.16u
    I_MXI60_I14_MP1 (VDD b1_6 XI60_I14_Bn VDD) gpdk090_pmos1v w=0.24u l=0.1u ad=0.0816p as=0.0816p pd=1.16u ps=1.16u
    I_MXI60_I14_MP5 (I60_pn6 b1_6 XI60_I14_p1 VDD) gpdk090_pmos1v w=0.48u l=0.1u ad=0.1056p as=0.1632p pd=0.92u ps=1.64u
    I_MXI60_I14_MP4 (XI60_I14_p1 XI60_I14_An I60_pn6 VDD) gpdk090_pmos1v w=0.48u l=0.1u ad=0.1056p as=0.1056p pd=0.92u ps=0.92u
    I_MXI60_I14_MP2 (VDD p0_5 XI60_I14_p1 VDD) gpdk090_pmos1v w=0.48u l=0.1u ad=0.1056p as=0.1056p pd=0.92u ps=0.92u
    I_MXI60_I14_MP3 (XI60_I14_p1 XI60_I14_Bn VDD VDD) gpdk090_pmos1v w=0.48u l=0.1u ad=0.1632p as=0.1056p pd=1.64u ps=0.92u
    I_MXI60_I14_MP0 (VDD p0_5 XI60_I14_An VDD) gpdk090_pmos1v w=0.24u l=0.1u ad=0.0816p as=0.0816p pd=1.16u ps=1.16u
    I_MXI60_I15_MP1 (VDD b1_7 XI60_I15_Bn VDD) gpdk090_pmos1v w=0.24u l=0.1u ad=0.0816p as=0.0816p pd=1.16u ps=1.16u
    I_MXI60_I15_MP5 (I60_pn7 b1_7 XI60_I15_p1 VDD) gpdk090_pmos1v w=0.48u l=0.1u ad=0.1056p as=0.1632p pd=0.92u ps=1.64u
    I_MXI60_I15_MP4 (XI60_I15_p1 XI60_I15_An I60_pn7 VDD) gpdk090_pmos1v w=0.48u l=0.1u ad=0.1056p as=0.1056p pd=0.92u ps=0.92u
    I_MXI60_I15_MP2 (VDD p0_6 XI60_I15_p1 VDD) gpdk090_pmos1v w=0.48u l=0.1u ad=0.1056p as=0.1056p pd=0.92u ps=0.92u
    I_MXI60_I15_MP3 (XI60_I15_p1 XI60_I15_Bn VDD VDD) gpdk090_pmos1v w=0.48u l=0.1u ad=0.1632p as=0.1056p pd=1.64u ps=0.92u
    I_MXI60_I15_MP0 (VDD p0_6 XI60_I15_An VDD) gpdk090_pmos1v w=0.24u l=0.1u ad=0.0816p as=0.0816p pd=1.16u ps=1.16u
    I_MXI60_I43_MP1 (VDD I60_G5_0 XI60_I43_Bn VDD) gpdk090_pmos1v w=0.24u l=0.1u ad=0.0816p as=0.0816p pd=1.16u ps=1.16u
    I_MXI60_I43_MP5 (p1_6 I60_G5_0 XI60_I43_p1 VDD) gpdk090_pmos1v w=0.48u l=0.1u ad=0.1056p as=0.1632p pd=0.92u ps=1.64u
    I_MXI60_I43_MP4 (XI60_I43_p1 XI60_I43_An p1_6 VDD) gpdk090_pmos1v w=0.48u l=0.1u ad=0.1056p as=0.1056p pd=0.92u ps=0.92u
    I_MXI60_I43_MP2 (VDD I60_pn6 XI60_I43_p1 VDD) gpdk090_pmos1v w=0.48u l=0.1u ad=0.1056p as=0.1056p pd=0.92u ps=0.92u
    I_MXI60_I43_MP3 (XI60_I43_p1 XI60_I43_Bn VDD VDD) gpdk090_pmos1v w=0.48u l=0.1u ad=0.1632p as=0.1056p pd=1.64u ps=0.92u
    I_MXI60_I43_MP0 (VDD I60_pn6 XI60_I43_An VDD) gpdk090_pmos1v w=0.24u l=0.1u ad=0.0816p as=0.0816p pd=1.16u ps=1.16u
    I_MXI60_I42_MP1 (VDD I60_G4_0 XI60_I42_Bn VDD) gpdk090_pmos1v w=0.24u l=0.1u ad=0.0816p as=0.0816p pd=1.16u ps=1.16u
    I_MXI60_I42_MP5 (p1_5 I60_G4_0 XI60_I42_p1 VDD) gpdk090_pmos1v w=0.48u l=0.1u ad=0.1056p as=0.1632p pd=0.92u ps=1.64u
    I_MXI60_I42_MP4 (XI60_I42_p1 XI60_I42_An p1_5 VDD) gpdk090_pmos1v w=0.48u l=0.1u ad=0.1056p as=0.1056p pd=0.92u ps=0.92u
    I_MXI60_I42_MP2 (VDD I60_pn5 XI60_I42_p1 VDD) gpdk090_pmos1v w=0.48u l=0.1u ad=0.1056p as=0.1056p pd=0.92u ps=0.92u
    I_MXI60_I42_MP3 (XI60_I42_p1 XI60_I42_Bn VDD VDD) gpdk090_pmos1v w=0.48u l=0.1u ad=0.1632p as=0.1056p pd=1.64u ps=0.92u
    I_MXI60_I42_MP0 (VDD I60_pn5 XI60_I42_An VDD) gpdk090_pmos1v w=0.24u l=0.1u ad=0.0816p as=0.0816p pd=1.16u ps=1.16u
    I_MXI60_I44_MP1 (VDD c1_7 XI60_I44_Bn VDD) gpdk090_pmos1v w=0.24u l=0.1u ad=0.0816p as=0.0816p pd=1.16u ps=1.16u
    I_MXI60_I44_MP5 (p1_7 c1_7 XI60_I44_p1 VDD) gpdk090_pmos1v w=0.48u l=0.1u ad=0.1056p as=0.1632p pd=0.92u ps=1.64u
    I_MXI60_I44_MP4 (XI60_I44_p1 XI60_I44_An p1_7 VDD) gpdk090_pmos1v w=0.48u l=0.1u ad=0.1056p as=0.1056p pd=0.92u ps=0.92u
    I_MXI60_I44_MP2 (VDD I60_pn7 XI60_I44_p1 VDD) gpdk090_pmos1v w=0.48u l=0.1u ad=0.1056p as=0.1056p pd=0.92u ps=0.92u
    I_MXI60_I44_MP3 (XI60_I44_p1 XI60_I44_Bn VDD VDD) gpdk090_pmos1v w=0.48u l=0.1u ad=0.1632p as=0.1056p pd=1.64u ps=0.92u
    I_MXI60_I44_MP0 (VDD I60_pn7 XI60_I44_An VDD) gpdk090_pmos1v w=0.24u l=0.1u ad=0.0816p as=0.0816p pd=1.16u ps=1.16u
    I_MXI72_I15_MP1 (VDD b2_7 XI72_I15_Bn VDD) gpdk090_pmos1v w=0.24u l=0.1u ad=0.0816p as=0.0816p pd=1.16u ps=1.16u
    I_MXI72_I15_MP5 (I72_pn7 b2_7 XI72_I15_p1 VDD) gpdk090_pmos1v w=0.48u l=0.1u ad=0.1056p as=0.1632p pd=0.92u ps=1.64u
    I_MXI72_I15_MP4 (XI72_I15_p1 XI72_I15_An I72_pn7 VDD) gpdk090_pmos1v w=0.48u l=0.1u ad=0.1056p as=0.1056p pd=0.92u ps=0.92u
    I_MXI72_I15_MP2 (VDD p1_6 XI72_I15_p1 VDD) gpdk090_pmos1v w=0.48u l=0.1u ad=0.1056p as=0.1056p pd=0.92u ps=0.92u
    I_MXI72_I15_MP3 (XI72_I15_p1 XI72_I15_Bn VDD VDD) gpdk090_pmos1v w=0.48u l=0.1u ad=0.1632p as=0.1056p pd=1.64u ps=0.92u
    I_MXI72_I15_MP0 (VDD p1_6 XI72_I15_An VDD) gpdk090_pmos1v w=0.24u l=0.1u ad=0.0816p as=0.0816p pd=1.16u ps=1.16u
    I_MXI123_MP2 (qu1 p6_8 VDD VDD) gpdk090_pmos1v w=0.48u l=0.1u ad=0.1056p as=0.1632p pd=0.92u ps=1.64u
    I_MXI123_MP2_1 (VDD p6_8 qu1 VDD) gpdk090_pmos1v w=0.48u l=0.1u ad=0.1632p as=0.1056p pd=1.64u ps=0.92u
    I_MXI111_MP2 (qu2 p5_8 VDD VDD) gpdk090_pmos1v w=0.48u l=0.1u ad=0.1056p as=0.1632p pd=0.92u ps=1.64u
    I_MXI111_MP2_1 (VDD p5_8 qu2 VDD) gpdk090_pmos1v w=0.48u l=0.1u ad=0.1632p as=0.1056p pd=1.64u ps=0.92u
    I_MXI99_MP2 (qu3 p4_8 VDD VDD) gpdk090_pmos1v w=0.48u l=0.1u ad=0.1056p as=0.1632p pd=0.92u ps=1.64u
    I_MXI99_MP2_1 (VDD p4_8 qu3 VDD) gpdk090_pmos1v w=0.48u l=0.1u ad=0.1632p as=0.1056p pd=1.64u ps=0.92u
    I_MXI87_MP2 (qu4 p3_8 VDD VDD) gpdk090_pmos1v w=0.48u l=0.1u ad=0.1056p as=0.1632p pd=0.92u ps=1.64u
    I_MXI87_MP2_1 (VDD p3_8 qu4 VDD) gpdk090_pmos1v w=0.48u l=0.1u ad=0.1632p as=0.1056p pd=1.64u ps=0.92u
    I_MXI75_MP2 (qu5 p2_8 VDD VDD) gpdk090_pmos1v w=0.48u l=0.1u ad=0.1056p as=0.1632p pd=0.92u ps=1.64u
    I_MXI75_MP2_1 (VDD p2_8 qu5 VDD) gpdk090_pmos1v w=0.48u l=0.1u ad=0.1632p as=0.1056p pd=1.64u ps=0.92u
    I_MXI51_MP2 (qu7 p0_8 VDD VDD) gpdk090_pmos1v w=0.48u l=0.1u ad=0.1056p as=0.1632p pd=0.92u ps=1.64u
    I_MXI51_MP2_1 (VDD p0_8 qu7 VDD) gpdk090_pmos1v w=0.48u l=0.1u ad=0.1632p as=0.1056p pd=1.64u ps=0.92u
    I_MXI63_MP2 (qu6 p1_8 VDD VDD) gpdk090_pmos1v w=0.48u l=0.1u ad=0.1056p as=0.1632p pd=0.92u ps=1.64u
    I_MXI63_MP2_1 (VDD p1_8 qu6 VDD) gpdk090_pmos1v w=0.48u l=0.1u ad=0.1632p as=0.1056p pd=1.64u ps=0.92u
    I_MXI120_I31_XG_MP2 (XI120_I31_XG_p1 I120_G7_6 I120_G7_4n VDD) gpdk090_pmos1v w=0.48u l=0.1u ad=0.1056p as=0.1632p pd=0.92u ps=1.64u
    I_MXI120_I31_XG_MP0 (VDD I120_P7_6 XI120_I31_XG_p1 VDD) gpdk090_pmos1v w=0.48u l=0.1u ad=0.1056p as=0.1056p pd=0.92u ps=0.92u
    I_MXI120_I31_XG_MP1 (XI120_I31_XG_p1 I120_G5_4 VDD VDD) gpdk090_pmos1v w=0.48u l=0.1u ad=0.1632p as=0.1056p pd=1.64u ps=0.92u
    I_MXI120_I30_XG_MP2 (XI120_I30_XG_p1 I120_G6_5 I120_G6_3n VDD) gpdk090_pmos1v w=0.48u l=0.1u ad=0.1056p as=0.1632p pd=0.92u ps=1.64u
    I_MXI120_I30_XG_MP0 (VDD I120_P6_5 XI120_I30_XG_p1 VDD) gpdk090_pmos1v w=0.48u l=0.1u ad=0.1056p as=0.1056p pd=0.92u ps=0.92u
    I_MXI120_I30_XG_MP1 (XI120_I30_XG_p1 I120_G4_3 VDD VDD) gpdk090_pmos1v w=0.48u l=0.1u ad=0.1632p as=0.1056p pd=1.64u ps=0.92u
    I_MXI120_I29_XG_MP2 (XI120_I29_XG_p1 I120_G5_4 I120_G5_2n VDD) gpdk090_pmos1v w=0.48u l=0.1u ad=0.1056p as=0.1632p pd=0.92u ps=1.64u
    I_MXI120_I29_XG_MP0 (VDD I120_P5_4 XI120_I29_XG_p1 VDD) gpdk090_pmos1v w=0.48u l=0.1u ad=0.1056p as=0.1056p pd=0.92u ps=0.92u
    I_MXI120_I29_XG_MP1 (XI120_I29_XG_p1 I120_G3_2 VDD VDD) gpdk090_pmos1v w=0.48u l=0.1u ad=0.1632p as=0.1056p pd=1.64u ps=0.92u
    I_MXI108_I30_XG_MP2 (XI108_I30_XG_p1 I108_G6_5 I108_G6_3n VDD) gpdk090_pmos1v w=0.48u l=0.1u ad=0.1056p as=0.1632p pd=0.92u ps=1.64u
    I_MXI108_I30_XG_MP0 (VDD I108_P6_5 XI108_I30_XG_p1 VDD) gpdk090_pmos1v w=0.48u l=0.1u ad=0.1056p as=0.1056p pd=0.92u ps=0.92u
    I_MXI108_I30_XG_MP1 (XI108_I30_XG_p1 I108_G4_3 VDD VDD) gpdk090_pmos1v w=0.48u l=0.1u ad=0.1632p as=0.1056p pd=1.64u ps=0.92u
    I_MXI108_I27_XG_MP2 (XI108_I27_XG_p1 I108_G3_2 I108_G3_0n VDD) gpdk090_pmos1v w=0.48u l=0.1u ad=0.1056p as=0.1632p pd=0.92u ps=1.64u
    I_MXI108_I27_XG_MP0 (VDD I108_P3_2 XI108_I27_XG_p1 VDD) gpdk090_pmos1v w=0.48u l=0.1u ad=0.1056p as=0.1056p pd=0.92u ps=0.92u
    I_MXI108_I27_XG_MP1 (XI108_I27_XG_p1 I108_G1_0 VDD VDD) gpdk090_pmos1v w=0.48u l=0.1u ad=0.1632p as=0.1056p pd=1.64u ps=0.92u
    I_MXI108_I29_XG_MP2 (XI108_I29_XG_p1 I108_G5_4 I108_G5_2n VDD) gpdk090_pmos1v w=0.48u l=0.1u ad=0.1056p as=0.1632p pd=0.92u ps=1.64u
    I_MXI108_I29_XG_MP0 (VDD I108_P5_4 XI108_I29_XG_p1 VDD) gpdk090_pmos1v w=0.48u l=0.1u ad=0.1056p as=0.1056p pd=0.92u ps=0.92u
    I_MXI108_I29_XG_MP1 (XI108_I29_XG_p1 I108_G3_2 VDD VDD) gpdk090_pmos1v w=0.48u l=0.1u ad=0.1632p as=0.1056p pd=1.64u ps=0.92u
    I_MXI108_I31_XG_MP2 (XI108_I31_XG_p1 I108_G7_6 I108_G7_4n VDD) gpdk090_pmos1v w=0.48u l=0.1u ad=0.1056p as=0.1632p pd=0.92u ps=1.64u
    I_MXI108_I31_XG_MP0 (VDD I108_P7_6 XI108_I31_XG_p1 VDD) gpdk090_pmos1v w=0.48u l=0.1u ad=0.1056p as=0.1056p pd=0.92u ps=0.92u
    I_MXI108_I31_XG_MP1 (XI108_I31_XG_p1 I108_G5_4 VDD VDD) gpdk090_pmos1v w=0.48u l=0.1u ad=0.1632p as=0.1056p pd=1.64u ps=0.92u
    I_MXI132_I31_XG_MP2 (XI132_I31_XG_p1 I132_G7_6 I132_G7_4n VDD) gpdk090_pmos1v w=0.48u l=0.1u ad=0.1056p as=0.1632p pd=0.92u ps=1.64u
    I_MXI132_I31_XG_MP0 (VDD I132_P7_6 XI132_I31_XG_p1 VDD) gpdk090_pmos1v w=0.48u l=0.1u ad=0.1056p as=0.1056p pd=0.92u ps=0.92u
    I_MXI132_I31_XG_MP1 (XI132_I31_XG_p1 I132_G5_4 VDD VDD) gpdk090_pmos1v w=0.48u l=0.1u ad=0.1632p as=0.1056p pd=1.64u ps=0.92u
    I_MXI120_I26_XG_MP2 (XI120_I26_XG_p1 I120_G2_1 I120_G2_0n VDD) gpdk090_pmos1v w=0.48u l=0.1u ad=0.1056p as=0.1632p pd=0.92u ps=1.64u
    I_MXI120_I26_XG_MP0 (VDD I120_P2_1 XI120_I26_XG_p1 VDD) gpdk090_pmos1v w=0.48u l=0.1u ad=0.1056p as=0.1056p pd=0.92u ps=0.92u
    I_MXI120_I26_XG_MP1 (XI120_I26_XG_p1 I120_G0_0 VDD VDD) gpdk090_pmos1v w=0.48u l=0.1u ad=0.1632p as=0.1056p pd=1.64u ps=0.92u
    I_MXI120_I28_XG_MP2 (XI120_I28_XG_p1 I120_G4_3 I120_G4_1n VDD) gpdk090_pmos1v w=0.48u l=0.1u ad=0.1056p as=0.1632p pd=0.92u ps=1.64u
    I_MXI120_I28_XG_MP0 (VDD I120_P4_3 XI120_I28_XG_p1 VDD) gpdk090_pmos1v w=0.48u l=0.1u ad=0.1056p as=0.1056p pd=0.92u ps=0.92u
    I_MXI120_I28_XG_MP1 (XI120_I28_XG_p1 I120_G2_1 VDD VDD) gpdk090_pmos1v w=0.48u l=0.1u ad=0.1632p as=0.1056p pd=1.64u ps=0.92u
    I_MXI120_I27_XG_MP2 (XI120_I27_XG_p1 I120_G3_2 I120_G3_0n VDD) gpdk090_pmos1v w=0.48u l=0.1u ad=0.1056p as=0.1632p pd=0.92u ps=1.64u
    I_MXI120_I27_XG_MP0 (VDD I120_P3_2 XI120_I27_XG_p1 VDD) gpdk090_pmos1v w=0.48u l=0.1u ad=0.1056p as=0.1056p pd=0.92u ps=0.92u
    I_MXI120_I27_XG_MP1 (XI120_I27_XG_p1 I120_G1_0 VDD VDD) gpdk090_pmos1v w=0.48u l=0.1u ad=0.1632p as=0.1056p pd=1.64u ps=0.92u
    I_MXI108_I26_XG_MP2 (XI108_I26_XG_p1 I108_G2_1 I108_G2_0n VDD) gpdk090_pmos1v w=0.48u l=0.1u ad=0.1056p as=0.1632p pd=0.92u ps=1.64u
    I_MXI108_I26_XG_MP0 (VDD I108_P2_1 XI108_I26_XG_p1 VDD) gpdk090_pmos1v w=0.48u l=0.1u ad=0.1056p as=0.1056p pd=0.92u ps=0.92u
    I_MXI108_I26_XG_MP1 (XI108_I26_XG_p1 I108_G0_0 VDD VDD) gpdk090_pmos1v w=0.48u l=0.1u ad=0.1632p as=0.1056p pd=1.64u ps=0.92u
    I_MXI108_I28_XG_MP2 (XI108_I28_XG_p1 I108_G4_3 I108_G4_1n VDD) gpdk090_pmos1v w=0.48u l=0.1u ad=0.1056p as=0.1632p pd=0.92u ps=1.64u
    I_MXI108_I28_XG_MP0 (VDD I108_P4_3 XI108_I28_XG_p1 VDD) gpdk090_pmos1v w=0.48u l=0.1u ad=0.1056p as=0.1056p pd=0.92u ps=0.92u
    I_MXI108_I28_XG_MP1 (XI108_I28_XG_p1 I108_G2_1 VDD VDD) gpdk090_pmos1v w=0.48u l=0.1u ad=0.1632p as=0.1056p pd=1.64u ps=0.92u
    I_MXI132_I29_XG_MP2 (XI132_I29_XG_p1 I132_G5_4 I132_G5_2n VDD) gpdk090_pmos1v w=0.48u l=0.1u ad=0.1056p as=0.1632p pd=0.92u ps=1.64u
    I_MXI132_I29_XG_MP0 (VDD I132_P5_4 XI132_I29_XG_p1 VDD) gpdk090_pmos1v w=0.48u l=0.1u ad=0.1056p as=0.1056p pd=0.92u ps=0.92u
    I_MXI132_I29_XG_MP1 (XI132_I29_XG_p1 I132_G3_2 VDD VDD) gpdk090_pmos1v w=0.48u l=0.1u ad=0.1632p as=0.1056p pd=1.64u ps=0.92u
    I_MXI132_I27_XG_MP2 (XI132_I27_XG_p1 I132_G3_2 I132_G3_0n VDD) gpdk090_pmos1v w=0.48u l=0.1u ad=0.1056p as=0.1632p pd=0.92u ps=1.64u
    I_MXI132_I27_XG_MP0 (VDD I132_P3_2 XI132_I27_XG_p1 VDD) gpdk090_pmos1v w=0.48u l=0.1u ad=0.1056p as=0.1056p pd=0.92u ps=0.92u
    I_MXI132_I27_XG_MP1 (XI132_I27_XG_p1 I132_G1_0 VDD VDD) gpdk090_pmos1v w=0.48u l=0.1u ad=0.1632p as=0.1056p pd=1.64u ps=0.92u
    I_MXI132_I30_XG_MP2 (XI132_I30_XG_p1 I132_G6_5 I132_G6_3n VDD) gpdk090_pmos1v w=0.48u l=0.1u ad=0.1056p as=0.1632p pd=0.92u ps=1.64u
    I_MXI132_I30_XG_MP0 (VDD I132_P6_5 XI132_I30_XG_p1 VDD) gpdk090_pmos1v w=0.48u l=0.1u ad=0.1056p as=0.1056p pd=0.92u ps=0.92u
    I_MXI132_I30_XG_MP1 (XI132_I30_XG_p1 I132_G4_3 VDD VDD) gpdk090_pmos1v w=0.48u l=0.1u ad=0.1632p as=0.1056p pd=1.64u ps=0.92u
    I_MXI132_I28_XG_MP2 (XI132_I28_XG_p1 I132_G4_3 I132_G4_1n VDD) gpdk090_pmos1v w=0.48u l=0.1u ad=0.1056p as=0.1632p pd=0.92u ps=1.64u
    I_MXI132_I28_XG_MP0 (VDD I132_P4_3 XI132_I28_XG_p1 VDD) gpdk090_pmos1v w=0.48u l=0.1u ad=0.1056p as=0.1056p pd=0.92u ps=0.92u
    I_MXI132_I28_XG_MP1 (XI132_I28_XG_p1 I132_G2_1 VDD VDD) gpdk090_pmos1v w=0.48u l=0.1u ad=0.1632p as=0.1056p pd=1.64u ps=0.92u
    I_MXI96_I27_XG_MP2 (XI96_I27_XG_p1 I96_G3_2 I96_G3_0n VDD) gpdk090_pmos1v w=0.48u l=0.1u ad=0.1056p as=0.1632p pd=0.92u ps=1.64u
    I_MXI96_I27_XG_MP0 (VDD I96_P3_2 XI96_I27_XG_p1 VDD) gpdk090_pmos1v w=0.48u l=0.1u ad=0.1056p as=0.1056p pd=0.92u ps=0.92u
    I_MXI96_I27_XG_MP1 (XI96_I27_XG_p1 I96_G1_0 VDD VDD) gpdk090_pmos1v w=0.48u l=0.1u ad=0.1632p as=0.1056p pd=1.64u ps=0.92u
    I_MXI96_I29_XG_MP2 (XI96_I29_XG_p1 I96_G5_4 I96_G5_2n VDD) gpdk090_pmos1v w=0.48u l=0.1u ad=0.1056p as=0.1632p pd=0.92u ps=1.64u
    I_MXI96_I29_XG_MP0 (VDD I96_P5_4 XI96_I29_XG_p1 VDD) gpdk090_pmos1v w=0.48u l=0.1u ad=0.1056p as=0.1056p pd=0.92u ps=0.92u
    I_MXI96_I29_XG_MP1 (XI96_I29_XG_p1 I96_G3_2 VDD VDD) gpdk090_pmos1v w=0.48u l=0.1u ad=0.1632p as=0.1056p pd=1.64u ps=0.92u
    I_MXI96_I31_XG_MP2 (XI96_I31_XG_p1 I96_G7_6 I96_G7_4n VDD) gpdk090_pmos1v w=0.48u l=0.1u ad=0.1056p as=0.1632p pd=0.92u ps=1.64u
    I_MXI96_I31_XG_MP0 (VDD I96_P7_6 XI96_I31_XG_p1 VDD) gpdk090_pmos1v w=0.48u l=0.1u ad=0.1056p as=0.1056p pd=0.92u ps=0.92u
    I_MXI96_I31_XG_MP1 (XI96_I31_XG_p1 I96_G5_4 VDD VDD) gpdk090_pmos1v w=0.48u l=0.1u ad=0.1632p as=0.1056p pd=1.64u ps=0.92u
    I_MXI132_I26_XG_MP2 (XI132_I26_XG_p1 I132_G2_1 I132_G2_0n VDD) gpdk090_pmos1v w=0.48u l=0.1u ad=0.1056p as=0.1632p pd=0.92u ps=1.64u
    I_MXI132_I26_XG_MP0 (VDD I132_P2_1 XI132_I26_XG_p1 VDD) gpdk090_pmos1v w=0.48u l=0.1u ad=0.1056p as=0.1056p pd=0.92u ps=0.92u
    I_MXI132_I26_XG_MP1 (XI132_I26_XG_p1 I132_G0_0 VDD VDD) gpdk090_pmos1v w=0.48u l=0.1u ad=0.1632p as=0.1056p pd=1.64u ps=0.92u
    I_MXI6_MP2 (XI6_p1 nak2 nakn3 VDD) gpdk090_pmos1v w=0.48u l=0.1u ad=0.1056p as=0.1632p pd=0.92u ps=1.64u
    I_MXI6_MP0 (VDD A_7 XI6_p1 VDD) gpdk090_pmos1v w=0.48u l=0.1u ad=0.1056p as=0.1056p pd=0.92u ps=0.92u
    I_MXI6_MP1 (XI6_p1 A_2 VDD VDD) gpdk090_pmos1v w=0.48u l=0.1u ad=0.1632p as=0.1056p pd=1.64u ps=0.92u
    I_MXI96_I26_XG_MP2 (XI96_I26_XG_p1 I96_G2_1 I96_G2_0n VDD) gpdk090_pmos1v w=0.48u l=0.1u ad=0.1056p as=0.1632p pd=0.92u ps=1.64u
    I_MXI96_I26_XG_MP0 (VDD I96_P2_1 XI96_I26_XG_p1 VDD) gpdk090_pmos1v w=0.48u l=0.1u ad=0.1056p as=0.1056p pd=0.92u ps=0.92u
    I_MXI96_I26_XG_MP1 (XI96_I26_XG_p1 I96_G0_0 VDD VDD) gpdk090_pmos1v w=0.48u l=0.1u ad=0.1632p as=0.1056p pd=1.64u ps=0.92u
    I_MXI96_I28_XG_MP2 (XI96_I28_XG_p1 I96_G4_3 I96_G4_1n VDD) gpdk090_pmos1v w=0.48u l=0.1u ad=0.1056p as=0.1632p pd=0.92u ps=1.64u
    I_MXI96_I28_XG_MP0 (VDD I96_P4_3 XI96_I28_XG_p1 VDD) gpdk090_pmos1v w=0.48u l=0.1u ad=0.1056p as=0.1056p pd=0.92u ps=0.92u
    I_MXI96_I28_XG_MP1 (XI96_I28_XG_p1 I96_G2_1 VDD VDD) gpdk090_pmos1v w=0.48u l=0.1u ad=0.1632p as=0.1056p pd=1.64u ps=0.92u
    I_MXI96_I30_XG_MP2 (XI96_I30_XG_p1 I96_G6_5 I96_G6_3n VDD) gpdk090_pmos1v w=0.48u l=0.1u ad=0.1056p as=0.1632p pd=0.92u ps=1.64u
    I_MXI96_I30_XG_MP0 (VDD I96_P6_5 XI96_I30_XG_p1 VDD) gpdk090_pmos1v w=0.48u l=0.1u ad=0.1056p as=0.1056p pd=0.92u ps=0.92u
    I_MXI96_I30_XG_MP1 (XI96_I30_XG_p1 I96_G4_3 VDD VDD) gpdk090_pmos1v w=0.48u l=0.1u ad=0.1632p as=0.1056p pd=1.64u ps=0.92u
    I_MXI152_I31_XG_MP2 (XI152_I31_XG_p1 I152_G7_6 I152_G7_4n VDD) gpdk090_pmos1v w=0.48u l=0.1u ad=0.1056p as=0.1632p pd=0.92u ps=1.64u
    I_MXI152_I31_XG_MP0 (VDD I152_P7_6 XI152_I31_XG_p1 VDD) gpdk090_pmos1v w=0.48u l=0.1u ad=0.1056p as=0.1056p pd=0.92u ps=0.92u
    I_MXI152_I31_XG_MP1 (XI152_I31_XG_p1 I152_G5_4 VDD VDD) gpdk090_pmos1v w=0.48u l=0.1u ad=0.1632p as=0.1056p pd=1.64u ps=0.92u
    I_MXI3_MP2 (XI3_p1 nak1 nakn2 VDD) gpdk090_pmos1v w=0.48u l=0.1u ad=0.1056p as=0.1632p pd=0.92u ps=1.64u
    I_MXI3_MP0 (VDD A_7 XI3_p1 VDD) gpdk090_pmos1v w=0.48u l=0.1u ad=0.1056p as=0.1056p pd=0.92u ps=0.92u
    I_MXI3_MP1 (XI3_p1 A_1 VDD VDD) gpdk090_pmos1v w=0.48u l=0.1u ad=0.1632p as=0.1056p pd=1.64u ps=0.92u
    I_MXI160_MP2 (XI160_p1 nqk2 nqkn3 VDD) gpdk090_pmos1v w=0.48u l=0.1u ad=0.1056p as=0.1632p pd=0.92u ps=1.64u
    I_MXI160_MP0 (VDD sq XI160_p1 VDD) gpdk090_pmos1v w=0.48u l=0.1u ad=0.1056p as=0.1056p pd=0.92u ps=0.92u
    I_MXI160_MP1 (XI160_p1 qu2 VDD VDD) gpdk090_pmos1v w=0.48u l=0.1u ad=0.1632p as=0.1056p pd=1.64u ps=0.92u
    I_MXI9_MP2 (XI9_p1 nak3 nakn4 VDD) gpdk090_pmos1v w=0.48u l=0.1u ad=0.1056p as=0.1632p pd=0.92u ps=1.64u
    I_MXI9_MP0 (VDD A_7 XI9_p1 VDD) gpdk090_pmos1v w=0.48u l=0.1u ad=0.1056p as=0.1056p pd=0.92u ps=0.92u
    I_MXI9_MP1 (XI9_p1 A_3 VDD VDD) gpdk090_pmos1v w=0.48u l=0.1u ad=0.1632p as=0.1056p pd=1.64u ps=0.92u
    I_MXI152_I29_XG_MP2 (XI152_I29_XG_p1 I152_G5_4 I152_G5_2n VDD) gpdk090_pmos1v w=0.48u l=0.1u ad=0.1056p as=0.1632p pd=0.92u ps=1.64u
    I_MXI152_I29_XG_MP0 (VDD I152_P5_4 XI152_I29_XG_p1 VDD) gpdk090_pmos1v w=0.48u l=0.1u ad=0.1056p as=0.1056p pd=0.92u ps=0.92u
    I_MXI152_I29_XG_MP1 (XI152_I29_XG_p1 I152_G3_2 VDD VDD) gpdk090_pmos1v w=0.48u l=0.1u ad=0.1632p as=0.1056p pd=1.64u ps=0.92u
    I_MXI152_I27_XG_MP2 (XI152_I27_XG_p1 I152_G3_2 I152_G3_0n VDD) gpdk090_pmos1v w=0.48u l=0.1u ad=0.1056p as=0.1632p pd=0.92u ps=1.64u
    I_MXI152_I27_XG_MP0 (VDD I152_P3_2 XI152_I27_XG_p1 VDD) gpdk090_pmos1v w=0.48u l=0.1u ad=0.1056p as=0.1056p pd=0.92u ps=0.92u
    I_MXI152_I27_XG_MP1 (XI152_I27_XG_p1 I152_G1_0 VDD VDD) gpdk090_pmos1v w=0.48u l=0.1u ad=0.1632p as=0.1056p pd=1.64u ps=0.92u
    I_MXI157_MP2 (XI157_p1 nqk1 nqkn2 VDD) gpdk090_pmos1v w=0.48u l=0.1u ad=0.1056p as=0.1632p pd=0.92u ps=1.64u
    I_MXI157_MP0 (VDD sq XI157_p1 VDD) gpdk090_pmos1v w=0.48u l=0.1u ad=0.1056p as=0.1056p pd=0.92u ps=0.92u
    I_MXI157_MP1 (XI157_p1 qu1 VDD VDD) gpdk090_pmos1v w=0.48u l=0.1u ad=0.1632p as=0.1056p pd=1.64u ps=0.92u
    I_MXI163_MP2 (XI163_p1 nqk3 nqkn4 VDD) gpdk090_pmos1v w=0.48u l=0.1u ad=0.1056p as=0.1632p pd=0.92u ps=1.64u
    I_MXI163_MP0 (VDD sq XI163_p1 VDD) gpdk090_pmos1v w=0.48u l=0.1u ad=0.1056p as=0.1056p pd=0.92u ps=0.92u
    I_MXI163_MP1 (XI163_p1 qu3 VDD VDD) gpdk090_pmos1v w=0.48u l=0.1u ad=0.1632p as=0.1056p pd=1.64u ps=0.92u
    I_MXI166_MP2 (XI166_p1 nqk4 nqkn5 VDD) gpdk090_pmos1v w=0.48u l=0.1u ad=0.1056p as=0.1632p pd=0.92u ps=1.64u
    I_MXI166_MP0 (VDD sq XI166_p1 VDD) gpdk090_pmos1v w=0.48u l=0.1u ad=0.1056p as=0.1056p pd=0.92u ps=0.92u
    I_MXI166_MP1 (XI166_p1 qu4 VDD VDD) gpdk090_pmos1v w=0.48u l=0.1u ad=0.1632p as=0.1056p pd=1.64u ps=0.92u
    I_MXI12_MP2 (XI12_p1 nak4 nakn5 VDD) gpdk090_pmos1v w=0.48u l=0.1u ad=0.1056p as=0.1632p pd=0.92u ps=1.64u
    I_MXI12_MP0 (VDD A_7 XI12_p1 VDD) gpdk090_pmos1v w=0.48u l=0.1u ad=0.1056p as=0.1056p pd=0.92u ps=0.92u
    I_MXI12_MP1 (XI12_p1 A_4 VDD VDD) gpdk090_pmos1v w=0.48u l=0.1u ad=0.1632p as=0.1056p pd=1.64u ps=0.92u
    I_MXI84_I26_XG_MP2 (XI84_I26_XG_p1 I84_G2_1 I84_G2_0n VDD) gpdk090_pmos1v w=0.48u l=0.1u ad=0.1056p as=0.1632p pd=0.92u ps=1.64u
    I_MXI84_I26_XG_MP0 (VDD I84_P2_1 XI84_I26_XG_p1 VDD) gpdk090_pmos1v w=0.48u l=0.1u ad=0.1056p as=0.1056p pd=0.92u ps=0.92u
    I_MXI84_I26_XG_MP1 (XI84_I26_XG_p1 I84_G0_0 VDD VDD) gpdk090_pmos1v w=0.48u l=0.1u ad=0.1632p as=0.1056p pd=1.64u ps=0.92u
    I_MXI152_I30_XG_MP2 (XI152_I30_XG_p1 I152_G6_5 I152_G6_3n VDD) gpdk090_pmos1v w=0.48u l=0.1u ad=0.1056p as=0.1632p pd=0.92u ps=1.64u
    I_MXI152_I30_XG_MP0 (VDD I152_P6_5 XI152_I30_XG_p1 VDD) gpdk090_pmos1v w=0.48u l=0.1u ad=0.1056p as=0.1056p pd=0.92u ps=0.92u
    I_MXI152_I30_XG_MP1 (XI152_I30_XG_p1 I152_G4_3 VDD VDD) gpdk090_pmos1v w=0.48u l=0.1u ad=0.1632p as=0.1056p pd=1.64u ps=0.92u
    I_MXI152_I28_XG_MP2 (XI152_I28_XG_p1 I152_G4_3 I152_G4_1n VDD) gpdk090_pmos1v w=0.48u l=0.1u ad=0.1056p as=0.1632p pd=0.92u ps=1.64u
    I_MXI152_I28_XG_MP0 (VDD I152_P4_3 XI152_I28_XG_p1 VDD) gpdk090_pmos1v w=0.48u l=0.1u ad=0.1056p as=0.1056p pd=0.92u ps=0.92u
    I_MXI152_I28_XG_MP1 (XI152_I28_XG_p1 I152_G2_1 VDD VDD) gpdk090_pmos1v w=0.48u l=0.1u ad=0.1632p as=0.1056p pd=1.64u ps=0.92u
    I_MXI35_MP2 (XI35_p1 nbk5 nbkn6 VDD) gpdk090_pmos1v w=0.48u l=0.1u ad=0.1056p as=0.1632p pd=0.92u ps=1.64u
    I_MXI35_MP0 (VDD B_7 XI35_p1 VDD) gpdk090_pmos1v w=0.48u l=0.1u ad=0.1056p as=0.1056p pd=0.92u ps=0.92u
    I_MXI35_MP1 (XI35_p1 B_5 VDD VDD) gpdk090_pmos1v w=0.48u l=0.1u ad=0.1632p as=0.1056p pd=1.64u ps=0.92u
    I_MXI38_MP2 (XI38_p1 nbk6 nbkn7 VDD) gpdk090_pmos1v w=0.48u l=0.1u ad=0.1056p as=0.1632p pd=0.92u ps=1.64u
    I_MXI38_MP0 (VDD B_7 XI38_p1 VDD) gpdk090_pmos1v w=0.48u l=0.1u ad=0.1056p as=0.1056p pd=0.92u ps=0.92u
    I_MXI38_MP1 (XI38_p1 B_6 VDD VDD) gpdk090_pmos1v w=0.48u l=0.1u ad=0.1632p as=0.1056p pd=1.64u ps=0.92u
    I_MXI23_MP2 (XI23_p1 nbk1 nbkn2 VDD) gpdk090_pmos1v w=0.48u l=0.1u ad=0.1056p as=0.1632p pd=0.92u ps=1.64u
    I_MXI23_MP0 (VDD B_7 XI23_p1 VDD) gpdk090_pmos1v w=0.48u l=0.1u ad=0.1056p as=0.1056p pd=0.92u ps=0.92u
    I_MXI23_MP1 (XI23_p1 B_1 VDD VDD) gpdk090_pmos1v w=0.48u l=0.1u ad=0.1632p as=0.1056p pd=1.64u ps=0.92u
    I_MXI172_MP2 (XI172_p1 nqk6 nqkn7 VDD) gpdk090_pmos1v w=0.48u l=0.1u ad=0.1056p as=0.1632p pd=0.92u ps=1.64u
    I_MXI172_MP0 (VDD sq XI172_p1 VDD) gpdk090_pmos1v w=0.48u l=0.1u ad=0.1056p as=0.1056p pd=0.92u ps=0.92u
    I_MXI172_MP1 (XI172_p1 qu6 VDD VDD) gpdk090_pmos1v w=0.48u l=0.1u ad=0.1632p as=0.1056p pd=1.64u ps=0.92u
    I_MXI169_MP2 (XI169_p1 nqk5 nqkn6 VDD) gpdk090_pmos1v w=0.48u l=0.1u ad=0.1056p as=0.1632p pd=0.92u ps=1.64u
    I_MXI169_MP0 (VDD sq XI169_p1 VDD) gpdk090_pmos1v w=0.48u l=0.1u ad=0.1056p as=0.1056p pd=0.92u ps=0.92u
    I_MXI169_MP1 (XI169_p1 qu5 VDD VDD) gpdk090_pmos1v w=0.48u l=0.1u ad=0.1632p as=0.1056p pd=1.64u ps=0.92u
    I_MXI84_I28_XG_MP2 (XI84_I28_XG_p1 I84_G4_3 I84_G4_1n VDD) gpdk090_pmos1v w=0.48u l=0.1u ad=0.1056p as=0.1632p pd=0.92u ps=1.64u
    I_MXI84_I28_XG_MP0 (VDD I84_P4_3 XI84_I28_XG_p1 VDD) gpdk090_pmos1v w=0.48u l=0.1u ad=0.1056p as=0.1056p pd=0.92u ps=0.92u
    I_MXI84_I28_XG_MP1 (XI84_I28_XG_p1 I84_G2_1 VDD VDD) gpdk090_pmos1v w=0.48u l=0.1u ad=0.1632p as=0.1056p pd=1.64u ps=0.92u
    I_MXI84_I30_XG_MP2 (XI84_I30_XG_p1 I84_G6_5 I84_G6_3n VDD) gpdk090_pmos1v w=0.48u l=0.1u ad=0.1056p as=0.1632p pd=0.92u ps=1.64u
    I_MXI84_I30_XG_MP0 (VDD I84_P6_5 XI84_I30_XG_p1 VDD) gpdk090_pmos1v w=0.48u l=0.1u ad=0.1056p as=0.1056p pd=0.92u ps=0.92u
    I_MXI84_I30_XG_MP1 (XI84_I30_XG_p1 I84_G4_3 VDD VDD) gpdk090_pmos1v w=0.48u l=0.1u ad=0.1632p as=0.1056p pd=1.64u ps=0.92u
    I_MXI152_I26_XG_MP2 (XI152_I26_XG_p1 I152_G2_1 I152_G2_0n VDD) gpdk090_pmos1v w=0.48u l=0.1u ad=0.1056p as=0.1632p pd=0.92u ps=1.64u
    I_MXI152_I26_XG_MP0 (VDD I152_P2_1 XI152_I26_XG_p1 VDD) gpdk090_pmos1v w=0.48u l=0.1u ad=0.1056p as=0.1056p pd=0.92u ps=0.92u
    I_MXI152_I26_XG_MP1 (XI152_I26_XG_p1 I152_G0_0 VDD VDD) gpdk090_pmos1v w=0.48u l=0.1u ad=0.1632p as=0.1056p pd=1.64u ps=0.92u
    I_MXI29_MP2 (XI29_p1 nbk3 nbkn4 VDD) gpdk090_pmos1v w=0.48u l=0.1u ad=0.1056p as=0.1632p pd=0.92u ps=1.64u
    I_MXI29_MP0 (VDD B_7 XI29_p1 VDD) gpdk090_pmos1v w=0.48u l=0.1u ad=0.1056p as=0.1056p pd=0.92u ps=0.92u
    I_MXI29_MP1 (XI29_p1 B_3 VDD VDD) gpdk090_pmos1v w=0.48u l=0.1u ad=0.1632p as=0.1056p pd=1.64u ps=0.92u
    I_MXI32_MP2 (XI32_p1 nbk4 nbkn5 VDD) gpdk090_pmos1v w=0.48u l=0.1u ad=0.1056p as=0.1632p pd=0.92u ps=1.64u
    I_MXI32_MP0 (VDD B_7 XI32_p1 VDD) gpdk090_pmos1v w=0.48u l=0.1u ad=0.1056p as=0.1056p pd=0.92u ps=0.92u
    I_MXI32_MP1 (XI32_p1 B_4 VDD VDD) gpdk090_pmos1v w=0.48u l=0.1u ad=0.1632p as=0.1056p pd=1.64u ps=0.92u
    I_MXI15_MP2 (XI15_p1 nak5 nakn6 VDD) gpdk090_pmos1v w=0.48u l=0.1u ad=0.1056p as=0.1632p pd=0.92u ps=1.64u
    I_MXI15_MP0 (VDD A_7 XI15_p1 VDD) gpdk090_pmos1v w=0.48u l=0.1u ad=0.1056p as=0.1056p pd=0.92u ps=0.92u
    I_MXI15_MP1 (XI15_p1 A_5 VDD VDD) gpdk090_pmos1v w=0.48u l=0.1u ad=0.1632p as=0.1056p pd=1.64u ps=0.92u
    I_MXI84_I27_XG_MP2 (XI84_I27_XG_p1 I84_G3_2 I84_G3_0n VDD) gpdk090_pmos1v w=0.48u l=0.1u ad=0.1056p as=0.1632p pd=0.92u ps=1.64u
    I_MXI84_I27_XG_MP0 (VDD I84_P3_2 XI84_I27_XG_p1 VDD) gpdk090_pmos1v w=0.48u l=0.1u ad=0.1056p as=0.1056p pd=0.92u ps=0.92u
    I_MXI84_I27_XG_MP1 (XI84_I27_XG_p1 I84_G1_0 VDD VDD) gpdk090_pmos1v w=0.48u l=0.1u ad=0.1632p as=0.1056p pd=1.64u ps=0.92u
    I_MXI84_I29_XG_MP2 (XI84_I29_XG_p1 I84_G5_4 I84_G5_2n VDD) gpdk090_pmos1v w=0.48u l=0.1u ad=0.1056p as=0.1632p pd=0.92u ps=1.64u
    I_MXI84_I29_XG_MP0 (VDD I84_P5_4 XI84_I29_XG_p1 VDD) gpdk090_pmos1v w=0.48u l=0.1u ad=0.1056p as=0.1056p pd=0.92u ps=0.92u
    I_MXI84_I29_XG_MP1 (XI84_I29_XG_p1 I84_G3_2 VDD VDD) gpdk090_pmos1v w=0.48u l=0.1u ad=0.1632p as=0.1056p pd=1.64u ps=0.92u
    I_MXI192_MP2 (XI192_p1 nrk6 nrkn7 VDD) gpdk090_pmos1v w=0.48u l=0.1u ad=0.1056p as=0.1632p pd=0.92u ps=1.64u
    I_MXI192_MP0 (VDD A_7 XI192_p1 VDD) gpdk090_pmos1v w=0.48u l=0.1u ad=0.1056p as=0.1056p pd=0.92u ps=0.92u
    I_MXI192_MP1 (XI192_p1 ru6 VDD VDD) gpdk090_pmos1v w=0.48u l=0.1u ad=0.1632p as=0.1056p pd=1.64u ps=0.92u
    I_MXI183_MP2 (XI183_p1 nrk3 nrkn4 VDD) gpdk090_pmos1v w=0.48u l=0.1u ad=0.1056p as=0.1632p pd=0.92u ps=1.64u
    I_MXI183_MP0 (VDD A_7 XI183_p1 VDD) gpdk090_pmos1v w=0.48u l=0.1u ad=0.1056p as=0.1056p pd=0.92u ps=0.92u
    I_MXI183_MP1 (XI183_p1 ru3 VDD VDD) gpdk090_pmos1v w=0.48u l=0.1u ad=0.1632p as=0.1056p pd=1.64u ps=0.92u
    I_MXI180_MP2 (XI180_p1 nrk2 nrkn3 VDD) gpdk090_pmos1v w=0.48u l=0.1u ad=0.1056p as=0.1632p pd=0.92u ps=1.64u
    I_MXI180_MP0 (VDD A_7 XI180_p1 VDD) gpdk090_pmos1v w=0.48u l=0.1u ad=0.1056p as=0.1056p pd=0.92u ps=0.92u
    I_MXI180_MP1 (XI180_p1 ru2 VDD VDD) gpdk090_pmos1v w=0.48u l=0.1u ad=0.1632p as=0.1056p pd=1.64u ps=0.92u
    I_MXI177_MP2 (XI177_p1 nrk1 nrkn2 VDD) gpdk090_pmos1v w=0.48u l=0.1u ad=0.1056p as=0.1632p pd=0.92u ps=1.64u
    I_MXI177_MP0 (VDD A_7 XI177_p1 VDD) gpdk090_pmos1v w=0.48u l=0.1u ad=0.1056p as=0.1056p pd=0.92u ps=0.92u
    I_MXI177_MP1 (XI177_p1 ru1 VDD VDD) gpdk090_pmos1v w=0.48u l=0.1u ad=0.1632p as=0.1056p pd=1.64u ps=0.92u
    I_MXI26_MP2 (XI26_p1 nbk2 nbkn3 VDD) gpdk090_pmos1v w=0.48u l=0.1u ad=0.1056p as=0.1632p pd=0.92u ps=1.64u
    I_MXI26_MP0 (VDD B_7 XI26_p1 VDD) gpdk090_pmos1v w=0.48u l=0.1u ad=0.1056p as=0.1056p pd=0.92u ps=0.92u
    I_MXI26_MP1 (XI26_p1 B_2 VDD VDD) gpdk090_pmos1v w=0.48u l=0.1u ad=0.1632p as=0.1056p pd=1.64u ps=0.92u
    I_MXI18_MP2 (XI18_p1 nak6 nakn7 VDD) gpdk090_pmos1v w=0.48u l=0.1u ad=0.1056p as=0.1632p pd=0.92u ps=1.64u
    I_MXI18_MP0 (VDD A_7 XI18_p1 VDD) gpdk090_pmos1v w=0.48u l=0.1u ad=0.1056p as=0.1056p pd=0.92u ps=0.92u
    I_MXI18_MP1 (XI18_p1 A_6 VDD VDD) gpdk090_pmos1v w=0.48u l=0.1u ad=0.1632p as=0.1056p pd=1.64u ps=0.92u
    I_MXI84_I31_XG_MP2 (XI84_I31_XG_p1 I84_G7_6 I84_G7_4n VDD) gpdk090_pmos1v w=0.48u l=0.1u ad=0.1056p as=0.1632p pd=0.92u ps=1.64u
    I_MXI84_I31_XG_MP0 (VDD I84_P7_6 XI84_I31_XG_p1 VDD) gpdk090_pmos1v w=0.48u l=0.1u ad=0.1056p as=0.1056p pd=0.92u ps=0.92u
    I_MXI84_I31_XG_MP1 (XI84_I31_XG_p1 I84_G5_4 VDD VDD) gpdk090_pmos1v w=0.48u l=0.1u ad=0.1632p as=0.1056p pd=1.64u ps=0.92u
    I_MXI189_MP2 (XI189_p1 nrk5 nrkn6 VDD) gpdk090_pmos1v w=0.48u l=0.1u ad=0.1056p as=0.1632p pd=0.92u ps=1.64u
    I_MXI189_MP0 (VDD A_7 XI189_p1 VDD) gpdk090_pmos1v w=0.48u l=0.1u ad=0.1056p as=0.1056p pd=0.92u ps=0.92u
    I_MXI189_MP1 (XI189_p1 ru5 VDD VDD) gpdk090_pmos1v w=0.48u l=0.1u ad=0.1632p as=0.1056p pd=1.64u ps=0.92u
    I_MXI186_MP2 (XI186_p1 nrk4 nrkn5 VDD) gpdk090_pmos1v w=0.48u l=0.1u ad=0.1056p as=0.1632p pd=0.92u ps=1.64u
    I_MXI186_MP0 (VDD A_7 XI186_p1 VDD) gpdk090_pmos1v w=0.48u l=0.1u ad=0.1056p as=0.1056p pd=0.92u ps=0.92u
    I_MXI186_MP1 (XI186_p1 ru4 VDD VDD) gpdk090_pmos1v w=0.48u l=0.1u ad=0.1632p as=0.1056p pd=1.64u ps=0.92u
    I_MXI72_I26_XG_MP2 (XI72_I26_XG_p1 I72_G2_1 I72_G2_0n VDD) gpdk090_pmos1v w=0.48u l=0.1u ad=0.1056p as=0.1632p pd=0.92u ps=1.64u
    I_MXI72_I26_XG_MP0 (VDD I72_P2_1 XI72_I26_XG_p1 VDD) gpdk090_pmos1v w=0.48u l=0.1u ad=0.1056p as=0.1056p pd=0.92u ps=0.92u
    I_MXI72_I26_XG_MP1 (XI72_I26_XG_p1 I72_G0_0 VDD VDD) gpdk090_pmos1v w=0.48u l=0.1u ad=0.1632p as=0.1056p pd=1.64u ps=0.92u
    I_MXI48_I28_XG_MP2 (XI48_I28_XG_p1 I48_G4_3 I48_G4_1n VDD) gpdk090_pmos1v w=0.48u l=0.1u ad=0.1056p as=0.1632p pd=0.92u ps=1.64u
    I_MXI48_I28_XG_MP0 (VDD I48_P4_3 XI48_I28_XG_p1 VDD) gpdk090_pmos1v w=0.48u l=0.1u ad=0.1056p as=0.1056p pd=0.92u ps=0.92u
    I_MXI48_I28_XG_MP1 (XI48_I28_XG_p1 I48_G2_1 VDD VDD) gpdk090_pmos1v w=0.48u l=0.1u ad=0.1632p as=0.1056p pd=1.64u ps=0.92u
    I_MXI48_I26_XG_MP2 (XI48_I26_XG_p1 I48_G2_1 I48_G2_0n VDD) gpdk090_pmos1v w=0.48u l=0.1u ad=0.1056p as=0.1632p pd=0.92u ps=1.64u
    I_MXI48_I26_XG_MP0 (VDD I48_P2_1 XI48_I26_XG_p1 VDD) gpdk090_pmos1v w=0.48u l=0.1u ad=0.1056p as=0.1056p pd=0.92u ps=0.92u
    I_MXI48_I26_XG_MP1 (XI48_I26_XG_p1 I48_G0_0 VDD VDD) gpdk090_pmos1v w=0.48u l=0.1u ad=0.1632p as=0.1056p pd=1.64u ps=0.92u
    I_MXI72_I28_XG_MP2 (XI72_I28_XG_p1 I72_G4_3 I72_G4_1n VDD) gpdk090_pmos1v w=0.48u l=0.1u ad=0.1056p as=0.1632p pd=0.92u ps=1.64u
    I_MXI72_I28_XG_MP0 (VDD I72_P4_3 XI72_I28_XG_p1 VDD) gpdk090_pmos1v w=0.48u l=0.1u ad=0.1056p as=0.1056p pd=0.92u ps=0.92u
    I_MXI72_I28_XG_MP1 (XI72_I28_XG_p1 I72_G2_1 VDD VDD) gpdk090_pmos1v w=0.48u l=0.1u ad=0.1632p as=0.1056p pd=1.64u ps=0.92u
    I_MXI48_I30_XG_MP2 (XI48_I30_XG_p1 I48_G6_5 I48_G6_3n VDD) gpdk090_pmos1v w=0.48u l=0.1u ad=0.1056p as=0.1632p pd=0.92u ps=1.64u
    I_MXI48_I30_XG_MP0 (VDD I48_P6_5 XI48_I30_XG_p1 VDD) gpdk090_pmos1v w=0.48u l=0.1u ad=0.1056p as=0.1056p pd=0.92u ps=0.92u
    I_MXI48_I30_XG_MP1 (XI48_I30_XG_p1 I48_G4_3 VDD VDD) gpdk090_pmos1v w=0.48u l=0.1u ad=0.1632p as=0.1056p pd=1.64u ps=0.92u
    I_MXI48_I27_XG_MP2 (XI48_I27_XG_p1 I48_G3_2 I48_G3_0n VDD) gpdk090_pmos1v w=0.48u l=0.1u ad=0.1056p as=0.1632p pd=0.92u ps=1.64u
    I_MXI48_I27_XG_MP0 (VDD I48_P3_2 XI48_I27_XG_p1 VDD) gpdk090_pmos1v w=0.48u l=0.1u ad=0.1056p as=0.1056p pd=0.92u ps=0.92u
    I_MXI48_I27_XG_MP1 (XI48_I27_XG_p1 I48_G1_0 VDD VDD) gpdk090_pmos1v w=0.48u l=0.1u ad=0.1632p as=0.1056p pd=1.64u ps=0.92u
    I_MXI60_I27_XG_MP2 (XI60_I27_XG_p1 I60_G3_2 I60_G3_0n VDD) gpdk090_pmos1v w=0.48u l=0.1u ad=0.1056p as=0.1632p pd=0.92u ps=1.64u
    I_MXI60_I27_XG_MP0 (VDD I60_P3_2 XI60_I27_XG_p1 VDD) gpdk090_pmos1v w=0.48u l=0.1u ad=0.1056p as=0.1056p pd=0.92u ps=0.92u
    I_MXI60_I27_XG_MP1 (XI60_I27_XG_p1 I60_G1_0 VDD VDD) gpdk090_pmos1v w=0.48u l=0.1u ad=0.1632p as=0.1056p pd=1.64u ps=0.92u
    I_MXI60_I26_XG_MP2 (XI60_I26_XG_p1 I60_G2_1 I60_G2_0n VDD) gpdk090_pmos1v w=0.48u l=0.1u ad=0.1056p as=0.1632p pd=0.92u ps=1.64u
    I_MXI60_I26_XG_MP0 (VDD I60_P2_1 XI60_I26_XG_p1 VDD) gpdk090_pmos1v w=0.48u l=0.1u ad=0.1056p as=0.1056p pd=0.92u ps=0.92u
    I_MXI60_I26_XG_MP1 (XI60_I26_XG_p1 I60_G0_0 VDD VDD) gpdk090_pmos1v w=0.48u l=0.1u ad=0.1632p as=0.1056p pd=1.64u ps=0.92u
    I_MXI60_I28_XG_MP2 (XI60_I28_XG_p1 I60_G4_3 I60_G4_1n VDD) gpdk090_pmos1v w=0.48u l=0.1u ad=0.1056p as=0.1632p pd=0.92u ps=1.64u
    I_MXI60_I28_XG_MP0 (VDD I60_P4_3 XI60_I28_XG_p1 VDD) gpdk090_pmos1v w=0.48u l=0.1u ad=0.1056p as=0.1056p pd=0.92u ps=0.92u
    I_MXI60_I28_XG_MP1 (XI60_I28_XG_p1 I60_G2_1 VDD VDD) gpdk090_pmos1v w=0.48u l=0.1u ad=0.1632p as=0.1056p pd=1.64u ps=0.92u
    I_MXI72_I27_XG_MP2 (XI72_I27_XG_p1 I72_G3_2 I72_G3_0n VDD) gpdk090_pmos1v w=0.48u l=0.1u ad=0.1056p as=0.1632p pd=0.92u ps=1.64u
    I_MXI72_I27_XG_MP0 (VDD I72_P3_2 XI72_I27_XG_p1 VDD) gpdk090_pmos1v w=0.48u l=0.1u ad=0.1056p as=0.1056p pd=0.92u ps=0.92u
    I_MXI72_I27_XG_MP1 (XI72_I27_XG_p1 I72_G1_0 VDD VDD) gpdk090_pmos1v w=0.48u l=0.1u ad=0.1632p as=0.1056p pd=1.64u ps=0.92u
    I_MXI72_I29_XG_MP2 (XI72_I29_XG_p1 I72_G5_4 I72_G5_2n VDD) gpdk090_pmos1v w=0.48u l=0.1u ad=0.1056p as=0.1632p pd=0.92u ps=1.64u
    I_MXI72_I29_XG_MP0 (VDD I72_P5_4 XI72_I29_XG_p1 VDD) gpdk090_pmos1v w=0.48u l=0.1u ad=0.1056p as=0.1056p pd=0.92u ps=0.92u
    I_MXI72_I29_XG_MP1 (XI72_I29_XG_p1 I72_G3_2 VDD VDD) gpdk090_pmos1v w=0.48u l=0.1u ad=0.1632p as=0.1056p pd=1.64u ps=0.92u
    I_MXI48_I31_XG_MP2 (XI48_I31_XG_p1 I48_G7_6 I48_G7_4n VDD) gpdk090_pmos1v w=0.48u l=0.1u ad=0.1056p as=0.1632p pd=0.92u ps=1.64u
    I_MXI48_I31_XG_MP0 (VDD I48_P7_6 XI48_I31_XG_p1 VDD) gpdk090_pmos1v w=0.48u l=0.1u ad=0.1056p as=0.1056p pd=0.92u ps=0.92u
    I_MXI48_I31_XG_MP1 (XI48_I31_XG_p1 I48_G5_4 VDD VDD) gpdk090_pmos1v w=0.48u l=0.1u ad=0.1632p as=0.1056p pd=1.64u ps=0.92u
    I_MXI48_I29_XG_MP2 (XI48_I29_XG_p1 I48_G5_4 I48_G5_2n VDD) gpdk090_pmos1v w=0.48u l=0.1u ad=0.1056p as=0.1632p pd=0.92u ps=1.64u
    I_MXI48_I29_XG_MP0 (VDD I48_P5_4 XI48_I29_XG_p1 VDD) gpdk090_pmos1v w=0.48u l=0.1u ad=0.1056p as=0.1056p pd=0.92u ps=0.92u
    I_MXI48_I29_XG_MP1 (XI48_I29_XG_p1 I48_G3_2 VDD VDD) gpdk090_pmos1v w=0.48u l=0.1u ad=0.1632p as=0.1056p pd=1.64u ps=0.92u
    I_MXI60_I29_XG_MP2 (XI60_I29_XG_p1 I60_G5_4 I60_G5_2n VDD) gpdk090_pmos1v w=0.48u l=0.1u ad=0.1056p as=0.1632p pd=0.92u ps=1.64u
    I_MXI60_I29_XG_MP0 (VDD I60_P5_4 XI60_I29_XG_p1 VDD) gpdk090_pmos1v w=0.48u l=0.1u ad=0.1056p as=0.1056p pd=0.92u ps=0.92u
    I_MXI60_I29_XG_MP1 (XI60_I29_XG_p1 I60_G3_2 VDD VDD) gpdk090_pmos1v w=0.48u l=0.1u ad=0.1632p as=0.1056p pd=1.64u ps=0.92u
    I_MXI60_I30_XG_MP2 (XI60_I30_XG_p1 I60_G6_5 I60_G6_3n VDD) gpdk090_pmos1v w=0.48u l=0.1u ad=0.1056p as=0.1632p pd=0.92u ps=1.64u
    I_MXI60_I30_XG_MP0 (VDD I60_P6_5 XI60_I30_XG_p1 VDD) gpdk090_pmos1v w=0.48u l=0.1u ad=0.1056p as=0.1056p pd=0.92u ps=0.92u
    I_MXI60_I30_XG_MP1 (XI60_I30_XG_p1 I60_G4_3 VDD VDD) gpdk090_pmos1v w=0.48u l=0.1u ad=0.1632p as=0.1056p pd=1.64u ps=0.92u
    I_MXI72_I30_XG_MP2 (XI72_I30_XG_p1 I72_G6_5 I72_G6_3n VDD) gpdk090_pmos1v w=0.48u l=0.1u ad=0.1056p as=0.1632p pd=0.92u ps=1.64u
    I_MXI72_I30_XG_MP0 (VDD I72_P6_5 XI72_I30_XG_p1 VDD) gpdk090_pmos1v w=0.48u l=0.1u ad=0.1056p as=0.1056p pd=0.92u ps=0.92u
    I_MXI72_I30_XG_MP1 (XI72_I30_XG_p1 I72_G4_3 VDD VDD) gpdk090_pmos1v w=0.48u l=0.1u ad=0.1632p as=0.1056p pd=1.64u ps=0.92u
    I_MXI60_I31_XG_MP2 (XI60_I31_XG_p1 I60_G7_6 I60_G7_4n VDD) gpdk090_pmos1v w=0.48u l=0.1u ad=0.1056p as=0.1632p pd=0.92u ps=1.64u
    I_MXI60_I31_XG_MP0 (VDD I60_P7_6 XI60_I31_XG_p1 VDD) gpdk090_pmos1v w=0.48u l=0.1u ad=0.1056p as=0.1056p pd=0.92u ps=0.92u
    I_MXI60_I31_XG_MP1 (XI60_I31_XG_p1 I60_G5_4 VDD VDD) gpdk090_pmos1v w=0.48u l=0.1u ad=0.1632p as=0.1056p pd=1.64u ps=0.92u
    I_MXI72_I31_XG_MP2 (XI72_I31_XG_p1 I72_G7_6 I72_G7_4n VDD) gpdk090_pmos1v w=0.48u l=0.1u ad=0.1056p as=0.1632p pd=0.92u ps=1.64u
    I_MXI72_I31_XG_MP0 (VDD I72_P7_6 XI72_I31_XG_p1 VDD) gpdk090_pmos1v w=0.48u l=0.1u ad=0.1056p as=0.1056p pd=0.92u ps=0.92u
    I_MXI72_I31_XG_MP1 (XI72_I31_XG_p1 I72_G5_4 VDD VDD) gpdk090_pmos1v w=0.48u l=0.1u ad=0.1632p as=0.1056p pd=1.64u ps=0.92u
    I_MXI120_I36_XG_MP2 (VDD I120_G7_4n c6_8 VDD) gpdk090_pmos1v w=0.24u l=0.1u ad=0.0936p as=0.0816p pd=0.92u ps=1.16u
    I_MXI120_I36_XG_MP0 (XI120_I36_XG_p1 I120_P7_4n VDD VDD) gpdk090_pmos1v w=0.48u l=0.1u ad=0.1056p as=0.0936p pd=0.92u ps=0.92u
    I_MXI120_I36_XG_MP1 (c6_8 I120_G3_0n XI120_I36_XG_p1 VDD) gpdk090_pmos1v w=0.48u l=0.1u ad=0.1632p as=0.1056p pd=1.64u ps=0.92u
    I_MXI120_I25_XG_MP2 (VDD I120_gn7 I120_G7_6 VDD) gpdk090_pmos1v w=0.24u l=0.1u ad=0.0936p as=0.0816p pd=0.92u ps=1.16u
    I_MXI120_I25_XG_MP0 (XI120_I25_XG_p1 I120_pn7 VDD VDD) gpdk090_pmos1v w=0.48u l=0.1u ad=0.1056p as=0.0936p pd=0.92u ps=0.92u
    I_MXI120_I25_XG_MP1 (I120_G7_6 I120_gn6 XI120_I25_XG_p1 VDD) gpdk090_pmos1v w=0.48u l=0.1u ad=0.1632p as=0.1056p pd=1.64u ps=0.92u
    I_MXI108_I35_XG_MP2 (VDD I108_G6_3n c5_7 VDD) gpdk090_pmos1v w=0.24u l=0.1u ad=0.0936p as=0.0816p pd=0.92u ps=1.16u
    I_MXI108_I35_XG_MP0 (XI108_I35_XG_p1 I108_P6_3n VDD VDD) gpdk090_pmos1v w=0.48u l=0.1u ad=0.1056p as=0.0936p pd=0.92u ps=0.92u
    I_MXI108_I35_XG_MP1 (c5_7 I108_G2_0n XI108_I35_XG_p1 VDD) gpdk090_pmos1v w=0.48u l=0.1u ad=0.1632p as=0.1056p pd=1.64u ps=0.92u
    I_MXI108_I34_XG_MP2 (VDD I108_G5_2n I108_G5_0 VDD) gpdk090_pmos1v w=0.24u l=0.1u ad=0.0936p as=0.0816p pd=0.92u ps=1.16u
    I_MXI108_I34_XG_MP0 (XI108_I34_XG_p1 I108_P5_2n VDD VDD) gpdk090_pmos1v w=0.48u l=0.1u ad=0.1056p as=0.0936p pd=0.92u ps=0.92u
    I_MXI108_I34_XG_MP1 (I108_G5_0 I108_G1_0n XI108_I34_XG_p1 VDD) gpdk090_pmos1v w=0.48u l=0.1u ad=0.1632p as=0.1056p pd=1.64u ps=0.92u
    I_MXI108_I25_XG_MP2 (VDD I108_gn7 I108_G7_6 VDD) gpdk090_pmos1v w=0.24u l=0.1u ad=0.0936p as=0.0816p pd=0.92u ps=1.16u
    I_MXI108_I25_XG_MP0 (XI108_I25_XG_p1 I108_pn7 VDD VDD) gpdk090_pmos1v w=0.48u l=0.1u ad=0.1056p as=0.0936p pd=0.92u ps=0.92u
    I_MXI108_I25_XG_MP1 (I108_G7_6 I108_gn6 XI108_I25_XG_p1 VDD) gpdk090_pmos1v w=0.48u l=0.1u ad=0.1632p as=0.1056p pd=1.64u ps=0.92u
    I_MXI132_I25_XG_MP2 (VDD I132_gn7 I132_G7_6 VDD) gpdk090_pmos1v w=0.24u l=0.1u ad=0.0936p as=0.0816p pd=0.92u ps=1.16u
    I_MXI132_I25_XG_MP0 (XI132_I25_XG_p1 I132_pn7 VDD VDD) gpdk090_pmos1v w=0.48u l=0.1u ad=0.1056p as=0.0936p pd=0.92u ps=0.92u
    I_MXI132_I25_XG_MP1 (I132_G7_6 I132_gn6 XI132_I25_XG_p1 VDD) gpdk090_pmos1v w=0.48u l=0.1u ad=0.1632p as=0.1056p pd=1.64u ps=0.92u
    I_MXI132_I24_XG_MP2 (VDD I132_gn6 I132_G6_5 VDD) gpdk090_pmos1v w=0.24u l=0.1u ad=0.0936p as=0.0816p pd=0.92u ps=1.16u
    I_MXI132_I24_XG_MP0 (XI132_I24_XG_p1 I132_pn6 VDD VDD) gpdk090_pmos1v w=0.48u l=0.1u ad=0.1056p as=0.0936p pd=0.92u ps=0.92u
    I_MXI132_I24_XG_MP1 (I132_G6_5 I132_gn5 XI132_I24_XG_p1 VDD) gpdk090_pmos1v w=0.48u l=0.1u ad=0.1632p as=0.1056p pd=1.64u ps=0.92u
    I_MXI120_I35_XG_MP2 (VDD I120_G6_3n c6_7 VDD) gpdk090_pmos1v w=0.24u l=0.1u ad=0.0936p as=0.0816p pd=0.92u ps=1.16u
    I_MXI120_I35_XG_MP0 (XI120_I35_XG_p1 I120_P6_3n VDD VDD) gpdk090_pmos1v w=0.48u l=0.1u ad=0.1056p as=0.0936p pd=0.92u ps=0.92u
    I_MXI120_I35_XG_MP1 (c6_7 I120_G2_0n XI120_I35_XG_p1 VDD) gpdk090_pmos1v w=0.48u l=0.1u ad=0.1632p as=0.1056p pd=1.64u ps=0.92u
    I_MXI120_I34_XG_MP2 (VDD I120_G5_2n I120_G5_0 VDD) gpdk090_pmos1v w=0.24u l=0.1u ad=0.0936p as=0.0816p pd=0.92u ps=1.16u
    I_MXI120_I34_XG_MP0 (XI120_I34_XG_p1 I120_P5_2n VDD VDD) gpdk090_pmos1v w=0.48u l=0.1u ad=0.1056p as=0.0936p pd=0.92u ps=0.92u
    I_MXI120_I34_XG_MP1 (I120_G5_0 I120_G1_0n XI120_I34_XG_p1 VDD) gpdk090_pmos1v w=0.48u l=0.1u ad=0.1632p as=0.1056p pd=1.64u ps=0.92u
    I_MXI120_I23_XG_MP2 (VDD I120_gn5 I120_G5_4 VDD) gpdk090_pmos1v w=0.24u l=0.1u ad=0.0936p as=0.0816p pd=0.92u ps=1.16u
    I_MXI120_I23_XG_MP0 (XI120_I23_XG_p1 I120_pn5 VDD VDD) gpdk090_pmos1v w=0.48u l=0.1u ad=0.1056p as=0.0936p pd=0.92u ps=0.92u
    I_MXI120_I23_XG_MP1 (I120_G5_4 I120_gn4 XI120_I23_XG_p1 VDD) gpdk090_pmos1v w=0.48u l=0.1u ad=0.1632p as=0.1056p pd=1.64u ps=0.92u
    I_MXI120_I24_XG_MP2 (VDD I120_gn6 I120_G6_5 VDD) gpdk090_pmos1v w=0.24u l=0.1u ad=0.0936p as=0.0816p pd=0.92u ps=1.16u
    I_MXI120_I24_XG_MP0 (XI120_I24_XG_p1 I120_pn6 VDD VDD) gpdk090_pmos1v w=0.48u l=0.1u ad=0.1056p as=0.0936p pd=0.92u ps=0.92u
    I_MXI120_I24_XG_MP1 (I120_G6_5 I120_gn5 XI120_I24_XG_p1 VDD) gpdk090_pmos1v w=0.48u l=0.1u ad=0.1632p as=0.1056p pd=1.64u ps=0.92u
    I_MXI108_I23_XG_MP2 (VDD I108_gn5 I108_G5_4 VDD) gpdk090_pmos1v w=0.24u l=0.1u ad=0.0936p as=0.0816p pd=0.92u ps=1.16u
    I_MXI108_I23_XG_MP0 (XI108_I23_XG_p1 I108_pn5 VDD VDD) gpdk090_pmos1v w=0.48u l=0.1u ad=0.1056p as=0.0936p pd=0.92u ps=0.92u
    I_MXI108_I23_XG_MP1 (I108_G5_4 I108_gn4 XI108_I23_XG_p1 VDD) gpdk090_pmos1v w=0.48u l=0.1u ad=0.1632p as=0.1056p pd=1.64u ps=0.92u
    I_MXI108_I36_XG_MP2 (VDD I108_G7_4n c5_8 VDD) gpdk090_pmos1v w=0.24u l=0.1u ad=0.0936p as=0.0816p pd=0.92u ps=1.16u
    I_MXI108_I36_XG_MP0 (XI108_I36_XG_p1 I108_P7_4n VDD VDD) gpdk090_pmos1v w=0.48u l=0.1u ad=0.1056p as=0.0936p pd=0.92u ps=0.92u
    I_MXI108_I36_XG_MP1 (c5_8 I108_G3_0n XI108_I36_XG_p1 VDD) gpdk090_pmos1v w=0.48u l=0.1u ad=0.1632p as=0.1056p pd=1.64u ps=0.92u
    I_MXI108_I24_XG_MP2 (VDD I108_gn6 I108_G6_5 VDD) gpdk090_pmos1v w=0.24u l=0.1u ad=0.0936p as=0.0816p pd=0.92u ps=1.16u
    I_MXI108_I24_XG_MP0 (XI108_I24_XG_p1 I108_pn6 VDD VDD) gpdk090_pmos1v w=0.48u l=0.1u ad=0.1056p as=0.0936p pd=0.92u ps=0.92u
    I_MXI108_I24_XG_MP1 (I108_G6_5 I108_gn5 XI108_I24_XG_p1 VDD) gpdk090_pmos1v w=0.48u l=0.1u ad=0.1632p as=0.1056p pd=1.64u ps=0.92u
    I_MXI132_I36_XG_MP2 (VDD I132_G7_4n c7_8 VDD) gpdk090_pmos1v w=0.24u l=0.1u ad=0.0936p as=0.0816p pd=0.92u ps=1.16u
    I_MXI132_I36_XG_MP0 (XI132_I36_XG_p1 I132_P7_4n VDD VDD) gpdk090_pmos1v w=0.48u l=0.1u ad=0.1056p as=0.0936p pd=0.92u ps=0.92u
    I_MXI132_I36_XG_MP1 (c7_8 I132_G3_0n XI132_I36_XG_p1 VDD) gpdk090_pmos1v w=0.48u l=0.1u ad=0.1632p as=0.1056p pd=1.64u ps=0.92u
    I_MXI132_I23_XG_MP2 (VDD I132_gn5 I132_G5_4 VDD) gpdk090_pmos1v w=0.24u l=0.1u ad=0.0936p as=0.0816p pd=0.92u ps=1.16u
    I_MXI132_I23_XG_MP0 (XI132_I23_XG_p1 I132_pn5 VDD VDD) gpdk090_pmos1v w=0.48u l=0.1u ad=0.1056p as=0.0936p pd=0.92u ps=0.92u
    I_MXI132_I23_XG_MP1 (I132_G5_4 I132_gn4 XI132_I23_XG_p1 VDD) gpdk090_pmos1v w=0.48u l=0.1u ad=0.1632p as=0.1056p pd=1.64u ps=0.92u
    I_MXI132_I22_XG_MP2 (VDD I132_gn4 I132_G4_3 VDD) gpdk090_pmos1v w=0.24u l=0.1u ad=0.0936p as=0.0816p pd=0.92u ps=1.16u
    I_MXI132_I22_XG_MP0 (XI132_I22_XG_p1 I132_pn4 VDD VDD) gpdk090_pmos1v w=0.48u l=0.1u ad=0.1056p as=0.0936p pd=0.92u ps=0.92u
    I_MXI132_I22_XG_MP1 (I132_G4_3 I132_gn3 XI132_I22_XG_p1 VDD) gpdk090_pmos1v w=0.48u l=0.1u ad=0.1632p as=0.1056p pd=1.64u ps=0.92u
    I_MXI120_I32_XG_MP2 (VDD I120_G4_1n I120_G4_0 VDD) gpdk090_pmos1v w=0.24u l=0.1u ad=0.0936p as=0.0816p pd=0.92u ps=1.16u
    I_MXI120_I32_XG_MP0 (XI120_I32_XG_p1 I120_P4_1n VDD VDD) gpdk090_pmos1v w=0.48u l=0.1u ad=0.1056p as=0.0936p pd=0.92u ps=0.92u
    I_MXI120_I32_XG_MP1 (I120_G4_0 I120_G0_0n XI120_I32_XG_p1 VDD) gpdk090_pmos1v w=0.48u l=0.1u ad=0.1632p as=0.1056p pd=1.64u ps=0.92u
    I_MXI120_I22_XG_MP2 (VDD I120_gn4 I120_G4_3 VDD) gpdk090_pmos1v w=0.24u l=0.1u ad=0.0936p as=0.0816p pd=0.92u ps=1.16u
    I_MXI120_I22_XG_MP0 (XI120_I22_XG_p1 I120_pn4 VDD VDD) gpdk090_pmos1v w=0.48u l=0.1u ad=0.1056p as=0.0936p pd=0.92u ps=0.92u
    I_MXI120_I22_XG_MP1 (I120_G4_3 I120_gn3 XI120_I22_XG_p1 VDD) gpdk090_pmos1v w=0.48u l=0.1u ad=0.1632p as=0.1056p pd=1.64u ps=0.92u
    I_MXI120_I21_XG_MP2 (VDD I120_gn3 I120_G3_2 VDD) gpdk090_pmos1v w=0.24u l=0.1u ad=0.0936p as=0.0816p pd=0.92u ps=1.16u
    I_MXI120_I21_XG_MP0 (XI120_I21_XG_p1 I120_pn3 VDD VDD) gpdk090_pmos1v w=0.48u l=0.1u ad=0.1056p as=0.0936p pd=0.92u ps=0.92u
    I_MXI120_I21_XG_MP1 (I120_G3_2 I120_gn2 XI120_I21_XG_p1 VDD) gpdk090_pmos1v w=0.48u l=0.1u ad=0.1632p as=0.1056p pd=1.64u ps=0.92u
    I_MXI108_I32_XG_MP2 (VDD I108_G4_1n I108_G4_0 VDD) gpdk090_pmos1v w=0.24u l=0.1u ad=0.0936p as=0.0816p pd=0.92u ps=1.16u
    I_MXI108_I32_XG_MP0 (XI108_I32_XG_p1 I108_P4_1n VDD VDD) gpdk090_pmos1v w=0.48u l=0.1u ad=0.1056p as=0.0936p pd=0.92u ps=0.92u
    I_MXI108_I32_XG_MP1 (I108_G4_0 I108_G0_0n XI108_I32_XG_p1 VDD) gpdk090_pmos1v w=0.48u l=0.1u ad=0.1632p as=0.1056p pd=1.64u ps=0.92u
    I_MXI108_I21_XG_MP2 (VDD I108_gn3 I108_G3_2 VDD) gpdk090_pmos1v w=0.24u l=0.1u ad=0.0936p as=0.0816p pd=0.92u ps=1.16u
    I_MXI108_I21_XG_MP0 (XI108_I21_XG_p1 I108_pn3 VDD VDD) gpdk090_pmos1v w=0.48u l=0.1u ad=0.1056p as=0.0936p pd=0.92u ps=0.92u
    I_MXI108_I21_XG_MP1 (I108_G3_2 I108_gn2 XI108_I21_XG_p1 VDD) gpdk090_pmos1v w=0.48u l=0.1u ad=0.1632p as=0.1056p pd=1.64u ps=0.92u
    I_MXI108_I22_XG_MP2 (VDD I108_gn4 I108_G4_3 VDD) gpdk090_pmos1v w=0.24u l=0.1u ad=0.0936p as=0.0816p pd=0.92u ps=1.16u
    I_MXI108_I22_XG_MP0 (XI108_I22_XG_p1 I108_pn4 VDD VDD) gpdk090_pmos1v w=0.48u l=0.1u ad=0.1056p as=0.0936p pd=0.92u ps=0.92u
    I_MXI108_I22_XG_MP1 (I108_G4_3 I108_gn3 XI108_I22_XG_p1 VDD) gpdk090_pmos1v w=0.48u l=0.1u ad=0.1632p as=0.1056p pd=1.64u ps=0.92u
    I_MXI132_I34_XG_MP2 (VDD I132_G5_2n I132_G5_0 VDD) gpdk090_pmos1v w=0.24u l=0.1u ad=0.0936p as=0.0816p pd=0.92u ps=1.16u
    I_MXI132_I34_XG_MP0 (XI132_I34_XG_p1 I132_P5_2n VDD VDD) gpdk090_pmos1v w=0.48u l=0.1u ad=0.1056p as=0.0936p pd=0.92u ps=0.92u
    I_MXI132_I34_XG_MP1 (I132_G5_0 I132_G1_0n XI132_I34_XG_p1 VDD) gpdk090_pmos1v w=0.48u l=0.1u ad=0.1632p as=0.1056p pd=1.64u ps=0.92u
    I_MXI132_I35_XG_MP2 (VDD I132_G6_3n c7_7 VDD) gpdk090_pmos1v w=0.24u l=0.1u ad=0.0936p as=0.0816p pd=0.92u ps=1.16u
    I_MXI132_I35_XG_MP0 (XI132_I35_XG_p1 I132_P6_3n VDD VDD) gpdk090_pmos1v w=0.48u l=0.1u ad=0.1056p as=0.0936p pd=0.92u ps=0.92u
    I_MXI132_I35_XG_MP1 (c7_7 I132_G2_0n XI132_I35_XG_p1 VDD) gpdk090_pmos1v w=0.48u l=0.1u ad=0.1632p as=0.1056p pd=1.64u ps=0.92u
    I_MXI132_I21_XG_MP2 (VDD I132_gn3 I132_G3_2 VDD) gpdk090_pmos1v w=0.24u l=0.1u ad=0.0936p as=0.0816p pd=0.92u ps=1.16u
    I_MXI132_I21_XG_MP0 (XI132_I21_XG_p1 I132_pn3 VDD VDD) gpdk090_pmos1v w=0.48u l=0.1u ad=0.1056p as=0.0936p pd=0.92u ps=0.92u
    I_MXI132_I21_XG_MP1 (I132_G3_2 I132_gn2 XI132_I21_XG_p1 VDD) gpdk090_pmos1v w=0.48u l=0.1u ad=0.1632p as=0.1056p pd=1.64u ps=0.92u
    I_MXI120_I19_XG_MP2 (VDD I120_gn1 I120_G1_0 VDD) gpdk090_pmos1v w=0.24u l=0.1u ad=0.0936p as=0.0816p pd=0.92u ps=1.16u
    I_MXI120_I19_XG_MP0 (XI120_I19_XG_p1 I120_pn1 VDD VDD) gpdk090_pmos1v w=0.48u l=0.1u ad=0.1056p as=0.0936p pd=0.92u ps=0.92u
    I_MXI120_I19_XG_MP1 (I120_G1_0 I120_G0_0n XI120_I19_XG_p1 VDD) gpdk090_pmos1v w=0.48u l=0.1u ad=0.1632p as=0.1056p pd=1.64u ps=0.92u
    I_MXI120_I20_XG_MP2 (VDD I120_gn2 I120_G2_1 VDD) gpdk090_pmos1v w=0.24u l=0.1u ad=0.0936p as=0.0816p pd=0.92u ps=1.16u
    I_MXI120_I20_XG_MP0 (XI120_I20_XG_p1 I120_pn2 VDD VDD) gpdk090_pmos1v w=0.48u l=0.1u ad=0.1056p as=0.0936p pd=0.92u ps=0.92u
    I_MXI120_I20_XG_MP1 (I120_G2_1 I120_gn1 XI120_I20_XG_p1 VDD) gpdk090_pmos1v w=0.48u l=0.1u ad=0.1632p as=0.1056p pd=1.64u ps=0.92u
    I_MXI108_I19_XG_MP2 (VDD I108_gn1 I108_G1_0 VDD) gpdk090_pmos1v w=0.24u l=0.1u ad=0.0936p as=0.0816p pd=0.92u ps=1.16u
    I_MXI108_I19_XG_MP0 (XI108_I19_XG_p1 I108_pn1 VDD VDD) gpdk090_pmos1v w=0.48u l=0.1u ad=0.1056p as=0.0936p pd=0.92u ps=0.92u
    I_MXI108_I19_XG_MP1 (I108_G1_0 I108_G0_0n XI108_I19_XG_p1 VDD) gpdk090_pmos1v w=0.48u l=0.1u ad=0.1632p as=0.1056p pd=1.64u ps=0.92u
    I_MXI108_I20_XG_MP2 (VDD I108_gn2 I108_G2_1 VDD) gpdk090_pmos1v w=0.24u l=0.1u ad=0.0936p as=0.0816p pd=0.92u ps=1.16u
    I_MXI108_I20_XG_MP0 (XI108_I20_XG_p1 I108_pn2 VDD VDD) gpdk090_pmos1v w=0.48u l=0.1u ad=0.1056p as=0.0936p pd=0.92u ps=0.92u
    I_MXI108_I20_XG_MP1 (I108_G2_1 I108_gn1 XI108_I20_XG_p1 VDD) gpdk090_pmos1v w=0.48u l=0.1u ad=0.1632p as=0.1056p pd=1.64u ps=0.92u
    I_MXI96_I34_XG_MP2 (VDD I96_G5_2n I96_G5_0 VDD) gpdk090_pmos1v w=0.24u l=0.1u ad=0.0936p as=0.0816p pd=0.92u ps=1.16u
    I_MXI96_I34_XG_MP0 (XI96_I34_XG_p1 I96_P5_2n VDD VDD) gpdk090_pmos1v w=0.48u l=0.1u ad=0.1056p as=0.0936p pd=0.92u ps=0.92u
    I_MXI96_I34_XG_MP1 (I96_G5_0 I96_G1_0n XI96_I34_XG_p1 VDD) gpdk090_pmos1v w=0.48u l=0.1u ad=0.1632p as=0.1056p pd=1.64u ps=0.92u
    I_MXI96_I36_XG_MP2 (VDD I96_G7_4n c4_8 VDD) gpdk090_pmos1v w=0.24u l=0.1u ad=0.0936p as=0.0816p pd=0.92u ps=1.16u
    I_MXI96_I36_XG_MP0 (XI96_I36_XG_p1 I96_P7_4n VDD VDD) gpdk090_pmos1v w=0.48u l=0.1u ad=0.1056p as=0.0936p pd=0.92u ps=0.92u
    I_MXI96_I36_XG_MP1 (c4_8 I96_G3_0n XI96_I36_XG_p1 VDD) gpdk090_pmos1v w=0.48u l=0.1u ad=0.1632p as=0.1056p pd=1.64u ps=0.92u
    I_MXI132_I32_XG_MP2 (VDD I132_G4_1n I132_G4_0 VDD) gpdk090_pmos1v w=0.24u l=0.1u ad=0.0936p as=0.0816p pd=0.92u ps=1.16u
    I_MXI132_I32_XG_MP0 (XI132_I32_XG_p1 I132_P4_1n VDD VDD) gpdk090_pmos1v w=0.48u l=0.1u ad=0.1056p as=0.0936p pd=0.92u ps=0.92u
    I_MXI132_I32_XG_MP1 (I132_G4_0 I132_G0_0n XI132_I32_XG_p1 VDD) gpdk090_pmos1v w=0.48u l=0.1u ad=0.1632p as=0.1056p pd=1.64u ps=0.92u
    I_MXI132_I20_XG_MP2 (VDD I132_gn2 I132_G2_1 VDD) gpdk090_pmos1v w=0.24u l=0.1u ad=0.0936p as=0.0816p pd=0.92u ps=1.16u
    I_MXI132_I20_XG_MP0 (XI132_I20_XG_p1 I132_pn2 VDD VDD) gpdk090_pmos1v w=0.48u l=0.1u ad=0.1056p as=0.0936p pd=0.92u ps=0.92u
    I_MXI132_I20_XG_MP1 (I132_G2_1 I132_gn1 XI132_I20_XG_p1 VDD) gpdk090_pmos1v w=0.48u l=0.1u ad=0.1632p as=0.1056p pd=1.64u ps=0.92u
    I_MXI120_I17_XG_MP2 (VDD I120_gn0 I120_G0_0 VDD) gpdk090_pmos1v w=0.24u l=0.1u ad=0.0936p as=0.0816p pd=0.92u ps=1.16u
    I_MXI120_I17_XG_MP0 (XI120_I17_XG_p1 I120_pn0 VDD VDD) gpdk090_pmos1v w=0.48u l=0.1u ad=0.1056p as=0.0936p pd=0.92u ps=0.92u
    I_MXI120_I17_XG_MP1 (I120_G0_0 I120_cinn XI120_I17_XG_p1 VDD) gpdk090_pmos1v w=0.48u l=0.1u ad=0.1632p as=0.1056p pd=1.64u ps=0.92u
    I_MXI108_I17_XG_MP2 (VDD I108_gn0 I108_G0_0 VDD) gpdk090_pmos1v w=0.24u l=0.1u ad=0.0936p as=0.0816p pd=0.92u ps=1.16u
    I_MXI108_I17_XG_MP0 (XI108_I17_XG_p1 I108_pn0 VDD VDD) gpdk090_pmos1v w=0.48u l=0.1u ad=0.1056p as=0.0936p pd=0.92u ps=0.92u
    I_MXI108_I17_XG_MP1 (I108_G0_0 I108_cinn XI108_I17_XG_p1 VDD) gpdk090_pmos1v w=0.48u l=0.1u ad=0.1632p as=0.1056p pd=1.64u ps=0.92u
    I_MXI96_I19_XG_MP2 (VDD I96_gn1 I96_G1_0 VDD) gpdk090_pmos1v w=0.24u l=0.1u ad=0.0936p as=0.0816p pd=0.92u ps=1.16u
    I_MXI96_I19_XG_MP0 (XI96_I19_XG_p1 I96_pn1 VDD VDD) gpdk090_pmos1v w=0.48u l=0.1u ad=0.1056p as=0.0936p pd=0.92u ps=0.92u
    I_MXI96_I19_XG_MP1 (I96_G1_0 I96_G0_0n XI96_I19_XG_p1 VDD) gpdk090_pmos1v w=0.48u l=0.1u ad=0.1632p as=0.1056p pd=1.64u ps=0.92u
    I_MXI96_I32_XG_MP2 (VDD I96_G4_1n I96_G4_0 VDD) gpdk090_pmos1v w=0.24u l=0.1u ad=0.0936p as=0.0816p pd=0.92u ps=1.16u
    I_MXI96_I32_XG_MP0 (XI96_I32_XG_p1 I96_P4_1n VDD VDD) gpdk090_pmos1v w=0.48u l=0.1u ad=0.1056p as=0.0936p pd=0.92u ps=0.92u
    I_MXI96_I32_XG_MP1 (I96_G4_0 I96_G0_0n XI96_I32_XG_p1 VDD) gpdk090_pmos1v w=0.48u l=0.1u ad=0.1632p as=0.1056p pd=1.64u ps=0.92u
    I_MXI96_I35_XG_MP2 (VDD I96_G6_3n c4_7 VDD) gpdk090_pmos1v w=0.24u l=0.1u ad=0.0936p as=0.0816p pd=0.92u ps=1.16u
    I_MXI96_I35_XG_MP0 (XI96_I35_XG_p1 I96_P6_3n VDD VDD) gpdk090_pmos1v w=0.48u l=0.1u ad=0.1056p as=0.0936p pd=0.92u ps=0.92u
    I_MXI96_I35_XG_MP1 (c4_7 I96_G2_0n XI96_I35_XG_p1 VDD) gpdk090_pmos1v w=0.48u l=0.1u ad=0.1632p as=0.1056p pd=1.64u ps=0.92u
    I_MXI96_I25_XG_MP2 (VDD I96_gn7 I96_G7_6 VDD) gpdk090_pmos1v w=0.24u l=0.1u ad=0.0936p as=0.0816p pd=0.92u ps=1.16u
    I_MXI96_I25_XG_MP0 (XI96_I25_XG_p1 I96_pn7 VDD VDD) gpdk090_pmos1v w=0.48u l=0.1u ad=0.1056p as=0.0936p pd=0.92u ps=0.92u
    I_MXI96_I25_XG_MP1 (I96_G7_6 I96_gn6 XI96_I25_XG_p1 VDD) gpdk090_pmos1v w=0.48u l=0.1u ad=0.1632p as=0.1056p pd=1.64u ps=0.92u
    I_MXI152_I25_XG_MP2 (VDD I152_gn7 I152_G7_6 VDD) gpdk090_pmos1v w=0.24u l=0.1u ad=0.0936p as=0.0816p pd=0.92u ps=1.16u
    I_MXI152_I25_XG_MP0 (XI152_I25_XG_p1 I152_pn7 VDD VDD) gpdk090_pmos1v w=0.48u l=0.1u ad=0.1056p as=0.0936p pd=0.92u ps=0.92u
    I_MXI152_I25_XG_MP1 (I152_G7_6 I152_gn6 XI152_I25_XG_p1 VDD) gpdk090_pmos1v w=0.48u l=0.1u ad=0.1632p as=0.1056p pd=1.64u ps=0.92u
    I_MXI152_I24_XG_MP2 (VDD I152_gn6 I152_G6_5 VDD) gpdk090_pmos1v w=0.24u l=0.1u ad=0.0936p as=0.0816p pd=0.92u ps=1.16u
    I_MXI152_I24_XG_MP0 (XI152_I24_XG_p1 I152_pn6 VDD VDD) gpdk090_pmos1v w=0.48u l=0.1u ad=0.1056p as=0.0936p pd=0.92u ps=0.92u
    I_MXI152_I24_XG_MP1 (I152_G6_5 I152_gn5 XI152_I24_XG_p1 VDD) gpdk090_pmos1v w=0.48u l=0.1u ad=0.1632p as=0.1056p pd=1.64u ps=0.92u
    I_MXI132_I19_XG_MP2 (VDD I132_gn1 I132_G1_0 VDD) gpdk090_pmos1v w=0.24u l=0.1u ad=0.0936p as=0.0816p pd=0.92u ps=1.16u
    I_MXI132_I19_XG_MP0 (XI132_I19_XG_p1 I132_pn1 VDD VDD) gpdk090_pmos1v w=0.48u l=0.1u ad=0.1056p as=0.0936p pd=0.92u ps=0.92u
    I_MXI132_I19_XG_MP1 (I132_G1_0 I132_G0_0n XI132_I19_XG_p1 VDD) gpdk090_pmos1v w=0.48u l=0.1u ad=0.1632p as=0.1056p pd=1.64u ps=0.92u
    I_MXI96_I17_XG_MP2 (VDD I96_gn0 I96_G0_0 VDD) gpdk090_pmos1v w=0.24u l=0.1u ad=0.0936p as=0.0816p pd=0.92u ps=1.16u
    I_MXI96_I17_XG_MP0 (XI96_I17_XG_p1 I96_pn0 VDD VDD) gpdk090_pmos1v w=0.48u l=0.1u ad=0.1056p as=0.0936p pd=0.92u ps=0.92u
    I_MXI96_I17_XG_MP1 (I96_G0_0 I96_cinn XI96_I17_XG_p1 VDD) gpdk090_pmos1v w=0.48u l=0.1u ad=0.1632p as=0.1056p pd=1.64u ps=0.92u
    I_MXI96_I20_XG_MP2 (VDD I96_gn2 I96_G2_1 VDD) gpdk090_pmos1v w=0.24u l=0.1u ad=0.0936p as=0.0816p pd=0.92u ps=1.16u
    I_MXI96_I20_XG_MP0 (XI96_I20_XG_p1 I96_pn2 VDD VDD) gpdk090_pmos1v w=0.48u l=0.1u ad=0.1056p as=0.0936p pd=0.92u ps=0.92u
    I_MXI96_I20_XG_MP1 (I96_G2_1 I96_gn1 XI96_I20_XG_p1 VDD) gpdk090_pmos1v w=0.48u l=0.1u ad=0.1632p as=0.1056p pd=1.64u ps=0.92u
    I_MXI96_I21_XG_MP2 (VDD I96_gn3 I96_G3_2 VDD) gpdk090_pmos1v w=0.24u l=0.1u ad=0.0936p as=0.0816p pd=0.92u ps=1.16u
    I_MXI96_I21_XG_MP0 (XI96_I21_XG_p1 I96_pn3 VDD VDD) gpdk090_pmos1v w=0.48u l=0.1u ad=0.1056p as=0.0936p pd=0.92u ps=0.92u
    I_MXI96_I21_XG_MP1 (I96_G3_2 I96_gn2 XI96_I21_XG_p1 VDD) gpdk090_pmos1v w=0.48u l=0.1u ad=0.1632p as=0.1056p pd=1.64u ps=0.92u
    I_MXI96_I22_XG_MP2 (VDD I96_gn4 I96_G4_3 VDD) gpdk090_pmos1v w=0.24u l=0.1u ad=0.0936p as=0.0816p pd=0.92u ps=1.16u
    I_MXI96_I22_XG_MP0 (XI96_I22_XG_p1 I96_pn4 VDD VDD) gpdk090_pmos1v w=0.48u l=0.1u ad=0.1056p as=0.0936p pd=0.92u ps=0.92u
    I_MXI96_I22_XG_MP1 (I96_G4_3 I96_gn3 XI96_I22_XG_p1 VDD) gpdk090_pmos1v w=0.48u l=0.1u ad=0.1632p as=0.1056p pd=1.64u ps=0.92u
    I_MXI96_I23_XG_MP2 (VDD I96_gn5 I96_G5_4 VDD) gpdk090_pmos1v w=0.24u l=0.1u ad=0.0936p as=0.0816p pd=0.92u ps=1.16u
    I_MXI96_I23_XG_MP0 (XI96_I23_XG_p1 I96_pn5 VDD VDD) gpdk090_pmos1v w=0.48u l=0.1u ad=0.1056p as=0.0936p pd=0.92u ps=0.92u
    I_MXI96_I23_XG_MP1 (I96_G5_4 I96_gn4 XI96_I23_XG_p1 VDD) gpdk090_pmos1v w=0.48u l=0.1u ad=0.1632p as=0.1056p pd=1.64u ps=0.92u
    I_MXI96_I24_XG_MP2 (VDD I96_gn6 I96_G6_5 VDD) gpdk090_pmos1v w=0.24u l=0.1u ad=0.0936p as=0.0816p pd=0.92u ps=1.16u
    I_MXI96_I24_XG_MP0 (XI96_I24_XG_p1 I96_pn6 VDD VDD) gpdk090_pmos1v w=0.48u l=0.1u ad=0.1056p as=0.0936p pd=0.92u ps=0.92u
    I_MXI96_I24_XG_MP1 (I96_G6_5 I96_gn5 XI96_I24_XG_p1 VDD) gpdk090_pmos1v w=0.48u l=0.1u ad=0.1632p as=0.1056p pd=1.64u ps=0.92u
    I_MXI152_I36_XG_MP2 (VDD I152_G7_4n rc7 VDD) gpdk090_pmos1v w=0.24u l=0.1u ad=0.0936p as=0.0816p pd=0.92u ps=1.16u
    I_MXI152_I36_XG_MP0 (XI152_I36_XG_p1 I152_P7_4n VDD VDD) gpdk090_pmos1v w=0.48u l=0.1u ad=0.1056p as=0.0936p pd=0.92u ps=0.92u
    I_MXI152_I36_XG_MP1 (rc7 I152_G3_0n XI152_I36_XG_p1 VDD) gpdk090_pmos1v w=0.48u l=0.1u ad=0.1632p as=0.1056p pd=1.64u ps=0.92u
    I_MXI152_I23_XG_MP2 (VDD I152_gn5 I152_G5_4 VDD) gpdk090_pmos1v w=0.24u l=0.1u ad=0.0936p as=0.0816p pd=0.92u ps=1.16u
    I_MXI152_I23_XG_MP0 (XI152_I23_XG_p1 I152_pn5 VDD VDD) gpdk090_pmos1v w=0.48u l=0.1u ad=0.1056p as=0.0936p pd=0.92u ps=0.92u
    I_MXI152_I23_XG_MP1 (I152_G5_4 I152_gn4 XI152_I23_XG_p1 VDD) gpdk090_pmos1v w=0.48u l=0.1u ad=0.1632p as=0.1056p pd=1.64u ps=0.92u
    I_MXI152_I22_XG_MP2 (VDD I152_gn4 I152_G4_3 VDD) gpdk090_pmos1v w=0.24u l=0.1u ad=0.0936p as=0.0816p pd=0.92u ps=1.16u
    I_MXI152_I22_XG_MP0 (XI152_I22_XG_p1 I152_pn4 VDD VDD) gpdk090_pmos1v w=0.48u l=0.1u ad=0.1056p as=0.0936p pd=0.92u ps=0.92u
    I_MXI152_I22_XG_MP1 (I152_G4_3 I152_gn3 XI152_I22_XG_p1 VDD) gpdk090_pmos1v w=0.48u l=0.1u ad=0.1632p as=0.1056p pd=1.64u ps=0.92u
    I_MXI132_I17_XG_MP2 (VDD I132_gn0 I132_G0_0 VDD) gpdk090_pmos1v w=0.24u l=0.1u ad=0.0936p as=0.0816p pd=0.92u ps=1.16u
    I_MXI132_I17_XG_MP0 (XI132_I17_XG_p1 I132_pn0 VDD VDD) gpdk090_pmos1v w=0.48u l=0.1u ad=0.1056p as=0.0936p pd=0.92u ps=0.92u
    I_MXI132_I17_XG_MP1 (I132_G0_0 I132_cinn XI132_I17_XG_p1 VDD) gpdk090_pmos1v w=0.48u l=0.1u ad=0.1632p as=0.1056p pd=1.64u ps=0.92u
    I_MXI152_I34_XG_MP2 (VDD I152_G5_2n I152_G5_0 VDD) gpdk090_pmos1v w=0.24u l=0.1u ad=0.0936p as=0.0816p pd=0.92u ps=1.16u
    I_MXI152_I34_XG_MP0 (XI152_I34_XG_p1 I152_P5_2n VDD VDD) gpdk090_pmos1v w=0.48u l=0.1u ad=0.1056p as=0.0936p pd=0.92u ps=0.92u
    I_MXI152_I34_XG_MP1 (I152_G5_0 I152_G1_0n XI152_I34_XG_p1 VDD) gpdk090_pmos1v w=0.48u l=0.1u ad=0.1632p as=0.1056p pd=1.64u ps=0.92u
    I_MXI152_I21_XG_MP2 (VDD I152_gn3 I152_G3_2 VDD) gpdk090_pmos1v w=0.24u l=0.1u ad=0.0936p as=0.0816p pd=0.92u ps=1.16u
    I_MXI152_I21_XG_MP0 (XI152_I21_XG_p1 I152_pn3 VDD VDD) gpdk090_pmos1v w=0.48u l=0.1u ad=0.1056p as=0.0936p pd=0.92u ps=0.92u
    I_MXI152_I21_XG_MP1 (I152_G3_2 I152_gn2 XI152_I21_XG_p1 VDD) gpdk090_pmos1v w=0.48u l=0.1u ad=0.1632p as=0.1056p pd=1.64u ps=0.92u
    I_MXI84_I17_XG_MP2 (VDD I84_gn0 I84_G0_0 VDD) gpdk090_pmos1v w=0.24u l=0.1u ad=0.0936p as=0.0816p pd=0.92u ps=1.16u
    I_MXI84_I17_XG_MP0 (XI84_I17_XG_p1 I84_pn0 VDD VDD) gpdk090_pmos1v w=0.48u l=0.1u ad=0.1056p as=0.0936p pd=0.92u ps=0.92u
    I_MXI84_I17_XG_MP1 (I84_G0_0 I84_cinn XI84_I17_XG_p1 VDD) gpdk090_pmos1v w=0.48u l=0.1u ad=0.1632p as=0.1056p pd=1.64u ps=0.92u
    I_MXI84_I32_XG_MP2 (VDD I84_G4_1n I84_G4_0 VDD) gpdk090_pmos1v w=0.24u l=0.1u ad=0.0936p as=0.0816p pd=0.92u ps=1.16u
    I_MXI84_I32_XG_MP0 (XI84_I32_XG_p1 I84_P4_1n VDD VDD) gpdk090_pmos1v w=0.48u l=0.1u ad=0.1056p as=0.0936p pd=0.92u ps=0.92u
    I_MXI84_I32_XG_MP1 (I84_G4_0 I84_G0_0n XI84_I32_XG_p1 VDD) gpdk090_pmos1v w=0.48u l=0.1u ad=0.1632p as=0.1056p pd=1.64u ps=0.92u
    I_MXI84_I35_XG_MP2 (VDD I84_G6_3n c3_7 VDD) gpdk090_pmos1v w=0.24u l=0.1u ad=0.0936p as=0.0816p pd=0.92u ps=1.16u
    I_MXI84_I35_XG_MP0 (XI84_I35_XG_p1 I84_P6_3n VDD VDD) gpdk090_pmos1v w=0.48u l=0.1u ad=0.1056p as=0.0936p pd=0.92u ps=0.92u
    I_MXI84_I35_XG_MP1 (c3_7 I84_G2_0n XI84_I35_XG_p1 VDD) gpdk090_pmos1v w=0.48u l=0.1u ad=0.1632p as=0.1056p pd=1.64u ps=0.92u
    I_MXI152_I32_XG_MP2 (VDD I152_G4_1n I152_G4_0 VDD) gpdk090_pmos1v w=0.24u l=0.1u ad=0.0936p as=0.0816p pd=0.92u ps=1.16u
    I_MXI152_I32_XG_MP0 (XI152_I32_XG_p1 I152_P4_1n VDD VDD) gpdk090_pmos1v w=0.48u l=0.1u ad=0.1056p as=0.0936p pd=0.92u ps=0.92u
    I_MXI152_I32_XG_MP1 (I152_G4_0 I152_G0_0n XI152_I32_XG_p1 VDD) gpdk090_pmos1v w=0.48u l=0.1u ad=0.1632p as=0.1056p pd=1.64u ps=0.92u
    I_MXI152_I20_XG_MP2 (VDD I152_gn2 I152_G2_1 VDD) gpdk090_pmos1v w=0.24u l=0.1u ad=0.0936p as=0.0816p pd=0.92u ps=1.16u
    I_MXI152_I20_XG_MP0 (XI152_I20_XG_p1 I152_pn2 VDD VDD) gpdk090_pmos1v w=0.48u l=0.1u ad=0.1056p as=0.0936p pd=0.92u ps=0.92u
    I_MXI152_I20_XG_MP1 (I152_G2_1 I152_gn1 XI152_I20_XG_p1 VDD) gpdk090_pmos1v w=0.48u l=0.1u ad=0.1632p as=0.1056p pd=1.64u ps=0.92u
    I_MXI152_I19_XG_MP2 (VDD I152_gn1 I152_G1_0 VDD) gpdk090_pmos1v w=0.24u l=0.1u ad=0.0936p as=0.0816p pd=0.92u ps=1.16u
    I_MXI152_I19_XG_MP0 (XI152_I19_XG_p1 I152_pn1 VDD VDD) gpdk090_pmos1v w=0.48u l=0.1u ad=0.1056p as=0.0936p pd=0.92u ps=0.92u
    I_MXI152_I19_XG_MP1 (I152_G1_0 I152_G0_0n XI152_I19_XG_p1 VDD) gpdk090_pmos1v w=0.48u l=0.1u ad=0.1632p as=0.1056p pd=1.64u ps=0.92u
    I_MXI152_I17_XG_MP2 (VDD I152_gn0 I152_G0_0 VDD) gpdk090_pmos1v w=0.24u l=0.1u ad=0.0936p as=0.0816p pd=0.92u ps=1.16u
    I_MXI152_I17_XG_MP0 (XI152_I17_XG_p1 I152_pn0 VDD VDD) gpdk090_pmos1v w=0.48u l=0.1u ad=0.1056p as=0.0936p pd=0.92u ps=0.92u
    I_MXI152_I17_XG_MP1 (I152_G0_0 I152_cinn XI152_I17_XG_p1 VDD) gpdk090_pmos1v w=0.48u l=0.1u ad=0.1632p as=0.1056p pd=1.64u ps=0.92u
    I_MXI84_I19_XG_MP2 (VDD I84_gn1 I84_G1_0 VDD) gpdk090_pmos1v w=0.24u l=0.1u ad=0.0936p as=0.0816p pd=0.92u ps=1.16u
    I_MXI84_I19_XG_MP0 (XI84_I19_XG_p1 I84_pn1 VDD VDD) gpdk090_pmos1v w=0.48u l=0.1u ad=0.1056p as=0.0936p pd=0.92u ps=0.92u
    I_MXI84_I19_XG_MP1 (I84_G1_0 I84_G0_0n XI84_I19_XG_p1 VDD) gpdk090_pmos1v w=0.48u l=0.1u ad=0.1632p as=0.1056p pd=1.64u ps=0.92u
    I_MXI84_I20_XG_MP2 (VDD I84_gn2 I84_G2_1 VDD) gpdk090_pmos1v w=0.24u l=0.1u ad=0.0936p as=0.0816p pd=0.92u ps=1.16u
    I_MXI84_I20_XG_MP0 (XI84_I20_XG_p1 I84_pn2 VDD VDD) gpdk090_pmos1v w=0.48u l=0.1u ad=0.1056p as=0.0936p pd=0.92u ps=0.92u
    I_MXI84_I20_XG_MP1 (I84_G2_1 I84_gn1 XI84_I20_XG_p1 VDD) gpdk090_pmos1v w=0.48u l=0.1u ad=0.1632p as=0.1056p pd=1.64u ps=0.92u
    I_MXI152_I35_XG_MP2 (VDD I152_G6_3n rc6 VDD) gpdk090_pmos1v w=0.24u l=0.1u ad=0.0936p as=0.0816p pd=0.92u ps=1.16u
    I_MXI152_I35_XG_MP0 (XI152_I35_XG_p1 I152_P6_3n VDD VDD) gpdk090_pmos1v w=0.48u l=0.1u ad=0.1056p as=0.0936p pd=0.92u ps=0.92u
    I_MXI152_I35_XG_MP1 (rc6 I152_G2_0n XI152_I35_XG_p1 VDD) gpdk090_pmos1v w=0.48u l=0.1u ad=0.1632p as=0.1056p pd=1.64u ps=0.92u
    I_MXI72_I17_XG_MP2 (VDD I72_gn0 I72_G0_0 VDD) gpdk090_pmos1v w=0.24u l=0.1u ad=0.0936p as=0.0816p pd=0.92u ps=1.16u
    I_MXI72_I17_XG_MP0 (XI72_I17_XG_p1 I72_pn0 VDD VDD) gpdk090_pmos1v w=0.48u l=0.1u ad=0.1056p as=0.0936p pd=0.92u ps=0.92u
    I_MXI72_I17_XG_MP1 (I72_G0_0 I72_cinn XI72_I17_XG_p1 VDD) gpdk090_pmos1v w=0.48u l=0.1u ad=0.1632p as=0.1056p pd=1.64u ps=0.92u
    I_MXI84_I21_XG_MP2 (VDD I84_gn3 I84_G3_2 VDD) gpdk090_pmos1v w=0.24u l=0.1u ad=0.0936p as=0.0816p pd=0.92u ps=1.16u
    I_MXI84_I21_XG_MP0 (XI84_I21_XG_p1 I84_pn3 VDD VDD) gpdk090_pmos1v w=0.48u l=0.1u ad=0.1056p as=0.0936p pd=0.92u ps=0.92u
    I_MXI84_I21_XG_MP1 (I84_G3_2 I84_gn2 XI84_I21_XG_p1 VDD) gpdk090_pmos1v w=0.48u l=0.1u ad=0.1632p as=0.1056p pd=1.64u ps=0.92u
    I_MXI84_I22_XG_MP2 (VDD I84_gn4 I84_G4_3 VDD) gpdk090_pmos1v w=0.24u l=0.1u ad=0.0936p as=0.0816p pd=0.92u ps=1.16u
    I_MXI84_I22_XG_MP0 (XI84_I22_XG_p1 I84_pn4 VDD VDD) gpdk090_pmos1v w=0.48u l=0.1u ad=0.1056p as=0.0936p pd=0.92u ps=0.92u
    I_MXI84_I22_XG_MP1 (I84_G4_3 I84_gn3 XI84_I22_XG_p1 VDD) gpdk090_pmos1v w=0.48u l=0.1u ad=0.1632p as=0.1056p pd=1.64u ps=0.92u
    I_MXI84_I34_XG_MP2 (VDD I84_G5_2n I84_G5_0 VDD) gpdk090_pmos1v w=0.24u l=0.1u ad=0.0936p as=0.0816p pd=0.92u ps=1.16u
    I_MXI84_I34_XG_MP0 (XI84_I34_XG_p1 I84_P5_2n VDD VDD) gpdk090_pmos1v w=0.48u l=0.1u ad=0.1056p as=0.0936p pd=0.92u ps=0.92u
    I_MXI84_I34_XG_MP1 (I84_G5_0 I84_G1_0n XI84_I34_XG_p1 VDD) gpdk090_pmos1v w=0.48u l=0.1u ad=0.1632p as=0.1056p pd=1.64u ps=0.92u
    I_MXI60_I17_XG_MP2 (VDD I60_gn0 I60_G0_0 VDD) gpdk090_pmos1v w=0.24u l=0.1u ad=0.0936p as=0.0816p pd=0.92u ps=1.16u
    I_MXI60_I17_XG_MP0 (XI60_I17_XG_p1 I60_pn0 VDD VDD) gpdk090_pmos1v w=0.48u l=0.1u ad=0.1056p as=0.0936p pd=0.92u ps=0.92u
    I_MXI60_I17_XG_MP1 (I60_G0_0 I60_cinn XI60_I17_XG_p1 VDD) gpdk090_pmos1v w=0.48u l=0.1u ad=0.1632p as=0.1056p pd=1.64u ps=0.92u
    I_MXI84_I23_XG_MP2 (VDD I84_gn5 I84_G5_4 VDD) gpdk090_pmos1v w=0.24u l=0.1u ad=0.0936p as=0.0816p pd=0.92u ps=1.16u
    I_MXI84_I23_XG_MP0 (XI84_I23_XG_p1 I84_pn5 VDD VDD) gpdk090_pmos1v w=0.48u l=0.1u ad=0.1056p as=0.0936p pd=0.92u ps=0.92u
    I_MXI84_I23_XG_MP1 (I84_G5_4 I84_gn4 XI84_I23_XG_p1 VDD) gpdk090_pmos1v w=0.48u l=0.1u ad=0.1632p as=0.1056p pd=1.64u ps=0.92u
    I_MXI84_I36_XG_MP2 (VDD I84_G7_4n c3_8 VDD) gpdk090_pmos1v w=0.24u l=0.1u ad=0.0936p as=0.0816p pd=0.92u ps=1.16u
    I_MXI84_I36_XG_MP0 (XI84_I36_XG_p1 I84_P7_4n VDD VDD) gpdk090_pmos1v w=0.48u l=0.1u ad=0.1056p as=0.0936p pd=0.92u ps=0.92u
    I_MXI84_I36_XG_MP1 (c3_8 I84_G3_0n XI84_I36_XG_p1 VDD) gpdk090_pmos1v w=0.48u l=0.1u ad=0.1632p as=0.1056p pd=1.64u ps=0.92u
    I_MXI48_I20_XG_MP2 (VDD I48_gn2 I48_G2_1 VDD) gpdk090_pmos1v w=0.24u l=0.1u ad=0.0936p as=0.0816p pd=0.92u ps=1.16u
    I_MXI48_I20_XG_MP0 (XI48_I20_XG_p1 I48_pn2 VDD VDD) gpdk090_pmos1v w=0.48u l=0.1u ad=0.1056p as=0.0936p pd=0.92u ps=0.92u
    I_MXI48_I20_XG_MP1 (I48_G2_1 I48_gn1 XI48_I20_XG_p1 VDD) gpdk090_pmos1v w=0.48u l=0.1u ad=0.1632p as=0.1056p pd=1.64u ps=0.92u
    I_MXI48_I17_XG_MP2 (VDD I48_gn0 I48_G0_0 VDD) gpdk090_pmos1v w=0.24u l=0.1u ad=0.0936p as=0.0816p pd=0.92u ps=1.16u
    I_MXI48_I17_XG_MP0 (XI48_I17_XG_p1 I48_pn0 VDD VDD) gpdk090_pmos1v w=0.48u l=0.1u ad=0.1056p as=0.0936p pd=0.92u ps=0.92u
    I_MXI48_I17_XG_MP1 (I48_G0_0 I48_cinn XI48_I17_XG_p1 VDD) gpdk090_pmos1v w=0.48u l=0.1u ad=0.1632p as=0.1056p pd=1.64u ps=0.92u
    I_MXI72_I20_XG_MP2 (VDD I72_gn2 I72_G2_1 VDD) gpdk090_pmos1v w=0.24u l=0.1u ad=0.0936p as=0.0816p pd=0.92u ps=1.16u
    I_MXI72_I20_XG_MP0 (XI72_I20_XG_p1 I72_pn2 VDD VDD) gpdk090_pmos1v w=0.48u l=0.1u ad=0.1056p as=0.0936p pd=0.92u ps=0.92u
    I_MXI72_I20_XG_MP1 (I72_G2_1 I72_gn1 XI72_I20_XG_p1 VDD) gpdk090_pmos1v w=0.48u l=0.1u ad=0.1632p as=0.1056p pd=1.64u ps=0.92u
    I_MXI72_I19_XG_MP2 (VDD I72_gn1 I72_G1_0 VDD) gpdk090_pmos1v w=0.24u l=0.1u ad=0.0936p as=0.0816p pd=0.92u ps=1.16u
    I_MXI72_I19_XG_MP0 (XI72_I19_XG_p1 I72_pn1 VDD VDD) gpdk090_pmos1v w=0.48u l=0.1u ad=0.1056p as=0.0936p pd=0.92u ps=0.92u
    I_MXI72_I19_XG_MP1 (I72_G1_0 I72_G0_0n XI72_I19_XG_p1 VDD) gpdk090_pmos1v w=0.48u l=0.1u ad=0.1632p as=0.1056p pd=1.64u ps=0.92u
    I_MXI84_I24_XG_MP2 (VDD I84_gn6 I84_G6_5 VDD) gpdk090_pmos1v w=0.24u l=0.1u ad=0.0936p as=0.0816p pd=0.92u ps=1.16u
    I_MXI84_I24_XG_MP0 (XI84_I24_XG_p1 I84_pn6 VDD VDD) gpdk090_pmos1v w=0.48u l=0.1u ad=0.1056p as=0.0936p pd=0.92u ps=0.92u
    I_MXI84_I24_XG_MP1 (I84_G6_5 I84_gn5 XI84_I24_XG_p1 VDD) gpdk090_pmos1v w=0.48u l=0.1u ad=0.1632p as=0.1056p pd=1.64u ps=0.92u
    I_MXI84_I25_XG_MP2 (VDD I84_gn7 I84_G7_6 VDD) gpdk090_pmos1v w=0.24u l=0.1u ad=0.0936p as=0.0816p pd=0.92u ps=1.16u
    I_MXI84_I25_XG_MP0 (XI84_I25_XG_p1 I84_pn7 VDD VDD) gpdk090_pmos1v w=0.48u l=0.1u ad=0.1056p as=0.0936p pd=0.92u ps=0.92u
    I_MXI84_I25_XG_MP1 (I84_G7_6 I84_gn6 XI84_I25_XG_p1 VDD) gpdk090_pmos1v w=0.48u l=0.1u ad=0.1632p as=0.1056p pd=1.64u ps=0.92u
    I_MXI48_I22_XG_MP2 (VDD I48_gn4 I48_G4_3 VDD) gpdk090_pmos1v w=0.24u l=0.1u ad=0.0936p as=0.0816p pd=0.92u ps=1.16u
    I_MXI48_I22_XG_MP0 (XI48_I22_XG_p1 I48_pn4 VDD VDD) gpdk090_pmos1v w=0.48u l=0.1u ad=0.1056p as=0.0936p pd=0.92u ps=0.92u
    I_MXI48_I22_XG_MP1 (I48_G4_3 I48_gn3 XI48_I22_XG_p1 VDD) gpdk090_pmos1v w=0.48u l=0.1u ad=0.1632p as=0.1056p pd=1.64u ps=0.92u
    I_MXI48_I21_XG_MP2 (VDD I48_gn3 I48_G3_2 VDD) gpdk090_pmos1v w=0.24u l=0.1u ad=0.0936p as=0.0816p pd=0.92u ps=1.16u
    I_MXI48_I21_XG_MP0 (XI48_I21_XG_p1 I48_pn3 VDD VDD) gpdk090_pmos1v w=0.48u l=0.1u ad=0.1056p as=0.0936p pd=0.92u ps=0.92u
    I_MXI48_I21_XG_MP1 (I48_G3_2 I48_gn2 XI48_I21_XG_p1 VDD) gpdk090_pmos1v w=0.48u l=0.1u ad=0.1632p as=0.1056p pd=1.64u ps=0.92u
    I_MXI48_I32_XG_MP2 (VDD I48_G4_1n I48_G4_0 VDD) gpdk090_pmos1v w=0.24u l=0.1u ad=0.0936p as=0.0816p pd=0.92u ps=1.16u
    I_MXI48_I32_XG_MP0 (XI48_I32_XG_p1 I48_P4_1n VDD VDD) gpdk090_pmos1v w=0.48u l=0.1u ad=0.1056p as=0.0936p pd=0.92u ps=0.92u
    I_MXI48_I32_XG_MP1 (I48_G4_0 I48_G0_0n XI48_I32_XG_p1 VDD) gpdk090_pmos1v w=0.48u l=0.1u ad=0.1632p as=0.1056p pd=1.64u ps=0.92u
    I_MXI48_I19_XG_MP2 (VDD I48_gn1 I48_G1_0 VDD) gpdk090_pmos1v w=0.24u l=0.1u ad=0.0936p as=0.0816p pd=0.92u ps=1.16u
    I_MXI48_I19_XG_MP0 (XI48_I19_XG_p1 I48_pn1 VDD VDD) gpdk090_pmos1v w=0.48u l=0.1u ad=0.1056p as=0.0936p pd=0.92u ps=0.92u
    I_MXI48_I19_XG_MP1 (I48_G1_0 I48_G0_0n XI48_I19_XG_p1 VDD) gpdk090_pmos1v w=0.48u l=0.1u ad=0.1632p as=0.1056p pd=1.64u ps=0.92u
    I_MXI60_I20_XG_MP2 (VDD I60_gn2 I60_G2_1 VDD) gpdk090_pmos1v w=0.24u l=0.1u ad=0.0936p as=0.0816p pd=0.92u ps=1.16u
    I_MXI60_I20_XG_MP0 (XI60_I20_XG_p1 I60_pn2 VDD VDD) gpdk090_pmos1v w=0.48u l=0.1u ad=0.1056p as=0.0936p pd=0.92u ps=0.92u
    I_MXI60_I20_XG_MP1 (I60_G2_1 I60_gn1 XI60_I20_XG_p1 VDD) gpdk090_pmos1v w=0.48u l=0.1u ad=0.1632p as=0.1056p pd=1.64u ps=0.92u
    I_MXI60_I19_XG_MP2 (VDD I60_gn1 I60_G1_0 VDD) gpdk090_pmos1v w=0.24u l=0.1u ad=0.0936p as=0.0816p pd=0.92u ps=1.16u
    I_MXI60_I19_XG_MP0 (XI60_I19_XG_p1 I60_pn1 VDD VDD) gpdk090_pmos1v w=0.48u l=0.1u ad=0.1056p as=0.0936p pd=0.92u ps=0.92u
    I_MXI60_I19_XG_MP1 (I60_G1_0 I60_G0_0n XI60_I19_XG_p1 VDD) gpdk090_pmos1v w=0.48u l=0.1u ad=0.1632p as=0.1056p pd=1.64u ps=0.92u
    I_MXI72_I21_XG_MP2 (VDD I72_gn3 I72_G3_2 VDD) gpdk090_pmos1v w=0.24u l=0.1u ad=0.0936p as=0.0816p pd=0.92u ps=1.16u
    I_MXI72_I21_XG_MP0 (XI72_I21_XG_p1 I72_pn3 VDD VDD) gpdk090_pmos1v w=0.48u l=0.1u ad=0.1056p as=0.0936p pd=0.92u ps=0.92u
    I_MXI72_I21_XG_MP1 (I72_G3_2 I72_gn2 XI72_I21_XG_p1 VDD) gpdk090_pmos1v w=0.48u l=0.1u ad=0.1632p as=0.1056p pd=1.64u ps=0.92u
    I_MXI72_I32_XG_MP2 (VDD I72_G4_1n I72_G4_0 VDD) gpdk090_pmos1v w=0.24u l=0.1u ad=0.0936p as=0.0816p pd=0.92u ps=1.16u
    I_MXI72_I32_XG_MP0 (XI72_I32_XG_p1 I72_P4_1n VDD VDD) gpdk090_pmos1v w=0.48u l=0.1u ad=0.1056p as=0.0936p pd=0.92u ps=0.92u
    I_MXI72_I32_XG_MP1 (I72_G4_0 I72_G0_0n XI72_I32_XG_p1 VDD) gpdk090_pmos1v w=0.48u l=0.1u ad=0.1632p as=0.1056p pd=1.64u ps=0.92u
    I_MXI48_I23_XG_MP2 (VDD I48_gn5 I48_G5_4 VDD) gpdk090_pmos1v w=0.24u l=0.1u ad=0.0936p as=0.0816p pd=0.92u ps=1.16u
    I_MXI48_I23_XG_MP0 (XI48_I23_XG_p1 I48_pn5 VDD VDD) gpdk090_pmos1v w=0.48u l=0.1u ad=0.1056p as=0.0936p pd=0.92u ps=0.92u
    I_MXI48_I23_XG_MP1 (I48_G5_4 I48_gn4 XI48_I23_XG_p1 VDD) gpdk090_pmos1v w=0.48u l=0.1u ad=0.1632p as=0.1056p pd=1.64u ps=0.92u
    I_MXI48_I24_XG_MP2 (VDD I48_gn6 I48_G6_5 VDD) gpdk090_pmos1v w=0.24u l=0.1u ad=0.0936p as=0.0816p pd=0.92u ps=1.16u
    I_MXI48_I24_XG_MP0 (XI48_I24_XG_p1 I48_pn6 VDD VDD) gpdk090_pmos1v w=0.48u l=0.1u ad=0.1056p as=0.0936p pd=0.92u ps=0.92u
    I_MXI48_I24_XG_MP1 (I48_G6_5 I48_gn5 XI48_I24_XG_p1 VDD) gpdk090_pmos1v w=0.48u l=0.1u ad=0.1632p as=0.1056p pd=1.64u ps=0.92u
    I_MXI48_I35_XG_MP2 (VDD I48_G6_3n c0_7 VDD) gpdk090_pmos1v w=0.24u l=0.1u ad=0.0936p as=0.0816p pd=0.92u ps=1.16u
    I_MXI48_I35_XG_MP0 (XI48_I35_XG_p1 I48_P6_3n VDD VDD) gpdk090_pmos1v w=0.48u l=0.1u ad=0.1056p as=0.0936p pd=0.92u ps=0.92u
    I_MXI48_I35_XG_MP1 (c0_7 I48_G2_0n XI48_I35_XG_p1 VDD) gpdk090_pmos1v w=0.48u l=0.1u ad=0.1632p as=0.1056p pd=1.64u ps=0.92u
    I_MXI60_I21_XG_MP2 (VDD I60_gn3 I60_G3_2 VDD) gpdk090_pmos1v w=0.24u l=0.1u ad=0.0936p as=0.0816p pd=0.92u ps=1.16u
    I_MXI60_I21_XG_MP0 (XI60_I21_XG_p1 I60_pn3 VDD VDD) gpdk090_pmos1v w=0.48u l=0.1u ad=0.1056p as=0.0936p pd=0.92u ps=0.92u
    I_MXI60_I21_XG_MP1 (I60_G3_2 I60_gn2 XI60_I21_XG_p1 VDD) gpdk090_pmos1v w=0.48u l=0.1u ad=0.1632p as=0.1056p pd=1.64u ps=0.92u
    I_MXI60_I22_XG_MP2 (VDD I60_gn4 I60_G4_3 VDD) gpdk090_pmos1v w=0.24u l=0.1u ad=0.0936p as=0.0816p pd=0.92u ps=1.16u
    I_MXI60_I22_XG_MP0 (XI60_I22_XG_p1 I60_pn4 VDD VDD) gpdk090_pmos1v w=0.48u l=0.1u ad=0.1056p as=0.0936p pd=0.92u ps=0.92u
    I_MXI60_I22_XG_MP1 (I60_G4_3 I60_gn3 XI60_I22_XG_p1 VDD) gpdk090_pmos1v w=0.48u l=0.1u ad=0.1632p as=0.1056p pd=1.64u ps=0.92u
    I_MXI60_I32_XG_MP2 (VDD I60_G4_1n I60_G4_0 VDD) gpdk090_pmos1v w=0.24u l=0.1u ad=0.0936p as=0.0816p pd=0.92u ps=1.16u
    I_MXI60_I32_XG_MP0 (XI60_I32_XG_p1 I60_P4_1n VDD VDD) gpdk090_pmos1v w=0.48u l=0.1u ad=0.1056p as=0.0936p pd=0.92u ps=0.92u
    I_MXI60_I32_XG_MP1 (I60_G4_0 I60_G0_0n XI60_I32_XG_p1 VDD) gpdk090_pmos1v w=0.48u l=0.1u ad=0.1632p as=0.1056p pd=1.64u ps=0.92u
    I_MXI72_I23_XG_MP2 (VDD I72_gn5 I72_G5_4 VDD) gpdk090_pmos1v w=0.24u l=0.1u ad=0.0936p as=0.0816p pd=0.92u ps=1.16u
    I_MXI72_I23_XG_MP0 (XI72_I23_XG_p1 I72_pn5 VDD VDD) gpdk090_pmos1v w=0.48u l=0.1u ad=0.1056p as=0.0936p pd=0.92u ps=0.92u
    I_MXI72_I23_XG_MP1 (I72_G5_4 I72_gn4 XI72_I23_XG_p1 VDD) gpdk090_pmos1v w=0.48u l=0.1u ad=0.1632p as=0.1056p pd=1.64u ps=0.92u
    I_MXI72_I22_XG_MP2 (VDD I72_gn4 I72_G4_3 VDD) gpdk090_pmos1v w=0.24u l=0.1u ad=0.0936p as=0.0816p pd=0.92u ps=1.16u
    I_MXI72_I22_XG_MP0 (XI72_I22_XG_p1 I72_pn4 VDD VDD) gpdk090_pmos1v w=0.48u l=0.1u ad=0.1056p as=0.0936p pd=0.92u ps=0.92u
    I_MXI72_I22_XG_MP1 (I72_G4_3 I72_gn3 XI72_I22_XG_p1 VDD) gpdk090_pmos1v w=0.48u l=0.1u ad=0.1632p as=0.1056p pd=1.64u ps=0.92u
    I_MXI72_I34_XG_MP2 (VDD I72_G5_2n I72_G5_0 VDD) gpdk090_pmos1v w=0.24u l=0.1u ad=0.0936p as=0.0816p pd=0.92u ps=1.16u
    I_MXI72_I34_XG_MP0 (XI72_I34_XG_p1 I72_P5_2n VDD VDD) gpdk090_pmos1v w=0.48u l=0.1u ad=0.1056p as=0.0936p pd=0.92u ps=0.92u
    I_MXI72_I34_XG_MP1 (I72_G5_0 I72_G1_0n XI72_I34_XG_p1 VDD) gpdk090_pmos1v w=0.48u l=0.1u ad=0.1632p as=0.1056p pd=1.64u ps=0.92u
    I_MXI48_I25_XG_MP2 (VDD I48_gn7 I48_G7_6 VDD) gpdk090_pmos1v w=0.24u l=0.1u ad=0.0936p as=0.0816p pd=0.92u ps=1.16u
    I_MXI48_I25_XG_MP0 (XI48_I25_XG_p1 I48_pn7 VDD VDD) gpdk090_pmos1v w=0.48u l=0.1u ad=0.1056p as=0.0936p pd=0.92u ps=0.92u
    I_MXI48_I25_XG_MP1 (I48_G7_6 I48_gn6 XI48_I25_XG_p1 VDD) gpdk090_pmos1v w=0.48u l=0.1u ad=0.1632p as=0.1056p pd=1.64u ps=0.92u
    I_MXI48_I36_XG_MP2 (VDD I48_G7_4n c0_8 VDD) gpdk090_pmos1v w=0.24u l=0.1u ad=0.0936p as=0.0816p pd=0.92u ps=1.16u
    I_MXI48_I36_XG_MP0 (XI48_I36_XG_p1 I48_P7_4n VDD VDD) gpdk090_pmos1v w=0.48u l=0.1u ad=0.1056p as=0.0936p pd=0.92u ps=0.92u
    I_MXI48_I36_XG_MP1 (c0_8 I48_G3_0n XI48_I36_XG_p1 VDD) gpdk090_pmos1v w=0.48u l=0.1u ad=0.1632p as=0.1056p pd=1.64u ps=0.92u
    I_MXI48_I34_XG_MP2 (VDD I48_G5_2n I48_G5_0 VDD) gpdk090_pmos1v w=0.24u l=0.1u ad=0.0936p as=0.0816p pd=0.92u ps=1.16u
    I_MXI48_I34_XG_MP0 (XI48_I34_XG_p1 I48_P5_2n VDD VDD) gpdk090_pmos1v w=0.48u l=0.1u ad=0.1056p as=0.0936p pd=0.92u ps=0.92u
    I_MXI48_I34_XG_MP1 (I48_G5_0 I48_G1_0n XI48_I34_XG_p1 VDD) gpdk090_pmos1v w=0.48u l=0.1u ad=0.1632p as=0.1056p pd=1.64u ps=0.92u
    I_MXI60_I24_XG_MP2 (VDD I60_gn6 I60_G6_5 VDD) gpdk090_pmos1v w=0.24u l=0.1u ad=0.0936p as=0.0816p pd=0.92u ps=1.16u
    I_MXI60_I24_XG_MP0 (XI60_I24_XG_p1 I60_pn6 VDD VDD) gpdk090_pmos1v w=0.48u l=0.1u ad=0.1056p as=0.0936p pd=0.92u ps=0.92u
    I_MXI60_I24_XG_MP1 (I60_G6_5 I60_gn5 XI60_I24_XG_p1 VDD) gpdk090_pmos1v w=0.48u l=0.1u ad=0.1632p as=0.1056p pd=1.64u ps=0.92u
    I_MXI60_I23_XG_MP2 (VDD I60_gn5 I60_G5_4 VDD) gpdk090_pmos1v w=0.24u l=0.1u ad=0.0936p as=0.0816p pd=0.92u ps=1.16u
    I_MXI60_I23_XG_MP0 (XI60_I23_XG_p1 I60_pn5 VDD VDD) gpdk090_pmos1v w=0.48u l=0.1u ad=0.1056p as=0.0936p pd=0.92u ps=0.92u
    I_MXI60_I23_XG_MP1 (I60_G5_4 I60_gn4 XI60_I23_XG_p1 VDD) gpdk090_pmos1v w=0.48u l=0.1u ad=0.1632p as=0.1056p pd=1.64u ps=0.92u
    I_MXI60_I34_XG_MP2 (VDD I60_G5_2n I60_G5_0 VDD) gpdk090_pmos1v w=0.24u l=0.1u ad=0.0936p as=0.0816p pd=0.92u ps=1.16u
    I_MXI60_I34_XG_MP0 (XI60_I34_XG_p1 I60_P5_2n VDD VDD) gpdk090_pmos1v w=0.48u l=0.1u ad=0.1056p as=0.0936p pd=0.92u ps=0.92u
    I_MXI60_I34_XG_MP1 (I60_G5_0 I60_G1_0n XI60_I34_XG_p1 VDD) gpdk090_pmos1v w=0.48u l=0.1u ad=0.1632p as=0.1056p pd=1.64u ps=0.92u
    I_MXI60_I35_XG_MP2 (VDD I60_G6_3n c1_7 VDD) gpdk090_pmos1v w=0.24u l=0.1u ad=0.0936p as=0.0816p pd=0.92u ps=1.16u
    I_MXI60_I35_XG_MP0 (XI60_I35_XG_p1 I60_P6_3n VDD VDD) gpdk090_pmos1v w=0.48u l=0.1u ad=0.1056p as=0.0936p pd=0.92u ps=0.92u
    I_MXI60_I35_XG_MP1 (c1_7 I60_G2_0n XI60_I35_XG_p1 VDD) gpdk090_pmos1v w=0.48u l=0.1u ad=0.1632p as=0.1056p pd=1.64u ps=0.92u
    I_MXI72_I24_XG_MP2 (VDD I72_gn6 I72_G6_5 VDD) gpdk090_pmos1v w=0.24u l=0.1u ad=0.0936p as=0.0816p pd=0.92u ps=1.16u
    I_MXI72_I24_XG_MP0 (XI72_I24_XG_p1 I72_pn6 VDD VDD) gpdk090_pmos1v w=0.48u l=0.1u ad=0.1056p as=0.0936p pd=0.92u ps=0.92u
    I_MXI72_I24_XG_MP1 (I72_G6_5 I72_gn5 XI72_I24_XG_p1 VDD) gpdk090_pmos1v w=0.48u l=0.1u ad=0.1632p as=0.1056p pd=1.64u ps=0.92u
    I_MXI72_I35_XG_MP2 (VDD I72_G6_3n c2_7 VDD) gpdk090_pmos1v w=0.24u l=0.1u ad=0.0936p as=0.0816p pd=0.92u ps=1.16u
    I_MXI72_I35_XG_MP0 (XI72_I35_XG_p1 I72_P6_3n VDD VDD) gpdk090_pmos1v w=0.48u l=0.1u ad=0.1056p as=0.0936p pd=0.92u ps=0.92u
    I_MXI72_I35_XG_MP1 (c2_7 I72_G2_0n XI72_I35_XG_p1 VDD) gpdk090_pmos1v w=0.48u l=0.1u ad=0.1632p as=0.1056p pd=1.64u ps=0.92u
    I_MXI60_I25_XG_MP2 (VDD I60_gn7 I60_G7_6 VDD) gpdk090_pmos1v w=0.24u l=0.1u ad=0.0936p as=0.0816p pd=0.92u ps=1.16u
    I_MXI60_I25_XG_MP0 (XI60_I25_XG_p1 I60_pn7 VDD VDD) gpdk090_pmos1v w=0.48u l=0.1u ad=0.1056p as=0.0936p pd=0.92u ps=0.92u
    I_MXI60_I25_XG_MP1 (I60_G7_6 I60_gn6 XI60_I25_XG_p1 VDD) gpdk090_pmos1v w=0.48u l=0.1u ad=0.1632p as=0.1056p pd=1.64u ps=0.92u
    I_MXI60_I36_XG_MP2 (VDD I60_G7_4n c1_8 VDD) gpdk090_pmos1v w=0.24u l=0.1u ad=0.0936p as=0.0816p pd=0.92u ps=1.16u
    I_MXI60_I36_XG_MP0 (XI60_I36_XG_p1 I60_P7_4n VDD VDD) gpdk090_pmos1v w=0.48u l=0.1u ad=0.1056p as=0.0936p pd=0.92u ps=0.92u
    I_MXI60_I36_XG_MP1 (c1_8 I60_G3_0n XI60_I36_XG_p1 VDD) gpdk090_pmos1v w=0.48u l=0.1u ad=0.1632p as=0.1056p pd=1.64u ps=0.92u
    I_MXI72_I25_XG_MP2 (VDD I72_gn7 I72_G7_6 VDD) gpdk090_pmos1v w=0.24u l=0.1u ad=0.0936p as=0.0816p pd=0.92u ps=1.16u
    I_MXI72_I25_XG_MP0 (XI72_I25_XG_p1 I72_pn7 VDD VDD) gpdk090_pmos1v w=0.48u l=0.1u ad=0.1056p as=0.0936p pd=0.92u ps=0.92u
    I_MXI72_I25_XG_MP1 (I72_G7_6 I72_gn6 XI72_I25_XG_p1 VDD) gpdk090_pmos1v w=0.48u l=0.1u ad=0.1632p as=0.1056p pd=1.64u ps=0.92u
    I_MXI72_I36_XG_MP2 (VDD I72_G7_4n c2_8 VDD) gpdk090_pmos1v w=0.24u l=0.1u ad=0.0936p as=0.0816p pd=0.92u ps=1.16u
    I_MXI72_I36_XG_MP0 (XI72_I36_XG_p1 I72_P7_4n VDD VDD) gpdk090_pmos1v w=0.48u l=0.1u ad=0.1056p as=0.0936p pd=0.92u ps=0.92u
    I_MXI72_I36_XG_MP1 (c2_8 I72_G3_0n XI72_I36_XG_p1 VDD) gpdk090_pmos1v w=0.48u l=0.1u ad=0.1632p as=0.1056p pd=1.64u ps=0.92u
    I_MXI132_I7_MP1 (I132_gn7 b7_7 VDD VDD) gpdk090_pmos1v w=0.24u l=0.1u ad=0.0528p as=0.0816p pd=0.68u ps=1.16u
    I_MXI132_I7_MP0 (VDD p6_6 I132_gn7 VDD) gpdk090_pmos1v w=0.24u l=0.1u ad=0.0816p as=0.0528p pd=1.16u ps=0.68u
    I_MXI132_I5_MP1 (I132_gn5 b7_5 VDD VDD) gpdk090_pmos1v w=0.24u l=0.1u ad=0.0528p as=0.0816p pd=0.68u ps=1.16u
    I_MXI132_I5_MP0 (VDD p6_4 I132_gn5 VDD) gpdk090_pmos1v w=0.24u l=0.1u ad=0.0816p as=0.0528p pd=1.16u ps=0.68u
    I_MXI120_I31_XP_MP1 (I120_P7_4n I120_P5_4 VDD VDD) gpdk090_pmos1v w=0.24u l=0.1u ad=0.0528p as=0.0816p pd=0.68u ps=1.16u
    I_MXI120_I31_XP_MP0 (VDD I120_P7_6 I120_P7_4n VDD) gpdk090_pmos1v w=0.24u l=0.1u ad=0.0816p as=0.0528p pd=1.16u ps=0.68u
    I_MXI120_I7_MP1 (I120_gn7 b6_7 VDD VDD) gpdk090_pmos1v w=0.24u l=0.1u ad=0.0528p as=0.0816p pd=0.68u ps=1.16u
    I_MXI120_I7_MP0 (VDD p5_6 I120_gn7 VDD) gpdk090_pmos1v w=0.24u l=0.1u ad=0.0816p as=0.0528p pd=1.16u ps=0.68u
    I_MXI108_I29_XP_MP1 (I108_P5_2n I108_P3_2 VDD VDD) gpdk090_pmos1v w=0.24u l=0.1u ad=0.0528p as=0.0816p pd=0.68u ps=1.16u
    I_MXI108_I29_XP_MP0 (VDD I108_P5_4 I108_P5_2n VDD) gpdk090_pmos1v w=0.24u l=0.1u ad=0.0816p as=0.0528p pd=1.16u ps=0.68u
    I_MXI108_I7_MP1 (I108_gn7 b5_7 VDD VDD) gpdk090_pmos1v w=0.24u l=0.1u ad=0.0528p as=0.0816p pd=0.68u ps=1.16u
    I_MXI108_I7_MP0 (VDD p4_6 I108_gn7 VDD) gpdk090_pmos1v w=0.24u l=0.1u ad=0.0816p as=0.0528p pd=1.16u ps=0.68u
    I_MXI132_I6_MP1 (I132_gn6 b7_6 VDD VDD) gpdk090_pmos1v w=0.24u l=0.1u ad=0.0528p as=0.0816p pd=0.68u ps=1.16u
    I_MXI132_I6_MP0 (VDD p6_5 I132_gn6 VDD) gpdk090_pmos1v w=0.24u l=0.1u ad=0.0816p as=0.0528p pd=1.16u ps=0.68u
    I_MXI120_I30_XP_MP1 (I120_P6_3n I120_P4_3 VDD VDD) gpdk090_pmos1v w=0.24u l=0.1u ad=0.0528p as=0.0816p pd=0.68u ps=1.16u
    I_MXI120_I30_XP_MP0 (VDD I120_P6_5 I120_P6_3n VDD) gpdk090_pmos1v w=0.24u l=0.1u ad=0.0816p as=0.0528p pd=1.16u ps=0.68u
    I_MXI120_I29_XP_MP1 (I120_P5_2n I120_P3_2 VDD VDD) gpdk090_pmos1v w=0.24u l=0.1u ad=0.0528p as=0.0816p pd=0.68u ps=1.16u
    I_MXI120_I29_XP_MP0 (VDD I120_P5_4 I120_P5_2n VDD) gpdk090_pmos1v w=0.24u l=0.1u ad=0.0816p as=0.0528p pd=1.16u ps=0.68u
    I_MXI120_I5_MP1 (I120_gn5 b6_5 VDD VDD) gpdk090_pmos1v w=0.24u l=0.1u ad=0.0528p as=0.0816p pd=0.68u ps=1.16u
    I_MXI120_I5_MP0 (VDD p5_4 I120_gn5 VDD) gpdk090_pmos1v w=0.24u l=0.1u ad=0.0816p as=0.0528p pd=1.16u ps=0.68u
    I_MXI120_I6_MP1 (I120_gn6 b6_6 VDD VDD) gpdk090_pmos1v w=0.24u l=0.1u ad=0.0528p as=0.0816p pd=0.68u ps=1.16u
    I_MXI120_I6_MP0 (VDD p5_5 I120_gn6 VDD) gpdk090_pmos1v w=0.24u l=0.1u ad=0.0816p as=0.0528p pd=1.16u ps=0.68u
    I_MXI108_I30_XP_MP1 (I108_P6_3n I108_P4_3 VDD VDD) gpdk090_pmos1v w=0.24u l=0.1u ad=0.0528p as=0.0816p pd=0.68u ps=1.16u
    I_MXI108_I30_XP_MP0 (VDD I108_P6_5 I108_P6_3n VDD) gpdk090_pmos1v w=0.24u l=0.1u ad=0.0816p as=0.0528p pd=1.16u ps=0.68u
    I_MXI108_I31_XP_MP1 (I108_P7_4n I108_P5_4 VDD VDD) gpdk090_pmos1v w=0.24u l=0.1u ad=0.0528p as=0.0816p pd=0.68u ps=1.16u
    I_MXI108_I31_XP_MP0 (VDD I108_P7_6 I108_P7_4n VDD) gpdk090_pmos1v w=0.24u l=0.1u ad=0.0816p as=0.0528p pd=1.16u ps=0.68u
    I_MXI108_I5_MP1 (I108_gn5 b5_5 VDD VDD) gpdk090_pmos1v w=0.24u l=0.1u ad=0.0528p as=0.0816p pd=0.68u ps=1.16u
    I_MXI108_I5_MP0 (VDD p4_4 I108_gn5 VDD) gpdk090_pmos1v w=0.24u l=0.1u ad=0.0816p as=0.0528p pd=1.16u ps=0.68u
    I_MXI108_I6_MP1 (I108_gn6 b5_6 VDD VDD) gpdk090_pmos1v w=0.24u l=0.1u ad=0.0528p as=0.0816p pd=0.68u ps=1.16u
    I_MXI108_I6_MP0 (VDD p4_5 I108_gn6 VDD) gpdk090_pmos1v w=0.24u l=0.1u ad=0.0816p as=0.0528p pd=1.16u ps=0.68u
    I_MXI132_I31_XP_MP1 (I132_P7_4n I132_P5_4 VDD VDD) gpdk090_pmos1v w=0.24u l=0.1u ad=0.0528p as=0.0816p pd=0.68u ps=1.16u
    I_MXI132_I31_XP_MP0 (VDD I132_P7_6 I132_P7_4n VDD) gpdk090_pmos1v w=0.24u l=0.1u ad=0.0816p as=0.0528p pd=1.16u ps=0.68u
    I_MXI132_I4_MP1 (I132_gn4 b7_4 VDD VDD) gpdk090_pmos1v w=0.24u l=0.1u ad=0.0528p as=0.0816p pd=0.68u ps=1.16u
    I_MXI132_I4_MP0 (VDD p6_3 I132_gn4 VDD) gpdk090_pmos1v w=0.24u l=0.1u ad=0.0816p as=0.0528p pd=1.16u ps=0.68u
    I_MXI120_I28_XP_MP1 (I120_P4_1n I120_P2_1 VDD VDD) gpdk090_pmos1v w=0.24u l=0.1u ad=0.0528p as=0.0816p pd=0.68u ps=1.16u
    I_MXI120_I28_XP_MP0 (VDD I120_P4_3 I120_P4_1n VDD) gpdk090_pmos1v w=0.24u l=0.1u ad=0.0816p as=0.0528p pd=1.16u ps=0.68u
    I_MXI120_I3_MP1 (I120_gn3 b6_3 VDD VDD) gpdk090_pmos1v w=0.24u l=0.1u ad=0.0528p as=0.0816p pd=0.68u ps=1.16u
    I_MXI120_I3_MP0 (VDD p5_2 I120_gn3 VDD) gpdk090_pmos1v w=0.24u l=0.1u ad=0.0816p as=0.0528p pd=1.16u ps=0.68u
    I_MXI120_I4_MP1 (I120_gn4 b6_4 VDD VDD) gpdk090_pmos1v w=0.24u l=0.1u ad=0.0528p as=0.0816p pd=0.68u ps=1.16u
    I_MXI120_I4_MP0 (VDD p5_3 I120_gn4 VDD) gpdk090_pmos1v w=0.24u l=0.1u ad=0.0816p as=0.0528p pd=1.16u ps=0.68u
    I_MXI108_I28_XP_MP1 (I108_P4_1n I108_P2_1 VDD VDD) gpdk090_pmos1v w=0.24u l=0.1u ad=0.0528p as=0.0816p pd=0.68u ps=1.16u
    I_MXI108_I28_XP_MP0 (VDD I108_P4_3 I108_P4_1n VDD) gpdk090_pmos1v w=0.24u l=0.1u ad=0.0816p as=0.0528p pd=1.16u ps=0.68u
    I_MXI108_I3_MP1 (I108_gn3 b5_3 VDD VDD) gpdk090_pmos1v w=0.24u l=0.1u ad=0.0528p as=0.0816p pd=0.68u ps=1.16u
    I_MXI108_I3_MP0 (VDD p4_2 I108_gn3 VDD) gpdk090_pmos1v w=0.24u l=0.1u ad=0.0816p as=0.0528p pd=1.16u ps=0.68u
    I_MXI108_I4_MP1 (I108_gn4 b5_4 VDD VDD) gpdk090_pmos1v w=0.24u l=0.1u ad=0.0528p as=0.0816p pd=0.68u ps=1.16u
    I_MXI108_I4_MP0 (VDD p4_3 I108_gn4 VDD) gpdk090_pmos1v w=0.24u l=0.1u ad=0.0816p as=0.0528p pd=1.16u ps=0.68u
    I_MXI152_I7_MP1 (I152_gn7 dm7 VDD VDD) gpdk090_pmos1v w=0.24u l=0.1u ad=0.0528p as=0.0816p pd=0.68u ps=1.16u
    I_MXI152_I7_MP0 (VDD p7_7 I152_gn7 VDD) gpdk090_pmos1v w=0.24u l=0.1u ad=0.0816p as=0.0528p pd=1.16u ps=0.68u
    I_MXI132_I29_XP_MP1 (I132_P5_2n I132_P3_2 VDD VDD) gpdk090_pmos1v w=0.24u l=0.1u ad=0.0528p as=0.0816p pd=0.68u ps=1.16u
    I_MXI132_I29_XP_MP0 (VDD I132_P5_4 I132_P5_2n VDD) gpdk090_pmos1v w=0.24u l=0.1u ad=0.0816p as=0.0528p pd=1.16u ps=0.68u
    I_MXI132_I30_XP_MP1 (I132_P6_3n I132_P4_3 VDD VDD) gpdk090_pmos1v w=0.24u l=0.1u ad=0.0528p as=0.0816p pd=0.68u ps=1.16u
    I_MXI132_I30_XP_MP0 (VDD I132_P6_5 I132_P6_3n VDD) gpdk090_pmos1v w=0.24u l=0.1u ad=0.0816p as=0.0528p pd=1.16u ps=0.68u
    I_MXI132_I3_MP1 (I132_gn3 b7_3 VDD VDD) gpdk090_pmos1v w=0.24u l=0.1u ad=0.0528p as=0.0816p pd=0.68u ps=1.16u
    I_MXI132_I3_MP0 (VDD p6_2 I132_gn3 VDD) gpdk090_pmos1v w=0.24u l=0.1u ad=0.0816p as=0.0528p pd=1.16u ps=0.68u
    I_MXI120_I1_MP1 (I120_gn1 b6_1 VDD VDD) gpdk090_pmos1v w=0.24u l=0.1u ad=0.0528p as=0.0816p pd=0.68u ps=1.16u
    I_MXI120_I1_MP0 (VDD p5_0 I120_gn1 VDD) gpdk090_pmos1v w=0.24u l=0.1u ad=0.0816p as=0.0528p pd=1.16u ps=0.68u
    I_MXI120_I2_MP1 (I120_gn2 b6_2 VDD VDD) gpdk090_pmos1v w=0.24u l=0.1u ad=0.0528p as=0.0816p pd=0.68u ps=1.16u
    I_MXI120_I2_MP0 (VDD p5_1 I120_gn2 VDD) gpdk090_pmos1v w=0.24u l=0.1u ad=0.0816p as=0.0528p pd=1.16u ps=0.68u
    I_MXI108_I2_MP1 (I108_gn2 b5_2 VDD VDD) gpdk090_pmos1v w=0.24u l=0.1u ad=0.0528p as=0.0816p pd=0.68u ps=1.16u
    I_MXI108_I2_MP0 (VDD p4_1 I108_gn2 VDD) gpdk090_pmos1v w=0.24u l=0.1u ad=0.0816p as=0.0528p pd=1.16u ps=0.68u
    I_MXI96_I29_XP_MP1 (I96_P5_2n I96_P3_2 VDD VDD) gpdk090_pmos1v w=0.24u l=0.1u ad=0.0528p as=0.0816p pd=0.68u ps=1.16u
    I_MXI96_I29_XP_MP0 (VDD I96_P5_4 I96_P5_2n VDD) gpdk090_pmos1v w=0.24u l=0.1u ad=0.0816p as=0.0528p pd=1.16u ps=0.68u
    I_MXI96_I31_XP_MP1 (I96_P7_4n I96_P5_4 VDD VDD) gpdk090_pmos1v w=0.24u l=0.1u ad=0.0528p as=0.0816p pd=0.68u ps=1.16u
    I_MXI96_I31_XP_MP0 (VDD I96_P7_6 I96_P7_4n VDD) gpdk090_pmos1v w=0.24u l=0.1u ad=0.0816p as=0.0528p pd=1.16u ps=0.68u
    I_MXI148_MP1 (dmn6 p7_8 VDD VDD) gpdk090_pmos1v w=0.24u l=0.1u ad=0.0528p as=0.0816p pd=0.68u ps=1.16u
    I_MXI148_MP0 (VDD dd6 dmn6 VDD) gpdk090_pmos1v w=0.24u l=0.1u ad=0.0816p as=0.0528p pd=1.16u ps=0.68u
    I_MXI150_MP1 (dmn7 p7_8 VDD VDD) gpdk090_pmos1v w=0.24u l=0.1u ad=0.0528p as=0.0816p pd=0.68u ps=1.16u
    I_MXI150_MP0 (VDD dd7 dmn7 VDD) gpdk090_pmos1v w=0.24u l=0.1u ad=0.0816p as=0.0528p pd=1.16u ps=0.68u
    I_MXI132_I28_XP_MP1 (I132_P4_1n I132_P2_1 VDD VDD) gpdk090_pmos1v w=0.24u l=0.1u ad=0.0528p as=0.0816p pd=0.68u ps=1.16u
    I_MXI132_I28_XP_MP0 (VDD I132_P4_3 I132_P4_1n VDD) gpdk090_pmos1v w=0.24u l=0.1u ad=0.0816p as=0.0528p pd=1.16u ps=0.68u
    I_MXI132_I2_MP1 (I132_gn2 b7_2 VDD VDD) gpdk090_pmos1v w=0.24u l=0.1u ad=0.0528p as=0.0816p pd=0.68u ps=1.16u
    I_MXI132_I2_MP0 (VDD p6_1 I132_gn2 VDD) gpdk090_pmos1v w=0.24u l=0.1u ad=0.0816p as=0.0528p pd=1.16u ps=0.68u
    I_MXI120_I0_MP1 (I120_gn0 b6_0 VDD VDD) gpdk090_pmos1v w=0.24u l=0.1u ad=0.0528p as=0.0816p pd=0.68u ps=1.16u
    I_MXI120_I0_MP0 (VDD aa1 I120_gn0 VDD) gpdk090_pmos1v w=0.24u l=0.1u ad=0.0816p as=0.0528p pd=1.16u ps=0.68u
    I_MXI108_I0_MP1 (I108_gn0 b5_0 VDD VDD) gpdk090_pmos1v w=0.24u l=0.1u ad=0.0528p as=0.0816p pd=0.68u ps=1.16u
    I_MXI108_I0_MP0 (VDD aa2 I108_gn0 VDD) gpdk090_pmos1v w=0.24u l=0.1u ad=0.0816p as=0.0528p pd=1.16u ps=0.68u
    I_MXI108_I1_MP1 (I108_gn1 b5_1 VDD VDD) gpdk090_pmos1v w=0.24u l=0.1u ad=0.0528p as=0.0816p pd=0.68u ps=1.16u
    I_MXI108_I1_MP0 (VDD p4_0 I108_gn1 VDD) gpdk090_pmos1v w=0.24u l=0.1u ad=0.0816p as=0.0528p pd=1.16u ps=0.68u
    I_MXI96_I28_XP_MP1 (I96_P4_1n I96_P2_1 VDD VDD) gpdk090_pmos1v w=0.24u l=0.1u ad=0.0528p as=0.0816p pd=0.68u ps=1.16u
    I_MXI96_I28_XP_MP0 (VDD I96_P4_3 I96_P4_1n VDD) gpdk090_pmos1v w=0.24u l=0.1u ad=0.0816p as=0.0528p pd=1.16u ps=0.68u
    I_MXI96_I30_XP_MP1 (I96_P6_3n I96_P4_3 VDD VDD) gpdk090_pmos1v w=0.24u l=0.1u ad=0.0528p as=0.0816p pd=0.68u ps=1.16u
    I_MXI96_I30_XP_MP0 (VDD I96_P6_5 I96_P6_3n VDD) gpdk090_pmos1v w=0.24u l=0.1u ad=0.0816p as=0.0528p pd=1.16u ps=0.68u
    I_MXI96_I7_MP1 (I96_gn7 b4_7 VDD VDD) gpdk090_pmos1v w=0.24u l=0.1u ad=0.0528p as=0.0816p pd=0.68u ps=1.16u
    I_MXI96_I7_MP0 (VDD p3_6 I96_gn7 VDD) gpdk090_pmos1v w=0.24u l=0.1u ad=0.0816p as=0.0528p pd=1.16u ps=0.68u
    I_MXI152_I6_MP1 (I152_gn6 dm6 VDD VDD) gpdk090_pmos1v w=0.24u l=0.1u ad=0.0528p as=0.0816p pd=0.68u ps=1.16u
    I_MXI152_I6_MP0 (VDD p7_6 I152_gn6 VDD) gpdk090_pmos1v w=0.24u l=0.1u ad=0.0816p as=0.0528p pd=1.16u ps=0.68u
    I_MXI152_I5_MP1 (I152_gn5 dm5 VDD VDD) gpdk090_pmos1v w=0.24u l=0.1u ad=0.0528p as=0.0816p pd=0.68u ps=1.16u
    I_MXI152_I5_MP0 (VDD p7_5 I152_gn5 VDD) gpdk090_pmos1v w=0.24u l=0.1u ad=0.0816p as=0.0528p pd=1.16u ps=0.68u
    I_MXI152_I4_MP1 (I152_gn4 dm4 VDD VDD) gpdk090_pmos1v w=0.24u l=0.1u ad=0.0528p as=0.0816p pd=0.68u ps=1.16u
    I_MXI152_I4_MP0 (VDD p7_4 I152_gn4 VDD) gpdk090_pmos1v w=0.24u l=0.1u ad=0.0816p as=0.0528p pd=1.16u ps=0.68u
    I_MXI146_MP1 (dmn5 p7_8 VDD VDD) gpdk090_pmos1v w=0.24u l=0.1u ad=0.0528p as=0.0816p pd=0.68u ps=1.16u
    I_MXI146_MP0 (VDD dd5 dmn5 VDD) gpdk090_pmos1v w=0.24u l=0.1u ad=0.0816p as=0.0528p pd=1.16u ps=0.68u
    I_MXI144_MP1 (dmn4 p7_8 VDD VDD) gpdk090_pmos1v w=0.24u l=0.1u ad=0.0528p as=0.0816p pd=0.68u ps=1.16u
    I_MXI144_MP0 (VDD dd4 dmn4 VDD) gpdk090_pmos1v w=0.24u l=0.1u ad=0.0816p as=0.0528p pd=1.16u ps=0.68u
    I_MXI132_I1_MP1 (I132_gn1 b7_1 VDD VDD) gpdk090_pmos1v w=0.24u l=0.1u ad=0.0528p as=0.0816p pd=0.68u ps=1.16u
    I_MXI132_I1_MP0 (VDD p6_0 I132_gn1 VDD) gpdk090_pmos1v w=0.24u l=0.1u ad=0.0816p as=0.0528p pd=1.16u ps=0.68u
    I_MXI132_I0_MP1 (I132_gn0 b7_0 VDD VDD) gpdk090_pmos1v w=0.24u l=0.1u ad=0.0528p as=0.0816p pd=0.68u ps=1.16u
    I_MXI132_I0_MP0 (VDD A_0 I132_gn0 VDD) gpdk090_pmos1v w=0.24u l=0.1u ad=0.0816p as=0.0528p pd=1.16u ps=0.68u
    I_MXI96_I0_MP1 (I96_gn0 b4_0 VDD VDD) gpdk090_pmos1v w=0.24u l=0.1u ad=0.0528p as=0.0816p pd=0.68u ps=1.16u
    I_MXI96_I0_MP0 (VDD aa3 I96_gn0 VDD) gpdk090_pmos1v w=0.24u l=0.1u ad=0.0816p as=0.0528p pd=1.16u ps=0.68u
    I_MXI96_I1_MP1 (I96_gn1 b4_1 VDD VDD) gpdk090_pmos1v w=0.24u l=0.1u ad=0.0528p as=0.0816p pd=0.68u ps=1.16u
    I_MXI96_I1_MP0 (VDD p3_0 I96_gn1 VDD) gpdk090_pmos1v w=0.24u l=0.1u ad=0.0816p as=0.0528p pd=1.16u ps=0.68u
    I_MXI152_I31_XP_MP1 (I152_P7_4n I152_P5_4 VDD VDD) gpdk090_pmos1v w=0.24u l=0.1u ad=0.0528p as=0.0816p pd=0.68u ps=1.16u
    I_MXI152_I31_XP_MP0 (VDD I152_P7_6 I152_P7_4n VDD) gpdk090_pmos1v w=0.24u l=0.1u ad=0.0816p as=0.0528p pd=1.16u ps=0.68u
    I_MXI152_I3_MP1 (I152_gn3 dm3 VDD VDD) gpdk090_pmos1v w=0.24u l=0.1u ad=0.0528p as=0.0816p pd=0.68u ps=1.16u
    I_MXI152_I3_MP0 (VDD p7_3 I152_gn3 VDD) gpdk090_pmos1v w=0.24u l=0.1u ad=0.0816p as=0.0528p pd=1.16u ps=0.68u
    I_MXI142_MP1 (dmn3 p7_8 VDD VDD) gpdk090_pmos1v w=0.24u l=0.1u ad=0.0528p as=0.0816p pd=0.68u ps=1.16u
    I_MXI142_MP0 (VDD dd3 dmn3 VDD) gpdk090_pmos1v w=0.24u l=0.1u ad=0.0816p as=0.0528p pd=1.16u ps=0.68u
    I_MXI0_MP1 (nakn1 A_0 VDD VDD) gpdk090_pmos1v w=0.24u l=0.1u ad=0.0528p as=0.0816p pd=0.68u ps=1.16u
    I_MXI0_MP0 (VDD A_7 nakn1 VDD) gpdk090_pmos1v w=0.24u l=0.1u ad=0.0816p as=0.0528p pd=1.16u ps=0.68u
    I_MXI96_I2_MP1 (I96_gn2 b4_2 VDD VDD) gpdk090_pmos1v w=0.24u l=0.1u ad=0.0528p as=0.0816p pd=0.68u ps=1.16u
    I_MXI96_I2_MP0 (VDD p3_1 I96_gn2 VDD) gpdk090_pmos1v w=0.24u l=0.1u ad=0.0816p as=0.0528p pd=1.16u ps=0.68u
    I_MXI96_I3_MP1 (I96_gn3 b4_3 VDD VDD) gpdk090_pmos1v w=0.24u l=0.1u ad=0.0528p as=0.0816p pd=0.68u ps=1.16u
    I_MXI96_I3_MP0 (VDD p3_2 I96_gn3 VDD) gpdk090_pmos1v w=0.24u l=0.1u ad=0.0816p as=0.0528p pd=1.16u ps=0.68u
    I_MXI96_I4_MP1 (I96_gn4 b4_4 VDD VDD) gpdk090_pmos1v w=0.24u l=0.1u ad=0.0528p as=0.0816p pd=0.68u ps=1.16u
    I_MXI96_I4_MP0 (VDD p3_3 I96_gn4 VDD) gpdk090_pmos1v w=0.24u l=0.1u ad=0.0816p as=0.0528p pd=1.16u ps=0.68u
    I_MXI96_I5_MP1 (I96_gn5 b4_5 VDD VDD) gpdk090_pmos1v w=0.24u l=0.1u ad=0.0528p as=0.0816p pd=0.68u ps=1.16u
    I_MXI96_I5_MP0 (VDD p3_4 I96_gn5 VDD) gpdk090_pmos1v w=0.24u l=0.1u ad=0.0816p as=0.0528p pd=1.16u ps=0.68u
    I_MXI96_I6_MP1 (I96_gn6 b4_6 VDD VDD) gpdk090_pmos1v w=0.24u l=0.1u ad=0.0528p as=0.0816p pd=0.68u ps=1.16u
    I_MXI96_I6_MP0 (VDD p3_5 I96_gn6 VDD) gpdk090_pmos1v w=0.24u l=0.1u ad=0.0816p as=0.0528p pd=1.16u ps=0.68u
    I_MXI152_I29_XP_MP1 (I152_P5_2n I152_P3_2 VDD VDD) gpdk090_pmos1v w=0.24u l=0.1u ad=0.0528p as=0.0816p pd=0.68u ps=1.16u
    I_MXI152_I29_XP_MP0 (VDD I152_P5_4 I152_P5_2n VDD) gpdk090_pmos1v w=0.24u l=0.1u ad=0.0816p as=0.0528p pd=1.16u ps=0.68u
    I_MXI152_I2_MP1 (I152_gn2 dm2 VDD VDD) gpdk090_pmos1v w=0.24u l=0.1u ad=0.0528p as=0.0816p pd=0.68u ps=1.16u
    I_MXI152_I2_MP0 (VDD p7_2 I152_gn2 VDD) gpdk090_pmos1v w=0.24u l=0.1u ad=0.0816p as=0.0528p pd=1.16u ps=0.68u
    I_MXI152_I0_MP1 (I152_gn0 dm0 VDD VDD) gpdk090_pmos1v w=0.24u l=0.1u ad=0.0528p as=0.0816p pd=0.68u ps=1.16u
    I_MXI152_I0_MP0 (VDD p7_0 I152_gn0 VDD) gpdk090_pmos1v w=0.24u l=0.1u ad=0.0816p as=0.0528p pd=1.16u ps=0.68u
    I_MXI138_MP1 (dmn1 p7_8 VDD VDD) gpdk090_pmos1v w=0.24u l=0.1u ad=0.0528p as=0.0816p pd=0.68u ps=1.16u
    I_MXI138_MP0 (VDD dd1 dmn1 VDD) gpdk090_pmos1v w=0.24u l=0.1u ad=0.0816p as=0.0528p pd=1.16u ps=0.68u
    I_MXI140_MP1 (dmn2 p7_8 VDD VDD) gpdk090_pmos1v w=0.24u l=0.1u ad=0.0528p as=0.0816p pd=0.68u ps=1.16u
    I_MXI140_MP0 (VDD dd2 dmn2 VDD) gpdk090_pmos1v w=0.24u l=0.1u ad=0.0816p as=0.0528p pd=1.16u ps=0.68u
    I_MXI136_MP1 (dmn0 p7_8 VDD VDD) gpdk090_pmos1v w=0.24u l=0.1u ad=0.0528p as=0.0816p pd=0.68u ps=1.16u
    I_MXI136_MP0 (VDD B_0 dmn0 VDD) gpdk090_pmos1v w=0.24u l=0.1u ad=0.0816p as=0.0528p pd=1.16u ps=0.68u
    I_MXI154_MP1 (nqkn1 Q_0 VDD VDD) gpdk090_pmos1v w=0.24u l=0.1u ad=0.0528p as=0.0816p pd=0.68u ps=1.16u
    I_MXI154_MP0 (VDD sq nqkn1 VDD) gpdk090_pmos1v w=0.24u l=0.1u ad=0.0816p as=0.0528p pd=1.16u ps=0.68u
    I_MXI84_I0_MP1 (I84_gn0 b3_0 VDD VDD) gpdk090_pmos1v w=0.24u l=0.1u ad=0.0528p as=0.0816p pd=0.68u ps=1.16u
    I_MXI84_I0_MP0 (VDD aa4 I84_gn0 VDD) gpdk090_pmos1v w=0.24u l=0.1u ad=0.0816p as=0.0528p pd=1.16u ps=0.68u
    I_MXI84_I28_XP_MP1 (I84_P4_1n I84_P2_1 VDD VDD) gpdk090_pmos1v w=0.24u l=0.1u ad=0.0528p as=0.0816p pd=0.68u ps=1.16u
    I_MXI84_I28_XP_MP0 (VDD I84_P4_3 I84_P4_1n VDD) gpdk090_pmos1v w=0.24u l=0.1u ad=0.0816p as=0.0528p pd=1.16u ps=0.68u
    I_MXI152_I30_XP_MP1 (I152_P6_3n I152_P4_3 VDD VDD) gpdk090_pmos1v w=0.24u l=0.1u ad=0.0528p as=0.0816p pd=0.68u ps=1.16u
    I_MXI152_I30_XP_MP0 (VDD I152_P6_5 I152_P6_3n VDD) gpdk090_pmos1v w=0.24u l=0.1u ad=0.0816p as=0.0528p pd=1.16u ps=0.68u
    I_MXI152_I28_XP_MP1 (I152_P4_1n I152_P2_1 VDD VDD) gpdk090_pmos1v w=0.24u l=0.1u ad=0.0528p as=0.0816p pd=0.68u ps=1.16u
    I_MXI152_I28_XP_MP0 (VDD I152_P4_3 I152_P4_1n VDD) gpdk090_pmos1v w=0.24u l=0.1u ad=0.0816p as=0.0528p pd=1.16u ps=0.68u
    I_MXI152_I1_MP1 (I152_gn1 dm1 VDD VDD) gpdk090_pmos1v w=0.24u l=0.1u ad=0.0528p as=0.0816p pd=0.68u ps=1.16u
    I_MXI152_I1_MP0 (VDD p7_1 I152_gn1 VDD) gpdk090_pmos1v w=0.24u l=0.1u ad=0.0816p as=0.0528p pd=1.16u ps=0.68u
    I_MXI20_MP1 (nbkn1 B_0 VDD VDD) gpdk090_pmos1v w=0.24u l=0.1u ad=0.0528p as=0.0816p pd=0.68u ps=1.16u
    I_MXI20_MP0 (VDD B_7 nbkn1 VDD) gpdk090_pmos1v w=0.24u l=0.1u ad=0.0816p as=0.0528p pd=1.16u ps=0.68u
    I_MXI84_I1_MP1 (I84_gn1 b3_1 VDD VDD) gpdk090_pmos1v w=0.24u l=0.1u ad=0.0528p as=0.0816p pd=0.68u ps=1.16u
    I_MXI84_I1_MP0 (VDD p2_0 I84_gn1 VDD) gpdk090_pmos1v w=0.24u l=0.1u ad=0.0816p as=0.0528p pd=1.16u ps=0.68u
    I_MXI84_I30_XP_MP1 (I84_P6_3n I84_P4_3 VDD VDD) gpdk090_pmos1v w=0.24u l=0.1u ad=0.0528p as=0.0816p pd=0.68u ps=1.16u
    I_MXI84_I30_XP_MP0 (VDD I84_P6_5 I84_P6_3n VDD) gpdk090_pmos1v w=0.24u l=0.1u ad=0.0816p as=0.0528p pd=1.16u ps=0.68u
    I_MXI199_MP1 (z2_1 z1_3 VDD VDD) gpdk090_pmos1v w=0.24u l=0.1u ad=0.0528p as=0.0816p pd=0.68u ps=1.16u
    I_MXI199_MP0 (VDD z1_2 z2_1 VDD) gpdk090_pmos1v w=0.24u l=0.1u ad=0.0816p as=0.0528p pd=1.16u ps=0.68u
    I_MXI198_MP1 (z2_0 z1_1 VDD VDD) gpdk090_pmos1v w=0.24u l=0.1u ad=0.0528p as=0.0816p pd=0.68u ps=1.16u
    I_MXI198_MP0 (VDD z1_0 z2_0 VDD) gpdk090_pmos1v w=0.24u l=0.1u ad=0.0816p as=0.0528p pd=1.16u ps=0.68u
    I_MXI202_MP1 (vn sqn VDD VDD) gpdk090_pmos1v w=0.24u l=0.1u ad=0.0528p as=0.0816p pd=0.68u ps=1.16u
    I_MXI202_MP0 (VDD Q_7 vn VDD) gpdk090_pmos1v w=0.24u l=0.1u ad=0.0816p as=0.0528p pd=1.16u ps=0.68u
    I_MXI72_I0_MP1 (I72_gn0 b2_0 VDD VDD) gpdk090_pmos1v w=0.24u l=0.1u ad=0.0528p as=0.0816p pd=0.68u ps=1.16u
    I_MXI72_I0_MP0 (VDD aa5 I72_gn0 VDD) gpdk090_pmos1v w=0.24u l=0.1u ad=0.0816p as=0.0528p pd=1.16u ps=0.68u
    I_MXI84_I2_MP1 (I84_gn2 b3_2 VDD VDD) gpdk090_pmos1v w=0.24u l=0.1u ad=0.0528p as=0.0816p pd=0.68u ps=1.16u
    I_MXI84_I2_MP0 (VDD p2_1 I84_gn2 VDD) gpdk090_pmos1v w=0.24u l=0.1u ad=0.0816p as=0.0528p pd=1.16u ps=0.68u
    I_MXI84_I29_XP_MP1 (I84_P5_2n I84_P3_2 VDD VDD) gpdk090_pmos1v w=0.24u l=0.1u ad=0.0528p as=0.0816p pd=0.68u ps=1.16u
    I_MXI84_I29_XP_MP0 (VDD I84_P5_4 I84_P5_2n VDD) gpdk090_pmos1v w=0.24u l=0.1u ad=0.0816p as=0.0528p pd=1.16u ps=0.68u
    I_MXI174_MP1 (nrkn1 R_0 VDD VDD) gpdk090_pmos1v w=0.24u l=0.1u ad=0.0528p as=0.0816p pd=0.68u ps=1.16u
    I_MXI174_MP0 (VDD A_7 nrkn1 VDD) gpdk090_pmos1v w=0.24u l=0.1u ad=0.0816p as=0.0528p pd=1.16u ps=0.68u
    I_MXI48_I0_MP1 (I48_gn0 b0_0 VDD VDD) gpdk090_pmos1v w=0.24u l=0.1u ad=0.0528p as=0.0816p pd=0.68u ps=1.16u
    I_MXI48_I0_MP0 (VDD aa7 I48_gn0 VDD) gpdk090_pmos1v w=0.24u l=0.1u ad=0.0816p as=0.0528p pd=1.16u ps=0.68u
    I_MXI60_I0_MP1 (I60_gn0 b1_0 VDD VDD) gpdk090_pmos1v w=0.24u l=0.1u ad=0.0528p as=0.0816p pd=0.68u ps=1.16u
    I_MXI60_I0_MP0 (VDD aa6 I60_gn0 VDD) gpdk090_pmos1v w=0.24u l=0.1u ad=0.0816p as=0.0528p pd=1.16u ps=0.68u
    I_MXI72_I1_MP1 (I72_gn1 b2_1 VDD VDD) gpdk090_pmos1v w=0.24u l=0.1u ad=0.0528p as=0.0816p pd=0.68u ps=1.16u
    I_MXI72_I1_MP0 (VDD p1_0 I72_gn1 VDD) gpdk090_pmos1v w=0.24u l=0.1u ad=0.0816p as=0.0528p pd=1.16u ps=0.68u
    I_MXI84_I3_MP1 (I84_gn3 b3_3 VDD VDD) gpdk090_pmos1v w=0.24u l=0.1u ad=0.0528p as=0.0816p pd=0.68u ps=1.16u
    I_MXI84_I3_MP0 (VDD p2_2 I84_gn3 VDD) gpdk090_pmos1v w=0.24u l=0.1u ad=0.0816p as=0.0528p pd=1.16u ps=0.68u
    I_MXI84_I4_MP1 (I84_gn4 b3_4 VDD VDD) gpdk090_pmos1v w=0.24u l=0.1u ad=0.0528p as=0.0816p pd=0.68u ps=1.16u
    I_MXI84_I4_MP0 (VDD p2_3 I84_gn4 VDD) gpdk090_pmos1v w=0.24u l=0.1u ad=0.0816p as=0.0528p pd=1.16u ps=0.68u
    I_MXI84_I31_XP_MP1 (I84_P7_4n I84_P5_4 VDD VDD) gpdk090_pmos1v w=0.24u l=0.1u ad=0.0528p as=0.0816p pd=0.68u ps=1.16u
    I_MXI84_I31_XP_MP0 (VDD I84_P7_6 I84_P7_4n VDD) gpdk090_pmos1v w=0.24u l=0.1u ad=0.0816p as=0.0528p pd=1.16u ps=0.68u
    I_MXI48_I3_MP1 (I48_gn3 b0_3 VDD VDD) gpdk090_pmos1v w=0.24u l=0.1u ad=0.0528p as=0.0816p pd=0.68u ps=1.16u
    I_MXI48_I3_MP0 (VDD VSS I48_gn3 VDD) gpdk090_pmos1v w=0.24u l=0.1u ad=0.0816p as=0.0528p pd=1.16u ps=0.68u
    I_MXI48_I2_MP1 (I48_gn2 b0_2 VDD VDD) gpdk090_pmos1v w=0.24u l=0.1u ad=0.0528p as=0.0816p pd=0.68u ps=1.16u
    I_MXI48_I2_MP0 (VDD VSS I48_gn2 VDD) gpdk090_pmos1v w=0.24u l=0.1u ad=0.0816p as=0.0528p pd=1.16u ps=0.68u
    I_MXI48_I1_MP1 (I48_gn1 b0_1 VDD VDD) gpdk090_pmos1v w=0.24u l=0.1u ad=0.0528p as=0.0816p pd=0.68u ps=1.16u
    I_MXI48_I1_MP0 (VDD VSS I48_gn1 VDD) gpdk090_pmos1v w=0.24u l=0.1u ad=0.0816p as=0.0528p pd=1.16u ps=0.68u
    I_MXI60_I1_MP1 (I60_gn1 b1_1 VDD VDD) gpdk090_pmos1v w=0.24u l=0.1u ad=0.0528p as=0.0816p pd=0.68u ps=1.16u
    I_MXI60_I1_MP0 (VDD p0_0 I60_gn1 VDD) gpdk090_pmos1v w=0.24u l=0.1u ad=0.0816p as=0.0528p pd=1.16u ps=0.68u
    I_MXI72_I2_MP1 (I72_gn2 b2_2 VDD VDD) gpdk090_pmos1v w=0.24u l=0.1u ad=0.0528p as=0.0816p pd=0.68u ps=1.16u
    I_MXI72_I2_MP0 (VDD p1_1 I72_gn2 VDD) gpdk090_pmos1v w=0.24u l=0.1u ad=0.0816p as=0.0528p pd=1.16u ps=0.68u
    I_MXI84_I5_MP1 (I84_gn5 b3_5 VDD VDD) gpdk090_pmos1v w=0.24u l=0.1u ad=0.0528p as=0.0816p pd=0.68u ps=1.16u
    I_MXI84_I5_MP0 (VDD p2_4 I84_gn5 VDD) gpdk090_pmos1v w=0.24u l=0.1u ad=0.0816p as=0.0528p pd=1.16u ps=0.68u
    I_MXI48_I4_MP1 (I48_gn4 b0_4 VDD VDD) gpdk090_pmos1v w=0.24u l=0.1u ad=0.0528p as=0.0816p pd=0.68u ps=1.16u
    I_MXI48_I4_MP0 (VDD VSS I48_gn4 VDD) gpdk090_pmos1v w=0.24u l=0.1u ad=0.0816p as=0.0528p pd=1.16u ps=0.68u
    I_MXI48_I28_XP_MP1 (I48_P4_1n I48_P2_1 VDD VDD) gpdk090_pmos1v w=0.24u l=0.1u ad=0.0528p as=0.0816p pd=0.68u ps=1.16u
    I_MXI48_I28_XP_MP0 (VDD I48_P4_3 I48_P4_1n VDD) gpdk090_pmos1v w=0.24u l=0.1u ad=0.0816p as=0.0528p pd=1.16u ps=0.68u
    I_MXI60_I3_MP1 (I60_gn3 b1_3 VDD VDD) gpdk090_pmos1v w=0.24u l=0.1u ad=0.0528p as=0.0816p pd=0.68u ps=1.16u
    I_MXI60_I3_MP0 (VDD p0_2 I60_gn3 VDD) gpdk090_pmos1v w=0.24u l=0.1u ad=0.0816p as=0.0528p pd=1.16u ps=0.68u
    I_MXI60_I2_MP1 (I60_gn2 b1_2 VDD VDD) gpdk090_pmos1v w=0.24u l=0.1u ad=0.0528p as=0.0816p pd=0.68u ps=1.16u
    I_MXI60_I2_MP0 (VDD p0_1 I60_gn2 VDD) gpdk090_pmos1v w=0.24u l=0.1u ad=0.0816p as=0.0528p pd=1.16u ps=0.68u
    I_MXI72_I3_MP1 (I72_gn3 b2_3 VDD VDD) gpdk090_pmos1v w=0.24u l=0.1u ad=0.0528p as=0.0816p pd=0.68u ps=1.16u
    I_MXI72_I3_MP0 (VDD p1_2 I72_gn3 VDD) gpdk090_pmos1v w=0.24u l=0.1u ad=0.0816p as=0.0528p pd=1.16u ps=0.68u
    I_MXI72_I28_XP_MP1 (I72_P4_1n I72_P2_1 VDD VDD) gpdk090_pmos1v w=0.24u l=0.1u ad=0.0528p as=0.0816p pd=0.68u ps=1.16u
    I_MXI72_I28_XP_MP0 (VDD I72_P4_3 I72_P4_1n VDD) gpdk090_pmos1v w=0.24u l=0.1u ad=0.0816p as=0.0528p pd=1.16u ps=0.68u
    I_MXI84_I6_MP1 (I84_gn6 b3_6 VDD VDD) gpdk090_pmos1v w=0.24u l=0.1u ad=0.0528p as=0.0816p pd=0.68u ps=1.16u
    I_MXI84_I6_MP0 (VDD p2_5 I84_gn6 VDD) gpdk090_pmos1v w=0.24u l=0.1u ad=0.0816p as=0.0528p pd=1.16u ps=0.68u
    I_MXI48_I5_MP1 (I48_gn5 b0_5 VDD VDD) gpdk090_pmos1v w=0.24u l=0.1u ad=0.0528p as=0.0816p pd=0.68u ps=1.16u
    I_MXI48_I5_MP0 (VDD VSS I48_gn5 VDD) gpdk090_pmos1v w=0.24u l=0.1u ad=0.0816p as=0.0528p pd=1.16u ps=0.68u
    I_MXI48_I30_XP_MP1 (I48_P6_3n I48_P4_3 VDD VDD) gpdk090_pmos1v w=0.24u l=0.1u ad=0.0528p as=0.0816p pd=0.68u ps=1.16u
    I_MXI48_I30_XP_MP0 (VDD I48_P6_5 I48_P6_3n VDD) gpdk090_pmos1v w=0.24u l=0.1u ad=0.0816p as=0.0528p pd=1.16u ps=0.68u
    I_MXI48_I29_XP_MP1 (I48_P5_2n I48_P3_2 VDD VDD) gpdk090_pmos1v w=0.24u l=0.1u ad=0.0528p as=0.0816p pd=0.68u ps=1.16u
    I_MXI48_I29_XP_MP0 (VDD I48_P5_4 I48_P5_2n VDD) gpdk090_pmos1v w=0.24u l=0.1u ad=0.0816p as=0.0528p pd=1.16u ps=0.68u
    I_MXI60_I4_MP1 (I60_gn4 b1_4 VDD VDD) gpdk090_pmos1v w=0.24u l=0.1u ad=0.0528p as=0.0816p pd=0.68u ps=1.16u
    I_MXI60_I4_MP0 (VDD p0_3 I60_gn4 VDD) gpdk090_pmos1v w=0.24u l=0.1u ad=0.0816p as=0.0528p pd=1.16u ps=0.68u
    I_MXI60_I28_XP_MP1 (I60_P4_1n I60_P2_1 VDD VDD) gpdk090_pmos1v w=0.24u l=0.1u ad=0.0528p as=0.0816p pd=0.68u ps=1.16u
    I_MXI60_I28_XP_MP0 (VDD I60_P4_3 I60_P4_1n VDD) gpdk090_pmos1v w=0.24u l=0.1u ad=0.0816p as=0.0528p pd=1.16u ps=0.68u
    I_MXI72_I4_MP1 (I72_gn4 b2_4 VDD VDD) gpdk090_pmos1v w=0.24u l=0.1u ad=0.0528p as=0.0816p pd=0.68u ps=1.16u
    I_MXI72_I4_MP0 (VDD p1_3 I72_gn4 VDD) gpdk090_pmos1v w=0.24u l=0.1u ad=0.0816p as=0.0528p pd=1.16u ps=0.68u
    I_MXI72_I30_XP_MP1 (I72_P6_3n I72_P4_3 VDD VDD) gpdk090_pmos1v w=0.24u l=0.1u ad=0.0528p as=0.0816p pd=0.68u ps=1.16u
    I_MXI72_I30_XP_MP0 (VDD I72_P6_5 I72_P6_3n VDD) gpdk090_pmos1v w=0.24u l=0.1u ad=0.0816p as=0.0528p pd=1.16u ps=0.68u
    I_MXI72_I29_XP_MP1 (I72_P5_2n I72_P3_2 VDD VDD) gpdk090_pmos1v w=0.24u l=0.1u ad=0.0528p as=0.0816p pd=0.68u ps=1.16u
    I_MXI72_I29_XP_MP0 (VDD I72_P5_4 I72_P5_2n VDD) gpdk090_pmos1v w=0.24u l=0.1u ad=0.0816p as=0.0528p pd=1.16u ps=0.68u
    I_MXI84_I7_MP1 (I84_gn7 b3_7 VDD VDD) gpdk090_pmos1v w=0.24u l=0.1u ad=0.0528p as=0.0816p pd=0.68u ps=1.16u
    I_MXI84_I7_MP0 (VDD p2_6 I84_gn7 VDD) gpdk090_pmos1v w=0.24u l=0.1u ad=0.0816p as=0.0528p pd=1.16u ps=0.68u
    I_MXI48_I6_MP1 (I48_gn6 b0_6 VDD VDD) gpdk090_pmos1v w=0.24u l=0.1u ad=0.0528p as=0.0816p pd=0.68u ps=1.16u
    I_MXI48_I6_MP0 (VDD VSS I48_gn6 VDD) gpdk090_pmos1v w=0.24u l=0.1u ad=0.0816p as=0.0528p pd=1.16u ps=0.68u
    I_MXI48_I31_XP_MP1 (I48_P7_4n I48_P5_4 VDD VDD) gpdk090_pmos1v w=0.24u l=0.1u ad=0.0528p as=0.0816p pd=0.68u ps=1.16u
    I_MXI48_I31_XP_MP0 (VDD I48_P7_6 I48_P7_4n VDD) gpdk090_pmos1v w=0.24u l=0.1u ad=0.0816p as=0.0528p pd=1.16u ps=0.68u
    I_MXI60_I6_MP1 (I60_gn6 b1_6 VDD VDD) gpdk090_pmos1v w=0.24u l=0.1u ad=0.0528p as=0.0816p pd=0.68u ps=1.16u
    I_MXI60_I6_MP0 (VDD p0_5 I60_gn6 VDD) gpdk090_pmos1v w=0.24u l=0.1u ad=0.0816p as=0.0528p pd=1.16u ps=0.68u
    I_MXI60_I5_MP1 (I60_gn5 b1_5 VDD VDD) gpdk090_pmos1v w=0.24u l=0.1u ad=0.0528p as=0.0816p pd=0.68u ps=1.16u
    I_MXI60_I5_MP0 (VDD p0_4 I60_gn5 VDD) gpdk090_pmos1v w=0.24u l=0.1u ad=0.0816p as=0.0528p pd=1.16u ps=0.68u
    I_MXI60_I29_XP_MP1 (I60_P5_2n I60_P3_2 VDD VDD) gpdk090_pmos1v w=0.24u l=0.1u ad=0.0528p as=0.0816p pd=0.68u ps=1.16u
    I_MXI60_I29_XP_MP0 (VDD I60_P5_4 I60_P5_2n VDD) gpdk090_pmos1v w=0.24u l=0.1u ad=0.0816p as=0.0528p pd=1.16u ps=0.68u
    I_MXI60_I31_XP_MP1 (I60_P7_4n I60_P5_4 VDD VDD) gpdk090_pmos1v w=0.24u l=0.1u ad=0.0528p as=0.0816p pd=0.68u ps=1.16u
    I_MXI60_I31_XP_MP0 (VDD I60_P7_6 I60_P7_4n VDD) gpdk090_pmos1v w=0.24u l=0.1u ad=0.0816p as=0.0528p pd=1.16u ps=0.68u
    I_MXI60_I30_XP_MP1 (I60_P6_3n I60_P4_3 VDD VDD) gpdk090_pmos1v w=0.24u l=0.1u ad=0.0528p as=0.0816p pd=0.68u ps=1.16u
    I_MXI60_I30_XP_MP0 (VDD I60_P6_5 I60_P6_3n VDD) gpdk090_pmos1v w=0.24u l=0.1u ad=0.0816p as=0.0528p pd=1.16u ps=0.68u
    I_MXI72_I5_MP1 (I72_gn5 b2_5 VDD VDD) gpdk090_pmos1v w=0.24u l=0.1u ad=0.0528p as=0.0816p pd=0.68u ps=1.16u
    I_MXI72_I5_MP0 (VDD p1_4 I72_gn5 VDD) gpdk090_pmos1v w=0.24u l=0.1u ad=0.0816p as=0.0528p pd=1.16u ps=0.68u
    I_MXI48_I7_MP1 (I48_gn7 b0_7 VDD VDD) gpdk090_pmos1v w=0.24u l=0.1u ad=0.0528p as=0.0816p pd=0.68u ps=1.16u
    I_MXI48_I7_MP0 (VDD VSS I48_gn7 VDD) gpdk090_pmos1v w=0.24u l=0.1u ad=0.0816p as=0.0528p pd=1.16u ps=0.68u
    I_MXI60_I7_MP1 (I60_gn7 b1_7 VDD VDD) gpdk090_pmos1v w=0.24u l=0.1u ad=0.0528p as=0.0816p pd=0.68u ps=1.16u
    I_MXI60_I7_MP0 (VDD p0_6 I60_gn7 VDD) gpdk090_pmos1v w=0.24u l=0.1u ad=0.0816p as=0.0528p pd=1.16u ps=0.68u
    I_MXI72_I6_MP1 (I72_gn6 b2_6 VDD VDD) gpdk090_pmos1v w=0.24u l=0.1u ad=0.0528p as=0.0816p pd=0.68u ps=1.16u
    I_MXI72_I6_MP0 (VDD p1_5 I72_gn6 VDD) gpdk090_pmos1v w=0.24u l=0.1u ad=0.0816p as=0.0528p pd=1.16u ps=0.68u
    I_MXI72_I7_MP1 (I72_gn7 b2_7 VDD VDD) gpdk090_pmos1v w=0.24u l=0.1u ad=0.0528p as=0.0816p pd=0.68u ps=1.16u
    I_MXI72_I7_MP0 (VDD p1_6 I72_gn7 VDD) gpdk090_pmos1v w=0.24u l=0.1u ad=0.0816p as=0.0528p pd=1.16u ps=0.68u
    I_MXI72_I31_XP_MP1 (I72_P7_4n I72_P5_4 VDD VDD) gpdk090_pmos1v w=0.24u l=0.1u ad=0.0528p as=0.0816p pd=0.68u ps=1.16u
    I_MXI72_I31_XP_MP0 (VDD I72_P7_6 I72_P7_4n VDD) gpdk090_pmos1v w=0.24u l=0.1u ad=0.0816p as=0.0528p pd=1.16u ps=0.68u
    I_MXI120_I25_XP_MP0 (XI120_I25_XP_p1 I120_pn7 VDD VDD) gpdk090_pmos1v w=0.48u l=0.1u ad=0.1056p as=0.1632p pd=0.92u ps=1.64u
    I_MXI120_I25_XP_MP1 (I120_P7_6 I120_pn6 XI120_I25_XP_p1 VDD) gpdk090_pmos1v w=0.48u l=0.1u ad=0.1632p as=0.1056p pd=1.64u ps=0.92u
    I_MXI108_I25_XP_MP0 (XI108_I25_XP_p1 I108_pn7 VDD VDD) gpdk090_pmos1v w=0.48u l=0.1u ad=0.1056p as=0.1632p pd=0.92u ps=1.64u
    I_MXI108_I25_XP_MP1 (I108_P7_6 I108_pn6 XI108_I25_XP_p1 VDD) gpdk090_pmos1v w=0.48u l=0.1u ad=0.1632p as=0.1056p pd=1.64u ps=0.92u
    I_MXI120_I24_XP_MP0 (XI120_I24_XP_p1 I120_pn6 VDD VDD) gpdk090_pmos1v w=0.48u l=0.1u ad=0.1056p as=0.1632p pd=0.92u ps=1.64u
    I_MXI120_I24_XP_MP1 (I120_P6_5 I120_pn5 XI120_I24_XP_p1 VDD) gpdk090_pmos1v w=0.48u l=0.1u ad=0.1632p as=0.1056p pd=1.64u ps=0.92u
    I_MXI120_I23_XP_MP0 (XI120_I23_XP_p1 I120_pn5 VDD VDD) gpdk090_pmos1v w=0.48u l=0.1u ad=0.1056p as=0.1632p pd=0.92u ps=1.64u
    I_MXI120_I23_XP_MP1 (I120_P5_4 I120_pn4 XI120_I23_XP_p1 VDD) gpdk090_pmos1v w=0.48u l=0.1u ad=0.1632p as=0.1056p pd=1.64u ps=0.92u
    I_MXI108_I24_XP_MP0 (XI108_I24_XP_p1 I108_pn6 VDD VDD) gpdk090_pmos1v w=0.48u l=0.1u ad=0.1056p as=0.1632p pd=0.92u ps=1.64u
    I_MXI108_I24_XP_MP1 (I108_P6_5 I108_pn5 XI108_I24_XP_p1 VDD) gpdk090_pmos1v w=0.48u l=0.1u ad=0.1632p as=0.1056p pd=1.64u ps=0.92u
    I_MXI108_I23_XP_MP0 (XI108_I23_XP_p1 I108_pn5 VDD VDD) gpdk090_pmos1v w=0.48u l=0.1u ad=0.1056p as=0.1632p pd=0.92u ps=1.64u
    I_MXI108_I23_XP_MP1 (I108_P5_4 I108_pn4 XI108_I23_XP_p1 VDD) gpdk090_pmos1v w=0.48u l=0.1u ad=0.1632p as=0.1056p pd=1.64u ps=0.92u
    I_MXI132_I25_XP_MP0 (XI132_I25_XP_p1 I132_pn7 VDD VDD) gpdk090_pmos1v w=0.48u l=0.1u ad=0.1056p as=0.1632p pd=0.92u ps=1.64u
    I_MXI132_I25_XP_MP1 (I132_P7_6 I132_pn6 XI132_I25_XP_p1 VDD) gpdk090_pmos1v w=0.48u l=0.1u ad=0.1632p as=0.1056p pd=1.64u ps=0.92u
    I_MXI132_I23_XP_MP0 (XI132_I23_XP_p1 I132_pn5 VDD VDD) gpdk090_pmos1v w=0.48u l=0.1u ad=0.1056p as=0.1632p pd=0.92u ps=1.64u
    I_MXI132_I23_XP_MP1 (I132_P5_4 I132_pn4 XI132_I23_XP_p1 VDD) gpdk090_pmos1v w=0.48u l=0.1u ad=0.1632p as=0.1056p pd=1.64u ps=0.92u
    I_MXI132_I24_XP_MP0 (XI132_I24_XP_p1 I132_pn6 VDD VDD) gpdk090_pmos1v w=0.48u l=0.1u ad=0.1056p as=0.1632p pd=0.92u ps=1.64u
    I_MXI132_I24_XP_MP1 (I132_P6_5 I132_pn5 XI132_I24_XP_p1 VDD) gpdk090_pmos1v w=0.48u l=0.1u ad=0.1632p as=0.1056p pd=1.64u ps=0.92u
    I_MXI120_I20_XP_MP0 (XI120_I20_XP_p1 I120_pn2 VDD VDD) gpdk090_pmos1v w=0.48u l=0.1u ad=0.1056p as=0.1632p pd=0.92u ps=1.64u
    I_MXI120_I20_XP_MP1 (I120_P2_1 I120_pn1 XI120_I20_XP_p1 VDD) gpdk090_pmos1v w=0.48u l=0.1u ad=0.1632p as=0.1056p pd=1.64u ps=0.92u
    I_MXI120_I22_XP_MP0 (XI120_I22_XP_p1 I120_pn4 VDD VDD) gpdk090_pmos1v w=0.48u l=0.1u ad=0.1056p as=0.1632p pd=0.92u ps=1.64u
    I_MXI120_I22_XP_MP1 (I120_P4_3 I120_pn3 XI120_I22_XP_p1 VDD) gpdk090_pmos1v w=0.48u l=0.1u ad=0.1632p as=0.1056p pd=1.64u ps=0.92u
    I_MXI120_I21_XP_MP0 (XI120_I21_XP_p1 I120_pn3 VDD VDD) gpdk090_pmos1v w=0.48u l=0.1u ad=0.1056p as=0.1632p pd=0.92u ps=1.64u
    I_MXI120_I21_XP_MP1 (I120_P3_2 I120_pn2 XI120_I21_XP_p1 VDD) gpdk090_pmos1v w=0.48u l=0.1u ad=0.1632p as=0.1056p pd=1.64u ps=0.92u
    I_MXI108_I20_XP_MP0 (XI108_I20_XP_p1 I108_pn2 VDD VDD) gpdk090_pmos1v w=0.48u l=0.1u ad=0.1056p as=0.1632p pd=0.92u ps=1.64u
    I_MXI108_I20_XP_MP1 (I108_P2_1 I108_pn1 XI108_I20_XP_p1 VDD) gpdk090_pmos1v w=0.48u l=0.1u ad=0.1632p as=0.1056p pd=1.64u ps=0.92u
    I_MXI108_I21_XP_MP0 (XI108_I21_XP_p1 I108_pn3 VDD VDD) gpdk090_pmos1v w=0.48u l=0.1u ad=0.1056p as=0.1632p pd=0.92u ps=1.64u
    I_MXI108_I21_XP_MP1 (I108_P3_2 I108_pn2 XI108_I21_XP_p1 VDD) gpdk090_pmos1v w=0.48u l=0.1u ad=0.1632p as=0.1056p pd=1.64u ps=0.92u
    I_MXI108_I22_XP_MP0 (XI108_I22_XP_p1 I108_pn4 VDD VDD) gpdk090_pmos1v w=0.48u l=0.1u ad=0.1056p as=0.1632p pd=0.92u ps=1.64u
    I_MXI108_I22_XP_MP1 (I108_P4_3 I108_pn3 XI108_I22_XP_p1 VDD) gpdk090_pmos1v w=0.48u l=0.1u ad=0.1632p as=0.1056p pd=1.64u ps=0.92u
    I_MXI132_I21_XP_MP0 (XI132_I21_XP_p1 I132_pn3 VDD VDD) gpdk090_pmos1v w=0.48u l=0.1u ad=0.1056p as=0.1632p pd=0.92u ps=1.64u
    I_MXI132_I21_XP_MP1 (I132_P3_2 I132_pn2 XI132_I21_XP_p1 VDD) gpdk090_pmos1v w=0.48u l=0.1u ad=0.1632p as=0.1056p pd=1.64u ps=0.92u
    I_MXI132_I22_XP_MP0 (XI132_I22_XP_p1 I132_pn4 VDD VDD) gpdk090_pmos1v w=0.48u l=0.1u ad=0.1056p as=0.1632p pd=0.92u ps=1.64u
    I_MXI132_I22_XP_MP1 (I132_P4_3 I132_pn3 XI132_I22_XP_p1 VDD) gpdk090_pmos1v w=0.48u l=0.1u ad=0.1632p as=0.1056p pd=1.64u ps=0.92u
    I_MXI96_I21_XP_MP0 (XI96_I21_XP_p1 I96_pn3 VDD VDD) gpdk090_pmos1v w=0.48u l=0.1u ad=0.1056p as=0.1632p pd=0.92u ps=1.64u
    I_MXI96_I21_XP_MP1 (I96_P3_2 I96_pn2 XI96_I21_XP_p1 VDD) gpdk090_pmos1v w=0.48u l=0.1u ad=0.1632p as=0.1056p pd=1.64u ps=0.92u
    I_MXI96_I23_XP_MP0 (XI96_I23_XP_p1 I96_pn5 VDD VDD) gpdk090_pmos1v w=0.48u l=0.1u ad=0.1056p as=0.1632p pd=0.92u ps=1.64u
    I_MXI96_I23_XP_MP1 (I96_P5_4 I96_pn4 XI96_I23_XP_p1 VDD) gpdk090_pmos1v w=0.48u l=0.1u ad=0.1632p as=0.1056p pd=1.64u ps=0.92u
    I_MXI96_I20_XP_MP0 (XI96_I20_XP_p1 I96_pn2 VDD VDD) gpdk090_pmos1v w=0.48u l=0.1u ad=0.1056p as=0.1632p pd=0.92u ps=1.64u
    I_MXI96_I20_XP_MP1 (I96_P2_1 I96_pn1 XI96_I20_XP_p1 VDD) gpdk090_pmos1v w=0.48u l=0.1u ad=0.1632p as=0.1056p pd=1.64u ps=0.92u
    I_MXI96_I22_XP_MP0 (XI96_I22_XP_p1 I96_pn4 VDD VDD) gpdk090_pmos1v w=0.48u l=0.1u ad=0.1056p as=0.1632p pd=0.92u ps=1.64u
    I_MXI96_I22_XP_MP1 (I96_P4_3 I96_pn3 XI96_I22_XP_p1 VDD) gpdk090_pmos1v w=0.48u l=0.1u ad=0.1632p as=0.1056p pd=1.64u ps=0.92u
    I_MXI96_I25_XP_MP0 (XI96_I25_XP_p1 I96_pn7 VDD VDD) gpdk090_pmos1v w=0.48u l=0.1u ad=0.1056p as=0.1632p pd=0.92u ps=1.64u
    I_MXI96_I25_XP_MP1 (I96_P7_6 I96_pn6 XI96_I25_XP_p1 VDD) gpdk090_pmos1v w=0.48u l=0.1u ad=0.1632p as=0.1056p pd=1.64u ps=0.92u
    I_MXI132_I20_XP_MP0 (XI132_I20_XP_p1 I132_pn2 VDD VDD) gpdk090_pmos1v w=0.48u l=0.1u ad=0.1056p as=0.1632p pd=0.92u ps=1.64u
    I_MXI132_I20_XP_MP1 (I132_P2_1 I132_pn1 XI132_I20_XP_p1 VDD) gpdk090_pmos1v w=0.48u l=0.1u ad=0.1632p as=0.1056p pd=1.64u ps=0.92u
    I_MXI96_I24_XP_MP0 (XI96_I24_XP_p1 I96_pn6 VDD VDD) gpdk090_pmos1v w=0.48u l=0.1u ad=0.1056p as=0.1632p pd=0.92u ps=1.64u
    I_MXI96_I24_XP_MP1 (I96_P6_5 I96_pn5 XI96_I24_XP_p1 VDD) gpdk090_pmos1v w=0.48u l=0.1u ad=0.1632p as=0.1056p pd=1.64u ps=0.92u
    I_MXI152_I25_XP_MP0 (XI152_I25_XP_p1 I152_pn7 VDD VDD) gpdk090_pmos1v w=0.48u l=0.1u ad=0.1056p as=0.1632p pd=0.92u ps=1.64u
    I_MXI152_I25_XP_MP1 (I152_P7_6 I152_pn6 XI152_I25_XP_p1 VDD) gpdk090_pmos1v w=0.48u l=0.1u ad=0.1632p as=0.1056p pd=1.64u ps=0.92u
    I_MXI152_I23_XP_MP0 (XI152_I23_XP_p1 I152_pn5 VDD VDD) gpdk090_pmos1v w=0.48u l=0.1u ad=0.1056p as=0.1632p pd=0.92u ps=1.64u
    I_MXI152_I23_XP_MP1 (I152_P5_4 I152_pn4 XI152_I23_XP_p1 VDD) gpdk090_pmos1v w=0.48u l=0.1u ad=0.1632p as=0.1056p pd=1.64u ps=0.92u
    I_MXI152_I22_XP_MP0 (XI152_I22_XP_p1 I152_pn4 VDD VDD) gpdk090_pmos1v w=0.48u l=0.1u ad=0.1056p as=0.1632p pd=0.92u ps=1.64u
    I_MXI152_I22_XP_MP1 (I152_P4_3 I152_pn3 XI152_I22_XP_p1 VDD) gpdk090_pmos1v w=0.48u l=0.1u ad=0.1632p as=0.1056p pd=1.64u ps=0.92u
    I_MXI152_I21_XP_MP0 (XI152_I21_XP_p1 I152_pn3 VDD VDD) gpdk090_pmos1v w=0.48u l=0.1u ad=0.1056p as=0.1632p pd=0.92u ps=1.64u
    I_MXI152_I21_XP_MP1 (I152_P3_2 I152_pn2 XI152_I21_XP_p1 VDD) gpdk090_pmos1v w=0.48u l=0.1u ad=0.1632p as=0.1056p pd=1.64u ps=0.92u
    I_MXI152_I24_XP_MP0 (XI152_I24_XP_p1 I152_pn6 VDD VDD) gpdk090_pmos1v w=0.48u l=0.1u ad=0.1056p as=0.1632p pd=0.92u ps=1.64u
    I_MXI152_I24_XP_MP1 (I152_P6_5 I152_pn5 XI152_I24_XP_p1 VDD) gpdk090_pmos1v w=0.48u l=0.1u ad=0.1632p as=0.1056p pd=1.64u ps=0.92u
    I_MXI197_MP0 (XI197_p1 B_6 VDD VDD) gpdk090_pmos1v w=0.48u l=0.1u ad=0.1056p as=0.1632p pd=0.92u ps=1.64u
    I_MXI197_MP1 (z1_3 B_7 XI197_p1 VDD) gpdk090_pmos1v w=0.48u l=0.1u ad=0.1632p as=0.1056p pd=1.64u ps=0.92u
    I_MXI194_MP0 (XI194_p1 B_0 VDD VDD) gpdk090_pmos1v w=0.48u l=0.1u ad=0.1056p as=0.1632p pd=0.92u ps=1.64u
    I_MXI194_MP1 (z1_0 B_1 XI194_p1 VDD) gpdk090_pmos1v w=0.48u l=0.1u ad=0.1632p as=0.1056p pd=1.64u ps=0.92u
    I_MXI84_I22_XP_MP0 (XI84_I22_XP_p1 I84_pn4 VDD VDD) gpdk090_pmos1v w=0.48u l=0.1u ad=0.1056p as=0.1632p pd=0.92u ps=1.64u
    I_MXI84_I22_XP_MP1 (I84_P4_3 I84_pn3 XI84_I22_XP_p1 VDD) gpdk090_pmos1v w=0.48u l=0.1u ad=0.1632p as=0.1056p pd=1.64u ps=0.92u
    I_MXI84_I20_XP_MP0 (XI84_I20_XP_p1 I84_pn2 VDD VDD) gpdk090_pmos1v w=0.48u l=0.1u ad=0.1056p as=0.1632p pd=0.92u ps=1.64u
    I_MXI84_I20_XP_MP1 (I84_P2_1 I84_pn1 XI84_I20_XP_p1 VDD) gpdk090_pmos1v w=0.48u l=0.1u ad=0.1632p as=0.1056p pd=1.64u ps=0.92u
    I_MXI84_I24_XP_MP0 (XI84_I24_XP_p1 I84_pn6 VDD VDD) gpdk090_pmos1v w=0.48u l=0.1u ad=0.1056p as=0.1632p pd=0.92u ps=1.64u
    I_MXI84_I24_XP_MP1 (I84_P6_5 I84_pn5 XI84_I24_XP_p1 VDD) gpdk090_pmos1v w=0.48u l=0.1u ad=0.1632p as=0.1056p pd=1.64u ps=0.92u
    I_MXI152_I20_XP_MP0 (XI152_I20_XP_p1 I152_pn2 VDD VDD) gpdk090_pmos1v w=0.48u l=0.1u ad=0.1056p as=0.1632p pd=0.92u ps=1.64u
    I_MXI152_I20_XP_MP1 (I152_P2_1 I152_pn1 XI152_I20_XP_p1 VDD) gpdk090_pmos1v w=0.48u l=0.1u ad=0.1632p as=0.1056p pd=1.64u ps=0.92u
    I_MXI196_MP0 (XI196_p1 B_4 VDD VDD) gpdk090_pmos1v w=0.48u l=0.1u ad=0.1056p as=0.1632p pd=0.92u ps=1.64u
    I_MXI196_MP1 (z1_2 B_5 XI196_p1 VDD) gpdk090_pmos1v w=0.48u l=0.1u ad=0.1632p as=0.1056p pd=1.64u ps=0.92u
    I_MXI195_MP0 (XI195_p1 B_2 VDD VDD) gpdk090_pmos1v w=0.48u l=0.1u ad=0.1056p as=0.1632p pd=0.92u ps=1.64u
    I_MXI195_MP1 (z1_1 B_3 XI195_p1 VDD) gpdk090_pmos1v w=0.48u l=0.1u ad=0.1632p as=0.1056p pd=1.64u ps=0.92u
    I_MXI200_MP0 (XI200_p1 z2_0 VDD VDD) gpdk090_pmos1v w=0.48u l=0.1u ad=0.1056p as=0.1632p pd=0.92u ps=1.64u
    I_MXI200_MP1 (DZ z2_1 XI200_p1 VDD) gpdk090_pmos1v w=0.48u l=0.1u ad=0.1632p as=0.1056p pd=1.64u ps=0.92u
    I_MXI203_MP0 (XI203_p1 vn VDD VDD) gpdk090_pmos1v w=0.48u l=0.1u ad=0.1056p as=0.1632p pd=0.92u ps=1.64u
    I_MXI203_MP1 (V DZ XI203_p1 VDD) gpdk090_pmos1v w=0.48u l=0.1u ad=0.1632p as=0.1056p pd=1.64u ps=0.92u
    I_MXI84_I21_XP_MP0 (XI84_I21_XP_p1 I84_pn3 VDD VDD) gpdk090_pmos1v w=0.48u l=0.1u ad=0.1056p as=0.1632p pd=0.92u ps=1.64u
    I_MXI84_I21_XP_MP1 (I84_P3_2 I84_pn2 XI84_I21_XP_p1 VDD) gpdk090_pmos1v w=0.48u l=0.1u ad=0.1632p as=0.1056p pd=1.64u ps=0.92u
    I_MXI84_I23_XP_MP0 (XI84_I23_XP_p1 I84_pn5 VDD VDD) gpdk090_pmos1v w=0.48u l=0.1u ad=0.1056p as=0.1632p pd=0.92u ps=1.64u
    I_MXI84_I23_XP_MP1 (I84_P5_4 I84_pn4 XI84_I23_XP_p1 VDD) gpdk090_pmos1v w=0.48u l=0.1u ad=0.1632p as=0.1056p pd=1.64u ps=0.92u
    I_MXI84_I25_XP_MP0 (XI84_I25_XP_p1 I84_pn7 VDD VDD) gpdk090_pmos1v w=0.48u l=0.1u ad=0.1056p as=0.1632p pd=0.92u ps=1.64u
    I_MXI84_I25_XP_MP1 (I84_P7_6 I84_pn6 XI84_I25_XP_p1 VDD) gpdk090_pmos1v w=0.48u l=0.1u ad=0.1632p as=0.1056p pd=1.64u ps=0.92u
    I_MXI72_I20_XP_MP0 (XI72_I20_XP_p1 I72_pn2 VDD VDD) gpdk090_pmos1v w=0.48u l=0.1u ad=0.1056p as=0.1632p pd=0.92u ps=1.64u
    I_MXI72_I20_XP_MP1 (I72_P2_1 I72_pn1 XI72_I20_XP_p1 VDD) gpdk090_pmos1v w=0.48u l=0.1u ad=0.1632p as=0.1056p pd=1.64u ps=0.92u
    I_MXI48_I22_XP_MP0 (XI48_I22_XP_p1 I48_pn4 VDD VDD) gpdk090_pmos1v w=0.48u l=0.1u ad=0.1056p as=0.1632p pd=0.92u ps=1.64u
    I_MXI48_I22_XP_MP1 (I48_P4_3 I48_pn3 XI48_I22_XP_p1 VDD) gpdk090_pmos1v w=0.48u l=0.1u ad=0.1632p as=0.1056p pd=1.64u ps=0.92u
    I_MXI48_I20_XP_MP0 (XI48_I20_XP_p1 I48_pn2 VDD VDD) gpdk090_pmos1v w=0.48u l=0.1u ad=0.1056p as=0.1632p pd=0.92u ps=1.64u
    I_MXI48_I20_XP_MP1 (I48_P2_1 I48_pn1 XI48_I20_XP_p1 VDD) gpdk090_pmos1v w=0.48u l=0.1u ad=0.1632p as=0.1056p pd=1.64u ps=0.92u
    I_MXI60_I20_XP_MP0 (XI60_I20_XP_p1 I60_pn2 VDD VDD) gpdk090_pmos1v w=0.48u l=0.1u ad=0.1056p as=0.1632p pd=0.92u ps=1.64u
    I_MXI60_I20_XP_MP1 (I60_P2_1 I60_pn1 XI60_I20_XP_p1 VDD) gpdk090_pmos1v w=0.48u l=0.1u ad=0.1632p as=0.1056p pd=1.64u ps=0.92u
    I_MXI72_I21_XP_MP0 (XI72_I21_XP_p1 I72_pn3 VDD VDD) gpdk090_pmos1v w=0.48u l=0.1u ad=0.1056p as=0.1632p pd=0.92u ps=1.64u
    I_MXI72_I21_XP_MP1 (I72_P3_2 I72_pn2 XI72_I21_XP_p1 VDD) gpdk090_pmos1v w=0.48u l=0.1u ad=0.1632p as=0.1056p pd=1.64u ps=0.92u
    I_MXI72_I22_XP_MP0 (XI72_I22_XP_p1 I72_pn4 VDD VDD) gpdk090_pmos1v w=0.48u l=0.1u ad=0.1056p as=0.1632p pd=0.92u ps=1.64u
    I_MXI72_I22_XP_MP1 (I72_P4_3 I72_pn3 XI72_I22_XP_p1 VDD) gpdk090_pmos1v w=0.48u l=0.1u ad=0.1632p as=0.1056p pd=1.64u ps=0.92u
    I_MXI48_I24_XP_MP0 (XI48_I24_XP_p1 I48_pn6 VDD VDD) gpdk090_pmos1v w=0.48u l=0.1u ad=0.1056p as=0.1632p pd=0.92u ps=1.64u
    I_MXI48_I24_XP_MP1 (I48_P6_5 I48_pn5 XI48_I24_XP_p1 VDD) gpdk090_pmos1v w=0.48u l=0.1u ad=0.1632p as=0.1056p pd=1.64u ps=0.92u
    I_MXI48_I21_XP_MP0 (XI48_I21_XP_p1 I48_pn3 VDD VDD) gpdk090_pmos1v w=0.48u l=0.1u ad=0.1056p as=0.1632p pd=0.92u ps=1.64u
    I_MXI48_I21_XP_MP1 (I48_P3_2 I48_pn2 XI48_I21_XP_p1 VDD) gpdk090_pmos1v w=0.48u l=0.1u ad=0.1632p as=0.1056p pd=1.64u ps=0.92u
    I_MXI48_I23_XP_MP0 (XI48_I23_XP_p1 I48_pn5 VDD VDD) gpdk090_pmos1v w=0.48u l=0.1u ad=0.1056p as=0.1632p pd=0.92u ps=1.64u
    I_MXI48_I23_XP_MP1 (I48_P5_4 I48_pn4 XI48_I23_XP_p1 VDD) gpdk090_pmos1v w=0.48u l=0.1u ad=0.1632p as=0.1056p pd=1.64u ps=0.92u
    I_MXI60_I21_XP_MP0 (XI60_I21_XP_p1 I60_pn3 VDD VDD) gpdk090_pmos1v w=0.48u l=0.1u ad=0.1056p as=0.1632p pd=0.92u ps=1.64u
    I_MXI60_I21_XP_MP1 (I60_P3_2 I60_pn2 XI60_I21_XP_p1 VDD) gpdk090_pmos1v w=0.48u l=0.1u ad=0.1632p as=0.1056p pd=1.64u ps=0.92u
    I_MXI60_I22_XP_MP0 (XI60_I22_XP_p1 I60_pn4 VDD VDD) gpdk090_pmos1v w=0.48u l=0.1u ad=0.1056p as=0.1632p pd=0.92u ps=1.64u
    I_MXI60_I22_XP_MP1 (I60_P4_3 I60_pn3 XI60_I22_XP_p1 VDD) gpdk090_pmos1v w=0.48u l=0.1u ad=0.1632p as=0.1056p pd=1.64u ps=0.92u
    I_MXI72_I23_XP_MP0 (XI72_I23_XP_p1 I72_pn5 VDD VDD) gpdk090_pmos1v w=0.48u l=0.1u ad=0.1056p as=0.1632p pd=0.92u ps=1.64u
    I_MXI72_I23_XP_MP1 (I72_P5_4 I72_pn4 XI72_I23_XP_p1 VDD) gpdk090_pmos1v w=0.48u l=0.1u ad=0.1632p as=0.1056p pd=1.64u ps=0.92u
    I_MXI48_I25_XP_MP0 (XI48_I25_XP_p1 I48_pn7 VDD VDD) gpdk090_pmos1v w=0.48u l=0.1u ad=0.1056p as=0.1632p pd=0.92u ps=1.64u
    I_MXI48_I25_XP_MP1 (I48_P7_6 I48_pn6 XI48_I25_XP_p1 VDD) gpdk090_pmos1v w=0.48u l=0.1u ad=0.1632p as=0.1056p pd=1.64u ps=0.92u
    I_MXI60_I23_XP_MP0 (XI60_I23_XP_p1 I60_pn5 VDD VDD) gpdk090_pmos1v w=0.48u l=0.1u ad=0.1056p as=0.1632p pd=0.92u ps=1.64u
    I_MXI60_I23_XP_MP1 (I60_P5_4 I60_pn4 XI60_I23_XP_p1 VDD) gpdk090_pmos1v w=0.48u l=0.1u ad=0.1632p as=0.1056p pd=1.64u ps=0.92u
    I_MXI60_I24_XP_MP0 (XI60_I24_XP_p1 I60_pn6 VDD VDD) gpdk090_pmos1v w=0.48u l=0.1u ad=0.1056p as=0.1632p pd=0.92u ps=1.64u
    I_MXI60_I24_XP_MP1 (I60_P6_5 I60_pn5 XI60_I24_XP_p1 VDD) gpdk090_pmos1v w=0.48u l=0.1u ad=0.1632p as=0.1056p pd=1.64u ps=0.92u
    I_MXI72_I24_XP_MP0 (XI72_I24_XP_p1 I72_pn6 VDD VDD) gpdk090_pmos1v w=0.48u l=0.1u ad=0.1056p as=0.1632p pd=0.92u ps=1.64u
    I_MXI72_I24_XP_MP1 (I72_P6_5 I72_pn5 XI72_I24_XP_p1 VDD) gpdk090_pmos1v w=0.48u l=0.1u ad=0.1632p as=0.1056p pd=1.64u ps=0.92u
    I_MXI72_I25_XP_MP0 (XI72_I25_XP_p1 I72_pn7 VDD VDD) gpdk090_pmos1v w=0.48u l=0.1u ad=0.1056p as=0.1632p pd=0.92u ps=1.64u
    I_MXI72_I25_XP_MP1 (I72_P7_6 I72_pn6 XI72_I25_XP_p1 VDD) gpdk090_pmos1v w=0.48u l=0.1u ad=0.1632p as=0.1056p pd=1.64u ps=0.92u
    I_MXI60_I25_XP_MP0 (XI60_I25_XP_p1 I60_pn7 VDD VDD) gpdk090_pmos1v w=0.48u l=0.1u ad=0.1056p as=0.1632p pd=0.92u ps=1.64u
    I_MXI60_I25_XP_MP1 (I60_P7_6 I60_pn6 XI60_I25_XP_p1 VDD) gpdk090_pmos1v w=0.48u l=0.1u ad=0.1632p as=0.1056p pd=1.64u ps=0.92u
    I_MXI108_I33_MP0 (I108_G1_0n I108_G1_0 VDD VDD) gpdk090_pmos1v w=0.24u l=0.1u ad=0.0816p as=0.0816p pd=1.16u ps=1.16u
    I_MXI120_I33_MP0 (I120_G1_0n I120_G1_0 VDD VDD) gpdk090_pmos1v w=0.24u l=0.1u ad=0.0816p as=0.0816p pd=1.16u ps=1.16u
    I_MXI132_I33_MP0 (I132_G1_0n I132_G1_0 VDD VDD) gpdk090_pmos1v w=0.24u l=0.1u ad=0.0816p as=0.0816p pd=1.16u ps=1.16u
    I_MXI120_I18_MP0 (I120_G0_0n I120_G0_0 VDD VDD) gpdk090_pmos1v w=0.24u l=0.1u ad=0.0816p as=0.0816p pd=1.16u ps=1.16u
    I_MXI108_I18_MP0 (I108_G0_0n I108_G0_0 VDD VDD) gpdk090_pmos1v w=0.24u l=0.1u ad=0.0816p as=0.0816p pd=1.16u ps=1.16u
    I_MXI96_I33_MP0 (I96_G1_0n I96_G1_0 VDD VDD) gpdk090_pmos1v w=0.24u l=0.1u ad=0.0816p as=0.0816p pd=1.16u ps=1.16u
    I_MXI149_MP0 (dm6 dmn6 VDD VDD) gpdk090_pmos1v w=0.24u l=0.1u ad=0.0816p as=0.0816p pd=1.16u ps=1.16u
    I_MXI151_MP0 (dm7 dmn7 VDD VDD) gpdk090_pmos1v w=0.24u l=0.1u ad=0.0816p as=0.0816p pd=1.16u ps=1.16u
    I_MXI120_I16_MP0 (I120_cinn qu2 VDD VDD) gpdk090_pmos1v w=0.24u l=0.1u ad=0.0816p as=0.0816p pd=1.16u ps=1.16u
    I_MXI108_I16_MP0 (I108_cinn qu3 VDD VDD) gpdk090_pmos1v w=0.24u l=0.1u ad=0.0816p as=0.0816p pd=1.16u ps=1.16u
    I_MXI96_I18_MP0 (I96_G0_0n I96_G0_0 VDD VDD) gpdk090_pmos1v w=0.24u l=0.1u ad=0.0816p as=0.0816p pd=1.16u ps=1.16u
    I_MXI147_MP0 (dm5 dmn5 VDD VDD) gpdk090_pmos1v w=0.24u l=0.1u ad=0.0816p as=0.0816p pd=1.16u ps=1.16u
    I_MXI145_MP0 (dm4 dmn4 VDD VDD) gpdk090_pmos1v w=0.24u l=0.1u ad=0.0816p as=0.0816p pd=1.16u ps=1.16u
    I_MXI132_I18_MP0 (I132_G0_0n I132_G0_0 VDD VDD) gpdk090_pmos1v w=0.24u l=0.1u ad=0.0816p as=0.0816p pd=1.16u ps=1.16u
    I_MXI132_I16_MP0 (I132_cinn qu1 VDD VDD) gpdk090_pmos1v w=0.24u l=0.1u ad=0.0816p as=0.0816p pd=1.16u ps=1.16u
    I_MXI5_MP0 (nak2 nakn2 VDD VDD) gpdk090_pmos1v w=0.24u l=0.1u ad=0.0816p as=0.0816p pd=1.16u ps=1.16u
    I_MXI96_I16_MP0 (I96_cinn qu4 VDD VDD) gpdk090_pmos1v w=0.24u l=0.1u ad=0.0816p as=0.0816p pd=1.16u ps=1.16u
    I_MXI143_MP0 (dm3 dmn3 VDD VDD) gpdk090_pmos1v w=0.24u l=0.1u ad=0.0816p as=0.0816p pd=1.16u ps=1.16u
    I_MXI2_MP0 (nak1 nakn1 VDD VDD) gpdk090_pmos1v w=0.24u l=0.1u ad=0.0816p as=0.0816p pd=1.16u ps=1.16u
    I_MXI8_MP0 (nak3 nakn3 VDD VDD) gpdk090_pmos1v w=0.24u l=0.1u ad=0.0816p as=0.0816p pd=1.16u ps=1.16u
    I_MXI11_MP0 (nak4 nakn4 VDD VDD) gpdk090_pmos1v w=0.24u l=0.1u ad=0.0816p as=0.0816p pd=1.16u ps=1.16u
    I_MXI152_I33_MP0 (I152_G1_0n I152_G1_0 VDD VDD) gpdk090_pmos1v w=0.24u l=0.1u ad=0.0816p as=0.0816p pd=1.16u ps=1.16u
    I_MXI141_MP0 (dm2 dmn2 VDD VDD) gpdk090_pmos1v w=0.24u l=0.1u ad=0.0816p as=0.0816p pd=1.16u ps=1.16u
    I_MXI139_MP0 (dm1 dmn1 VDD VDD) gpdk090_pmos1v w=0.24u l=0.1u ad=0.0816p as=0.0816p pd=1.16u ps=1.16u
    I_MXI137_MP0 (dm0 dmn0 VDD VDD) gpdk090_pmos1v w=0.24u l=0.1u ad=0.0816p as=0.0816p pd=1.16u ps=1.16u
    I_MXI135_MP0 (Q_0 p7_8 VDD VDD) gpdk090_pmos1v w=0.24u l=0.1u ad=0.0816p as=0.0816p pd=1.16u ps=1.16u
    I_MXI156_MP0 (nqk1 nqkn1 VDD VDD) gpdk090_pmos1v w=0.24u l=0.1u ad=0.0816p as=0.0816p pd=1.16u ps=1.16u
    I_MXI159_MP0 (nqk2 nqkn2 VDD VDD) gpdk090_pmos1v w=0.24u l=0.1u ad=0.0816p as=0.0816p pd=1.16u ps=1.16u
    I_MXI162_MP0 (nqk3 nqkn3 VDD VDD) gpdk090_pmos1v w=0.24u l=0.1u ad=0.0816p as=0.0816p pd=1.16u ps=1.16u
    I_MXI165_MP0 (nqk4 nqkn4 VDD VDD) gpdk090_pmos1v w=0.24u l=0.1u ad=0.0816p as=0.0816p pd=1.16u ps=1.16u
    I_MXI168_MP0 (nqk5 nqkn5 VDD VDD) gpdk090_pmos1v w=0.24u l=0.1u ad=0.0816p as=0.0816p pd=1.16u ps=1.16u
    I_MXI84_I16_MP0 (I84_cinn qu5 VDD VDD) gpdk090_pmos1v w=0.24u l=0.1u ad=0.0816p as=0.0816p pd=1.16u ps=1.16u
    I_MXI84_I18_MP0 (I84_G0_0n I84_G0_0 VDD VDD) gpdk090_pmos1v w=0.24u l=0.1u ad=0.0816p as=0.0816p pd=1.16u ps=1.16u
    I_MXI152_I18_MP0 (I152_G0_0n I152_G0_0 VDD VDD) gpdk090_pmos1v w=0.24u l=0.1u ad=0.0816p as=0.0816p pd=1.16u ps=1.16u
    I_MXI152_I16_MP0 (I152_cinn VSS VDD VDD) gpdk090_pmos1v w=0.24u l=0.1u ad=0.0816p as=0.0816p pd=1.16u ps=1.16u
    I_MXI34_MP0 (nbk5 nbkn5 VDD VDD) gpdk090_pmos1v w=0.24u l=0.1u ad=0.0816p as=0.0816p pd=1.16u ps=1.16u
    I_MXI37_MP0 (nbk6 nbkn6 VDD VDD) gpdk090_pmos1v w=0.24u l=0.1u ad=0.0816p as=0.0816p pd=1.16u ps=1.16u
    I_MXI22_MP0 (nbk1 nbkn1 VDD VDD) gpdk090_pmos1v w=0.24u l=0.1u ad=0.0816p as=0.0816p pd=1.16u ps=1.16u
    I_MXI201_MP0 (sqn sq VDD VDD) gpdk090_pmos1v w=0.24u l=0.1u ad=0.0816p as=0.0816p pd=1.16u ps=1.16u
    I_MXI171_MP0 (nqk6 nqkn6 VDD VDD) gpdk090_pmos1v w=0.24u l=0.1u ad=0.0816p as=0.0816p pd=1.16u ps=1.16u
    I_MXI28_MP0 (nbk3 nbkn3 VDD VDD) gpdk090_pmos1v w=0.24u l=0.1u ad=0.0816p as=0.0816p pd=1.16u ps=1.16u
    I_MXI31_MP0 (nbk4 nbkn4 VDD VDD) gpdk090_pmos1v w=0.24u l=0.1u ad=0.0816p as=0.0816p pd=1.16u ps=1.16u
    I_MXI17_MP0 (nak6 nakn6 VDD VDD) gpdk090_pmos1v w=0.24u l=0.1u ad=0.0816p as=0.0816p pd=1.16u ps=1.16u
    I_MXI14_MP0 (nak5 nakn5 VDD VDD) gpdk090_pmos1v w=0.24u l=0.1u ad=0.0816p as=0.0816p pd=1.16u ps=1.16u
    I_MXI72_I16_MP0 (I72_cinn qu6 VDD VDD) gpdk090_pmos1v w=0.24u l=0.1u ad=0.0816p as=0.0816p pd=1.16u ps=1.16u
    I_MXI84_I33_MP0 (I84_G1_0n I84_G1_0 VDD VDD) gpdk090_pmos1v w=0.24u l=0.1u ad=0.0816p as=0.0816p pd=1.16u ps=1.16u
    I_MXI191_MP0 (nrk6 nrkn6 VDD VDD) gpdk090_pmos1v w=0.24u l=0.1u ad=0.0816p as=0.0816p pd=1.16u ps=1.16u
    I_MXI185_MP0 (nrk4 nrkn4 VDD VDD) gpdk090_pmos1v w=0.24u l=0.1u ad=0.0816p as=0.0816p pd=1.16u ps=1.16u
    I_MXI182_MP0 (nrk3 nrkn3 VDD VDD) gpdk090_pmos1v w=0.24u l=0.1u ad=0.0816p as=0.0816p pd=1.16u ps=1.16u
    I_MXI179_MP0 (nrk2 nrkn2 VDD VDD) gpdk090_pmos1v w=0.24u l=0.1u ad=0.0816p as=0.0816p pd=1.16u ps=1.16u
    I_MXI176_MP0 (nrk1 nrkn1 VDD VDD) gpdk090_pmos1v w=0.24u l=0.1u ad=0.0816p as=0.0816p pd=1.16u ps=1.16u
    I_MXI25_MP0 (nbk2 nbkn2 VDD VDD) gpdk090_pmos1v w=0.24u l=0.1u ad=0.0816p as=0.0816p pd=1.16u ps=1.16u
    I_MXI188_MP0 (nrk5 nrkn5 VDD VDD) gpdk090_pmos1v w=0.24u l=0.1u ad=0.0816p as=0.0816p pd=1.16u ps=1.16u
    I_MXI48_I16_MP0 (I48_cinn VDD VDD VDD) gpdk090_pmos1v w=0.24u l=0.1u ad=0.0816p as=0.0816p pd=1.16u ps=1.16u
    I_MXI60_I16_MP0 (I60_cinn qu7 VDD VDD) gpdk090_pmos1v w=0.24u l=0.1u ad=0.0816p as=0.0816p pd=1.16u ps=1.16u
    I_MXI72_I18_MP0 (I72_G0_0n I72_G0_0 VDD VDD) gpdk090_pmos1v w=0.24u l=0.1u ad=0.0816p as=0.0816p pd=1.16u ps=1.16u
    I_MXI48_I18_MP0 (I48_G0_0n I48_G0_0 VDD VDD) gpdk090_pmos1v w=0.24u l=0.1u ad=0.0816p as=0.0816p pd=1.16u ps=1.16u
    I_MXI60_I18_MP0 (I60_G0_0n I60_G0_0 VDD VDD) gpdk090_pmos1v w=0.24u l=0.1u ad=0.0816p as=0.0816p pd=1.16u ps=1.16u
    I_MXI48_I33_MP0 (I48_G1_0n I48_G1_0 VDD VDD) gpdk090_pmos1v w=0.24u l=0.1u ad=0.0816p as=0.0816p pd=1.16u ps=1.16u
    I_MXI72_I33_MP0 (I72_G1_0n I72_G1_0 VDD VDD) gpdk090_pmos1v w=0.24u l=0.1u ad=0.0816p as=0.0816p pd=1.16u ps=1.16u
    I_MXI60_I33_MP0 (I60_G1_0n I60_G1_0 VDD VDD) gpdk090_pmos1v w=0.24u l=0.1u ad=0.0816p as=0.0816p pd=1.16u ps=1.16u
    I_MXI131_MP1 (VDD qu1 XI131_Bn VDD) gpdk090_pmos1v w=0.24u l=0.1u ad=0.0816p as=0.0816p pd=1.16u ps=1.16u
    I_MXI131_MP5 (b7_7 XI131_Bn XI131_p1 VDD) gpdk090_pmos1v w=0.48u l=0.1u ad=0.1056p as=0.1632p pd=0.92u ps=1.64u
    I_MXI131_MP4 (XI131_p1 XI131_An b7_7 VDD) gpdk090_pmos1v w=0.48u l=0.1u ad=0.1056p as=0.1056p pd=0.92u ps=0.92u
    I_MXI131_MP2 (VDD dd7 XI131_p1 VDD) gpdk090_pmos1v w=0.48u l=0.1u ad=0.1056p as=0.1056p pd=0.92u ps=0.92u
    I_MXI131_MP3 (XI131_p1 qu1 VDD VDD) gpdk090_pmos1v w=0.48u l=0.1u ad=0.1632p as=0.1056p pd=1.64u ps=0.92u
    I_MXI131_MP0 (VDD dd7 XI131_An VDD) gpdk090_pmos1v w=0.24u l=0.1u ad=0.0816p as=0.0816p pd=1.16u ps=1.16u
    I_MXI130_MP1 (VDD qu1 XI130_Bn VDD) gpdk090_pmos1v w=0.24u l=0.1u ad=0.0816p as=0.0816p pd=1.16u ps=1.16u
    I_MXI130_MP5 (b7_6 XI130_Bn XI130_p1 VDD) gpdk090_pmos1v w=0.48u l=0.1u ad=0.1056p as=0.1632p pd=0.92u ps=1.64u
    I_MXI130_MP4 (XI130_p1 XI130_An b7_6 VDD) gpdk090_pmos1v w=0.48u l=0.1u ad=0.1056p as=0.1056p pd=0.92u ps=0.92u
    I_MXI130_MP2 (VDD dd6 XI130_p1 VDD) gpdk090_pmos1v w=0.48u l=0.1u ad=0.1056p as=0.1056p pd=0.92u ps=0.92u
    I_MXI130_MP3 (XI130_p1 qu1 VDD VDD) gpdk090_pmos1v w=0.48u l=0.1u ad=0.1632p as=0.1056p pd=1.64u ps=0.92u
    I_MXI130_MP0 (VDD dd6 XI130_An VDD) gpdk090_pmos1v w=0.24u l=0.1u ad=0.0816p as=0.0816p pd=1.16u ps=1.16u
    I_MXI120_I41_MP1 (VDD I120_G3_0n XI120_I41_Bn VDD) gpdk090_pmos1v w=0.24u l=0.1u ad=0.0816p as=0.0816p pd=1.16u ps=1.16u
    I_MXI120_I41_MP5 (p6_4 XI120_I41_Bn XI120_I41_p1 VDD) gpdk090_pmos1v w=0.48u l=0.1u ad=0.1056p as=0.1632p pd=0.92u ps=1.64u
    I_MXI120_I41_MP4 (XI120_I41_p1 XI120_I41_An p6_4 VDD) gpdk090_pmos1v w=0.48u l=0.1u ad=0.1056p as=0.1056p pd=0.92u ps=0.92u
    I_MXI120_I41_MP2 (VDD I120_pn4 XI120_I41_p1 VDD) gpdk090_pmos1v w=0.48u l=0.1u ad=0.1056p as=0.1056p pd=0.92u ps=0.92u
    I_MXI120_I41_MP3 (XI120_I41_p1 I120_G3_0n VDD VDD) gpdk090_pmos1v w=0.48u l=0.1u ad=0.1632p as=0.1056p pd=1.64u ps=0.92u
    I_MXI120_I41_MP0 (VDD I120_pn4 XI120_I41_An VDD) gpdk090_pmos1v w=0.24u l=0.1u ad=0.0816p as=0.0816p pd=1.16u ps=1.16u
    I_MXI122_MP1 (VDD c6_8 XI122_Bn VDD) gpdk090_pmos1v w=0.24u l=0.1u ad=0.0816p as=0.0816p pd=1.16u ps=1.16u
    I_MXI122_MP5 (p6_8 XI122_Bn XI122_p1 VDD) gpdk090_pmos1v w=0.48u l=0.1u ad=0.1056p as=0.1632p pd=0.92u ps=1.64u
    I_MXI122_MP4 (XI122_p1 XI122_An p6_8 VDD) gpdk090_pmos1v w=0.48u l=0.1u ad=0.1056p as=0.1056p pd=0.92u ps=0.92u
    I_MXI122_MP2 (VDD h6 XI122_p1 VDD) gpdk090_pmos1v w=0.48u l=0.1u ad=0.1056p as=0.1056p pd=0.92u ps=0.92u
    I_MXI122_MP3 (XI122_p1 c6_8 VDD VDD) gpdk090_pmos1v w=0.48u l=0.1u ad=0.1632p as=0.1056p pd=1.64u ps=0.92u
    I_MXI122_MP0 (VDD h6 XI122_An VDD) gpdk090_pmos1v w=0.24u l=0.1u ad=0.0816p as=0.0816p pd=1.16u ps=1.16u
    I_MXI119_MP1 (VDD qu2 XI119_Bn VDD) gpdk090_pmos1v w=0.24u l=0.1u ad=0.0816p as=0.0816p pd=1.16u ps=1.16u
    I_MXI119_MP5 (b6_7 XI119_Bn XI119_p1 VDD) gpdk090_pmos1v w=0.48u l=0.1u ad=0.1056p as=0.1632p pd=0.92u ps=1.64u
    I_MXI119_MP4 (XI119_p1 XI119_An b6_7 VDD) gpdk090_pmos1v w=0.48u l=0.1u ad=0.1056p as=0.1056p pd=0.92u ps=0.92u
    I_MXI119_MP2 (VDD dd7 XI119_p1 VDD) gpdk090_pmos1v w=0.48u l=0.1u ad=0.1056p as=0.1056p pd=0.92u ps=0.92u
    I_MXI119_MP3 (XI119_p1 qu2 VDD VDD) gpdk090_pmos1v w=0.48u l=0.1u ad=0.1632p as=0.1056p pd=1.64u ps=0.92u
    I_MXI119_MP0 (VDD dd7 XI119_An VDD) gpdk090_pmos1v w=0.24u l=0.1u ad=0.0816p as=0.0816p pd=1.16u ps=1.16u
    I_MXI121_MP1 (VDD qu2 XI121_Bn VDD) gpdk090_pmos1v w=0.24u l=0.1u ad=0.0816p as=0.0816p pd=1.16u ps=1.16u
    I_MXI121_MP5 (h6 XI121_Bn XI121_p1 VDD) gpdk090_pmos1v w=0.48u l=0.1u ad=0.1056p as=0.1632p pd=0.92u ps=1.64u
    I_MXI121_MP4 (XI121_p1 XI121_An h6 VDD) gpdk090_pmos1v w=0.48u l=0.1u ad=0.1056p as=0.1056p pd=0.92u ps=0.92u
    I_MXI121_MP2 (VDD p5_7 XI121_p1 VDD) gpdk090_pmos1v w=0.48u l=0.1u ad=0.1056p as=0.1056p pd=0.92u ps=0.92u
    I_MXI121_MP3 (XI121_p1 qu2 VDD VDD) gpdk090_pmos1v w=0.48u l=0.1u ad=0.1632p as=0.1056p pd=1.64u ps=0.92u
    I_MXI121_MP0 (VDD p5_7 XI121_An VDD) gpdk090_pmos1v w=0.24u l=0.1u ad=0.0816p as=0.0816p pd=1.16u ps=1.16u
    I_MXI110_MP1 (VDD c5_8 XI110_Bn VDD) gpdk090_pmos1v w=0.24u l=0.1u ad=0.0816p as=0.0816p pd=1.16u ps=1.16u
    I_MXI110_MP5 (p5_8 XI110_Bn XI110_p1 VDD) gpdk090_pmos1v w=0.48u l=0.1u ad=0.1056p as=0.1632p pd=0.92u ps=1.64u
    I_MXI110_MP4 (XI110_p1 XI110_An p5_8 VDD) gpdk090_pmos1v w=0.48u l=0.1u ad=0.1056p as=0.1056p pd=0.92u ps=0.92u
    I_MXI110_MP2 (VDD h5 XI110_p1 VDD) gpdk090_pmos1v w=0.48u l=0.1u ad=0.1056p as=0.1056p pd=0.92u ps=0.92u
    I_MXI110_MP3 (XI110_p1 c5_8 VDD VDD) gpdk090_pmos1v w=0.48u l=0.1u ad=0.1632p as=0.1056p pd=1.64u ps=0.92u
    I_MXI110_MP0 (VDD h5 XI110_An VDD) gpdk090_pmos1v w=0.24u l=0.1u ad=0.0816p as=0.0816p pd=1.16u ps=1.16u
    I_MXI107_MP1 (VDD qu3 XI107_Bn VDD) gpdk090_pmos1v w=0.24u l=0.1u ad=0.0816p as=0.0816p pd=1.16u ps=1.16u
    I_MXI107_MP5 (b5_7 XI107_Bn XI107_p1 VDD) gpdk090_pmos1v w=0.48u l=0.1u ad=0.1056p as=0.1632p pd=0.92u ps=1.64u
    I_MXI107_MP4 (XI107_p1 XI107_An b5_7 VDD) gpdk090_pmos1v w=0.48u l=0.1u ad=0.1056p as=0.1056p pd=0.92u ps=0.92u
    I_MXI107_MP2 (VDD dd7 XI107_p1 VDD) gpdk090_pmos1v w=0.48u l=0.1u ad=0.1056p as=0.1056p pd=0.92u ps=0.92u
    I_MXI107_MP3 (XI107_p1 qu3 VDD VDD) gpdk090_pmos1v w=0.48u l=0.1u ad=0.1632p as=0.1056p pd=1.64u ps=0.92u
    I_MXI107_MP0 (VDD dd7 XI107_An VDD) gpdk090_pmos1v w=0.24u l=0.1u ad=0.0816p as=0.0816p pd=1.16u ps=1.16u
    I_MXI133_MP1 (VDD qu1 XI133_Bn VDD) gpdk090_pmos1v w=0.24u l=0.1u ad=0.0816p as=0.0816p pd=1.16u ps=1.16u
    I_MXI133_MP5 (h7 XI133_Bn XI133_p1 VDD) gpdk090_pmos1v w=0.48u l=0.1u ad=0.1056p as=0.1632p pd=0.92u ps=1.64u
    I_MXI133_MP4 (XI133_p1 XI133_An h7 VDD) gpdk090_pmos1v w=0.48u l=0.1u ad=0.1056p as=0.1056p pd=0.92u ps=0.92u
    I_MXI133_MP2 (VDD p6_7 XI133_p1 VDD) gpdk090_pmos1v w=0.48u l=0.1u ad=0.1056p as=0.1056p pd=0.92u ps=0.92u
    I_MXI133_MP3 (XI133_p1 qu1 VDD VDD) gpdk090_pmos1v w=0.48u l=0.1u ad=0.1632p as=0.1056p pd=1.64u ps=0.92u
    I_MXI133_MP0 (VDD p6_7 XI133_An VDD) gpdk090_pmos1v w=0.24u l=0.1u ad=0.0816p as=0.0816p pd=1.16u ps=1.16u
    I_MXI129_MP1 (VDD qu1 XI129_Bn VDD) gpdk090_pmos1v w=0.24u l=0.1u ad=0.0816p as=0.0816p pd=1.16u ps=1.16u
    I_MXI129_MP5 (b7_5 XI129_Bn XI129_p1 VDD) gpdk090_pmos1v w=0.48u l=0.1u ad=0.1056p as=0.1632p pd=0.92u ps=1.64u
    I_MXI129_MP4 (XI129_p1 XI129_An b7_5 VDD) gpdk090_pmos1v w=0.48u l=0.1u ad=0.1056p as=0.1056p pd=0.92u ps=0.92u
    I_MXI129_MP2 (VDD dd5 XI129_p1 VDD) gpdk090_pmos1v w=0.48u l=0.1u ad=0.1056p as=0.1056p pd=0.92u ps=0.92u
    I_MXI129_MP3 (XI129_p1 qu1 VDD VDD) gpdk090_pmos1v w=0.48u l=0.1u ad=0.1632p as=0.1056p pd=1.64u ps=0.92u
    I_MXI129_MP0 (VDD dd5 XI129_An VDD) gpdk090_pmos1v w=0.24u l=0.1u ad=0.0816p as=0.0816p pd=1.16u ps=1.16u
    I_MXI118_MP1 (VDD qu2 XI118_Bn VDD) gpdk090_pmos1v w=0.24u l=0.1u ad=0.0816p as=0.0816p pd=1.16u ps=1.16u
    I_MXI118_MP5 (b6_6 XI118_Bn XI118_p1 VDD) gpdk090_pmos1v w=0.48u l=0.1u ad=0.1056p as=0.1632p pd=0.92u ps=1.64u
    I_MXI118_MP4 (XI118_p1 XI118_An b6_6 VDD) gpdk090_pmos1v w=0.48u l=0.1u ad=0.1056p as=0.1056p pd=0.92u ps=0.92u
    I_MXI118_MP2 (VDD dd6 XI118_p1 VDD) gpdk090_pmos1v w=0.48u l=0.1u ad=0.1056p as=0.1056p pd=0.92u ps=0.92u
    I_MXI118_MP3 (XI118_p1 qu2 VDD VDD) gpdk090_pmos1v w=0.48u l=0.1u ad=0.1632p as=0.1056p pd=1.64u ps=0.92u
    I_MXI118_MP0 (VDD dd6 XI118_An VDD) gpdk090_pmos1v w=0.24u l=0.1u ad=0.0816p as=0.0816p pd=1.16u ps=1.16u
    I_MXI108_I41_MP1 (VDD I108_G3_0n XI108_I41_Bn VDD) gpdk090_pmos1v w=0.24u l=0.1u ad=0.0816p as=0.0816p pd=1.16u ps=1.16u
    I_MXI108_I41_MP5 (p5_4 XI108_I41_Bn XI108_I41_p1 VDD) gpdk090_pmos1v w=0.48u l=0.1u ad=0.1056p as=0.1632p pd=0.92u ps=1.64u
    I_MXI108_I41_MP4 (XI108_I41_p1 XI108_I41_An p5_4 VDD) gpdk090_pmos1v w=0.48u l=0.1u ad=0.1056p as=0.1056p pd=0.92u ps=0.92u
    I_MXI108_I41_MP2 (VDD I108_pn4 XI108_I41_p1 VDD) gpdk090_pmos1v w=0.48u l=0.1u ad=0.1056p as=0.1056p pd=0.92u ps=0.92u
    I_MXI108_I41_MP3 (XI108_I41_p1 I108_G3_0n VDD VDD) gpdk090_pmos1v w=0.48u l=0.1u ad=0.1632p as=0.1056p pd=1.64u ps=0.92u
    I_MXI108_I41_MP0 (VDD I108_pn4 XI108_I41_An VDD) gpdk090_pmos1v w=0.24u l=0.1u ad=0.0816p as=0.0816p pd=1.16u ps=1.16u
    I_MXI109_MP1 (VDD qu3 XI109_Bn VDD) gpdk090_pmos1v w=0.24u l=0.1u ad=0.0816p as=0.0816p pd=1.16u ps=1.16u
    I_MXI109_MP5 (h5 XI109_Bn XI109_p1 VDD) gpdk090_pmos1v w=0.48u l=0.1u ad=0.1056p as=0.1632p pd=0.92u ps=1.64u
    I_MXI109_MP4 (XI109_p1 XI109_An h5 VDD) gpdk090_pmos1v w=0.48u l=0.1u ad=0.1056p as=0.1056p pd=0.92u ps=0.92u
    I_MXI109_MP2 (VDD p4_7 XI109_p1 VDD) gpdk090_pmos1v w=0.48u l=0.1u ad=0.1056p as=0.1056p pd=0.92u ps=0.92u
    I_MXI109_MP3 (XI109_p1 qu3 VDD VDD) gpdk090_pmos1v w=0.48u l=0.1u ad=0.1632p as=0.1056p pd=1.64u ps=0.92u
    I_MXI109_MP0 (VDD p4_7 XI109_An VDD) gpdk090_pmos1v w=0.24u l=0.1u ad=0.0816p as=0.0816p pd=1.16u ps=1.16u
    I_MXI106_MP1 (VDD qu3 XI106_Bn VDD) gpdk090_pmos1v w=0.24u l=0.1u ad=0.0816p as=0.0816p pd=1.16u ps=1.16u
    I_MXI106_MP5 (b5_6 XI106_Bn XI106_p1 VDD) gpdk090_pmos1v w=0.48u l=0.1u ad=0.1056p as=0.1632p pd=0.92u ps=1.64u
    I_MXI106_MP4 (XI106_p1 XI106_An b5_6 VDD) gpdk090_pmos1v w=0.48u l=0.1u ad=0.1056p as=0.1056p pd=0.92u ps=0.92u
    I_MXI106_MP2 (VDD dd6 XI106_p1 VDD) gpdk090_pmos1v w=0.48u l=0.1u ad=0.1056p as=0.1056p pd=0.92u ps=0.92u
    I_MXI106_MP3 (XI106_p1 qu3 VDD VDD) gpdk090_pmos1v w=0.48u l=0.1u ad=0.1632p as=0.1056p pd=1.64u ps=0.92u
    I_MXI106_MP0 (VDD dd6 XI106_An VDD) gpdk090_pmos1v w=0.24u l=0.1u ad=0.0816p as=0.0816p pd=1.16u ps=1.16u
    I_MXI134_MP1 (VDD c7_8 XI134_Bn VDD) gpdk090_pmos1v w=0.24u l=0.1u ad=0.0816p as=0.0816p pd=1.16u ps=1.16u
    I_MXI134_MP5 (p7_8 XI134_Bn XI134_p1 VDD) gpdk090_pmos1v w=0.48u l=0.1u ad=0.1056p as=0.1632p pd=0.92u ps=1.64u
    I_MXI134_MP4 (XI134_p1 XI134_An p7_8 VDD) gpdk090_pmos1v w=0.48u l=0.1u ad=0.1056p as=0.1056p pd=0.92u ps=0.92u
    I_MXI134_MP2 (VDD h7 XI134_p1 VDD) gpdk090_pmos1v w=0.48u l=0.1u ad=0.1056p as=0.1056p pd=0.92u ps=0.92u
    I_MXI134_MP3 (XI134_p1 c7_8 VDD VDD) gpdk090_pmos1v w=0.48u l=0.1u ad=0.1632p as=0.1056p pd=1.64u ps=0.92u
    I_MXI134_MP0 (VDD h7 XI134_An VDD) gpdk090_pmos1v w=0.24u l=0.1u ad=0.0816p as=0.0816p pd=1.16u ps=1.16u
    I_MXI120_I40_MP1 (VDD I120_G2_0n XI120_I40_Bn VDD) gpdk090_pmos1v w=0.24u l=0.1u ad=0.0816p as=0.0816p pd=1.16u ps=1.16u
    I_MXI120_I40_MP5 (p6_3 XI120_I40_Bn XI120_I40_p1 VDD) gpdk090_pmos1v w=0.48u l=0.1u ad=0.1056p as=0.1632p pd=0.92u ps=1.64u
    I_MXI120_I40_MP4 (XI120_I40_p1 XI120_I40_An p6_3 VDD) gpdk090_pmos1v w=0.48u l=0.1u ad=0.1056p as=0.1056p pd=0.92u ps=0.92u
    I_MXI120_I40_MP2 (VDD I120_pn3 XI120_I40_p1 VDD) gpdk090_pmos1v w=0.48u l=0.1u ad=0.1056p as=0.1056p pd=0.92u ps=0.92u
    I_MXI120_I40_MP3 (XI120_I40_p1 I120_G2_0n VDD VDD) gpdk090_pmos1v w=0.48u l=0.1u ad=0.1632p as=0.1056p pd=1.64u ps=0.92u
    I_MXI120_I40_MP0 (VDD I120_pn3 XI120_I40_An VDD) gpdk090_pmos1v w=0.24u l=0.1u ad=0.0816p as=0.0816p pd=1.16u ps=1.16u
    I_MXI128_MP1 (VDD qu1 XI128_Bn VDD) gpdk090_pmos1v w=0.24u l=0.1u ad=0.0816p as=0.0816p pd=1.16u ps=1.16u
    I_MXI128_MP5 (b7_4 XI128_Bn XI128_p1 VDD) gpdk090_pmos1v w=0.48u l=0.1u ad=0.1056p as=0.1632p pd=0.92u ps=1.64u
    I_MXI128_MP4 (XI128_p1 XI128_An b7_4 VDD) gpdk090_pmos1v w=0.48u l=0.1u ad=0.1056p as=0.1056p pd=0.92u ps=0.92u
    I_MXI128_MP2 (VDD dd4 XI128_p1 VDD) gpdk090_pmos1v w=0.48u l=0.1u ad=0.1056p as=0.1056p pd=0.92u ps=0.92u
    I_MXI128_MP3 (XI128_p1 qu1 VDD VDD) gpdk090_pmos1v w=0.48u l=0.1u ad=0.1632p as=0.1056p pd=1.64u ps=0.92u
    I_MXI128_MP0 (VDD dd4 XI128_An VDD) gpdk090_pmos1v w=0.24u l=0.1u ad=0.0816p as=0.0816p pd=1.16u ps=1.16u
    I_MXI117_MP1 (VDD qu2 XI117_Bn VDD) gpdk090_pmos1v w=0.24u l=0.1u ad=0.0816p as=0.0816p pd=1.16u ps=1.16u
    I_MXI117_MP5 (b6_5 XI117_Bn XI117_p1 VDD) gpdk090_pmos1v w=0.48u l=0.1u ad=0.1056p as=0.1632p pd=0.92u ps=1.64u
    I_MXI117_MP4 (XI117_p1 XI117_An b6_5 VDD) gpdk090_pmos1v w=0.48u l=0.1u ad=0.1056p as=0.1056p pd=0.92u ps=0.92u
    I_MXI117_MP2 (VDD dd5 XI117_p1 VDD) gpdk090_pmos1v w=0.48u l=0.1u ad=0.1056p as=0.1056p pd=0.92u ps=0.92u
    I_MXI117_MP3 (XI117_p1 qu2 VDD VDD) gpdk090_pmos1v w=0.48u l=0.1u ad=0.1632p as=0.1056p pd=1.64u ps=0.92u
    I_MXI117_MP0 (VDD dd5 XI117_An VDD) gpdk090_pmos1v w=0.24u l=0.1u ad=0.0816p as=0.0816p pd=1.16u ps=1.16u
    I_MXI108_I40_MP1 (VDD I108_G2_0n XI108_I40_Bn VDD) gpdk090_pmos1v w=0.24u l=0.1u ad=0.0816p as=0.0816p pd=1.16u ps=1.16u
    I_MXI108_I40_MP5 (p5_3 XI108_I40_Bn XI108_I40_p1 VDD) gpdk090_pmos1v w=0.48u l=0.1u ad=0.1056p as=0.1632p pd=0.92u ps=1.64u
    I_MXI108_I40_MP4 (XI108_I40_p1 XI108_I40_An p5_3 VDD) gpdk090_pmos1v w=0.48u l=0.1u ad=0.1056p as=0.1056p pd=0.92u ps=0.92u
    I_MXI108_I40_MP2 (VDD I108_pn3 XI108_I40_p1 VDD) gpdk090_pmos1v w=0.48u l=0.1u ad=0.1056p as=0.1056p pd=0.92u ps=0.92u
    I_MXI108_I40_MP3 (XI108_I40_p1 I108_G2_0n VDD VDD) gpdk090_pmos1v w=0.48u l=0.1u ad=0.1632p as=0.1056p pd=1.64u ps=0.92u
    I_MXI108_I40_MP0 (VDD I108_pn3 XI108_I40_An VDD) gpdk090_pmos1v w=0.24u l=0.1u ad=0.0816p as=0.0816p pd=1.16u ps=1.16u
    I_MXI104_MP1 (VDD qu3 XI104_Bn VDD) gpdk090_pmos1v w=0.24u l=0.1u ad=0.0816p as=0.0816p pd=1.16u ps=1.16u
    I_MXI104_MP5 (b5_4 XI104_Bn XI104_p1 VDD) gpdk090_pmos1v w=0.48u l=0.1u ad=0.1056p as=0.1632p pd=0.92u ps=1.64u
    I_MXI104_MP4 (XI104_p1 XI104_An b5_4 VDD) gpdk090_pmos1v w=0.48u l=0.1u ad=0.1056p as=0.1056p pd=0.92u ps=0.92u
    I_MXI104_MP2 (VDD dd4 XI104_p1 VDD) gpdk090_pmos1v w=0.48u l=0.1u ad=0.1056p as=0.1056p pd=0.92u ps=0.92u
    I_MXI104_MP3 (XI104_p1 qu3 VDD VDD) gpdk090_pmos1v w=0.48u l=0.1u ad=0.1632p as=0.1056p pd=1.64u ps=0.92u
    I_MXI104_MP0 (VDD dd4 XI104_An VDD) gpdk090_pmos1v w=0.24u l=0.1u ad=0.0816p as=0.0816p pd=1.16u ps=1.16u
    I_MXI96_I41_MP1 (VDD I96_G3_0n XI96_I41_Bn VDD) gpdk090_pmos1v w=0.24u l=0.1u ad=0.0816p as=0.0816p pd=1.16u ps=1.16u
    I_MXI96_I41_MP5 (p4_4 XI96_I41_Bn XI96_I41_p1 VDD) gpdk090_pmos1v w=0.48u l=0.1u ad=0.1056p as=0.1632p pd=0.92u ps=1.64u
    I_MXI96_I41_MP4 (XI96_I41_p1 XI96_I41_An p4_4 VDD) gpdk090_pmos1v w=0.48u l=0.1u ad=0.1056p as=0.1056p pd=0.92u ps=0.92u
    I_MXI96_I41_MP2 (VDD I96_pn4 XI96_I41_p1 VDD) gpdk090_pmos1v w=0.48u l=0.1u ad=0.1056p as=0.1056p pd=0.92u ps=0.92u
    I_MXI96_I41_MP3 (XI96_I41_p1 I96_G3_0n VDD VDD) gpdk090_pmos1v w=0.48u l=0.1u ad=0.1632p as=0.1056p pd=1.64u ps=0.92u
    I_MXI96_I41_MP0 (VDD I96_pn4 XI96_I41_An VDD) gpdk090_pmos1v w=0.24u l=0.1u ad=0.0816p as=0.0816p pd=1.16u ps=1.16u
    I_MXI105_MP1 (VDD qu3 XI105_Bn VDD) gpdk090_pmos1v w=0.24u l=0.1u ad=0.0816p as=0.0816p pd=1.16u ps=1.16u
    I_MXI105_MP5 (b5_5 XI105_Bn XI105_p1 VDD) gpdk090_pmos1v w=0.48u l=0.1u ad=0.1056p as=0.1632p pd=0.92u ps=1.64u
    I_MXI105_MP4 (XI105_p1 XI105_An b5_5 VDD) gpdk090_pmos1v w=0.48u l=0.1u ad=0.1056p as=0.1056p pd=0.92u ps=0.92u
    I_MXI105_MP2 (VDD dd5 XI105_p1 VDD) gpdk090_pmos1v w=0.48u l=0.1u ad=0.1056p as=0.1056p pd=0.92u ps=0.92u
    I_MXI105_MP3 (XI105_p1 qu3 VDD VDD) gpdk090_pmos1v w=0.48u l=0.1u ad=0.1632p as=0.1056p pd=1.64u ps=0.92u
    I_MXI105_MP0 (VDD dd5 XI105_An VDD) gpdk090_pmos1v w=0.24u l=0.1u ad=0.0816p as=0.0816p pd=1.16u ps=1.16u
    I_MXI98_MP1 (VDD c4_8 XI98_Bn VDD) gpdk090_pmos1v w=0.24u l=0.1u ad=0.0816p as=0.0816p pd=1.16u ps=1.16u
    I_MXI98_MP5 (p4_8 XI98_Bn XI98_p1 VDD) gpdk090_pmos1v w=0.48u l=0.1u ad=0.1056p as=0.1632p pd=0.92u ps=1.64u
    I_MXI98_MP4 (XI98_p1 XI98_An p4_8 VDD) gpdk090_pmos1v w=0.48u l=0.1u ad=0.1056p as=0.1056p pd=0.92u ps=0.92u
    I_MXI98_MP2 (VDD h4 XI98_p1 VDD) gpdk090_pmos1v w=0.48u l=0.1u ad=0.1056p as=0.1056p pd=0.92u ps=0.92u
    I_MXI98_MP3 (XI98_p1 c4_8 VDD VDD) gpdk090_pmos1v w=0.48u l=0.1u ad=0.1632p as=0.1056p pd=1.64u ps=0.92u
    I_MXI98_MP0 (VDD h4 XI98_An VDD) gpdk090_pmos1v w=0.24u l=0.1u ad=0.0816p as=0.0816p pd=1.16u ps=1.16u
    I_MXI127_MP1 (VDD qu1 XI127_Bn VDD) gpdk090_pmos1v w=0.24u l=0.1u ad=0.0816p as=0.0816p pd=1.16u ps=1.16u
    I_MXI127_MP5 (b7_3 XI127_Bn XI127_p1 VDD) gpdk090_pmos1v w=0.48u l=0.1u ad=0.1056p as=0.1632p pd=0.92u ps=1.64u
    I_MXI127_MP4 (XI127_p1 XI127_An b7_3 VDD) gpdk090_pmos1v w=0.48u l=0.1u ad=0.1056p as=0.1056p pd=0.92u ps=0.92u
    I_MXI127_MP2 (VDD dd3 XI127_p1 VDD) gpdk090_pmos1v w=0.48u l=0.1u ad=0.1056p as=0.1056p pd=0.92u ps=0.92u
    I_MXI127_MP3 (XI127_p1 qu1 VDD VDD) gpdk090_pmos1v w=0.48u l=0.1u ad=0.1632p as=0.1056p pd=1.64u ps=0.92u
    I_MXI127_MP0 (VDD dd3 XI127_An VDD) gpdk090_pmos1v w=0.24u l=0.1u ad=0.0816p as=0.0816p pd=1.16u ps=1.16u
    I_MXI115_MP1 (VDD qu2 XI115_Bn VDD) gpdk090_pmos1v w=0.24u l=0.1u ad=0.0816p as=0.0816p pd=1.16u ps=1.16u
    I_MXI115_MP5 (b6_3 XI115_Bn XI115_p1 VDD) gpdk090_pmos1v w=0.48u l=0.1u ad=0.1056p as=0.1632p pd=0.92u ps=1.64u
    I_MXI115_MP4 (XI115_p1 XI115_An b6_3 VDD) gpdk090_pmos1v w=0.48u l=0.1u ad=0.1056p as=0.1056p pd=0.92u ps=0.92u
    I_MXI115_MP2 (VDD dd3 XI115_p1 VDD) gpdk090_pmos1v w=0.48u l=0.1u ad=0.1056p as=0.1056p pd=0.92u ps=0.92u
    I_MXI115_MP3 (XI115_p1 qu2 VDD VDD) gpdk090_pmos1v w=0.48u l=0.1u ad=0.1632p as=0.1056p pd=1.64u ps=0.92u
    I_MXI115_MP0 (VDD dd3 XI115_An VDD) gpdk090_pmos1v w=0.24u l=0.1u ad=0.0816p as=0.0816p pd=1.16u ps=1.16u
    I_MXI116_MP1 (VDD qu2 XI116_Bn VDD) gpdk090_pmos1v w=0.24u l=0.1u ad=0.0816p as=0.0816p pd=1.16u ps=1.16u
    I_MXI116_MP5 (b6_4 XI116_Bn XI116_p1 VDD) gpdk090_pmos1v w=0.48u l=0.1u ad=0.1056p as=0.1632p pd=0.92u ps=1.64u
    I_MXI116_MP4 (XI116_p1 XI116_An b6_4 VDD) gpdk090_pmos1v w=0.48u l=0.1u ad=0.1056p as=0.1056p pd=0.92u ps=0.92u
    I_MXI116_MP2 (VDD dd4 XI116_p1 VDD) gpdk090_pmos1v w=0.48u l=0.1u ad=0.1056p as=0.1056p pd=0.92u ps=0.92u
    I_MXI116_MP3 (XI116_p1 qu2 VDD VDD) gpdk090_pmos1v w=0.48u l=0.1u ad=0.1632p as=0.1056p pd=1.64u ps=0.92u
    I_MXI116_MP0 (VDD dd4 XI116_An VDD) gpdk090_pmos1v w=0.24u l=0.1u ad=0.0816p as=0.0816p pd=1.16u ps=1.16u
    I_MXI103_MP1 (VDD qu3 XI103_Bn VDD) gpdk090_pmos1v w=0.24u l=0.1u ad=0.0816p as=0.0816p pd=1.16u ps=1.16u
    I_MXI103_MP5 (b5_3 XI103_Bn XI103_p1 VDD) gpdk090_pmos1v w=0.48u l=0.1u ad=0.1056p as=0.1632p pd=0.92u ps=1.64u
    I_MXI103_MP4 (XI103_p1 XI103_An b5_3 VDD) gpdk090_pmos1v w=0.48u l=0.1u ad=0.1056p as=0.1056p pd=0.92u ps=0.92u
    I_MXI103_MP2 (VDD dd3 XI103_p1 VDD) gpdk090_pmos1v w=0.48u l=0.1u ad=0.1056p as=0.1056p pd=0.92u ps=0.92u
    I_MXI103_MP3 (XI103_p1 qu3 VDD VDD) gpdk090_pmos1v w=0.48u l=0.1u ad=0.1632p as=0.1056p pd=1.64u ps=0.92u
    I_MXI103_MP0 (VDD dd3 XI103_An VDD) gpdk090_pmos1v w=0.24u l=0.1u ad=0.0816p as=0.0816p pd=1.16u ps=1.16u
    I_MXI96_I40_MP1 (VDD I96_G2_0n XI96_I40_Bn VDD) gpdk090_pmos1v w=0.24u l=0.1u ad=0.0816p as=0.0816p pd=1.16u ps=1.16u
    I_MXI96_I40_MP5 (p4_3 XI96_I40_Bn XI96_I40_p1 VDD) gpdk090_pmos1v w=0.48u l=0.1u ad=0.1056p as=0.1632p pd=0.92u ps=1.64u
    I_MXI96_I40_MP4 (XI96_I40_p1 XI96_I40_An p4_3 VDD) gpdk090_pmos1v w=0.48u l=0.1u ad=0.1056p as=0.1056p pd=0.92u ps=0.92u
    I_MXI96_I40_MP2 (VDD I96_pn3 XI96_I40_p1 VDD) gpdk090_pmos1v w=0.48u l=0.1u ad=0.1056p as=0.1056p pd=0.92u ps=0.92u
    I_MXI96_I40_MP3 (XI96_I40_p1 I96_G2_0n VDD VDD) gpdk090_pmos1v w=0.48u l=0.1u ad=0.1632p as=0.1056p pd=1.64u ps=0.92u
    I_MXI96_I40_MP0 (VDD I96_pn3 XI96_I40_An VDD) gpdk090_pmos1v w=0.24u l=0.1u ad=0.0816p as=0.0816p pd=1.16u ps=1.16u
    I_MXI132_I41_MP1 (VDD I132_G3_0n XI132_I41_Bn VDD) gpdk090_pmos1v w=0.24u l=0.1u ad=0.0816p as=0.0816p pd=1.16u ps=1.16u
    I_MXI132_I41_MP5 (p7_4 XI132_I41_Bn XI132_I41_p1 VDD) gpdk090_pmos1v w=0.48u l=0.1u ad=0.1056p as=0.1632p pd=0.92u ps=1.64u
    I_MXI132_I41_MP4 (XI132_I41_p1 XI132_I41_An p7_4 VDD) gpdk090_pmos1v w=0.48u l=0.1u ad=0.1056p as=0.1056p pd=0.92u ps=0.92u
    I_MXI132_I41_MP2 (VDD I132_pn4 XI132_I41_p1 VDD) gpdk090_pmos1v w=0.48u l=0.1u ad=0.1056p as=0.1056p pd=0.92u ps=0.92u
    I_MXI132_I41_MP3 (XI132_I41_p1 I132_G3_0n VDD VDD) gpdk090_pmos1v w=0.48u l=0.1u ad=0.1632p as=0.1056p pd=1.64u ps=0.92u
    I_MXI132_I41_MP0 (VDD I132_pn4 XI132_I41_An VDD) gpdk090_pmos1v w=0.24u l=0.1u ad=0.0816p as=0.0816p pd=1.16u ps=1.16u
    I_MXI132_I40_MP1 (VDD I132_G2_0n XI132_I40_Bn VDD) gpdk090_pmos1v w=0.24u l=0.1u ad=0.0816p as=0.0816p pd=1.16u ps=1.16u
    I_MXI132_I40_MP5 (p7_3 XI132_I40_Bn XI132_I40_p1 VDD) gpdk090_pmos1v w=0.48u l=0.1u ad=0.1056p as=0.1632p pd=0.92u ps=1.64u
    I_MXI132_I40_MP4 (XI132_I40_p1 XI132_I40_An p7_3 VDD) gpdk090_pmos1v w=0.48u l=0.1u ad=0.1056p as=0.1056p pd=0.92u ps=0.92u
    I_MXI132_I40_MP2 (VDD I132_pn3 XI132_I40_p1 VDD) gpdk090_pmos1v w=0.48u l=0.1u ad=0.1056p as=0.1056p pd=0.92u ps=0.92u
    I_MXI132_I40_MP3 (XI132_I40_p1 I132_G2_0n VDD VDD) gpdk090_pmos1v w=0.48u l=0.1u ad=0.1632p as=0.1056p pd=1.64u ps=0.92u
    I_MXI132_I40_MP0 (VDD I132_pn3 XI132_I40_An VDD) gpdk090_pmos1v w=0.24u l=0.1u ad=0.0816p as=0.0816p pd=1.16u ps=1.16u
    I_MXI126_MP1 (VDD qu1 XI126_Bn VDD) gpdk090_pmos1v w=0.24u l=0.1u ad=0.0816p as=0.0816p pd=1.16u ps=1.16u
    I_MXI126_MP5 (b7_2 XI126_Bn XI126_p1 VDD) gpdk090_pmos1v w=0.48u l=0.1u ad=0.1056p as=0.1632p pd=0.92u ps=1.64u
    I_MXI126_MP4 (XI126_p1 XI126_An b7_2 VDD) gpdk090_pmos1v w=0.48u l=0.1u ad=0.1056p as=0.1056p pd=0.92u ps=0.92u
    I_MXI126_MP2 (VDD dd2 XI126_p1 VDD) gpdk090_pmos1v w=0.48u l=0.1u ad=0.1056p as=0.1056p pd=0.92u ps=0.92u
    I_MXI126_MP3 (XI126_p1 qu1 VDD VDD) gpdk090_pmos1v w=0.48u l=0.1u ad=0.1632p as=0.1056p pd=1.64u ps=0.92u
    I_MXI126_MP0 (VDD dd2 XI126_An VDD) gpdk090_pmos1v w=0.24u l=0.1u ad=0.0816p as=0.0816p pd=1.16u ps=1.16u
    I_MXI113_MP1 (VDD qu2 XI113_Bn VDD) gpdk090_pmos1v w=0.24u l=0.1u ad=0.0816p as=0.0816p pd=1.16u ps=1.16u
    I_MXI113_MP5 (b6_1 XI113_Bn XI113_p1 VDD) gpdk090_pmos1v w=0.48u l=0.1u ad=0.1056p as=0.1632p pd=0.92u ps=1.64u
    I_MXI113_MP4 (XI113_p1 XI113_An b6_1 VDD) gpdk090_pmos1v w=0.48u l=0.1u ad=0.1056p as=0.1056p pd=0.92u ps=0.92u
    I_MXI113_MP2 (VDD dd1 XI113_p1 VDD) gpdk090_pmos1v w=0.48u l=0.1u ad=0.1056p as=0.1056p pd=0.92u ps=0.92u
    I_MXI113_MP3 (XI113_p1 qu2 VDD VDD) gpdk090_pmos1v w=0.48u l=0.1u ad=0.1632p as=0.1056p pd=1.64u ps=0.92u
    I_MXI113_MP0 (VDD dd1 XI113_An VDD) gpdk090_pmos1v w=0.24u l=0.1u ad=0.0816p as=0.0816p pd=1.16u ps=1.16u
    I_MXI114_MP1 (VDD qu2 XI114_Bn VDD) gpdk090_pmos1v w=0.24u l=0.1u ad=0.0816p as=0.0816p pd=1.16u ps=1.16u
    I_MXI114_MP5 (b6_2 XI114_Bn XI114_p1 VDD) gpdk090_pmos1v w=0.48u l=0.1u ad=0.1056p as=0.1632p pd=0.92u ps=1.64u
    I_MXI114_MP4 (XI114_p1 XI114_An b6_2 VDD) gpdk090_pmos1v w=0.48u l=0.1u ad=0.1056p as=0.1056p pd=0.92u ps=0.92u
    I_MXI114_MP2 (VDD dd2 XI114_p1 VDD) gpdk090_pmos1v w=0.48u l=0.1u ad=0.1056p as=0.1056p pd=0.92u ps=0.92u
    I_MXI114_MP3 (XI114_p1 qu2 VDD VDD) gpdk090_pmos1v w=0.48u l=0.1u ad=0.1632p as=0.1056p pd=1.64u ps=0.92u
    I_MXI114_MP0 (VDD dd2 XI114_An VDD) gpdk090_pmos1v w=0.24u l=0.1u ad=0.0816p as=0.0816p pd=1.16u ps=1.16u
    I_MXI101_MP1 (VDD qu3 XI101_Bn VDD) gpdk090_pmos1v w=0.24u l=0.1u ad=0.0816p as=0.0816p pd=1.16u ps=1.16u
    I_MXI101_MP5 (b5_1 XI101_Bn XI101_p1 VDD) gpdk090_pmos1v w=0.48u l=0.1u ad=0.1056p as=0.1632p pd=0.92u ps=1.64u
    I_MXI101_MP4 (XI101_p1 XI101_An b5_1 VDD) gpdk090_pmos1v w=0.48u l=0.1u ad=0.1056p as=0.1056p pd=0.92u ps=0.92u
    I_MXI101_MP2 (VDD dd1 XI101_p1 VDD) gpdk090_pmos1v w=0.48u l=0.1u ad=0.1056p as=0.1056p pd=0.92u ps=0.92u
    I_MXI101_MP3 (XI101_p1 qu3 VDD VDD) gpdk090_pmos1v w=0.48u l=0.1u ad=0.1632p as=0.1056p pd=1.64u ps=0.92u
    I_MXI101_MP0 (VDD dd1 XI101_An VDD) gpdk090_pmos1v w=0.24u l=0.1u ad=0.0816p as=0.0816p pd=1.16u ps=1.16u
    I_MXI102_MP1 (VDD qu3 XI102_Bn VDD) gpdk090_pmos1v w=0.24u l=0.1u ad=0.0816p as=0.0816p pd=1.16u ps=1.16u
    I_MXI102_MP5 (b5_2 XI102_Bn XI102_p1 VDD) gpdk090_pmos1v w=0.48u l=0.1u ad=0.1056p as=0.1632p pd=0.92u ps=1.64u
    I_MXI102_MP4 (XI102_p1 XI102_An b5_2 VDD) gpdk090_pmos1v w=0.48u l=0.1u ad=0.1056p as=0.1056p pd=0.92u ps=0.92u
    I_MXI102_MP2 (VDD dd2 XI102_p1 VDD) gpdk090_pmos1v w=0.48u l=0.1u ad=0.1056p as=0.1056p pd=0.92u ps=0.92u
    I_MXI102_MP3 (XI102_p1 qu3 VDD VDD) gpdk090_pmos1v w=0.48u l=0.1u ad=0.1632p as=0.1056p pd=1.64u ps=0.92u
    I_MXI102_MP0 (VDD dd2 XI102_An VDD) gpdk090_pmos1v w=0.24u l=0.1u ad=0.0816p as=0.0816p pd=1.16u ps=1.16u
    I_MXI125_MP1 (VDD qu1 XI125_Bn VDD) gpdk090_pmos1v w=0.24u l=0.1u ad=0.0816p as=0.0816p pd=1.16u ps=1.16u
    I_MXI125_MP5 (b7_1 XI125_Bn XI125_p1 VDD) gpdk090_pmos1v w=0.48u l=0.1u ad=0.1056p as=0.1632p pd=0.92u ps=1.64u
    I_MXI125_MP4 (XI125_p1 XI125_An b7_1 VDD) gpdk090_pmos1v w=0.48u l=0.1u ad=0.1056p as=0.1056p pd=0.92u ps=0.92u
    I_MXI125_MP2 (VDD dd1 XI125_p1 VDD) gpdk090_pmos1v w=0.48u l=0.1u ad=0.1056p as=0.1056p pd=0.92u ps=0.92u
    I_MXI125_MP3 (XI125_p1 qu1 VDD VDD) gpdk090_pmos1v w=0.48u l=0.1u ad=0.1632p as=0.1056p pd=1.64u ps=0.92u
    I_MXI125_MP0 (VDD dd1 XI125_An VDD) gpdk090_pmos1v w=0.24u l=0.1u ad=0.0816p as=0.0816p pd=1.16u ps=1.16u
    I_MXI112_MP1 (VDD qu2 XI112_Bn VDD) gpdk090_pmos1v w=0.24u l=0.1u ad=0.0816p as=0.0816p pd=1.16u ps=1.16u
    I_MXI112_MP5 (b6_0 XI112_Bn XI112_p1 VDD) gpdk090_pmos1v w=0.48u l=0.1u ad=0.1056p as=0.1632p pd=0.92u ps=1.64u
    I_MXI112_MP4 (XI112_p1 XI112_An b6_0 VDD) gpdk090_pmos1v w=0.48u l=0.1u ad=0.1056p as=0.1056p pd=0.92u ps=0.92u
    I_MXI112_MP2 (VDD B_0 XI112_p1 VDD) gpdk090_pmos1v w=0.48u l=0.1u ad=0.1056p as=0.1056p pd=0.92u ps=0.92u
    I_MXI112_MP3 (XI112_p1 qu2 VDD VDD) gpdk090_pmos1v w=0.48u l=0.1u ad=0.1632p as=0.1056p pd=1.64u ps=0.92u
    I_MXI112_MP0 (VDD B_0 XI112_An VDD) gpdk090_pmos1v w=0.24u l=0.1u ad=0.0816p as=0.0816p pd=1.16u ps=1.16u
    I_MXI100_MP1 (VDD qu3 XI100_Bn VDD) gpdk090_pmos1v w=0.24u l=0.1u ad=0.0816p as=0.0816p pd=1.16u ps=1.16u
    I_MXI100_MP5 (b5_0 XI100_Bn XI100_p1 VDD) gpdk090_pmos1v w=0.48u l=0.1u ad=0.1056p as=0.1632p pd=0.92u ps=1.64u
    I_MXI100_MP4 (XI100_p1 XI100_An b5_0 VDD) gpdk090_pmos1v w=0.48u l=0.1u ad=0.1056p as=0.1056p pd=0.92u ps=0.92u
    I_MXI100_MP2 (VDD B_0 XI100_p1 VDD) gpdk090_pmos1v w=0.48u l=0.1u ad=0.1056p as=0.1056p pd=0.92u ps=0.92u
    I_MXI100_MP3 (XI100_p1 qu3 VDD VDD) gpdk090_pmos1v w=0.48u l=0.1u ad=0.1632p as=0.1056p pd=1.64u ps=0.92u
    I_MXI100_MP0 (VDD B_0 XI100_An VDD) gpdk090_pmos1v w=0.24u l=0.1u ad=0.0816p as=0.0816p pd=1.16u ps=1.16u
    I_MXI89_MP1 (VDD qu4 XI89_Bn VDD) gpdk090_pmos1v w=0.24u l=0.1u ad=0.0816p as=0.0816p pd=1.16u ps=1.16u
    I_MXI89_MP5 (b4_1 XI89_Bn XI89_p1 VDD) gpdk090_pmos1v w=0.48u l=0.1u ad=0.1056p as=0.1632p pd=0.92u ps=1.64u
    I_MXI89_MP4 (XI89_p1 XI89_An b4_1 VDD) gpdk090_pmos1v w=0.48u l=0.1u ad=0.1056p as=0.1056p pd=0.92u ps=0.92u
    I_MXI89_MP2 (VDD dd1 XI89_p1 VDD) gpdk090_pmos1v w=0.48u l=0.1u ad=0.1056p as=0.1056p pd=0.92u ps=0.92u
    I_MXI89_MP3 (XI89_p1 qu4 VDD VDD) gpdk090_pmos1v w=0.48u l=0.1u ad=0.1632p as=0.1056p pd=1.64u ps=0.92u
    I_MXI89_MP0 (VDD dd1 XI89_An VDD) gpdk090_pmos1v w=0.24u l=0.1u ad=0.0816p as=0.0816p pd=1.16u ps=1.16u
    I_MXI95_MP1 (VDD qu4 XI95_Bn VDD) gpdk090_pmos1v w=0.24u l=0.1u ad=0.0816p as=0.0816p pd=1.16u ps=1.16u
    I_MXI95_MP5 (b4_7 XI95_Bn XI95_p1 VDD) gpdk090_pmos1v w=0.48u l=0.1u ad=0.1056p as=0.1632p pd=0.92u ps=1.64u
    I_MXI95_MP4 (XI95_p1 XI95_An b4_7 VDD) gpdk090_pmos1v w=0.48u l=0.1u ad=0.1056p as=0.1056p pd=0.92u ps=0.92u
    I_MXI95_MP2 (VDD dd7 XI95_p1 VDD) gpdk090_pmos1v w=0.48u l=0.1u ad=0.1056p as=0.1056p pd=0.92u ps=0.92u
    I_MXI95_MP3 (XI95_p1 qu4 VDD VDD) gpdk090_pmos1v w=0.48u l=0.1u ad=0.1632p as=0.1056p pd=1.64u ps=0.92u
    I_MXI95_MP0 (VDD dd7 XI95_An VDD) gpdk090_pmos1v w=0.24u l=0.1u ad=0.0816p as=0.0816p pd=1.16u ps=1.16u
    I_MXI124_MP1 (VDD qu1 XI124_Bn VDD) gpdk090_pmos1v w=0.24u l=0.1u ad=0.0816p as=0.0816p pd=1.16u ps=1.16u
    I_MXI124_MP5 (b7_0 XI124_Bn XI124_p1 VDD) gpdk090_pmos1v w=0.48u l=0.1u ad=0.1056p as=0.1632p pd=0.92u ps=1.64u
    I_MXI124_MP4 (XI124_p1 XI124_An b7_0 VDD) gpdk090_pmos1v w=0.48u l=0.1u ad=0.1056p as=0.1056p pd=0.92u ps=0.92u
    I_MXI124_MP2 (VDD B_0 XI124_p1 VDD) gpdk090_pmos1v w=0.48u l=0.1u ad=0.1056p as=0.1056p pd=0.92u ps=0.92u
    I_MXI124_MP3 (XI124_p1 qu1 VDD VDD) gpdk090_pmos1v w=0.48u l=0.1u ad=0.1632p as=0.1056p pd=1.64u ps=0.92u
    I_MXI124_MP0 (VDD B_0 XI124_An VDD) gpdk090_pmos1v w=0.24u l=0.1u ad=0.0816p as=0.0816p pd=1.16u ps=1.16u
    I_MXI88_MP1 (VDD qu4 XI88_Bn VDD) gpdk090_pmos1v w=0.24u l=0.1u ad=0.0816p as=0.0816p pd=1.16u ps=1.16u
    I_MXI88_MP5 (b4_0 XI88_Bn XI88_p1 VDD) gpdk090_pmos1v w=0.48u l=0.1u ad=0.1056p as=0.1632p pd=0.92u ps=1.64u
    I_MXI88_MP4 (XI88_p1 XI88_An b4_0 VDD) gpdk090_pmos1v w=0.48u l=0.1u ad=0.1056p as=0.1056p pd=0.92u ps=0.92u
    I_MXI88_MP2 (VDD B_0 XI88_p1 VDD) gpdk090_pmos1v w=0.48u l=0.1u ad=0.1056p as=0.1056p pd=0.92u ps=0.92u
    I_MXI88_MP3 (XI88_p1 qu4 VDD VDD) gpdk090_pmos1v w=0.48u l=0.1u ad=0.1632p as=0.1056p pd=1.64u ps=0.92u
    I_MXI88_MP0 (VDD B_0 XI88_An VDD) gpdk090_pmos1v w=0.24u l=0.1u ad=0.0816p as=0.0816p pd=1.16u ps=1.16u
    I_MXI90_MP1 (VDD qu4 XI90_Bn VDD) gpdk090_pmos1v w=0.24u l=0.1u ad=0.0816p as=0.0816p pd=1.16u ps=1.16u
    I_MXI90_MP5 (b4_2 XI90_Bn XI90_p1 VDD) gpdk090_pmos1v w=0.48u l=0.1u ad=0.1056p as=0.1632p pd=0.92u ps=1.64u
    I_MXI90_MP4 (XI90_p1 XI90_An b4_2 VDD) gpdk090_pmos1v w=0.48u l=0.1u ad=0.1056p as=0.1056p pd=0.92u ps=0.92u
    I_MXI90_MP2 (VDD dd2 XI90_p1 VDD) gpdk090_pmos1v w=0.48u l=0.1u ad=0.1056p as=0.1056p pd=0.92u ps=0.92u
    I_MXI90_MP3 (XI90_p1 qu4 VDD VDD) gpdk090_pmos1v w=0.48u l=0.1u ad=0.1632p as=0.1056p pd=1.64u ps=0.92u
    I_MXI90_MP0 (VDD dd2 XI90_An VDD) gpdk090_pmos1v w=0.24u l=0.1u ad=0.0816p as=0.0816p pd=1.16u ps=1.16u
    I_MXI91_MP1 (VDD qu4 XI91_Bn VDD) gpdk090_pmos1v w=0.24u l=0.1u ad=0.0816p as=0.0816p pd=1.16u ps=1.16u
    I_MXI91_MP5 (b4_3 XI91_Bn XI91_p1 VDD) gpdk090_pmos1v w=0.48u l=0.1u ad=0.1056p as=0.1632p pd=0.92u ps=1.64u
    I_MXI91_MP4 (XI91_p1 XI91_An b4_3 VDD) gpdk090_pmos1v w=0.48u l=0.1u ad=0.1056p as=0.1056p pd=0.92u ps=0.92u
    I_MXI91_MP2 (VDD dd3 XI91_p1 VDD) gpdk090_pmos1v w=0.48u l=0.1u ad=0.1056p as=0.1056p pd=0.92u ps=0.92u
    I_MXI91_MP3 (XI91_p1 qu4 VDD VDD) gpdk090_pmos1v w=0.48u l=0.1u ad=0.1632p as=0.1056p pd=1.64u ps=0.92u
    I_MXI91_MP0 (VDD dd3 XI91_An VDD) gpdk090_pmos1v w=0.24u l=0.1u ad=0.0816p as=0.0816p pd=1.16u ps=1.16u
    I_MXI92_MP1 (VDD qu4 XI92_Bn VDD) gpdk090_pmos1v w=0.24u l=0.1u ad=0.0816p as=0.0816p pd=1.16u ps=1.16u
    I_MXI92_MP5 (b4_4 XI92_Bn XI92_p1 VDD) gpdk090_pmos1v w=0.48u l=0.1u ad=0.1056p as=0.1632p pd=0.92u ps=1.64u
    I_MXI92_MP4 (XI92_p1 XI92_An b4_4 VDD) gpdk090_pmos1v w=0.48u l=0.1u ad=0.1056p as=0.1056p pd=0.92u ps=0.92u
    I_MXI92_MP2 (VDD dd4 XI92_p1 VDD) gpdk090_pmos1v w=0.48u l=0.1u ad=0.1056p as=0.1056p pd=0.92u ps=0.92u
    I_MXI92_MP3 (XI92_p1 qu4 VDD VDD) gpdk090_pmos1v w=0.48u l=0.1u ad=0.1632p as=0.1056p pd=1.64u ps=0.92u
    I_MXI92_MP0 (VDD dd4 XI92_An VDD) gpdk090_pmos1v w=0.24u l=0.1u ad=0.0816p as=0.0816p pd=1.16u ps=1.16u
    I_MXI94_MP1 (VDD qu4 XI94_Bn VDD) gpdk090_pmos1v w=0.24u l=0.1u ad=0.0816p as=0.0816p pd=1.16u ps=1.16u
    I_MXI94_MP5 (b4_6 XI94_Bn XI94_p1 VDD) gpdk090_pmos1v w=0.48u l=0.1u ad=0.1056p as=0.1632p pd=0.92u ps=1.64u
    I_MXI94_MP4 (XI94_p1 XI94_An b4_6 VDD) gpdk090_pmos1v w=0.48u l=0.1u ad=0.1056p as=0.1056p pd=0.92u ps=0.92u
    I_MXI94_MP2 (VDD dd6 XI94_p1 VDD) gpdk090_pmos1v w=0.48u l=0.1u ad=0.1056p as=0.1056p pd=0.92u ps=0.92u
    I_MXI94_MP3 (XI94_p1 qu4 VDD VDD) gpdk090_pmos1v w=0.48u l=0.1u ad=0.1632p as=0.1056p pd=1.64u ps=0.92u
    I_MXI94_MP0 (VDD dd6 XI94_An VDD) gpdk090_pmos1v w=0.24u l=0.1u ad=0.0816p as=0.0816p pd=1.16u ps=1.16u
    I_MXI97_MP1 (VDD qu4 XI97_Bn VDD) gpdk090_pmos1v w=0.24u l=0.1u ad=0.0816p as=0.0816p pd=1.16u ps=1.16u
    I_MXI97_MP5 (h4 XI97_Bn XI97_p1 VDD) gpdk090_pmos1v w=0.48u l=0.1u ad=0.1056p as=0.1632p pd=0.92u ps=1.64u
    I_MXI97_MP4 (XI97_p1 XI97_An h4 VDD) gpdk090_pmos1v w=0.48u l=0.1u ad=0.1056p as=0.1056p pd=0.92u ps=0.92u
    I_MXI97_MP2 (VDD p3_7 XI97_p1 VDD) gpdk090_pmos1v w=0.48u l=0.1u ad=0.1056p as=0.1056p pd=0.92u ps=0.92u
    I_MXI97_MP3 (XI97_p1 qu4 VDD VDD) gpdk090_pmos1v w=0.48u l=0.1u ad=0.1632p as=0.1056p pd=1.64u ps=0.92u
    I_MXI97_MP0 (VDD p3_7 XI97_An VDD) gpdk090_pmos1v w=0.24u l=0.1u ad=0.0816p as=0.0816p pd=1.16u ps=1.16u
    I_MXI152_I41_MP1 (VDD I152_G3_0n XI152_I41_Bn VDD) gpdk090_pmos1v w=0.24u l=0.1u ad=0.0816p as=0.0816p pd=1.16u ps=1.16u
    I_MXI152_I41_MP5 (ru4 XI152_I41_Bn XI152_I41_p1 VDD) gpdk090_pmos1v w=0.48u l=0.1u ad=0.1056p as=0.1632p pd=0.92u ps=1.64u
    I_MXI152_I41_MP4 (XI152_I41_p1 XI152_I41_An ru4 VDD) gpdk090_pmos1v w=0.48u l=0.1u ad=0.1056p as=0.1056p pd=0.92u ps=0.92u
    I_MXI152_I41_MP2 (VDD I152_pn4 XI152_I41_p1 VDD) gpdk090_pmos1v w=0.48u l=0.1u ad=0.1056p as=0.1056p pd=0.92u ps=0.92u
    I_MXI152_I41_MP3 (XI152_I41_p1 I152_G3_0n VDD VDD) gpdk090_pmos1v w=0.48u l=0.1u ad=0.1632p as=0.1056p pd=1.64u ps=0.92u
    I_MXI152_I41_MP0 (VDD I152_pn4 XI152_I41_An VDD) gpdk090_pmos1v w=0.24u l=0.1u ad=0.0816p as=0.0816p pd=1.16u ps=1.16u
    I_MXI153_MP1 (VDD B_7 XI153_Bn VDD) gpdk090_pmos1v w=0.24u l=0.1u ad=0.0816p as=0.0816p pd=1.16u ps=1.16u
    I_MXI153_MP5 (sq XI153_Bn XI153_p1 VDD) gpdk090_pmos1v w=0.48u l=0.1u ad=0.1056p as=0.1632p pd=0.92u ps=1.64u
    I_MXI153_MP4 (XI153_p1 XI153_An sq VDD) gpdk090_pmos1v w=0.48u l=0.1u ad=0.1056p as=0.1056p pd=0.92u ps=0.92u
    I_MXI153_MP2 (VDD A_7 XI153_p1 VDD) gpdk090_pmos1v w=0.48u l=0.1u ad=0.1056p as=0.1056p pd=0.92u ps=0.92u
    I_MXI153_MP3 (XI153_p1 B_7 VDD VDD) gpdk090_pmos1v w=0.48u l=0.1u ad=0.1632p as=0.1056p pd=1.64u ps=0.92u
    I_MXI153_MP0 (VDD A_7 XI153_An VDD) gpdk090_pmos1v w=0.24u l=0.1u ad=0.0816p as=0.0816p pd=1.16u ps=1.16u
    I_MXI76_MP1 (VDD qu5 XI76_Bn VDD) gpdk090_pmos1v w=0.24u l=0.1u ad=0.0816p as=0.0816p pd=1.16u ps=1.16u
    I_MXI76_MP5 (b3_0 XI76_Bn XI76_p1 VDD) gpdk090_pmos1v w=0.48u l=0.1u ad=0.1056p as=0.1632p pd=0.92u ps=1.64u
    I_MXI76_MP4 (XI76_p1 XI76_An b3_0 VDD) gpdk090_pmos1v w=0.48u l=0.1u ad=0.1056p as=0.1056p pd=0.92u ps=0.92u
    I_MXI76_MP2 (VDD B_0 XI76_p1 VDD) gpdk090_pmos1v w=0.48u l=0.1u ad=0.1056p as=0.1056p pd=0.92u ps=0.92u
    I_MXI76_MP3 (XI76_p1 qu5 VDD VDD) gpdk090_pmos1v w=0.48u l=0.1u ad=0.1632p as=0.1056p pd=1.64u ps=0.92u
    I_MXI76_MP0 (VDD B_0 XI76_An VDD) gpdk090_pmos1v w=0.24u l=0.1u ad=0.0816p as=0.0816p pd=1.16u ps=1.16u
    I_MXI84_I40_MP1 (VDD I84_G2_0n XI84_I40_Bn VDD) gpdk090_pmos1v w=0.24u l=0.1u ad=0.0816p as=0.0816p pd=1.16u ps=1.16u
    I_MXI84_I40_MP5 (p3_3 XI84_I40_Bn XI84_I40_p1 VDD) gpdk090_pmos1v w=0.48u l=0.1u ad=0.1056p as=0.1632p pd=0.92u ps=1.64u
    I_MXI84_I40_MP4 (XI84_I40_p1 XI84_I40_An p3_3 VDD) gpdk090_pmos1v w=0.48u l=0.1u ad=0.1056p as=0.1056p pd=0.92u ps=0.92u
    I_MXI84_I40_MP2 (VDD I84_pn3 XI84_I40_p1 VDD) gpdk090_pmos1v w=0.48u l=0.1u ad=0.1056p as=0.1056p pd=0.92u ps=0.92u
    I_MXI84_I40_MP3 (XI84_I40_p1 I84_G2_0n VDD VDD) gpdk090_pmos1v w=0.48u l=0.1u ad=0.1632p as=0.1056p pd=1.64u ps=0.92u
    I_MXI84_I40_MP0 (VDD I84_pn3 XI84_I40_An VDD) gpdk090_pmos1v w=0.24u l=0.1u ad=0.0816p as=0.0816p pd=1.16u ps=1.16u
    I_MXI93_MP1 (VDD qu4 XI93_Bn VDD) gpdk090_pmos1v w=0.24u l=0.1u ad=0.0816p as=0.0816p pd=1.16u ps=1.16u
    I_MXI93_MP5 (b4_5 XI93_Bn XI93_p1 VDD) gpdk090_pmos1v w=0.48u l=0.1u ad=0.1056p as=0.1632p pd=0.92u ps=1.64u
    I_MXI93_MP4 (XI93_p1 XI93_An b4_5 VDD) gpdk090_pmos1v w=0.48u l=0.1u ad=0.1056p as=0.1056p pd=0.92u ps=0.92u
    I_MXI93_MP2 (VDD dd5 XI93_p1 VDD) gpdk090_pmos1v w=0.48u l=0.1u ad=0.1056p as=0.1056p pd=0.92u ps=0.92u
    I_MXI93_MP3 (XI93_p1 qu4 VDD VDD) gpdk090_pmos1v w=0.48u l=0.1u ad=0.1632p as=0.1056p pd=1.64u ps=0.92u
    I_MXI93_MP0 (VDD dd5 XI93_An VDD) gpdk090_pmos1v w=0.24u l=0.1u ad=0.0816p as=0.0816p pd=1.16u ps=1.16u
    I_MXI64_MP1 (VDD qu6 XI64_Bn VDD) gpdk090_pmos1v w=0.24u l=0.1u ad=0.0816p as=0.0816p pd=1.16u ps=1.16u
    I_MXI64_MP5 (b2_0 XI64_Bn XI64_p1 VDD) gpdk090_pmos1v w=0.48u l=0.1u ad=0.1056p as=0.1632p pd=0.92u ps=1.64u
    I_MXI64_MP4 (XI64_p1 XI64_An b2_0 VDD) gpdk090_pmos1v w=0.48u l=0.1u ad=0.1056p as=0.1056p pd=0.92u ps=0.92u
    I_MXI64_MP2 (VDD B_0 XI64_p1 VDD) gpdk090_pmos1v w=0.48u l=0.1u ad=0.1056p as=0.1056p pd=0.92u ps=0.92u
    I_MXI64_MP3 (XI64_p1 qu6 VDD VDD) gpdk090_pmos1v w=0.48u l=0.1u ad=0.1632p as=0.1056p pd=1.64u ps=0.92u
    I_MXI64_MP0 (VDD B_0 XI64_An VDD) gpdk090_pmos1v w=0.24u l=0.1u ad=0.0816p as=0.0816p pd=1.16u ps=1.16u
    I_MXI77_MP1 (VDD qu5 XI77_Bn VDD) gpdk090_pmos1v w=0.24u l=0.1u ad=0.0816p as=0.0816p pd=1.16u ps=1.16u
    I_MXI77_MP5 (b3_1 XI77_Bn XI77_p1 VDD) gpdk090_pmos1v w=0.48u l=0.1u ad=0.1056p as=0.1632p pd=0.92u ps=1.64u
    I_MXI77_MP4 (XI77_p1 XI77_An b3_1 VDD) gpdk090_pmos1v w=0.48u l=0.1u ad=0.1056p as=0.1056p pd=0.92u ps=0.92u
    I_MXI77_MP2 (VDD dd1 XI77_p1 VDD) gpdk090_pmos1v w=0.48u l=0.1u ad=0.1056p as=0.1056p pd=0.92u ps=0.92u
    I_MXI77_MP3 (XI77_p1 qu5 VDD VDD) gpdk090_pmos1v w=0.48u l=0.1u ad=0.1632p as=0.1056p pd=1.64u ps=0.92u
    I_MXI77_MP0 (VDD dd1 XI77_An VDD) gpdk090_pmos1v w=0.24u l=0.1u ad=0.0816p as=0.0816p pd=1.16u ps=1.16u
    I_MXI152_I40_MP1 (VDD I152_G2_0n XI152_I40_Bn VDD) gpdk090_pmos1v w=0.24u l=0.1u ad=0.0816p as=0.0816p pd=1.16u ps=1.16u
    I_MXI152_I40_MP5 (ru3 XI152_I40_Bn XI152_I40_p1 VDD) gpdk090_pmos1v w=0.48u l=0.1u ad=0.1056p as=0.1632p pd=0.92u ps=1.64u
    I_MXI152_I40_MP4 (XI152_I40_p1 XI152_I40_An ru3 VDD) gpdk090_pmos1v w=0.48u l=0.1u ad=0.1056p as=0.1056p pd=0.92u ps=0.92u
    I_MXI152_I40_MP2 (VDD I152_pn3 XI152_I40_p1 VDD) gpdk090_pmos1v w=0.48u l=0.1u ad=0.1056p as=0.1056p pd=0.92u ps=0.92u
    I_MXI152_I40_MP3 (XI152_I40_p1 I152_G2_0n VDD VDD) gpdk090_pmos1v w=0.48u l=0.1u ad=0.1632p as=0.1056p pd=1.64u ps=0.92u
    I_MXI152_I40_MP0 (VDD I152_pn3 XI152_I40_An VDD) gpdk090_pmos1v w=0.24u l=0.1u ad=0.0816p as=0.0816p pd=1.16u ps=1.16u
    I_MXI40_MP1 (VDD VDD XI40_Bn VDD) gpdk090_pmos1v w=0.24u l=0.1u ad=0.0816p as=0.0816p pd=1.16u ps=1.16u
    I_MXI40_MP5 (b0_0 XI40_Bn XI40_p1 VDD) gpdk090_pmos1v w=0.48u l=0.1u ad=0.1056p as=0.1632p pd=0.92u ps=1.64u
    I_MXI40_MP4 (XI40_p1 XI40_An b0_0 VDD) gpdk090_pmos1v w=0.48u l=0.1u ad=0.1056p as=0.1056p pd=0.92u ps=0.92u
    I_MXI40_MP2 (VDD B_0 XI40_p1 VDD) gpdk090_pmos1v w=0.48u l=0.1u ad=0.1056p as=0.1056p pd=0.92u ps=0.92u
    I_MXI40_MP3 (XI40_p1 VDD VDD VDD) gpdk090_pmos1v w=0.48u l=0.1u ad=0.1632p as=0.1056p pd=1.64u ps=0.92u
    I_MXI40_MP0 (VDD B_0 XI40_An VDD) gpdk090_pmos1v w=0.24u l=0.1u ad=0.0816p as=0.0816p pd=1.16u ps=1.16u
    I_MXI52_MP1 (VDD qu7 XI52_Bn VDD) gpdk090_pmos1v w=0.24u l=0.1u ad=0.0816p as=0.0816p pd=1.16u ps=1.16u
    I_MXI52_MP5 (b1_0 XI52_Bn XI52_p1 VDD) gpdk090_pmos1v w=0.48u l=0.1u ad=0.1056p as=0.1632p pd=0.92u ps=1.64u
    I_MXI52_MP4 (XI52_p1 XI52_An b1_0 VDD) gpdk090_pmos1v w=0.48u l=0.1u ad=0.1056p as=0.1056p pd=0.92u ps=0.92u
    I_MXI52_MP2 (VDD B_0 XI52_p1 VDD) gpdk090_pmos1v w=0.48u l=0.1u ad=0.1056p as=0.1056p pd=0.92u ps=0.92u
    I_MXI52_MP3 (XI52_p1 qu7 VDD VDD) gpdk090_pmos1v w=0.48u l=0.1u ad=0.1632p as=0.1056p pd=1.64u ps=0.92u
    I_MXI52_MP0 (VDD B_0 XI52_An VDD) gpdk090_pmos1v w=0.24u l=0.1u ad=0.0816p as=0.0816p pd=1.16u ps=1.16u
    I_MXI78_MP1 (VDD qu5 XI78_Bn VDD) gpdk090_pmos1v w=0.24u l=0.1u ad=0.0816p as=0.0816p pd=1.16u ps=1.16u
    I_MXI78_MP5 (b3_2 XI78_Bn XI78_p1 VDD) gpdk090_pmos1v w=0.48u l=0.1u ad=0.1056p as=0.1632p pd=0.92u ps=1.64u
    I_MXI78_MP4 (XI78_p1 XI78_An b3_2 VDD) gpdk090_pmos1v w=0.48u l=0.1u ad=0.1056p as=0.1056p pd=0.92u ps=0.92u
    I_MXI78_MP2 (VDD dd2 XI78_p1 VDD) gpdk090_pmos1v w=0.48u l=0.1u ad=0.1056p as=0.1056p pd=0.92u ps=0.92u
    I_MXI78_MP3 (XI78_p1 qu5 VDD VDD) gpdk090_pmos1v w=0.48u l=0.1u ad=0.1632p as=0.1056p pd=1.64u ps=0.92u
    I_MXI78_MP0 (VDD dd2 XI78_An VDD) gpdk090_pmos1v w=0.24u l=0.1u ad=0.0816p as=0.0816p pd=1.16u ps=1.16u
    I_MXI84_I41_MP1 (VDD I84_G3_0n XI84_I41_Bn VDD) gpdk090_pmos1v w=0.24u l=0.1u ad=0.0816p as=0.0816p pd=1.16u ps=1.16u
    I_MXI84_I41_MP5 (p3_4 XI84_I41_Bn XI84_I41_p1 VDD) gpdk090_pmos1v w=0.48u l=0.1u ad=0.1056p as=0.1632p pd=0.92u ps=1.64u
    I_MXI84_I41_MP4 (XI84_I41_p1 XI84_I41_An p3_4 VDD) gpdk090_pmos1v w=0.48u l=0.1u ad=0.1056p as=0.1056p pd=0.92u ps=0.92u
    I_MXI84_I41_MP2 (VDD I84_pn4 XI84_I41_p1 VDD) gpdk090_pmos1v w=0.48u l=0.1u ad=0.1056p as=0.1056p pd=0.92u ps=0.92u
    I_MXI84_I41_MP3 (XI84_I41_p1 I84_G3_0n VDD VDD) gpdk090_pmos1v w=0.48u l=0.1u ad=0.1632p as=0.1056p pd=1.64u ps=0.92u
    I_MXI84_I41_MP0 (VDD I84_pn4 XI84_I41_An VDD) gpdk090_pmos1v w=0.24u l=0.1u ad=0.0816p as=0.0816p pd=1.16u ps=1.16u
    I_MXI43_MP1 (VDD VDD XI43_Bn VDD) gpdk090_pmos1v w=0.24u l=0.1u ad=0.0816p as=0.0816p pd=1.16u ps=1.16u
    I_MXI43_MP5 (b0_3 XI43_Bn XI43_p1 VDD) gpdk090_pmos1v w=0.48u l=0.1u ad=0.1056p as=0.1632p pd=0.92u ps=1.64u
    I_MXI43_MP4 (XI43_p1 XI43_An b0_3 VDD) gpdk090_pmos1v w=0.48u l=0.1u ad=0.1056p as=0.1056p pd=0.92u ps=0.92u
    I_MXI43_MP2 (VDD dd3 XI43_p1 VDD) gpdk090_pmos1v w=0.48u l=0.1u ad=0.1056p as=0.1056p pd=0.92u ps=0.92u
    I_MXI43_MP3 (XI43_p1 VDD VDD VDD) gpdk090_pmos1v w=0.48u l=0.1u ad=0.1632p as=0.1056p pd=1.64u ps=0.92u
    I_MXI43_MP0 (VDD dd3 XI43_An VDD) gpdk090_pmos1v w=0.24u l=0.1u ad=0.0816p as=0.0816p pd=1.16u ps=1.16u
    I_MXI42_MP1 (VDD VDD XI42_Bn VDD) gpdk090_pmos1v w=0.24u l=0.1u ad=0.0816p as=0.0816p pd=1.16u ps=1.16u
    I_MXI42_MP5 (b0_2 XI42_Bn XI42_p1 VDD) gpdk090_pmos1v w=0.48u l=0.1u ad=0.1056p as=0.1632p pd=0.92u ps=1.64u
    I_MXI42_MP4 (XI42_p1 XI42_An b0_2 VDD) gpdk090_pmos1v w=0.48u l=0.1u ad=0.1056p as=0.1056p pd=0.92u ps=0.92u
    I_MXI42_MP2 (VDD dd2 XI42_p1 VDD) gpdk090_pmos1v w=0.48u l=0.1u ad=0.1056p as=0.1056p pd=0.92u ps=0.92u
    I_MXI42_MP3 (XI42_p1 VDD VDD VDD) gpdk090_pmos1v w=0.48u l=0.1u ad=0.1632p as=0.1056p pd=1.64u ps=0.92u
    I_MXI42_MP0 (VDD dd2 XI42_An VDD) gpdk090_pmos1v w=0.24u l=0.1u ad=0.0816p as=0.0816p pd=1.16u ps=1.16u
    I_MXI41_MP1 (VDD VDD XI41_Bn VDD) gpdk090_pmos1v w=0.24u l=0.1u ad=0.0816p as=0.0816p pd=1.16u ps=1.16u
    I_MXI41_MP5 (b0_1 XI41_Bn XI41_p1 VDD) gpdk090_pmos1v w=0.48u l=0.1u ad=0.1056p as=0.1632p pd=0.92u ps=1.64u
    I_MXI41_MP4 (XI41_p1 XI41_An b0_1 VDD) gpdk090_pmos1v w=0.48u l=0.1u ad=0.1056p as=0.1056p pd=0.92u ps=0.92u
    I_MXI41_MP2 (VDD dd1 XI41_p1 VDD) gpdk090_pmos1v w=0.48u l=0.1u ad=0.1056p as=0.1056p pd=0.92u ps=0.92u
    I_MXI41_MP3 (XI41_p1 VDD VDD VDD) gpdk090_pmos1v w=0.48u l=0.1u ad=0.1632p as=0.1056p pd=1.64u ps=0.92u
    I_MXI41_MP0 (VDD dd1 XI41_An VDD) gpdk090_pmos1v w=0.24u l=0.1u ad=0.0816p as=0.0816p pd=1.16u ps=1.16u
    I_MXI53_MP1 (VDD qu7 XI53_Bn VDD) gpdk090_pmos1v w=0.24u l=0.1u ad=0.0816p as=0.0816p pd=1.16u ps=1.16u
    I_MXI53_MP5 (b1_1 XI53_Bn XI53_p1 VDD) gpdk090_pmos1v w=0.48u l=0.1u ad=0.1056p as=0.1632p pd=0.92u ps=1.64u
    I_MXI53_MP4 (XI53_p1 XI53_An b1_1 VDD) gpdk090_pmos1v w=0.48u l=0.1u ad=0.1056p as=0.1056p pd=0.92u ps=0.92u
    I_MXI53_MP2 (VDD dd1 XI53_p1 VDD) gpdk090_pmos1v w=0.48u l=0.1u ad=0.1056p as=0.1056p pd=0.92u ps=0.92u
    I_MXI53_MP3 (XI53_p1 qu7 VDD VDD) gpdk090_pmos1v w=0.48u l=0.1u ad=0.1632p as=0.1056p pd=1.64u ps=0.92u
    I_MXI53_MP0 (VDD dd1 XI53_An VDD) gpdk090_pmos1v w=0.24u l=0.1u ad=0.0816p as=0.0816p pd=1.16u ps=1.16u
    I_MXI65_MP1 (VDD qu6 XI65_Bn VDD) gpdk090_pmos1v w=0.24u l=0.1u ad=0.0816p as=0.0816p pd=1.16u ps=1.16u
    I_MXI65_MP5 (b2_1 XI65_Bn XI65_p1 VDD) gpdk090_pmos1v w=0.48u l=0.1u ad=0.1056p as=0.1632p pd=0.92u ps=1.64u
    I_MXI65_MP4 (XI65_p1 XI65_An b2_1 VDD) gpdk090_pmos1v w=0.48u l=0.1u ad=0.1056p as=0.1056p pd=0.92u ps=0.92u
    I_MXI65_MP2 (VDD dd1 XI65_p1 VDD) gpdk090_pmos1v w=0.48u l=0.1u ad=0.1056p as=0.1056p pd=0.92u ps=0.92u
    I_MXI65_MP3 (XI65_p1 qu6 VDD VDD) gpdk090_pmos1v w=0.48u l=0.1u ad=0.1632p as=0.1056p pd=1.64u ps=0.92u
    I_MXI65_MP0 (VDD dd1 XI65_An VDD) gpdk090_pmos1v w=0.24u l=0.1u ad=0.0816p as=0.0816p pd=1.16u ps=1.16u
    I_MXI79_MP1 (VDD qu5 XI79_Bn VDD) gpdk090_pmos1v w=0.24u l=0.1u ad=0.0816p as=0.0816p pd=1.16u ps=1.16u
    I_MXI79_MP5 (b3_3 XI79_Bn XI79_p1 VDD) gpdk090_pmos1v w=0.48u l=0.1u ad=0.1056p as=0.1632p pd=0.92u ps=1.64u
    I_MXI79_MP4 (XI79_p1 XI79_An b3_3 VDD) gpdk090_pmos1v w=0.48u l=0.1u ad=0.1056p as=0.1056p pd=0.92u ps=0.92u
    I_MXI79_MP2 (VDD dd3 XI79_p1 VDD) gpdk090_pmos1v w=0.48u l=0.1u ad=0.1056p as=0.1056p pd=0.92u ps=0.92u
    I_MXI79_MP3 (XI79_p1 qu5 VDD VDD) gpdk090_pmos1v w=0.48u l=0.1u ad=0.1632p as=0.1056p pd=1.64u ps=0.92u
    I_MXI79_MP0 (VDD dd3 XI79_An VDD) gpdk090_pmos1v w=0.24u l=0.1u ad=0.0816p as=0.0816p pd=1.16u ps=1.16u
    I_MXI80_MP1 (VDD qu5 XI80_Bn VDD) gpdk090_pmos1v w=0.24u l=0.1u ad=0.0816p as=0.0816p pd=1.16u ps=1.16u
    I_MXI80_MP5 (b3_4 XI80_Bn XI80_p1 VDD) gpdk090_pmos1v w=0.48u l=0.1u ad=0.1056p as=0.1632p pd=0.92u ps=1.64u
    I_MXI80_MP4 (XI80_p1 XI80_An b3_4 VDD) gpdk090_pmos1v w=0.48u l=0.1u ad=0.1056p as=0.1056p pd=0.92u ps=0.92u
    I_MXI80_MP2 (VDD dd4 XI80_p1 VDD) gpdk090_pmos1v w=0.48u l=0.1u ad=0.1056p as=0.1056p pd=0.92u ps=0.92u
    I_MXI80_MP3 (XI80_p1 qu5 VDD VDD) gpdk090_pmos1v w=0.48u l=0.1u ad=0.1632p as=0.1056p pd=1.64u ps=0.92u
    I_MXI80_MP0 (VDD dd4 XI80_An VDD) gpdk090_pmos1v w=0.24u l=0.1u ad=0.0816p as=0.0816p pd=1.16u ps=1.16u
    I_MXI44_MP1 (VDD VDD XI44_Bn VDD) gpdk090_pmos1v w=0.24u l=0.1u ad=0.0816p as=0.0816p pd=1.16u ps=1.16u
    I_MXI44_MP5 (b0_4 XI44_Bn XI44_p1 VDD) gpdk090_pmos1v w=0.48u l=0.1u ad=0.1056p as=0.1632p pd=0.92u ps=1.64u
    I_MXI44_MP4 (XI44_p1 XI44_An b0_4 VDD) gpdk090_pmos1v w=0.48u l=0.1u ad=0.1056p as=0.1056p pd=0.92u ps=0.92u
    I_MXI44_MP2 (VDD dd4 XI44_p1 VDD) gpdk090_pmos1v w=0.48u l=0.1u ad=0.1056p as=0.1056p pd=0.92u ps=0.92u
    I_MXI44_MP3 (XI44_p1 VDD VDD VDD) gpdk090_pmos1v w=0.48u l=0.1u ad=0.1632p as=0.1056p pd=1.64u ps=0.92u
    I_MXI44_MP0 (VDD dd4 XI44_An VDD) gpdk090_pmos1v w=0.24u l=0.1u ad=0.0816p as=0.0816p pd=1.16u ps=1.16u
    I_MXI55_MP1 (VDD qu7 XI55_Bn VDD) gpdk090_pmos1v w=0.24u l=0.1u ad=0.0816p as=0.0816p pd=1.16u ps=1.16u
    I_MXI55_MP5 (b1_3 XI55_Bn XI55_p1 VDD) gpdk090_pmos1v w=0.48u l=0.1u ad=0.1056p as=0.1632p pd=0.92u ps=1.64u
    I_MXI55_MP4 (XI55_p1 XI55_An b1_3 VDD) gpdk090_pmos1v w=0.48u l=0.1u ad=0.1056p as=0.1056p pd=0.92u ps=0.92u
    I_MXI55_MP2 (VDD dd3 XI55_p1 VDD) gpdk090_pmos1v w=0.48u l=0.1u ad=0.1056p as=0.1056p pd=0.92u ps=0.92u
    I_MXI55_MP3 (XI55_p1 qu7 VDD VDD) gpdk090_pmos1v w=0.48u l=0.1u ad=0.1632p as=0.1056p pd=1.64u ps=0.92u
    I_MXI55_MP0 (VDD dd3 XI55_An VDD) gpdk090_pmos1v w=0.24u l=0.1u ad=0.0816p as=0.0816p pd=1.16u ps=1.16u
    I_MXI54_MP1 (VDD qu7 XI54_Bn VDD) gpdk090_pmos1v w=0.24u l=0.1u ad=0.0816p as=0.0816p pd=1.16u ps=1.16u
    I_MXI54_MP5 (b1_2 XI54_Bn XI54_p1 VDD) gpdk090_pmos1v w=0.48u l=0.1u ad=0.1056p as=0.1632p pd=0.92u ps=1.64u
    I_MXI54_MP4 (XI54_p1 XI54_An b1_2 VDD) gpdk090_pmos1v w=0.48u l=0.1u ad=0.1056p as=0.1056p pd=0.92u ps=0.92u
    I_MXI54_MP2 (VDD dd2 XI54_p1 VDD) gpdk090_pmos1v w=0.48u l=0.1u ad=0.1056p as=0.1056p pd=0.92u ps=0.92u
    I_MXI54_MP3 (XI54_p1 qu7 VDD VDD) gpdk090_pmos1v w=0.48u l=0.1u ad=0.1632p as=0.1056p pd=1.64u ps=0.92u
    I_MXI54_MP0 (VDD dd2 XI54_An VDD) gpdk090_pmos1v w=0.24u l=0.1u ad=0.0816p as=0.0816p pd=1.16u ps=1.16u
    I_MXI67_MP1 (VDD qu6 XI67_Bn VDD) gpdk090_pmos1v w=0.24u l=0.1u ad=0.0816p as=0.0816p pd=1.16u ps=1.16u
    I_MXI67_MP5 (b2_3 XI67_Bn XI67_p1 VDD) gpdk090_pmos1v w=0.48u l=0.1u ad=0.1056p as=0.1632p pd=0.92u ps=1.64u
    I_MXI67_MP4 (XI67_p1 XI67_An b2_3 VDD) gpdk090_pmos1v w=0.48u l=0.1u ad=0.1056p as=0.1056p pd=0.92u ps=0.92u
    I_MXI67_MP2 (VDD dd3 XI67_p1 VDD) gpdk090_pmos1v w=0.48u l=0.1u ad=0.1056p as=0.1056p pd=0.92u ps=0.92u
    I_MXI67_MP3 (XI67_p1 qu6 VDD VDD) gpdk090_pmos1v w=0.48u l=0.1u ad=0.1632p as=0.1056p pd=1.64u ps=0.92u
    I_MXI67_MP0 (VDD dd3 XI67_An VDD) gpdk090_pmos1v w=0.24u l=0.1u ad=0.0816p as=0.0816p pd=1.16u ps=1.16u
    I_MXI66_MP1 (VDD qu6 XI66_Bn VDD) gpdk090_pmos1v w=0.24u l=0.1u ad=0.0816p as=0.0816p pd=1.16u ps=1.16u
    I_MXI66_MP5 (b2_2 XI66_Bn XI66_p1 VDD) gpdk090_pmos1v w=0.48u l=0.1u ad=0.1056p as=0.1632p pd=0.92u ps=1.64u
    I_MXI66_MP4 (XI66_p1 XI66_An b2_2 VDD) gpdk090_pmos1v w=0.48u l=0.1u ad=0.1056p as=0.1056p pd=0.92u ps=0.92u
    I_MXI66_MP2 (VDD dd2 XI66_p1 VDD) gpdk090_pmos1v w=0.48u l=0.1u ad=0.1056p as=0.1056p pd=0.92u ps=0.92u
    I_MXI66_MP3 (XI66_p1 qu6 VDD VDD) gpdk090_pmos1v w=0.48u l=0.1u ad=0.1632p as=0.1056p pd=1.64u ps=0.92u
    I_MXI66_MP0 (VDD dd2 XI66_An VDD) gpdk090_pmos1v w=0.24u l=0.1u ad=0.0816p as=0.0816p pd=1.16u ps=1.16u
    I_MXI72_I40_MP1 (VDD I72_G2_0n XI72_I40_Bn VDD) gpdk090_pmos1v w=0.24u l=0.1u ad=0.0816p as=0.0816p pd=1.16u ps=1.16u
    I_MXI72_I40_MP5 (p2_3 XI72_I40_Bn XI72_I40_p1 VDD) gpdk090_pmos1v w=0.48u l=0.1u ad=0.1056p as=0.1632p pd=0.92u ps=1.64u
    I_MXI72_I40_MP4 (XI72_I40_p1 XI72_I40_An p2_3 VDD) gpdk090_pmos1v w=0.48u l=0.1u ad=0.1056p as=0.1056p pd=0.92u ps=0.92u
    I_MXI72_I40_MP2 (VDD I72_pn3 XI72_I40_p1 VDD) gpdk090_pmos1v w=0.48u l=0.1u ad=0.1056p as=0.1056p pd=0.92u ps=0.92u
    I_MXI72_I40_MP3 (XI72_I40_p1 I72_G2_0n VDD VDD) gpdk090_pmos1v w=0.48u l=0.1u ad=0.1632p as=0.1056p pd=1.64u ps=0.92u
    I_MXI72_I40_MP0 (VDD I72_pn3 XI72_I40_An VDD) gpdk090_pmos1v w=0.24u l=0.1u ad=0.0816p as=0.0816p pd=1.16u ps=1.16u
    I_MXI81_MP1 (VDD qu5 XI81_Bn VDD) gpdk090_pmos1v w=0.24u l=0.1u ad=0.0816p as=0.0816p pd=1.16u ps=1.16u
    I_MXI81_MP5 (b3_5 XI81_Bn XI81_p1 VDD) gpdk090_pmos1v w=0.48u l=0.1u ad=0.1056p as=0.1632p pd=0.92u ps=1.64u
    I_MXI81_MP4 (XI81_p1 XI81_An b3_5 VDD) gpdk090_pmos1v w=0.48u l=0.1u ad=0.1056p as=0.1056p pd=0.92u ps=0.92u
    I_MXI81_MP2 (VDD dd5 XI81_p1 VDD) gpdk090_pmos1v w=0.48u l=0.1u ad=0.1056p as=0.1056p pd=0.92u ps=0.92u
    I_MXI81_MP3 (XI81_p1 qu5 VDD VDD) gpdk090_pmos1v w=0.48u l=0.1u ad=0.1632p as=0.1056p pd=1.64u ps=0.92u
    I_MXI81_MP0 (VDD dd5 XI81_An VDD) gpdk090_pmos1v w=0.24u l=0.1u ad=0.0816p as=0.0816p pd=1.16u ps=1.16u
    I_MXI86_MP1 (VDD c3_8 XI86_Bn VDD) gpdk090_pmos1v w=0.24u l=0.1u ad=0.0816p as=0.0816p pd=1.16u ps=1.16u
    I_MXI86_MP5 (p3_8 XI86_Bn XI86_p1 VDD) gpdk090_pmos1v w=0.48u l=0.1u ad=0.1056p as=0.1632p pd=0.92u ps=1.64u
    I_MXI86_MP4 (XI86_p1 XI86_An p3_8 VDD) gpdk090_pmos1v w=0.48u l=0.1u ad=0.1056p as=0.1056p pd=0.92u ps=0.92u
    I_MXI86_MP2 (VDD h3 XI86_p1 VDD) gpdk090_pmos1v w=0.48u l=0.1u ad=0.1056p as=0.1056p pd=0.92u ps=0.92u
    I_MXI86_MP3 (XI86_p1 c3_8 VDD VDD) gpdk090_pmos1v w=0.48u l=0.1u ad=0.1632p as=0.1056p pd=1.64u ps=0.92u
    I_MXI86_MP0 (VDD h3 XI86_An VDD) gpdk090_pmos1v w=0.24u l=0.1u ad=0.0816p as=0.0816p pd=1.16u ps=1.16u
    I_MXI45_MP1 (VDD VDD XI45_Bn VDD) gpdk090_pmos1v w=0.24u l=0.1u ad=0.0816p as=0.0816p pd=1.16u ps=1.16u
    I_MXI45_MP5 (b0_5 XI45_Bn XI45_p1 VDD) gpdk090_pmos1v w=0.48u l=0.1u ad=0.1056p as=0.1632p pd=0.92u ps=1.64u
    I_MXI45_MP4 (XI45_p1 XI45_An b0_5 VDD) gpdk090_pmos1v w=0.48u l=0.1u ad=0.1056p as=0.1056p pd=0.92u ps=0.92u
    I_MXI45_MP2 (VDD dd5 XI45_p1 VDD) gpdk090_pmos1v w=0.48u l=0.1u ad=0.1056p as=0.1056p pd=0.92u ps=0.92u
    I_MXI45_MP3 (XI45_p1 VDD VDD VDD) gpdk090_pmos1v w=0.48u l=0.1u ad=0.1632p as=0.1056p pd=1.64u ps=0.92u
    I_MXI45_MP0 (VDD dd5 XI45_An VDD) gpdk090_pmos1v w=0.24u l=0.1u ad=0.0816p as=0.0816p pd=1.16u ps=1.16u
    I_MXI56_MP1 (VDD qu7 XI56_Bn VDD) gpdk090_pmos1v w=0.24u l=0.1u ad=0.0816p as=0.0816p pd=1.16u ps=1.16u
    I_MXI56_MP5 (b1_4 XI56_Bn XI56_p1 VDD) gpdk090_pmos1v w=0.48u l=0.1u ad=0.1056p as=0.1632p pd=0.92u ps=1.64u
    I_MXI56_MP4 (XI56_p1 XI56_An b1_4 VDD) gpdk090_pmos1v w=0.48u l=0.1u ad=0.1056p as=0.1056p pd=0.92u ps=0.92u
    I_MXI56_MP2 (VDD dd4 XI56_p1 VDD) gpdk090_pmos1v w=0.48u l=0.1u ad=0.1056p as=0.1056p pd=0.92u ps=0.92u
    I_MXI56_MP3 (XI56_p1 qu7 VDD VDD) gpdk090_pmos1v w=0.48u l=0.1u ad=0.1632p as=0.1056p pd=1.64u ps=0.92u
    I_MXI56_MP0 (VDD dd4 XI56_An VDD) gpdk090_pmos1v w=0.24u l=0.1u ad=0.0816p as=0.0816p pd=1.16u ps=1.16u
    I_MXI68_MP1 (VDD qu6 XI68_Bn VDD) gpdk090_pmos1v w=0.24u l=0.1u ad=0.0816p as=0.0816p pd=1.16u ps=1.16u
    I_MXI68_MP5 (b2_4 XI68_Bn XI68_p1 VDD) gpdk090_pmos1v w=0.48u l=0.1u ad=0.1056p as=0.1632p pd=0.92u ps=1.64u
    I_MXI68_MP4 (XI68_p1 XI68_An b2_4 VDD) gpdk090_pmos1v w=0.48u l=0.1u ad=0.1056p as=0.1056p pd=0.92u ps=0.92u
    I_MXI68_MP2 (VDD dd4 XI68_p1 VDD) gpdk090_pmos1v w=0.48u l=0.1u ad=0.1056p as=0.1056p pd=0.92u ps=0.92u
    I_MXI68_MP3 (XI68_p1 qu6 VDD VDD) gpdk090_pmos1v w=0.48u l=0.1u ad=0.1632p as=0.1056p pd=1.64u ps=0.92u
    I_MXI68_MP0 (VDD dd4 XI68_An VDD) gpdk090_pmos1v w=0.24u l=0.1u ad=0.0816p as=0.0816p pd=1.16u ps=1.16u
    I_MXI72_I41_MP1 (VDD I72_G3_0n XI72_I41_Bn VDD) gpdk090_pmos1v w=0.24u l=0.1u ad=0.0816p as=0.0816p pd=1.16u ps=1.16u
    I_MXI72_I41_MP5 (p2_4 XI72_I41_Bn XI72_I41_p1 VDD) gpdk090_pmos1v w=0.48u l=0.1u ad=0.1056p as=0.1632p pd=0.92u ps=1.64u
    I_MXI72_I41_MP4 (XI72_I41_p1 XI72_I41_An p2_4 VDD) gpdk090_pmos1v w=0.48u l=0.1u ad=0.1056p as=0.1056p pd=0.92u ps=0.92u
    I_MXI72_I41_MP2 (VDD I72_pn4 XI72_I41_p1 VDD) gpdk090_pmos1v w=0.48u l=0.1u ad=0.1056p as=0.1056p pd=0.92u ps=0.92u
    I_MXI72_I41_MP3 (XI72_I41_p1 I72_G3_0n VDD VDD) gpdk090_pmos1v w=0.48u l=0.1u ad=0.1632p as=0.1056p pd=1.64u ps=0.92u
    I_MXI72_I41_MP0 (VDD I72_pn4 XI72_I41_An VDD) gpdk090_pmos1v w=0.24u l=0.1u ad=0.0816p as=0.0816p pd=1.16u ps=1.16u
    I_MXI82_MP1 (VDD qu5 XI82_Bn VDD) gpdk090_pmos1v w=0.24u l=0.1u ad=0.0816p as=0.0816p pd=1.16u ps=1.16u
    I_MXI82_MP5 (b3_6 XI82_Bn XI82_p1 VDD) gpdk090_pmos1v w=0.48u l=0.1u ad=0.1056p as=0.1632p pd=0.92u ps=1.64u
    I_MXI82_MP4 (XI82_p1 XI82_An b3_6 VDD) gpdk090_pmos1v w=0.48u l=0.1u ad=0.1056p as=0.1056p pd=0.92u ps=0.92u
    I_MXI82_MP2 (VDD dd6 XI82_p1 VDD) gpdk090_pmos1v w=0.48u l=0.1u ad=0.1056p as=0.1056p pd=0.92u ps=0.92u
    I_MXI82_MP3 (XI82_p1 qu5 VDD VDD) gpdk090_pmos1v w=0.48u l=0.1u ad=0.1632p as=0.1056p pd=1.64u ps=0.92u
    I_MXI82_MP0 (VDD dd6 XI82_An VDD) gpdk090_pmos1v w=0.24u l=0.1u ad=0.0816p as=0.0816p pd=1.16u ps=1.16u
    I_MXI48_I40_MP1 (VDD I48_G2_0n XI48_I40_Bn VDD) gpdk090_pmos1v w=0.24u l=0.1u ad=0.0816p as=0.0816p pd=1.16u ps=1.16u
    I_MXI48_I40_MP5 (p0_3 XI48_I40_Bn XI48_I40_p1 VDD) gpdk090_pmos1v w=0.48u l=0.1u ad=0.1056p as=0.1632p pd=0.92u ps=1.64u
    I_MXI48_I40_MP4 (XI48_I40_p1 XI48_I40_An p0_3 VDD) gpdk090_pmos1v w=0.48u l=0.1u ad=0.1056p as=0.1056p pd=0.92u ps=0.92u
    I_MXI48_I40_MP2 (VDD I48_pn3 XI48_I40_p1 VDD) gpdk090_pmos1v w=0.48u l=0.1u ad=0.1056p as=0.1056p pd=0.92u ps=0.92u
    I_MXI48_I40_MP3 (XI48_I40_p1 I48_G2_0n VDD VDD) gpdk090_pmos1v w=0.48u l=0.1u ad=0.1632p as=0.1056p pd=1.64u ps=0.92u
    I_MXI48_I40_MP0 (VDD I48_pn3 XI48_I40_An VDD) gpdk090_pmos1v w=0.24u l=0.1u ad=0.0816p as=0.0816p pd=1.16u ps=1.16u
    I_MXI57_MP1 (VDD qu7 XI57_Bn VDD) gpdk090_pmos1v w=0.24u l=0.1u ad=0.0816p as=0.0816p pd=1.16u ps=1.16u
    I_MXI57_MP5 (b1_5 XI57_Bn XI57_p1 VDD) gpdk090_pmos1v w=0.48u l=0.1u ad=0.1056p as=0.1632p pd=0.92u ps=1.64u
    I_MXI57_MP4 (XI57_p1 XI57_An b1_5 VDD) gpdk090_pmos1v w=0.48u l=0.1u ad=0.1056p as=0.1056p pd=0.92u ps=0.92u
    I_MXI57_MP2 (VDD dd5 XI57_p1 VDD) gpdk090_pmos1v w=0.48u l=0.1u ad=0.1056p as=0.1056p pd=0.92u ps=0.92u
    I_MXI57_MP3 (XI57_p1 qu7 VDD VDD) gpdk090_pmos1v w=0.48u l=0.1u ad=0.1632p as=0.1056p pd=1.64u ps=0.92u
    I_MXI57_MP0 (VDD dd5 XI57_An VDD) gpdk090_pmos1v w=0.24u l=0.1u ad=0.0816p as=0.0816p pd=1.16u ps=1.16u
    I_MXI60_I40_MP1 (VDD I60_G2_0n XI60_I40_Bn VDD) gpdk090_pmos1v w=0.24u l=0.1u ad=0.0816p as=0.0816p pd=1.16u ps=1.16u
    I_MXI60_I40_MP5 (p1_3 XI60_I40_Bn XI60_I40_p1 VDD) gpdk090_pmos1v w=0.48u l=0.1u ad=0.1056p as=0.1632p pd=0.92u ps=1.64u
    I_MXI60_I40_MP4 (XI60_I40_p1 XI60_I40_An p1_3 VDD) gpdk090_pmos1v w=0.48u l=0.1u ad=0.1056p as=0.1056p pd=0.92u ps=0.92u
    I_MXI60_I40_MP2 (VDD I60_pn3 XI60_I40_p1 VDD) gpdk090_pmos1v w=0.48u l=0.1u ad=0.1056p as=0.1056p pd=0.92u ps=0.92u
    I_MXI60_I40_MP3 (XI60_I40_p1 I60_G2_0n VDD VDD) gpdk090_pmos1v w=0.48u l=0.1u ad=0.1632p as=0.1056p pd=1.64u ps=0.92u
    I_MXI60_I40_MP0 (VDD I60_pn3 XI60_I40_An VDD) gpdk090_pmos1v w=0.24u l=0.1u ad=0.0816p as=0.0816p pd=1.16u ps=1.16u
    I_MXI69_MP1 (VDD qu6 XI69_Bn VDD) gpdk090_pmos1v w=0.24u l=0.1u ad=0.0816p as=0.0816p pd=1.16u ps=1.16u
    I_MXI69_MP5 (b2_5 XI69_Bn XI69_p1 VDD) gpdk090_pmos1v w=0.48u l=0.1u ad=0.1056p as=0.1632p pd=0.92u ps=1.64u
    I_MXI69_MP4 (XI69_p1 XI69_An b2_5 VDD) gpdk090_pmos1v w=0.48u l=0.1u ad=0.1056p as=0.1056p pd=0.92u ps=0.92u
    I_MXI69_MP2 (VDD dd5 XI69_p1 VDD) gpdk090_pmos1v w=0.48u l=0.1u ad=0.1056p as=0.1056p pd=0.92u ps=0.92u
    I_MXI69_MP3 (XI69_p1 qu6 VDD VDD) gpdk090_pmos1v w=0.48u l=0.1u ad=0.1632p as=0.1056p pd=1.64u ps=0.92u
    I_MXI69_MP0 (VDD dd5 XI69_An VDD) gpdk090_pmos1v w=0.24u l=0.1u ad=0.0816p as=0.0816p pd=1.16u ps=1.16u
    I_MXI83_MP1 (VDD qu5 XI83_Bn VDD) gpdk090_pmos1v w=0.24u l=0.1u ad=0.0816p as=0.0816p pd=1.16u ps=1.16u
    I_MXI83_MP5 (b3_7 XI83_Bn XI83_p1 VDD) gpdk090_pmos1v w=0.48u l=0.1u ad=0.1056p as=0.1632p pd=0.92u ps=1.64u
    I_MXI83_MP4 (XI83_p1 XI83_An b3_7 VDD) gpdk090_pmos1v w=0.48u l=0.1u ad=0.1056p as=0.1056p pd=0.92u ps=0.92u
    I_MXI83_MP2 (VDD dd7 XI83_p1 VDD) gpdk090_pmos1v w=0.48u l=0.1u ad=0.1056p as=0.1056p pd=0.92u ps=0.92u
    I_MXI83_MP3 (XI83_p1 qu5 VDD VDD) gpdk090_pmos1v w=0.48u l=0.1u ad=0.1632p as=0.1056p pd=1.64u ps=0.92u
    I_MXI83_MP0 (VDD dd7 XI83_An VDD) gpdk090_pmos1v w=0.24u l=0.1u ad=0.0816p as=0.0816p pd=1.16u ps=1.16u
    I_MXI46_MP1 (VDD VDD XI46_Bn VDD) gpdk090_pmos1v w=0.24u l=0.1u ad=0.0816p as=0.0816p pd=1.16u ps=1.16u
    I_MXI46_MP5 (b0_6 XI46_Bn XI46_p1 VDD) gpdk090_pmos1v w=0.48u l=0.1u ad=0.1056p as=0.1632p pd=0.92u ps=1.64u
    I_MXI46_MP4 (XI46_p1 XI46_An b0_6 VDD) gpdk090_pmos1v w=0.48u l=0.1u ad=0.1056p as=0.1056p pd=0.92u ps=0.92u
    I_MXI46_MP2 (VDD dd6 XI46_p1 VDD) gpdk090_pmos1v w=0.48u l=0.1u ad=0.1056p as=0.1056p pd=0.92u ps=0.92u
    I_MXI46_MP3 (XI46_p1 VDD VDD VDD) gpdk090_pmos1v w=0.48u l=0.1u ad=0.1632p as=0.1056p pd=1.64u ps=0.92u
    I_MXI46_MP0 (VDD dd6 XI46_An VDD) gpdk090_pmos1v w=0.24u l=0.1u ad=0.0816p as=0.0816p pd=1.16u ps=1.16u
    I_MXI48_I41_MP1 (VDD I48_G3_0n XI48_I41_Bn VDD) gpdk090_pmos1v w=0.24u l=0.1u ad=0.0816p as=0.0816p pd=1.16u ps=1.16u
    I_MXI48_I41_MP5 (p0_4 XI48_I41_Bn XI48_I41_p1 VDD) gpdk090_pmos1v w=0.48u l=0.1u ad=0.1056p as=0.1632p pd=0.92u ps=1.64u
    I_MXI48_I41_MP4 (XI48_I41_p1 XI48_I41_An p0_4 VDD) gpdk090_pmos1v w=0.48u l=0.1u ad=0.1056p as=0.1056p pd=0.92u ps=0.92u
    I_MXI48_I41_MP2 (VDD I48_pn4 XI48_I41_p1 VDD) gpdk090_pmos1v w=0.48u l=0.1u ad=0.1056p as=0.1056p pd=0.92u ps=0.92u
    I_MXI48_I41_MP3 (XI48_I41_p1 I48_G3_0n VDD VDD) gpdk090_pmos1v w=0.48u l=0.1u ad=0.1632p as=0.1056p pd=1.64u ps=0.92u
    I_MXI48_I41_MP0 (VDD I48_pn4 XI48_I41_An VDD) gpdk090_pmos1v w=0.24u l=0.1u ad=0.0816p as=0.0816p pd=1.16u ps=1.16u
    I_MXI58_MP1 (VDD qu7 XI58_Bn VDD) gpdk090_pmos1v w=0.24u l=0.1u ad=0.0816p as=0.0816p pd=1.16u ps=1.16u
    I_MXI58_MP5 (b1_6 XI58_Bn XI58_p1 VDD) gpdk090_pmos1v w=0.48u l=0.1u ad=0.1056p as=0.1632p pd=0.92u ps=1.64u
    I_MXI58_MP4 (XI58_p1 XI58_An b1_6 VDD) gpdk090_pmos1v w=0.48u l=0.1u ad=0.1056p as=0.1056p pd=0.92u ps=0.92u
    I_MXI58_MP2 (VDD dd6 XI58_p1 VDD) gpdk090_pmos1v w=0.48u l=0.1u ad=0.1056p as=0.1056p pd=0.92u ps=0.92u
    I_MXI58_MP3 (XI58_p1 qu7 VDD VDD) gpdk090_pmos1v w=0.48u l=0.1u ad=0.1632p as=0.1056p pd=1.64u ps=0.92u
    I_MXI58_MP0 (VDD dd6 XI58_An VDD) gpdk090_pmos1v w=0.24u l=0.1u ad=0.0816p as=0.0816p pd=1.16u ps=1.16u
    I_MXI60_I41_MP1 (VDD I60_G3_0n XI60_I41_Bn VDD) gpdk090_pmos1v w=0.24u l=0.1u ad=0.0816p as=0.0816p pd=1.16u ps=1.16u
    I_MXI60_I41_MP5 (p1_4 XI60_I41_Bn XI60_I41_p1 VDD) gpdk090_pmos1v w=0.48u l=0.1u ad=0.1056p as=0.1632p pd=0.92u ps=1.64u
    I_MXI60_I41_MP4 (XI60_I41_p1 XI60_I41_An p1_4 VDD) gpdk090_pmos1v w=0.48u l=0.1u ad=0.1056p as=0.1056p pd=0.92u ps=0.92u
    I_MXI60_I41_MP2 (VDD I60_pn4 XI60_I41_p1 VDD) gpdk090_pmos1v w=0.48u l=0.1u ad=0.1056p as=0.1056p pd=0.92u ps=0.92u
    I_MXI60_I41_MP3 (XI60_I41_p1 I60_G3_0n VDD VDD) gpdk090_pmos1v w=0.48u l=0.1u ad=0.1632p as=0.1056p pd=1.64u ps=0.92u
    I_MXI60_I41_MP0 (VDD I60_pn4 XI60_I41_An VDD) gpdk090_pmos1v w=0.24u l=0.1u ad=0.0816p as=0.0816p pd=1.16u ps=1.16u
    I_MXI70_MP1 (VDD qu6 XI70_Bn VDD) gpdk090_pmos1v w=0.24u l=0.1u ad=0.0816p as=0.0816p pd=1.16u ps=1.16u
    I_MXI70_MP5 (b2_6 XI70_Bn XI70_p1 VDD) gpdk090_pmos1v w=0.48u l=0.1u ad=0.1056p as=0.1632p pd=0.92u ps=1.64u
    I_MXI70_MP4 (XI70_p1 XI70_An b2_6 VDD) gpdk090_pmos1v w=0.48u l=0.1u ad=0.1056p as=0.1056p pd=0.92u ps=0.92u
    I_MXI70_MP2 (VDD dd6 XI70_p1 VDD) gpdk090_pmos1v w=0.48u l=0.1u ad=0.1056p as=0.1056p pd=0.92u ps=0.92u
    I_MXI70_MP3 (XI70_p1 qu6 VDD VDD) gpdk090_pmos1v w=0.48u l=0.1u ad=0.1632p as=0.1056p pd=1.64u ps=0.92u
    I_MXI70_MP0 (VDD dd6 XI70_An VDD) gpdk090_pmos1v w=0.24u l=0.1u ad=0.0816p as=0.0816p pd=1.16u ps=1.16u
    I_MXI85_MP1 (VDD qu5 XI85_Bn VDD) gpdk090_pmos1v w=0.24u l=0.1u ad=0.0816p as=0.0816p pd=1.16u ps=1.16u
    I_MXI85_MP5 (h3 XI85_Bn XI85_p1 VDD) gpdk090_pmos1v w=0.48u l=0.1u ad=0.1056p as=0.1632p pd=0.92u ps=1.64u
    I_MXI85_MP4 (XI85_p1 XI85_An h3 VDD) gpdk090_pmos1v w=0.48u l=0.1u ad=0.1056p as=0.1056p pd=0.92u ps=0.92u
    I_MXI85_MP2 (VDD p2_7 XI85_p1 VDD) gpdk090_pmos1v w=0.48u l=0.1u ad=0.1056p as=0.1056p pd=0.92u ps=0.92u
    I_MXI85_MP3 (XI85_p1 qu5 VDD VDD) gpdk090_pmos1v w=0.48u l=0.1u ad=0.1632p as=0.1056p pd=1.64u ps=0.92u
    I_MXI85_MP0 (VDD p2_7 XI85_An VDD) gpdk090_pmos1v w=0.24u l=0.1u ad=0.0816p as=0.0816p pd=1.16u ps=1.16u
    I_MXI47_MP1 (VDD VDD XI47_Bn VDD) gpdk090_pmos1v w=0.24u l=0.1u ad=0.0816p as=0.0816p pd=1.16u ps=1.16u
    I_MXI47_MP5 (b0_7 XI47_Bn XI47_p1 VDD) gpdk090_pmos1v w=0.48u l=0.1u ad=0.1056p as=0.1632p pd=0.92u ps=1.64u
    I_MXI47_MP4 (XI47_p1 XI47_An b0_7 VDD) gpdk090_pmos1v w=0.48u l=0.1u ad=0.1056p as=0.1056p pd=0.92u ps=0.92u
    I_MXI47_MP2 (VDD dd7 XI47_p1 VDD) gpdk090_pmos1v w=0.48u l=0.1u ad=0.1056p as=0.1056p pd=0.92u ps=0.92u
    I_MXI47_MP3 (XI47_p1 VDD VDD VDD) gpdk090_pmos1v w=0.48u l=0.1u ad=0.1632p as=0.1056p pd=1.64u ps=0.92u
    I_MXI47_MP0 (VDD dd7 XI47_An VDD) gpdk090_pmos1v w=0.24u l=0.1u ad=0.0816p as=0.0816p pd=1.16u ps=1.16u
    I_MXI49_MP1 (VDD VDD XI49_Bn VDD) gpdk090_pmos1v w=0.24u l=0.1u ad=0.0816p as=0.0816p pd=1.16u ps=1.16u
    I_MXI49_MP5 (h0 XI49_Bn XI49_p1 VDD) gpdk090_pmos1v w=0.48u l=0.1u ad=0.1056p as=0.1632p pd=0.92u ps=1.64u
    I_MXI49_MP4 (XI49_p1 XI49_An h0 VDD) gpdk090_pmos1v w=0.48u l=0.1u ad=0.1056p as=0.1056p pd=0.92u ps=0.92u
    I_MXI49_MP2 (VDD VSS XI49_p1 VDD) gpdk090_pmos1v w=0.48u l=0.1u ad=0.1056p as=0.1056p pd=0.92u ps=0.92u
    I_MXI49_MP3 (XI49_p1 VDD VDD VDD) gpdk090_pmos1v w=0.48u l=0.1u ad=0.1632p as=0.1056p pd=1.64u ps=0.92u
    I_MXI49_MP0 (VDD VSS XI49_An VDD) gpdk090_pmos1v w=0.24u l=0.1u ad=0.0816p as=0.0816p pd=1.16u ps=1.16u
    I_MXI50_MP1 (VDD c0_8 XI50_Bn VDD) gpdk090_pmos1v w=0.24u l=0.1u ad=0.0816p as=0.0816p pd=1.16u ps=1.16u
    I_MXI50_MP5 (p0_8 XI50_Bn XI50_p1 VDD) gpdk090_pmos1v w=0.48u l=0.1u ad=0.1056p as=0.1632p pd=0.92u ps=1.64u
    I_MXI50_MP4 (XI50_p1 XI50_An p0_8 VDD) gpdk090_pmos1v w=0.48u l=0.1u ad=0.1056p as=0.1056p pd=0.92u ps=0.92u
    I_MXI50_MP2 (VDD h0 XI50_p1 VDD) gpdk090_pmos1v w=0.48u l=0.1u ad=0.1056p as=0.1056p pd=0.92u ps=0.92u
    I_MXI50_MP3 (XI50_p1 c0_8 VDD VDD) gpdk090_pmos1v w=0.48u l=0.1u ad=0.1632p as=0.1056p pd=1.64u ps=0.92u
    I_MXI50_MP0 (VDD h0 XI50_An VDD) gpdk090_pmos1v w=0.24u l=0.1u ad=0.0816p as=0.0816p pd=1.16u ps=1.16u
    I_MXI61_MP1 (VDD qu7 XI61_Bn VDD) gpdk090_pmos1v w=0.24u l=0.1u ad=0.0816p as=0.0816p pd=1.16u ps=1.16u
    I_MXI61_MP5 (h1 XI61_Bn XI61_p1 VDD) gpdk090_pmos1v w=0.48u l=0.1u ad=0.1056p as=0.1632p pd=0.92u ps=1.64u
    I_MXI61_MP4 (XI61_p1 XI61_An h1 VDD) gpdk090_pmos1v w=0.48u l=0.1u ad=0.1056p as=0.1056p pd=0.92u ps=0.92u
    I_MXI61_MP2 (VDD p0_7 XI61_p1 VDD) gpdk090_pmos1v w=0.48u l=0.1u ad=0.1056p as=0.1056p pd=0.92u ps=0.92u
    I_MXI61_MP3 (XI61_p1 qu7 VDD VDD) gpdk090_pmos1v w=0.48u l=0.1u ad=0.1632p as=0.1056p pd=1.64u ps=0.92u
    I_MXI61_MP0 (VDD p0_7 XI61_An VDD) gpdk090_pmos1v w=0.24u l=0.1u ad=0.0816p as=0.0816p pd=1.16u ps=1.16u
    I_MXI59_MP1 (VDD qu7 XI59_Bn VDD) gpdk090_pmos1v w=0.24u l=0.1u ad=0.0816p as=0.0816p pd=1.16u ps=1.16u
    I_MXI59_MP5 (b1_7 XI59_Bn XI59_p1 VDD) gpdk090_pmos1v w=0.48u l=0.1u ad=0.1056p as=0.1632p pd=0.92u ps=1.64u
    I_MXI59_MP4 (XI59_p1 XI59_An b1_7 VDD) gpdk090_pmos1v w=0.48u l=0.1u ad=0.1056p as=0.1056p pd=0.92u ps=0.92u
    I_MXI59_MP2 (VDD dd7 XI59_p1 VDD) gpdk090_pmos1v w=0.48u l=0.1u ad=0.1056p as=0.1056p pd=0.92u ps=0.92u
    I_MXI59_MP3 (XI59_p1 qu7 VDD VDD) gpdk090_pmos1v w=0.48u l=0.1u ad=0.1632p as=0.1056p pd=1.64u ps=0.92u
    I_MXI59_MP0 (VDD dd7 XI59_An VDD) gpdk090_pmos1v w=0.24u l=0.1u ad=0.0816p as=0.0816p pd=1.16u ps=1.16u
    I_MXI62_MP1 (VDD c1_8 XI62_Bn VDD) gpdk090_pmos1v w=0.24u l=0.1u ad=0.0816p as=0.0816p pd=1.16u ps=1.16u
    I_MXI62_MP5 (p1_8 XI62_Bn XI62_p1 VDD) gpdk090_pmos1v w=0.48u l=0.1u ad=0.1056p as=0.1632p pd=0.92u ps=1.64u
    I_MXI62_MP4 (XI62_p1 XI62_An p1_8 VDD) gpdk090_pmos1v w=0.48u l=0.1u ad=0.1056p as=0.1056p pd=0.92u ps=0.92u
    I_MXI62_MP2 (VDD h1 XI62_p1 VDD) gpdk090_pmos1v w=0.48u l=0.1u ad=0.1056p as=0.1056p pd=0.92u ps=0.92u
    I_MXI62_MP3 (XI62_p1 c1_8 VDD VDD) gpdk090_pmos1v w=0.48u l=0.1u ad=0.1632p as=0.1056p pd=1.64u ps=0.92u
    I_MXI62_MP0 (VDD h1 XI62_An VDD) gpdk090_pmos1v w=0.24u l=0.1u ad=0.0816p as=0.0816p pd=1.16u ps=1.16u
    I_MXI73_MP1 (VDD qu6 XI73_Bn VDD) gpdk090_pmos1v w=0.24u l=0.1u ad=0.0816p as=0.0816p pd=1.16u ps=1.16u
    I_MXI73_MP5 (h2 XI73_Bn XI73_p1 VDD) gpdk090_pmos1v w=0.48u l=0.1u ad=0.1056p as=0.1632p pd=0.92u ps=1.64u
    I_MXI73_MP4 (XI73_p1 XI73_An h2 VDD) gpdk090_pmos1v w=0.48u l=0.1u ad=0.1056p as=0.1056p pd=0.92u ps=0.92u
    I_MXI73_MP2 (VDD p1_7 XI73_p1 VDD) gpdk090_pmos1v w=0.48u l=0.1u ad=0.1056p as=0.1056p pd=0.92u ps=0.92u
    I_MXI73_MP3 (XI73_p1 qu6 VDD VDD) gpdk090_pmos1v w=0.48u l=0.1u ad=0.1632p as=0.1056p pd=1.64u ps=0.92u
    I_MXI73_MP0 (VDD p1_7 XI73_An VDD) gpdk090_pmos1v w=0.24u l=0.1u ad=0.0816p as=0.0816p pd=1.16u ps=1.16u
    I_MXI74_MP1 (VDD c2_8 XI74_Bn VDD) gpdk090_pmos1v w=0.24u l=0.1u ad=0.0816p as=0.0816p pd=1.16u ps=1.16u
    I_MXI74_MP5 (p2_8 XI74_Bn XI74_p1 VDD) gpdk090_pmos1v w=0.48u l=0.1u ad=0.1056p as=0.1632p pd=0.92u ps=1.64u
    I_MXI74_MP4 (XI74_p1 XI74_An p2_8 VDD) gpdk090_pmos1v w=0.48u l=0.1u ad=0.1056p as=0.1056p pd=0.92u ps=0.92u
    I_MXI74_MP2 (VDD h2 XI74_p1 VDD) gpdk090_pmos1v w=0.48u l=0.1u ad=0.1056p as=0.1056p pd=0.92u ps=0.92u
    I_MXI74_MP3 (XI74_p1 c2_8 VDD VDD) gpdk090_pmos1v w=0.48u l=0.1u ad=0.1632p as=0.1056p pd=1.64u ps=0.92u
    I_MXI74_MP0 (VDD h2 XI74_An VDD) gpdk090_pmos1v w=0.24u l=0.1u ad=0.0816p as=0.0816p pd=1.16u ps=1.16u
    I_MXI71_MP1 (VDD qu6 XI71_Bn VDD) gpdk090_pmos1v w=0.24u l=0.1u ad=0.0816p as=0.0816p pd=1.16u ps=1.16u
    I_MXI71_MP5 (b2_7 XI71_Bn XI71_p1 VDD) gpdk090_pmos1v w=0.48u l=0.1u ad=0.1056p as=0.1632p pd=0.92u ps=1.64u
    I_MXI71_MP4 (XI71_p1 XI71_An b2_7 VDD) gpdk090_pmos1v w=0.48u l=0.1u ad=0.1056p as=0.1056p pd=0.92u ps=0.92u
    I_MXI71_MP2 (VDD dd7 XI71_p1 VDD) gpdk090_pmos1v w=0.48u l=0.1u ad=0.1056p as=0.1056p pd=0.92u ps=0.92u
    I_MXI71_MP3 (XI71_p1 qu6 VDD VDD) gpdk090_pmos1v w=0.48u l=0.1u ad=0.1632p as=0.1056p pd=1.64u ps=0.92u
    I_MXI71_MP0 (VDD dd7 XI71_An VDD) gpdk090_pmos1v w=0.24u l=0.1u ad=0.0816p as=0.0816p pd=1.16u ps=1.16u
    I_C1 (VDD VSS) capacitor c=3.699E-13
    I_C2 (A_0 VSS) capacitor c=5.258E-15
    I_C3 (A_1 VSS) capacitor c=5.445E-15
    I_C4 (A_2 VSS) capacitor c=4.232E-15
    I_C5 (A_3 VSS) capacitor c=4.369E-15
    I_C6 (A_4 VSS) capacitor c=5.926E-15
    I_C7 (A_5 VSS) capacitor c=4.373E-15
    I_C8 (A_6 VSS) capacitor c=4.992E-15
    I_C9 (A_7 VSS) capacitor c=1.963E-14
    I_C10 (B_0 VSS) capacitor c=1.797E-14
    I_C11 (B_1 VSS) capacitor c=6.283E-15
    I_C12 (B_2 VSS) capacitor c=5.835E-15
    I_C13 (B_3 VSS) capacitor c=6.816E-15
    I_C14 (B_4 VSS) capacitor c=6.344E-15
    I_C15 (B_5 VSS) capacitor c=5.631E-15
    I_C16 (B_6 VSS) capacitor c=5.519E-15
    I_C17 (B_7 VSS) capacitor c=1.116E-14
    I_C18 (DZ VSS) capacitor c=5.551E-15
    I_C19 (Q_0 VSS) capacitor c=3.912E-15
    I_C20 (Q_1 VSS) capacitor c=3.570E-15
    I_C21 (Q_2 VSS) capacitor c=3.385E-15
    I_C22 (Q_3 VSS) capacitor c=3.383E-15
    I_C23 (Q_4 VSS) capacitor c=5.389E-15
    I_C24 (Q_5 VSS) capacitor c=4.373E-15
    I_C25 (Q_6 VSS) capacitor c=4.932E-15
    I_C26 (Q_7 VSS) capacitor c=4.140E-15
    I_C27 (R_0 VSS) capacitor c=4.537E-15
    I_C28 (R_1 VSS) capacitor c=1.760E-15
    I_C29 (R_2 VSS) capacitor c=2.717E-15
    I_C30 (R_3 VSS) capacitor c=1.787E-15
    I_C31 (R_4 VSS) capacitor c=1.299E-15
    I_C32 (R_5 VSS) capacitor c=1.391E-15
    I_C33 (R_6 VSS) capacitor c=1.068E-15
    I_C34 (R_7 VSS) capacitor c=1.468E-15
    I_C35 (V VSS) capacitor c=5.827E-15
    I_C36 (dd7 VSS) capacitor c=3.583E-14
    I_C37 (qu6 VSS) capacitor c=2.004E-14
    I_C38 (b2_7 VSS) capacitor c=1.954E-15
    I_C39 (h2 VSS) capacitor c=1.619E-15
    I_C40 (c2_8 VSS) capacitor c=3.225E-15
    I_C41 (p2_8 VSS) capacitor c=1.920E-15
    I_C42 (p1_7 VSS) capacitor c=1.823E-15
    I_C43 (h1 VSS) capacitor c=3.305E-15
    I_C44 (c1_8 VSS) capacitor c=2.487E-15
    I_C45 (p1_8 VSS) capacitor c=1.699E-15
    I_C46 (qu7 VSS) capacitor c=2.100E-14
    I_C47 (b1_7 VSS) capacitor c=1.914E-15
    I_C48 (p0_7 VSS) capacitor c=2.879E-15
    I_C49 (h0 VSS) capacitor c=1.645E-15
    I_C50 (c0_8 VSS) capacitor c=1.790E-15
    I_C51 (p0_8 VSS) capacitor c=1.371E-15
    I_C52 (b0_7 VSS) capacitor c=2.016E-15
    I_C53 (p2_7 VSS) capacitor c=1.885E-15
    I_C54 (qu5 VSS) capacitor c=2.274E-14
    I_C55 (h3 VSS) capacitor c=2.710E-15
    I_C56 (dd6 VSS) capacitor c=3.589E-14
    I_C57 (b2_6 VSS) capacitor c=2.352E-15
    I_C58 (I60_pn4 VSS) capacitor c=5.872E-15
    I_C59 (I60_G3_0n VSS) capacitor c=3.510E-15
    I_C60 (p1_4 VSS) capacitor c=3.023E-15
    I_C61 (b1_6 VSS) capacitor c=2.268E-15
    I_C62 (I48_pn4 VSS) capacitor c=4.917E-15
    I_C63 (I48_G3_0n VSS) capacitor c=2.741E-15
    I_C64 (p0_4 VSS) capacitor c=3.350E-15
    I_C65 (b0_6 VSS) capacitor c=2.489E-15
    I_C66 (b3_7 VSS) capacitor c=2.330E-15
    I_C67 (dd5 VSS) capacitor c=3.344E-14
    I_C68 (b2_5 VSS) capacitor c=2.116E-15
    I_C69 (I60_pn3 VSS) capacitor c=3.835E-15
    I_C70 (I60_G2_0n VSS) capacitor c=2.892E-15
    I_C71 (p1_3 VSS) capacitor c=2.895E-15
    I_C72 (b1_5 VSS) capacitor c=2.358E-15
    I_C73 (I48_pn3 VSS) capacitor c=4.817E-15
    I_C74 (I48_G2_0n VSS) capacitor c=3.647E-15
    I_C75 (p0_3 VSS) capacitor c=3.440E-15
    I_C76 (b3_6 VSS) capacitor c=1.960E-15
    I_C77 (I72_pn4 VSS) capacitor c=4.228E-15
    I_C78 (I72_G3_0n VSS) capacitor c=3.923E-15
    I_C79 (p2_4 VSS) capacitor c=3.027E-15
    I_C80 (dd4 VSS) capacitor c=2.629E-14
    I_C81 (b2_4 VSS) capacitor c=2.236E-15
    I_C82 (b1_4 VSS) capacitor c=2.370E-15
    I_C83 (b0_5 VSS) capacitor c=2.296E-15
    I_C84 (c3_8 VSS) capacitor c=2.385E-15
    I_C85 (p3_8 VSS) capacitor c=2.050E-15
    I_C86 (b3_5 VSS) capacitor c=1.945E-15
    I_C87 (I72_pn3 VSS) capacitor c=4.906E-15
    I_C88 (I72_G2_0n VSS) capacitor c=3.617E-15
    I_C89 (p2_3 VSS) capacitor c=3.135E-15
    I_C90 (dd2 VSS) capacitor c=2.184E-14
    I_C91 (b2_2 VSS) capacitor c=2.058E-15
    I_C92 (dd3 VSS) capacitor c=2.409E-14
    I_C93 (b2_3 VSS) capacitor c=2.211E-15
    I_C94 (b1_2 VSS) capacitor c=2.423E-15
    I_C95 (b1_3 VSS) capacitor c=2.117E-15
    I_C96 (b0_4 VSS) capacitor c=2.438E-15
    I_C97 (b3_4 VSS) capacitor c=1.935E-15
    I_C98 (b3_3 VSS) capacitor c=2.220E-15
    I_C99 (dd1 VSS) capacitor c=1.882E-14
    I_C100 (b2_1 VSS) capacitor c=2.097E-15
    I_C101 (b1_1 VSS) capacitor c=2.285E-15
    I_C102 (b0_1 VSS) capacitor c=2.397E-15
    I_C103 (b0_2 VSS) capacitor c=2.279E-15
    I_C104 (b0_3 VSS) capacitor c=1.998E-15
    I_C105 (I84_pn4 VSS) capacitor c=4.101E-15
    I_C106 (I84_G3_0n VSS) capacitor c=2.345E-15
    I_C107 (p3_4 VSS) capacitor c=3.614E-15
    I_C108 (b3_2 VSS) capacitor c=2.698E-15
    I_C109 (b1_0 VSS) capacitor c=2.600E-15
    I_C110 (b0_0 VSS) capacitor c=2.219E-15
    I_C111 (I152_pn3 VSS) capacitor c=4.315E-15
    I_C112 (I152_G2_0n VSS) capacitor c=2.693E-15
    I_C113 (ru3 VSS) capacitor c=2.838E-15
    I_C114 (b3_1 VSS) capacitor c=2.575E-15
    I_C115 (b2_0 VSS) capacitor c=2.330E-15
    I_C116 (qu4 VSS) capacitor c=2.268E-14
    I_C117 (b4_5 VSS) capacitor c=2.603E-15
    I_C118 (I84_pn3 VSS) capacitor c=4.252E-15
    I_C119 (I84_G2_0n VSS) capacitor c=3.348E-15
    I_C120 (p3_3 VSS) capacitor c=4.324E-15
    I_C121 (b3_0 VSS) capacitor c=2.343E-15
    I_C122 (sq VSS) capacitor c=6.725E-15
    I_C123 (I152_pn4 VSS) capacitor c=4.024E-15
    I_C124 (I152_G3_0n VSS) capacitor c=2.577E-15
    I_C125 (ru4 VSS) capacitor c=3.487E-15
    I_C126 (p3_7 VSS) capacitor c=2.530E-15
    I_C127 (h4 VSS) capacitor c=2.767E-15
    I_C128 (b4_6 VSS) capacitor c=2.280E-15
    I_C129 (b4_4 VSS) capacitor c=2.028E-15
    I_C130 (b4_3 VSS) capacitor c=1.906E-15
    I_C131 (b4_2 VSS) capacitor c=2.542E-15
    I_C132 (b4_0 VSS) capacitor c=2.601E-15
    I_C133 (qu1 VSS) capacitor c=2.196E-14
    I_C134 (b7_0 VSS) capacitor c=2.141E-15
    I_C135 (b4_7 VSS) capacitor c=2.080E-15
    I_C136 (b4_1 VSS) capacitor c=2.011E-15
    I_C137 (qu3 VSS) capacitor c=1.963E-14
    I_C138 (b5_0 VSS) capacitor c=2.263E-15
    I_C139 (qu2 VSS) capacitor c=2.063E-14
    I_C140 (b6_0 VSS) capacitor c=2.651E-15
    I_C141 (b7_1 VSS) capacitor c=2.142E-15
    I_C142 (b5_2 VSS) capacitor c=2.293E-15
    I_C143 (b5_1 VSS) capacitor c=2.204E-15
    I_C144 (b6_2 VSS) capacitor c=2.438E-15
    I_C145 (b6_1 VSS) capacitor c=2.317E-15
    I_C146 (b7_2 VSS) capacitor c=1.924E-15
    I_C147 (I132_pn3 VSS) capacitor c=4.155E-15
    I_C148 (I132_G2_0n VSS) capacitor c=2.682E-15
    I_C149 (p7_3 VSS) capacitor c=2.988E-15
    I_C150 (I132_pn4 VSS) capacitor c=5.091E-15
    I_C151 (I132_G3_0n VSS) capacitor c=3.232E-15
    I_C152 (p7_4 VSS) capacitor c=3.005E-15
    I_C153 (I96_pn3 VSS) capacitor c=4.092E-15
    I_C154 (I96_G2_0n VSS) capacitor c=3.504E-15
    I_C155 (p4_3 VSS) capacitor c=2.747E-15
    I_C156 (b5_3 VSS) capacitor c=2.651E-15
    I_C157 (b6_4 VSS) capacitor c=2.970E-15
    I_C158 (b6_3 VSS) capacitor c=2.375E-15
    I_C159 (b7_3 VSS) capacitor c=1.911E-15
    I_C160 (c4_8 VSS) capacitor c=2.018E-15
    I_C161 (p4_8 VSS) capacitor c=1.165E-15
    I_C162 (b5_5 VSS) capacitor c=2.310E-15
    I_C163 (I96_pn4 VSS) capacitor c=4.942E-15
    I_C164 (I96_G3_0n VSS) capacitor c=3.575E-15
    I_C165 (p4_4 VSS) capacitor c=2.825E-15
    I_C166 (b5_4 VSS) capacitor c=2.016E-15
    I_C167 (I108_pn3 VSS) capacitor c=4.164E-15
    I_C168 (I108_G2_0n VSS) capacitor c=3.720E-15
    I_C169 (p5_3 VSS) capacitor c=2.373E-15
    I_C170 (b6_5 VSS) capacitor c=2.038E-15
    I_C171 (b7_4 VSS) capacitor c=2.308E-15
    I_C172 (I120_pn3 VSS) capacitor c=5.127E-15
    I_C173 (I120_G2_0n VSS) capacitor c=3.074E-15
    I_C174 (p6_3 VSS) capacitor c=2.552E-15
    I_C175 (h7 VSS) capacitor c=2.043E-15
    I_C176 (c7_8 VSS) capacitor c=1.829E-15
    I_C177 (p7_8 VSS) capacitor c=9.613E-15
    I_C178 (b5_6 VSS) capacitor c=1.957E-15
    I_C179 (p4_7 VSS) capacitor c=3.270E-15
    I_C180 (h5 VSS) capacitor c=2.820E-15
    I_C181 (I108_pn4 VSS) capacitor c=3.943E-15
    I_C182 (I108_G3_0n VSS) capacitor c=3.181E-15
    I_C183 (p5_4 VSS) capacitor c=4.345E-15
    I_C184 (b6_6 VSS) capacitor c=2.222E-15
    I_C185 (b7_5 VSS) capacitor c=2.679E-15
    I_C186 (p6_7 VSS) capacitor c=1.894E-15
    I_C187 (b5_7 VSS) capacitor c=2.079E-15
    I_C188 (c5_8 VSS) capacitor c=1.816E-15
    I_C189 (p5_8 VSS) capacitor c=3.487E-15
    I_C190 (p5_7 VSS) capacitor c=1.981E-15
    I_C191 (h6 VSS) capacitor c=2.158E-15
    I_C192 (b6_7 VSS) capacitor c=2.150E-15
    I_C193 (c6_8 VSS) capacitor c=1.931E-15
    I_C194 (p6_8 VSS) capacitor c=1.289E-15
    I_C195 (I120_pn4 VSS) capacitor c=5.812E-15
    I_C196 (I120_G3_0n VSS) capacitor c=2.922E-15
    I_C197 (p6_4 VSS) capacitor c=3.956E-15
    I_C198 (b7_6 VSS) capacitor c=2.050E-15
    I_C199 (b7_7 VSS) capacitor c=1.887E-15
    I_C200 (I60_G1_0 VSS) capacitor c=3.624E-15
    I_C201 (I60_G1_0n VSS) capacitor c=8.466E-16
    I_C202 (I72_G1_0 VSS) capacitor c=4.958E-15
    I_C203 (I72_G1_0n VSS) capacitor c=9.529E-16
    I_C204 (I48_G1_0 VSS) capacitor c=3.745E-15
    I_C205 (I48_G1_0n VSS) capacitor c=9.421E-16
    I_C206 (I60_G0_0 VSS) capacitor c=3.659E-15
    I_C207 (I60_G0_0n VSS) capacitor c=2.357E-15
    I_C208 (I48_G0_0 VSS) capacitor c=4.408E-15
    I_C209 (I48_G0_0n VSS) capacitor c=1.293E-15
    I_C210 (I72_G0_0 VSS) capacitor c=4.032E-15
    I_C211 (I72_G0_0n VSS) capacitor c=2.270E-15
    I_C212 (I60_cinn VSS) capacitor c=9.534E-16
    I_C213 (I48_cinn VSS) capacitor c=8.050E-16
    I_C214 (nrkn5 VSS) capacitor c=2.222E-15
    I_C215 (nrk5 VSS) capacitor c=6.413E-16
    I_C216 (nbkn2 VSS) capacitor c=2.357E-15
    I_C217 (nbk2 VSS) capacitor c=9.396E-16
    I_C218 (nrkn1 VSS) capacitor c=2.021E-15
    I_C219 (nrk1 VSS) capacitor c=9.578E-16
    I_C220 (nrkn2 VSS) capacitor c=1.704E-15
    I_C221 (nrk2 VSS) capacitor c=8.831E-16
    I_C222 (nrkn3 VSS) capacitor c=2.120E-15
    I_C223 (nrk3 VSS) capacitor c=1.226E-15
    I_C224 (nrkn4 VSS) capacitor c=2.587E-15
    I_C225 (nrk4 VSS) capacitor c=1.002E-15
    I_C226 (nrkn6 VSS) capacitor c=2.099E-15
    I_C227 (nrk6 VSS) capacitor c=7.664E-16
    I_C228 (I84_G1_0 VSS) capacitor c=4.164E-15
    I_C229 (I84_G1_0n VSS) capacitor c=8.529E-16
    I_C230 (I72_cinn VSS) capacitor c=6.312E-16
    I_C231 (nakn5 VSS) capacitor c=2.742E-15
    I_C232 (nak5 VSS) capacitor c=6.912E-16
    I_C233 (nakn6 VSS) capacitor c=2.098E-15
    I_C234 (nak6 VSS) capacitor c=1.066E-15
    I_C235 (nbkn4 VSS) capacitor c=2.145E-15
    I_C236 (nbk4 VSS) capacitor c=6.261E-16
    I_C237 (nbkn3 VSS) capacitor c=2.136E-15
    I_C238 (nbk3 VSS) capacitor c=7.076E-16
    I_C239 (nqkn6 VSS) capacitor c=1.917E-15
    I_C240 (nqk6 VSS) capacitor c=8.910E-16
    I_C241 (sqn VSS) capacitor c=7.980E-16
    I_C242 (nbkn1 VSS) capacitor c=1.697E-15
    I_C243 (nbk1 VSS) capacitor c=6.617E-16
    I_C244 (nbkn6 VSS) capacitor c=1.906E-15
    I_C245 (nbk6 VSS) capacitor c=8.753E-16
    I_C246 (nbkn5 VSS) capacitor c=2.166E-15
    I_C247 (nbk5 VSS) capacitor c=8.114E-16
    I_C248 (I152_cinn VSS) capacitor c=6.636E-16
    I_C249 (I152_G0_0 VSS) capacitor c=3.983E-15
    I_C250 (I152_G0_0n VSS) capacitor c=1.893E-15
    I_C251 (I84_G0_0 VSS) capacitor c=2.869E-15
    I_C252 (I84_G0_0n VSS) capacitor c=2.430E-15
    I_C253 (I84_cinn VSS) capacitor c=6.201E-16
    I_C254 (nqkn5 VSS) capacitor c=1.983E-15
    I_C255 (nqk5 VSS) capacitor c=7.426E-16
    I_C256 (nqkn4 VSS) capacitor c=1.911E-15
    I_C257 (nqk4 VSS) capacitor c=7.472E-16
    I_C258 (nqkn3 VSS) capacitor c=1.942E-15
    I_C259 (nqk3 VSS) capacitor c=6.337E-16
    I_C260 (nqkn2 VSS) capacitor c=1.800E-15
    I_C261 (nqk2 VSS) capacitor c=7.793E-16
    I_C262 (nqkn1 VSS) capacitor c=1.824E-15
    I_C263 (nqk1 VSS) capacitor c=1.025E-15
    I_C264 (dmn0 VSS) capacitor c=7.550E-16
    I_C265 (dm0 VSS) capacitor c=1.703E-15
    I_C266 (dmn1 VSS) capacitor c=1.110E-15
    I_C267 (dm1 VSS) capacitor c=2.096E-15
    I_C268 (dmn2 VSS) capacitor c=1.488E-15
    I_C269 (dm2 VSS) capacitor c=1.530E-15
    I_C270 (I152_G1_0 VSS) capacitor c=4.133E-15
    I_C271 (I152_G1_0n VSS) capacitor c=9.141E-16
    I_C272 (nakn4 VSS) capacitor c=1.894E-15
    I_C273 (nak4 VSS) capacitor c=9.040E-16
    I_C274 (nakn3 VSS) capacitor c=2.293E-15
    I_C275 (nak3 VSS) capacitor c=7.890E-16
    I_C276 (nakn1 VSS) capacitor c=1.983E-15
    I_C277 (nak1 VSS) capacitor c=8.319E-16
    I_C278 (dmn3 VSS) capacitor c=7.208E-16
    I_C279 (dm3 VSS) capacitor c=1.656E-15
    I_C280 (I96_cinn VSS) capacitor c=6.406E-16
    I_C281 (nakn2 VSS) capacitor c=1.874E-15
    I_C282 (nak2 VSS) capacitor c=8.328E-16
    I_C283 (I132_cinn VSS) capacitor c=8.051E-16
    I_C284 (I132_G0_0 VSS) capacitor c=4.376E-15
    I_C285 (I132_G0_0n VSS) capacitor c=1.672E-15
    I_C286 (dmn4 VSS) capacitor c=8.385E-16
    I_C287 (dm4 VSS) capacitor c=1.730E-15
    I_C288 (dmn5 VSS) capacitor c=6.734E-16
    I_C289 (dm5 VSS) capacitor c=1.935E-15
    I_C290 (I96_G0_0 VSS) capacitor c=4.949E-15
    I_C291 (I96_G0_0n VSS) capacitor c=1.305E-15
    I_C292 (I108_cinn VSS) capacitor c=7.437E-16
    I_C293 (I120_cinn VSS) capacitor c=8.292E-16
    I_C294 (dmn7 VSS) capacitor c=7.445E-16
    I_C295 (dm7 VSS) capacitor c=1.769E-15
    I_C296 (dmn6 VSS) capacitor c=7.324E-16
    I_C297 (dm6 VSS) capacitor c=1.719E-15
    I_C298 (I96_G1_0 VSS) capacitor c=3.570E-15
    I_C299 (I96_G1_0n VSS) capacitor c=1.299E-15
    I_C300 (I108_G0_0 VSS) capacitor c=4.291E-15
    I_C301 (I108_G0_0n VSS) capacitor c=2.302E-15
    I_C302 (I120_G0_0 VSS) capacitor c=3.547E-15
    I_C303 (I120_G0_0n VSS) capacitor c=2.099E-15
    I_C304 (I132_G1_0 VSS) capacitor c=4.269E-15
    I_C305 (I132_G1_0n VSS) capacitor c=8.260E-16
    I_C306 (I120_G1_0 VSS) capacitor c=4.742E-15
    I_C307 (I120_G1_0n VSS) capacitor c=6.351E-16
    I_C308 (I108_G1_0 VSS) capacitor c=4.037E-15
    I_C309 (I108_G1_0n VSS) capacitor c=8.132E-16
    I_C310 (I60_pn7 VSS) capacitor c=4.612E-15
    I_C311 (I60_pn6 VSS) capacitor c=4.754E-15
    I_C312 (I60_P7_6 VSS) capacitor c=2.308E-15
    I_C313 (I72_pn7 VSS) capacitor c=3.332E-15
    I_C314 (I72_pn6 VSS) capacitor c=4.039E-15
    I_C315 (I72_P7_6 VSS) capacitor c=2.066E-15
    I_C316 (I72_pn5 VSS) capacitor c=6.070E-15
    I_C317 (I72_P6_5 VSS) capacitor c=1.752E-15
    I_C318 (I60_pn5 VSS) capacitor c=4.863E-15
    I_C319 (I60_P6_5 VSS) capacitor c=1.768E-15
    I_C320 (I60_P5_4 VSS) capacitor c=2.127E-15
    I_C321 (I48_pn7 VSS) capacitor c=3.237E-15
    I_C322 (I48_pn6 VSS) capacitor c=5.776E-15
    I_C323 (I48_P7_6 VSS) capacitor c=1.645E-15
    I_C324 (I72_P5_4 VSS) capacitor c=2.921E-15
    I_C325 (I60_P4_3 VSS) capacitor c=2.170E-15
    I_C326 (I60_pn2 VSS) capacitor c=3.678E-15
    I_C327 (I60_P3_2 VSS) capacitor c=1.619E-15
    I_C328 (I48_pn5 VSS) capacitor c=5.341E-15
    I_C329 (I48_P5_4 VSS) capacitor c=2.623E-15
    I_C330 (I48_pn2 VSS) capacitor c=4.674E-15
    I_C331 (I48_P3_2 VSS) capacitor c=1.443E-15
    I_C332 (I48_P6_5 VSS) capacitor c=1.379E-15
    I_C333 (I72_P4_3 VSS) capacitor c=2.869E-15
    I_C334 (I72_pn2 VSS) capacitor c=4.108E-15
    I_C335 (I72_P3_2 VSS) capacitor c=2.802E-15
    I_C336 (I60_pn1 VSS) capacitor c=3.112E-15
    I_C337 (I60_P2_1 VSS) capacitor c=1.634E-15
    I_C338 (I48_pn1 VSS) capacitor c=3.134E-15
    I_C339 (I48_P2_1 VSS) capacitor c=1.895E-15
    I_C340 (I48_P4_3 VSS) capacitor c=3.161E-15
    I_C341 (I72_pn1 VSS) capacitor c=4.219E-15
    I_C342 (I72_P2_1 VSS) capacitor c=1.508E-15
    I_C343 (I84_pn7 VSS) capacitor c=4.543E-15
    I_C344 (I84_pn6 VSS) capacitor c=5.958E-15
    I_C345 (I84_P7_6 VSS) capacitor c=1.590E-15
    I_C346 (I84_pn5 VSS) capacitor c=4.858E-15
    I_C347 (I84_P5_4 VSS) capacitor c=3.079E-15
    I_C348 (I84_pn2 VSS) capacitor c=4.768E-15
    I_C349 (I84_P3_2 VSS) capacitor c=1.673E-15
    I_C350 (vn VSS) capacitor c=8.465E-16
    I_C351 (z2_0 VSS) capacitor c=7.368E-16
    I_C352 (z2_1 VSS) capacitor c=1.232E-15
    I_C353 (z1_1 VSS) capacitor c=8.212E-16
    I_C354 (z1_2 VSS) capacitor c=1.354E-15
    I_C355 (I152_pn2 VSS) capacitor c=4.815E-15
    I_C356 (I152_pn1 VSS) capacitor c=3.182E-15
    I_C357 (I152_P2_1 VSS) capacitor c=2.023E-15
    I_C358 (I84_P6_5 VSS) capacitor c=1.683E-15
    I_C359 (I84_pn1 VSS) capacitor c=3.538E-15
    I_C360 (I84_P2_1 VSS) capacitor c=1.980E-15
    I_C361 (I84_P4_3 VSS) capacitor c=2.515E-15
    I_C362 (z1_0 VSS) capacitor c=7.851E-16
    I_C363 (z1_3 VSS) capacitor c=7.332E-16
    I_C364 (I152_pn6 VSS) capacitor c=3.988E-15
    I_C365 (I152_pn5 VSS) capacitor c=5.414E-15
    I_C366 (I152_P6_5 VSS) capacitor c=1.818E-15
    I_C367 (I152_P3_2 VSS) capacitor c=2.508E-15
    I_C368 (I152_P4_3 VSS) capacitor c=3.189E-15
    I_C369 (I152_P5_4 VSS) capacitor c=2.294E-15
    I_C370 (I152_pn7 VSS) capacitor c=4.181E-15
    I_C371 (I152_P7_6 VSS) capacitor c=1.652E-15
    I_C372 (I96_pn6 VSS) capacitor c=4.695E-15
    I_C373 (I96_pn5 VSS) capacitor c=5.124E-15
    I_C374 (I96_P6_5 VSS) capacitor c=1.617E-15
    I_C375 (I132_pn2 VSS) capacitor c=4.796E-15
    I_C376 (I132_pn1 VSS) capacitor c=3.553E-15
    I_C377 (I132_P2_1 VSS) capacitor c=2.237E-15
    I_C378 (I96_pn7 VSS) capacitor c=2.666E-15
    I_C379 (I96_P7_6 VSS) capacitor c=1.707E-15
    I_C380 (I96_P4_3 VSS) capacitor c=2.040E-15
    I_C381 (I96_pn2 VSS) capacitor c=3.907E-15
    I_C382 (I96_pn1 VSS) capacitor c=3.090E-15
    I_C383 (I96_P2_1 VSS) capacitor c=1.276E-15
    I_C384 (I96_P5_4 VSS) capacitor c=2.804E-15
    I_C385 (I96_P3_2 VSS) capacitor c=1.843E-15
    I_C386 (I132_P4_3 VSS) capacitor c=2.703E-15
    I_C387 (I132_P3_2 VSS) capacitor c=1.889E-15
    I_C388 (I108_P4_3 VSS) capacitor c=2.683E-15
    I_C389 (I108_pn2 VSS) capacitor c=5.298E-15
    I_C390 (I108_P3_2 VSS) capacitor c=3.026E-15
    I_C391 (I108_pn1 VSS) capacitor c=3.517E-15
    I_C392 (I108_P2_1 VSS) capacitor c=1.556E-15
    I_C393 (I120_pn2 VSS) capacitor c=4.517E-15
    I_C394 (I120_P3_2 VSS) capacitor c=1.791E-15
    I_C395 (I120_P4_3 VSS) capacitor c=2.896E-15
    I_C396 (I120_pn1 VSS) capacitor c=3.377E-15
    I_C397 (I120_P2_1 VSS) capacitor c=1.402E-15
    I_C398 (I132_pn6 VSS) capacitor c=4.971E-15
    I_C399 (I132_pn5 VSS) capacitor c=5.748E-15
    I_C400 (I132_P6_5 VSS) capacitor c=1.995E-15
    I_C401 (I132_P5_4 VSS) capacitor c=3.024E-15
    I_C402 (I132_pn7 VSS) capacitor c=3.495E-15
    I_C403 (I132_P7_6 VSS) capacitor c=1.753E-15
    I_C404 (I108_pn5 VSS) capacitor c=4.897E-15
    I_C405 (I108_P5_4 VSS) capacitor c=2.120E-15
    I_C406 (I108_pn6 VSS) capacitor c=5.527E-15
    I_C407 (I108_P6_5 VSS) capacitor c=1.464E-15
    I_C408 (I120_pn5 VSS) capacitor c=4.682E-15
    I_C409 (I120_P5_4 VSS) capacitor c=2.381E-15
    I_C410 (I120_pn6 VSS) capacitor c=5.908E-15
    I_C411 (I120_P6_5 VSS) capacitor c=1.867E-15
    I_C412 (I108_pn7 VSS) capacitor c=4.433E-15
    I_C413 (I108_P7_6 VSS) capacitor c=1.920E-15
    I_C414 (I120_pn7 VSS) capacitor c=4.684E-15
    I_C415 (I120_P7_6 VSS) capacitor c=1.768E-15
    I_C416 (I72_P7_4n VSS) capacitor c=1.474E-15
    I_C417 (p1_6 VSS) capacitor c=4.804E-15
    I_C418 (I72_gn7 VSS) capacitor c=7.114E-16
    I_C419 (p1_5 VSS) capacitor c=3.271E-15
    I_C420 (I72_gn6 VSS) capacitor c=2.027E-15
    I_C421 (p0_6 VSS) capacitor c=3.939E-15
    I_C422 (I60_gn7 VSS) capacitor c=8.461E-16
    I_C423 (I48_gn7 VSS) capacitor c=1.250E-15
    I_C424 (I72_gn5 VSS) capacitor c=1.355E-15
    I_C425 (I60_P6_3n VSS) capacitor c=1.140E-15
    I_C426 (I60_P7_4n VSS) capacitor c=1.262E-15
    I_C427 (I60_P5_2n VSS) capacitor c=1.368E-15
    I_C428 (I60_gn5 VSS) capacitor c=1.257E-15
    I_C429 (p0_5 VSS) capacitor c=3.032E-15
    I_C430 (I60_gn6 VSS) capacitor c=1.984E-15
    I_C431 (I48_P7_4n VSS) capacitor c=1.007E-15
    I_C432 (I48_gn6 VSS) capacitor c=1.529E-15
    I_C433 (p2_6 VSS) capacitor c=2.690E-15
    I_C434 (I84_gn7 VSS) capacitor c=2.030E-15
    I_C435 (I72_P5_2n VSS) capacitor c=1.056E-15
    I_C436 (I72_P6_3n VSS) capacitor c=1.126E-15
    I_C437 (I72_gn4 VSS) capacitor c=1.587E-15
    I_C438 (I60_P4_1n VSS) capacitor c=1.026E-15
    I_C439 (I60_gn4 VSS) capacitor c=1.914E-15
    I_C440 (I48_P5_2n VSS) capacitor c=1.613E-15
    I_C441 (I48_P6_3n VSS) capacitor c=1.126E-15
    I_C442 (I48_gn5 VSS) capacitor c=1.570E-15
    I_C443 (p2_5 VSS) capacitor c=2.876E-15
    I_C444 (I84_gn6 VSS) capacitor c=2.108E-15
    I_C445 (I72_P4_1n VSS) capacitor c=1.093E-15
    I_C446 (p1_2 VSS) capacitor c=2.867E-15
    I_C447 (I72_gn3 VSS) capacitor c=2.768E-15
    I_C448 (p0_1 VSS) capacitor c=2.533E-15
    I_C449 (I60_gn2 VSS) capacitor c=2.399E-15
    I_C450 (p0_2 VSS) capacitor c=3.432E-15
    I_C451 (I60_gn3 VSS) capacitor c=1.450E-15
    I_C452 (I48_P4_1n VSS) capacitor c=1.244E-15
    I_C453 (I48_gn4 VSS) capacitor c=1.754E-15
    I_C454 (I84_gn5 VSS) capacitor c=2.268E-15
    I_C455 (p1_1 VSS) capacitor c=2.926E-15
    I_C456 (I72_gn2 VSS) capacitor c=1.785E-15
    I_C457 (p0_0 VSS) capacitor c=2.383E-15
    I_C458 (I60_gn1 VSS) capacitor c=1.454E-15
    I_C459 (I48_gn1 VSS) capacitor c=1.448E-15
    I_C460 (I48_gn2 VSS) capacitor c=1.873E-15
    I_C461 (I48_gn3 VSS) capacitor c=1.750E-15
    I_C462 (I84_P7_4n VSS) capacitor c=1.426E-15
    I_C463 (I84_gn4 VSS) capacitor c=1.718E-15
    I_C464 (p2_2 VSS) capacitor c=2.556E-15
    I_C465 (I84_gn3 VSS) capacitor c=1.793E-15
    I_C466 (p1_0 VSS) capacitor c=2.784E-15
    I_C467 (I72_gn1 VSS) capacitor c=1.810E-15
    I_C468 (aa6 VSS) capacitor c=2.376E-15
    I_C469 (I60_gn0 VSS) capacitor c=9.572E-16
    I_C470 (aa7 VSS) capacitor c=2.907E-15
    I_C471 (I48_gn0 VSS) capacitor c=1.071E-15
    I_C472 (I84_P5_2n VSS) capacitor c=9.826E-16
    I_C473 (p2_1 VSS) capacitor c=2.555E-15
    I_C474 (I84_gn2 VSS) capacitor c=1.387E-15
    I_C475 (aa5 VSS) capacitor c=2.570E-15
    I_C476 (I72_gn0 VSS) capacitor c=8.003E-16
    I_C477 (I84_P6_3n VSS) capacitor c=1.144E-15
    I_C478 (p2_0 VSS) capacitor c=2.587E-15
    I_C479 (I84_gn1 VSS) capacitor c=2.568E-15
    I_C480 (p7_1 VSS) capacitor c=3.289E-15
    I_C481 (I152_gn1 VSS) capacitor c=1.837E-15
    I_C482 (I152_P4_1n VSS) capacitor c=1.015E-15
    I_C483 (I152_P6_3n VSS) capacitor c=1.037E-15
    I_C484 (I84_P4_1n VSS) capacitor c=1.109E-15
    I_C485 (aa4 VSS) capacitor c=3.129E-15
    I_C486 (I84_gn0 VSS) capacitor c=8.654E-16
    I_C487 (p7_0 VSS) capacitor c=2.404E-15
    I_C488 (I152_gn0 VSS) capacitor c=1.217E-15
    I_C489 (p7_2 VSS) capacitor c=3.004E-15
    I_C490 (I152_gn2 VSS) capacitor c=1.729E-15
    I_C491 (I152_P5_2n VSS) capacitor c=9.855E-16
    I_C492 (p3_5 VSS) capacitor c=3.100E-15
    I_C493 (I96_gn6 VSS) capacitor c=2.056E-15
    I_C494 (I96_gn5 VSS) capacitor c=2.088E-15
    I_C495 (I96_gn4 VSS) capacitor c=1.580E-15
    I_C496 (p3_2 VSS) capacitor c=3.482E-15
    I_C497 (I96_gn3 VSS) capacitor c=1.766E-15
    I_C498 (p3_1 VSS) capacitor c=2.969E-15
    I_C499 (I96_gn2 VSS) capacitor c=1.789E-15
    I_C500 (I152_gn3 VSS) capacitor c=1.795E-15
    I_C501 (I152_P7_4n VSS) capacitor c=1.062E-15
    I_C502 (p3_0 VSS) capacitor c=2.788E-15
    I_C503 (I96_gn1 VSS) capacitor c=1.848E-15
    I_C504 (aa3 VSS) capacitor c=2.584E-15
    I_C505 (I96_gn0 VSS) capacitor c=1.122E-15
    I_C506 (I132_gn0 VSS) capacitor c=1.206E-15
    I_C507 (p6_0 VSS) capacitor c=3.095E-15
    I_C508 (I132_gn1 VSS) capacitor c=1.896E-15
    I_C509 (I152_gn4 VSS) capacitor c=2.129E-15
    I_C510 (p7_5 VSS) capacitor c=2.987E-15
    I_C511 (I152_gn5 VSS) capacitor c=1.351E-15
    I_C512 (p7_6 VSS) capacitor c=3.236E-15
    I_C513 (I152_gn6 VSS) capacitor c=1.184E-15
    I_C514 (p3_6 VSS) capacitor c=4.212E-15
    I_C515 (I96_gn7 VSS) capacitor c=8.413E-16
    I_C516 (I96_P6_3n VSS) capacitor c=8.875E-16
    I_C517 (I96_P4_1n VSS) capacitor c=1.133E-15
    I_C518 (p4_0 VSS) capacitor c=2.770E-15
    I_C519 (I108_gn1 VSS) capacitor c=1.800E-15
    I_C520 (aa2 VSS) capacitor c=3.044E-15
    I_C521 (I108_gn0 VSS) capacitor c=9.782E-16
    I_C522 (aa1 VSS) capacitor c=3.208E-15
    I_C523 (I120_gn0 VSS) capacitor c=8.987E-16
    I_C524 (p6_1 VSS) capacitor c=2.951E-15
    I_C525 (I132_gn2 VSS) capacitor c=3.747E-15
    I_C526 (I132_P4_1n VSS) capacitor c=9.581E-16
    I_C527 (I96_P7_4n VSS) capacitor c=9.858E-16
    I_C528 (I96_P5_2n VSS) capacitor c=8.427E-16
    I_C529 (p4_1 VSS) capacitor c=2.382E-15
    I_C530 (I108_gn2 VSS) capacitor c=1.951E-15
    I_C531 (p5_1 VSS) capacitor c=3.647E-15
    I_C532 (I120_gn2 VSS) capacitor c=2.153E-15
    I_C533 (p5_0 VSS) capacitor c=3.415E-15
    I_C534 (I120_gn1 VSS) capacitor c=1.591E-15
    I_C535 (p6_2 VSS) capacitor c=2.578E-15
    I_C536 (I132_gn3 VSS) capacitor c=1.328E-15
    I_C537 (I132_P6_3n VSS) capacitor c=9.868E-16
    I_C538 (I132_P5_2n VSS) capacitor c=1.186E-15
    I_C539 (p7_7 VSS) capacitor c=2.126E-15
    I_C540 (I152_gn7 VSS) capacitor c=1.461E-15
    I_C541 (I108_gn4 VSS) capacitor c=1.435E-15
    I_C542 (p4_2 VSS) capacitor c=2.795E-15
    I_C543 (I108_gn3 VSS) capacitor c=1.228E-15
    I_C544 (I108_P4_1n VSS) capacitor c=9.382E-16
    I_C545 (I120_gn4 VSS) capacitor c=2.567E-15
    I_C546 (p5_2 VSS) capacitor c=3.519E-15
    I_C547 (I120_gn3 VSS) capacitor c=1.638E-15
    I_C548 (I120_P4_1n VSS) capacitor c=1.319E-15
    I_C549 (I132_gn4 VSS) capacitor c=1.284E-15
    I_C550 (I132_P7_4n VSS) capacitor c=8.876E-16
    I_C551 (p4_5 VSS) capacitor c=3.154E-15
    I_C552 (I108_gn6 VSS) capacitor c=2.124E-15
    I_C553 (I108_gn5 VSS) capacitor c=1.436E-15
    I_C554 (I108_P7_4n VSS) capacitor c=9.105E-16
    I_C555 (I108_P6_3n VSS) capacitor c=1.037E-15
    I_C556 (p5_5 VSS) capacitor c=2.766E-15
    I_C557 (I120_gn6 VSS) capacitor c=1.798E-15
    I_C558 (I120_gn5 VSS) capacitor c=1.589E-15
    I_C559 (I120_P5_2n VSS) capacitor c=1.012E-15
    I_C560 (I120_P6_3n VSS) capacitor c=1.182E-15
    I_C561 (p6_5 VSS) capacitor c=3.510E-15
    I_C562 (I132_gn6 VSS) capacitor c=1.523E-15
    I_C563 (p4_6 VSS) capacitor c=2.823E-15
    I_C564 (I108_gn7 VSS) capacitor c=1.014E-15
    I_C565 (I108_P5_2n VSS) capacitor c=1.046E-15
    I_C566 (p5_6 VSS) capacitor c=3.846E-15
    I_C567 (I120_gn7 VSS) capacitor c=1.080E-15
    I_C568 (I120_P7_4n VSS) capacitor c=9.784E-16
    I_C569 (I132_gn5 VSS) capacitor c=2.187E-15
    I_C570 (p6_6 VSS) capacitor c=4.431E-15
    I_C571 (I132_gn7 VSS) capacitor c=1.118E-15
    I_C572 (I72_G7_4n VSS) capacitor c=8.799E-16
    I_C573 (I72_G7_6 VSS) capacitor c=1.204E-15
    I_C574 (I60_G7_4n VSS) capacitor c=1.132E-15
    I_C575 (I60_G7_6 VSS) capacitor c=1.357E-15
    I_C576 (I72_G6_3n VSS) capacitor c=9.789E-16
    I_C577 (c2_7 VSS) capacitor c=1.927E-15
    I_C578 (I72_G6_5 VSS) capacitor c=1.300E-15
    I_C579 (I60_G6_3n VSS) capacitor c=6.539E-16
    I_C580 (c1_7 VSS) capacitor c=1.974E-15
    I_C581 (I60_G5_2n VSS) capacitor c=1.399E-15
    I_C582 (I60_G5_0 VSS) capacitor c=1.774E-15
    I_C583 (I60_G5_4 VSS) capacitor c=1.740E-15
    I_C584 (I60_G6_5 VSS) capacitor c=2.565E-15
    I_C585 (I48_G5_2n VSS) capacitor c=1.463E-15
    I_C586 (I48_G5_0 VSS) capacitor c=1.615E-15
    I_C587 (I48_G7_4n VSS) capacitor c=1.523E-15
    I_C588 (I48_G7_6 VSS) capacitor c=1.547E-15
    I_C589 (I72_G5_2n VSS) capacitor c=9.251E-16
    I_C590 (I72_G5_0 VSS) capacitor c=1.768E-15
    I_C591 (I72_G4_3 VSS) capacitor c=2.193E-15
    I_C592 (I72_G5_4 VSS) capacitor c=3.955E-15
    I_C593 (I60_G4_1n VSS) capacitor c=1.111E-15
    I_C594 (I60_G4_0 VSS) capacitor c=2.143E-15
    I_C595 (I60_G4_3 VSS) capacitor c=2.556E-15
    I_C596 (I60_G3_2 VSS) capacitor c=2.470E-15
    I_C597 (I48_G6_3n VSS) capacitor c=1.428E-15
    I_C598 (c0_7 VSS) capacitor c=2.715E-15
    I_C599 (I48_G6_5 VSS) capacitor c=1.481E-15
    I_C600 (I48_G5_4 VSS) capacitor c=2.542E-15
    I_C601 (I72_G4_1n VSS) capacitor c=9.649E-16
    I_C602 (I72_G4_0 VSS) capacitor c=1.919E-15
    I_C603 (I72_G3_2 VSS) capacitor c=2.611E-15
    I_C604 (I60_G2_1 VSS) capacitor c=2.063E-15
    I_C605 (I48_G4_1n VSS) capacitor c=1.440E-15
    I_C606 (I48_G4_0 VSS) capacitor c=1.859E-15
    I_C607 (I48_G3_2 VSS) capacitor c=3.204E-15
    I_C608 (I48_G4_3 VSS) capacitor c=2.587E-15
    I_C609 (I84_G7_6 VSS) capacitor c=2.088E-15
    I_C610 (I84_G6_5 VSS) capacitor c=2.252E-15
    I_C611 (I72_G2_1 VSS) capacitor c=2.337E-15
    I_C612 (I48_pn0 VSS) capacitor c=3.078E-15
    I_C613 (I48_G2_1 VSS) capacitor c=1.777E-15
    I_C614 (I84_G7_4n VSS) capacitor c=1.001E-15
    I_C615 (I84_G5_4 VSS) capacitor c=2.572E-15
    I_C616 (I60_pn0 VSS) capacitor c=2.613E-15
    I_C617 (I84_G5_2n VSS) capacitor c=1.274E-15
    I_C618 (I84_G5_0 VSS) capacitor c=1.869E-15
    I_C619 (I84_G4_3 VSS) capacitor c=2.233E-15
    I_C620 (I84_G3_2 VSS) capacitor c=2.639E-15
    I_C621 (I72_pn0 VSS) capacitor c=2.434E-15
    I_C622 (I152_G6_3n VSS) capacitor c=1.073E-15
    I_C623 (rc6 VSS) capacitor c=1.512E-15
    I_C624 (I84_G2_1 VSS) capacitor c=2.298E-15
    I_C625 (I152_pn0 VSS) capacitor c=4.145E-15
    I_C626 (I152_G2_1 VSS) capacitor c=2.242E-15
    I_C627 (I152_G4_1n VSS) capacitor c=8.274E-16
    I_C628 (I152_G4_0 VSS) capacitor c=1.715E-15
    I_C629 (I84_G6_3n VSS) capacitor c=1.577E-15
    I_C630 (c3_7 VSS) capacitor c=2.432E-15
    I_C631 (I84_G4_1n VSS) capacitor c=1.045E-15
    I_C632 (I84_G4_0 VSS) capacitor c=1.745E-15
    I_C633 (I84_pn0 VSS) capacitor c=2.733E-15
    I_C634 (I152_G3_2 VSS) capacitor c=2.276E-15
    I_C635 (I152_G5_2n VSS) capacitor c=8.802E-16
    I_C636 (I152_G5_0 VSS) capacitor c=1.713E-15
    I_C637 (I132_pn0 VSS) capacitor c=3.208E-15
    I_C638 (I152_G4_3 VSS) capacitor c=2.725E-15
    I_C639 (I152_G5_4 VSS) capacitor c=1.754E-15
    I_C640 (I152_G7_4n VSS) capacitor c=7.291E-16
    I_C641 (rc7 VSS) capacitor c=4.897E-16
    I_C642 (I96_G6_5 VSS) capacitor c=1.360E-15
    I_C643 (I96_G5_4 VSS) capacitor c=3.550E-15
    I_C644 (I96_G4_3 VSS) capacitor c=2.029E-15
    I_C645 (I96_G3_2 VSS) capacitor c=3.087E-15
    I_C646 (I96_G2_1 VSS) capacitor c=1.509E-15
    I_C647 (I96_pn0 VSS) capacitor c=2.317E-15
    I_C648 (I152_G6_5 VSS) capacitor c=2.490E-15
    I_C649 (I152_G7_6 VSS) capacitor c=1.111E-15
    I_C650 (I96_G7_6 VSS) capacitor c=1.388E-15
    I_C651 (I96_G6_3n VSS) capacitor c=9.019E-16
    I_C652 (c4_7 VSS) capacitor c=1.576E-15
    I_C653 (I96_G4_1n VSS) capacitor c=1.284E-15
    I_C654 (I96_G4_0 VSS) capacitor c=1.497E-15
    I_C655 (I108_pn0 VSS) capacitor c=2.637E-15
    I_C656 (I120_pn0 VSS) capacitor c=2.806E-15
    I_C657 (I132_G2_1 VSS) capacitor c=2.158E-15
    I_C658 (I132_G4_1n VSS) capacitor c=1.510E-15
    I_C659 (I132_G4_0 VSS) capacitor c=1.656E-15
    I_C660 (I96_G7_4n VSS) capacitor c=1.061E-15
    I_C661 (I96_G5_2n VSS) capacitor c=9.828E-16
    I_C662 (I96_G5_0 VSS) capacitor c=1.542E-15
    I_C663 (I108_G2_1 VSS) capacitor c=2.560E-15
    I_C664 (I120_G2_1 VSS) capacitor c=3.247E-15
    I_C665 (I132_G3_2 VSS) capacitor c=3.005E-15
    I_C666 (I132_G6_3n VSS) capacitor c=1.072E-15
    I_C667 (c7_7 VSS) capacitor c=2.305E-15
    I_C668 (I132_G5_2n VSS) capacitor c=7.480E-16
    I_C669 (I132_G5_0 VSS) capacitor c=1.665E-15
    I_C670 (I108_G4_3 VSS) capacitor c=2.810E-15
    I_C671 (I108_G3_2 VSS) capacitor c=2.178E-15
    I_C672 (I108_G4_1n VSS) capacitor c=1.364E-15
    I_C673 (I108_G4_0 VSS) capacitor c=1.793E-15
    I_C674 (I120_G3_2 VSS) capacitor c=2.271E-15
    I_C675 (I120_G4_3 VSS) capacitor c=2.823E-15
    I_C676 (I120_G4_1n VSS) capacitor c=1.344E-15
    I_C677 (I120_G4_0 VSS) capacitor c=1.642E-15
    I_C678 (I132_G4_3 VSS) capacitor c=1.967E-15
    I_C679 (I132_G5_4 VSS) capacitor c=2.906E-15
    I_C680 (I132_G7_4n VSS) capacitor c=1.334E-15
    I_C681 (I108_G6_5 VSS) capacitor c=3.027E-15
    I_C682 (I108_G7_4n VSS) capacitor c=9.952E-16
    I_C683 (I108_G5_4 VSS) capacitor c=1.983E-15
    I_C684 (I120_G6_5 VSS) capacitor c=2.191E-15
    I_C685 (I120_G5_4 VSS) capacitor c=2.238E-15
    I_C686 (I120_G5_2n VSS) capacitor c=1.419E-15
    I_C687 (I120_G5_0 VSS) capacitor c=1.797E-15
    I_C688 (I120_G6_3n VSS) capacitor c=1.401E-15
    I_C689 (c6_7 VSS) capacitor c=1.547E-15
    I_C690 (I132_G6_5 VSS) capacitor c=1.893E-15
    I_C691 (I132_G7_6 VSS) capacitor c=1.351E-15
    I_C692 (I108_G7_6 VSS) capacitor c=1.571E-15
    I_C693 (I108_G5_2n VSS) capacitor c=1.330E-15
    I_C694 (I108_G5_0 VSS) capacitor c=1.534E-15
    I_C695 (I108_G6_3n VSS) capacitor c=1.109E-15
    I_C696 (c5_7 VSS) capacitor c=1.895E-15
    I_C697 (I120_G7_6 VSS) capacitor c=1.300E-15
    I_C698 (I120_G7_4n VSS) capacitor c=9.862E-16
    I_C699 (ru5 VSS) capacitor c=3.122E-15
    I_C700 (nakn7 VSS) capacitor c=1.253E-15
    I_C701 (ru1 VSS) capacitor c=2.244E-15
    I_C702 (ru2 VSS) capacitor c=2.791E-15
    I_C703 (ru6 VSS) capacitor c=3.349E-15
    I_C704 (nrkn7 VSS) capacitor c=1.690E-15
    I_C705 (nqkn7 VSS) capacitor c=1.494E-15
    I_C706 (nbkn7 VSS) capacitor c=1.427E-15
    I_C707 (ru7 VSS) capacitor c=1.819E-15
    I_C708 (XI132_I15_p1 VSS) capacitor c=5.279E-16
    I_C709 (XI132_I15_n1 VSS) capacitor c=3.364E-18
    I_C710 (XI132_I15_n2 VSS) capacitor c=1.075E-17
    I_C711 (XI132_I15_Bn VSS) capacitor c=1.079E-15
    I_C712 (XI132_I15_An VSS) capacitor c=8.959E-16
    I_C713 (XI132_I13_p1 VSS) capacitor c=5.264E-16
    I_C714 (XI132_I13_n2 VSS) capacitor c=8.940E-18
    I_C715 (XI132_I13_Bn VSS) capacitor c=1.065E-15
    I_C716 (XI132_I13_An VSS) capacitor c=9.353E-16
    I_C717 (XI120_I44_p1 VSS) capacitor c=5.083E-16
    I_C718 (XI120_I44_n1 VSS) capacitor c=4.635E-19
    I_C719 (XI120_I44_n2 VSS) capacitor c=1.049E-17
    I_C720 (XI120_I44_Bn VSS) capacitor c=1.077E-15
    I_C721 (XI120_I44_An VSS) capacitor c=9.039E-16
    I_C722 (XI120_I43_p1 VSS) capacitor c=5.379E-16
    I_C723 (XI120_I43_n1 VSS) capacitor c=5.786E-19
    I_C724 (XI120_I43_n2 VSS) capacitor c=8.220E-18
    I_C725 (XI120_I43_Bn VSS) capacitor c=1.066E-15
    I_C726 (XI120_I43_An VSS) capacitor c=9.225E-16
    I_C727 (XI120_I15_p1 VSS) capacitor c=5.431E-16
    I_C728 (XI120_I15_n1 VSS) capacitor c=1.240E-18
    I_C729 (XI120_I15_n2 VSS) capacitor c=6.286E-18
    I_C730 (XI120_I15_Bn VSS) capacitor c=1.099E-15
    I_C731 (XI120_I15_An VSS) capacitor c=9.604E-16
    I_C732 (XI108_I44_p1 VSS) capacitor c=5.537E-16
    I_C733 (XI108_I44_n1 VSS) capacitor c=1.435E-18
    I_C734 (XI108_I44_n2 VSS) capacitor c=6.810E-18
    I_C735 (XI108_I44_Bn VSS) capacitor c=1.113E-15
    I_C736 (XI108_I44_An VSS) capacitor c=9.332E-16
    I_C737 (XI108_I43_p1 VSS) capacitor c=5.202E-16
    I_C738 (XI108_I43_n1 VSS) capacitor c=2.014E-18
    I_C739 (XI108_I43_n2 VSS) capacitor c=9.770E-18
    I_C740 (XI108_I43_Bn VSS) capacitor c=1.073E-15
    I_C741 (XI108_I43_An VSS) capacitor c=9.216E-16
    I_C742 (XI108_I15_p1 VSS) capacitor c=5.441E-16
    I_C743 (XI108_I15_n1 VSS) capacitor c=6.381E-19
    I_C744 (XI108_I15_n2 VSS) capacitor c=7.623E-18
    I_C745 (XI108_I15_Bn VSS) capacitor c=1.102E-15
    I_C746 (XI108_I15_An VSS) capacitor c=9.249E-16
    I_C747 (XI132_I14_p1 VSS) capacitor c=5.612E-16
    I_C748 (XI132_I14_n2 VSS) capacitor c=8.939E-18
    I_C749 (XI132_I14_Bn VSS) capacitor c=1.056E-15
    I_C750 (XI132_I14_An VSS) capacitor c=9.113E-16
    I_C751 (XI120_I42_p1 VSS) capacitor c=5.527E-16
    I_C752 (XI120_I42_n1 VSS) capacitor c=5.934E-19
    I_C753 (XI120_I42_n2 VSS) capacitor c=9.847E-18
    I_C754 (XI120_I42_Bn VSS) capacitor c=1.086E-15
    I_C755 (XI120_I42_An VSS) capacitor c=9.156E-16
    I_C756 (XI120_I13_p1 VSS) capacitor c=5.378E-16
    I_C757 (XI120_I13_n1 VSS) capacitor c=3.960E-18
    I_C758 (XI120_I13_n2 VSS) capacitor c=9.877E-18
    I_C759 (XI120_I13_Bn VSS) capacitor c=1.089E-15
    I_C760 (XI120_I13_An VSS) capacitor c=9.200E-16
    I_C761 (XI120_I14_p1 VSS) capacitor c=5.172E-16
    I_C762 (XI120_I14_n2 VSS) capacitor c=9.210E-18
    I_C763 (XI120_I14_Bn VSS) capacitor c=1.046E-15
    I_C764 (XI120_I14_An VSS) capacitor c=9.483E-16
    I_C765 (XI108_I42_p1 VSS) capacitor c=5.406E-16
    I_C766 (XI108_I42_n1 VSS) capacitor c=3.820E-19
    I_C767 (XI108_I42_n2 VSS) capacitor c=9.413E-18
    I_C768 (XI108_I42_Bn VSS) capacitor c=1.089E-15
    I_C769 (XI108_I42_An VSS) capacitor c=9.362E-16
    I_C770 (XI108_I14_p1 VSS) capacitor c=5.459E-16
    I_C771 (XI108_I14_n1 VSS) capacitor c=1.497E-18
    I_C772 (XI108_I14_n2 VSS) capacitor c=6.675E-18
    I_C773 (XI108_I14_Bn VSS) capacitor c=1.055E-15
    I_C774 (XI108_I14_An VSS) capacitor c=9.302E-16
    I_C775 (XI132_I43_p1 VSS) capacitor c=5.449E-16
    I_C776 (XI132_I43_n2 VSS) capacitor c=1.053E-17
    I_C777 (XI132_I43_Bn VSS) capacitor c=1.076E-15
    I_C778 (XI132_I43_An VSS) capacitor c=9.618E-16
    I_C779 (XI132_I12_p1 VSS) capacitor c=5.217E-16
    I_C780 (XI132_I12_n1 VSS) capacitor c=1.310E-18
    I_C781 (XI132_I12_n2 VSS) capacitor c=7.250E-18
    I_C782 (XI132_I12_Bn VSS) capacitor c=1.086E-15
    I_C783 (XI132_I12_An VSS) capacitor c=9.511E-16
    I_C784 (XI120_I12_p1 VSS) capacitor c=5.273E-16
    I_C785 (XI120_I12_n1 VSS) capacitor c=1.090E-18
    I_C786 (XI120_I12_n2 VSS) capacitor c=8.344E-18
    I_C787 (XI120_I12_Bn VSS) capacitor c=1.045E-15
    I_C788 (XI120_I12_An VSS) capacitor c=9.513E-16
    I_C789 (XI108_I11_p1 VSS) capacitor c=5.523E-16
    I_C790 (XI108_I11_n1 VSS) capacitor c=2.594E-19
    I_C791 (XI108_I11_n2 VSS) capacitor c=7.998E-18
    I_C792 (XI108_I11_Bn VSS) capacitor c=1.056E-15
    I_C793 (XI108_I11_An VSS) capacitor c=9.331E-16
    I_C794 (XI108_I12_p1 VSS) capacitor c=5.792E-16
    I_C795 (XI108_I12_n1 VSS) capacitor c=4.678E-19
    I_C796 (XI108_I12_n2 VSS) capacitor c=1.053E-17
    I_C797 (XI108_I12_Bn VSS) capacitor c=1.078E-15
    I_C798 (XI108_I12_An VSS) capacitor c=9.306E-16
    I_C799 (XI108_I13_p1 VSS) capacitor c=5.247E-16
    I_C800 (XI108_I13_n1 VSS) capacitor c=1.251E-18
    I_C801 (XI108_I13_n2 VSS) capacitor c=1.069E-17
    I_C802 (XI108_I13_Bn VSS) capacitor c=1.086E-15
    I_C803 (XI108_I13_An VSS) capacitor c=9.388E-16
    I_C804 (XI96_I43_p1 VSS) capacitor c=5.248E-16
    I_C805 (XI96_I43_n1 VSS) capacitor c=5.798E-19
    I_C806 (XI96_I43_n2 VSS) capacitor c=1.089E-17
    I_C807 (XI96_I43_Bn VSS) capacitor c=1.072E-15
    I_C808 (XI96_I43_An VSS) capacitor c=9.469E-16
    I_C809 (XI132_I44_p1 VSS) capacitor c=5.293E-16
    I_C810 (XI132_I44_n2 VSS) capacitor c=1.205E-17
    I_C811 (XI132_I44_Bn VSS) capacitor c=1.026E-15
    I_C812 (XI132_I44_An VSS) capacitor c=8.927E-16
    I_C813 (XI132_I11_p1 VSS) capacitor c=5.625E-16
    I_C814 (XI132_I11_n1 VSS) capacitor c=6.796E-19
    I_C815 (XI132_I11_n2 VSS) capacitor c=8.544E-18
    I_C816 (XI132_I11_Bn VSS) capacitor c=1.037E-15
    I_C817 (XI132_I11_An VSS) capacitor c=9.321E-16
    I_C818 (XI120_I39_p1 VSS) capacitor c=5.704E-16
    I_C819 (XI120_I39_n1 VSS) capacitor c=1.256E-18
    I_C820 (XI120_I39_n2 VSS) capacitor c=8.556E-18
    I_C821 (XI120_I39_Bn VSS) capacitor c=1.069E-15
    I_C822 (XI120_I39_An VSS) capacitor c=9.552E-16
    I_C823 (XI120_I9_p1 VSS) capacitor c=5.721E-16
    I_C824 (XI120_I9_n1 VSS) capacitor c=7.170E-20
    I_C825 (XI120_I9_n2 VSS) capacitor c=7.835E-18
    I_C826 (XI120_I9_Bn VSS) capacitor c=1.097E-15
    I_C827 (XI120_I9_An VSS) capacitor c=9.430E-16
    I_C828 (XI120_I11_p1 VSS) capacitor c=5.320E-16
    I_C829 (XI120_I11_n1 VSS) capacitor c=1.749E-18
    I_C830 (XI120_I11_n2 VSS) capacitor c=9.901E-18
    I_C831 (XI120_I11_Bn VSS) capacitor c=1.050E-15
    I_C832 (XI120_I11_An VSS) capacitor c=9.343E-16
    I_C833 (XI108_I38_p1 VSS) capacitor c=5.424E-16
    I_C834 (XI108_I38_n1 VSS) capacitor c=6.822E-20
    I_C835 (XI108_I38_n2 VSS) capacitor c=7.865E-18
    I_C836 (XI108_I38_Bn VSS) capacitor c=1.089E-15
    I_C837 (XI108_I38_An VSS) capacitor c=9.258E-16
    I_C838 (XI108_I9_p1 VSS) capacitor c=5.354E-16
    I_C839 (XI108_I9_n2 VSS) capacitor c=8.497E-18
    I_C840 (XI108_I9_Bn VSS) capacitor c=1.039E-15
    I_C841 (XI108_I9_An VSS) capacitor c=9.110E-16
    I_C842 (XI108_I39_p1 VSS) capacitor c=5.799E-16
    I_C843 (XI108_I39_n1 VSS) capacitor c=1.377E-18
    I_C844 (XI108_I39_n2 VSS) capacitor c=1.323E-17
    I_C845 (XI108_I39_Bn VSS) capacitor c=1.093E-15
    I_C846 (XI108_I39_An VSS) capacitor c=9.316E-16
    I_C847 (XI96_I39_p1 VSS) capacitor c=5.355E-16
    I_C848 (XI96_I39_n1 VSS) capacitor c=7.196E-19
    I_C849 (XI96_I39_n2 VSS) capacitor c=1.042E-17
    I_C850 (XI96_I39_Bn VSS) capacitor c=1.057E-15
    I_C851 (XI96_I39_An VSS) capacitor c=9.374E-16
    I_C852 (XI96_I42_p1 VSS) capacitor c=5.166E-16
    I_C853 (XI96_I42_n1 VSS) capacitor c=1.249E-18
    I_C854 (XI96_I42_n2 VSS) capacitor c=9.615E-18
    I_C855 (XI96_I42_Bn VSS) capacitor c=1.057E-15
    I_C856 (XI96_I42_An VSS) capacitor c=9.680E-16
    I_C857 (XI152_I15_p1 VSS) capacitor c=5.526E-16
    I_C858 (XI152_I15_n1 VSS) capacitor c=5.378E-19
    I_C859 (XI152_I15_n2 VSS) capacitor c=7.455E-18
    I_C860 (XI152_I15_Bn VSS) capacitor c=1.053E-15
    I_C861 (XI152_I15_An VSS) capacitor c=8.958E-16
    I_C862 (XI132_I42_p1 VSS) capacitor c=5.503E-16
    I_C863 (XI132_I42_n1 VSS) capacitor c=1.660E-19
    I_C864 (XI132_I42_n2 VSS) capacitor c=1.229E-17
    I_C865 (XI132_I42_Bn VSS) capacitor c=1.060E-15
    I_C866 (XI132_I42_An VSS) capacitor c=9.237E-16
    I_C867 (XI132_I10_p1 VSS) capacitor c=5.558E-16
    I_C868 (XI132_I10_n2 VSS) capacitor c=9.574E-18
    I_C869 (XI132_I10_Bn VSS) capacitor c=1.098E-15
    I_C870 (XI132_I10_An VSS) capacitor c=9.901E-16
    I_C871 (XI120_I38_p1 VSS) capacitor c=5.108E-16
    I_C872 (XI120_I38_n1 VSS) capacitor c=4.862E-19
    I_C873 (XI120_I38_n2 VSS) capacitor c=9.310E-18
    I_C874 (XI120_I38_Bn VSS) capacitor c=1.055E-15
    I_C875 (XI120_I38_An VSS) capacitor c=9.184E-16
    I_C876 (XI120_I10_p1 VSS) capacitor c=5.591E-16
    I_C877 (XI120_I10_n1 VSS) capacitor c=1.302E-18
    I_C878 (XI120_I10_n2 VSS) capacitor c=4.873E-18
    I_C879 (XI120_I10_Bn VSS) capacitor c=1.052E-15
    I_C880 (XI120_I10_An VSS) capacitor c=8.987E-16
    I_C881 (XI108_I37_p1 VSS) capacitor c=5.386E-16
    I_C882 (XI108_I37_n1 VSS) capacitor c=2.114E-18
    I_C883 (XI108_I37_n2 VSS) capacitor c=8.440E-18
    I_C884 (XI108_I37_Bn VSS) capacitor c=1.051E-15
    I_C885 (XI108_I37_An VSS) capacitor c=9.323E-16
    I_C886 (XI108_I8_p1 VSS) capacitor c=5.840E-16
    I_C887 (XI108_I8_n2 VSS) capacitor c=8.419E-18
    I_C888 (XI108_I8_Bn VSS) capacitor c=1.077E-15
    I_C889 (XI108_I8_An VSS) capacitor c=9.224E-16
    I_C890 (XI108_I10_p1 VSS) capacitor c=5.510E-16
    I_C891 (XI108_I10_n1 VSS) capacitor c=3.761E-18
    I_C892 (XI108_I10_n2 VSS) capacitor c=8.427E-18
    I_C893 (XI108_I10_Bn VSS) capacitor c=1.073E-15
    I_C894 (XI108_I10_An VSS) capacitor c=9.317E-16
    I_C895 (XI96_I38_p1 VSS) capacitor c=5.462E-16
    I_C896 (XI96_I38_n1 VSS) capacitor c=3.820E-19
    I_C897 (XI96_I38_n2 VSS) capacitor c=6.827E-18
    I_C898 (XI96_I38_Bn VSS) capacitor c=1.074E-15
    I_C899 (XI96_I38_An VSS) capacitor c=9.189E-16
    I_C900 (XI96_I9_p1 VSS) capacitor c=5.203E-16
    I_C901 (XI96_I9_n1 VSS) capacitor c=5.786E-19
    I_C902 (XI96_I9_n2 VSS) capacitor c=8.821E-18
    I_C903 (XI96_I9_Bn VSS) capacitor c=1.087E-15
    I_C904 (XI96_I9_An VSS) capacitor c=9.089E-16
    I_C905 (XI96_I44_p1 VSS) capacitor c=5.238E-16
    I_C906 (XI96_I44_n1 VSS) capacitor c=4.674E-18
    I_C907 (XI96_I44_n2 VSS) capacitor c=1.083E-17
    I_C908 (XI96_I44_Bn VSS) capacitor c=1.078E-15
    I_C909 (XI96_I44_An VSS) capacitor c=9.159E-16
    I_C910 (XI96_I15_p1 VSS) capacitor c=5.463E-16
    I_C911 (XI96_I15_n1 VSS) capacitor c=8.981E-19
    I_C912 (XI96_I15_n2 VSS) capacitor c=8.688E-18
    I_C913 (XI96_I15_Bn VSS) capacitor c=1.060E-15
    I_C914 (XI96_I15_An VSS) capacitor c=9.191E-16
    I_C915 (XI152_I14_p1 VSS) capacitor c=5.650E-16
    I_C916 (XI152_I14_n2 VSS) capacitor c=1.053E-17
    I_C917 (XI152_I14_Bn VSS) capacitor c=1.042E-15
    I_C918 (XI152_I14_An VSS) capacitor c=9.132E-16
    I_C919 (XI152_I13_p1 VSS) capacitor c=5.820E-16
    I_C920 (XI152_I13_n2 VSS) capacitor c=8.363E-18
    I_C921 (XI152_I13_Bn VSS) capacitor c=1.097E-15
    I_C922 (XI152_I13_An VSS) capacitor c=9.647E-16
    I_C923 (XI132_I39_p1 VSS) capacitor c=5.707E-16
    I_C924 (XI132_I39_n2 VSS) capacitor c=5.755E-18
    I_C925 (XI132_I39_Bn VSS) capacitor c=1.096E-15
    I_C926 (XI132_I39_An VSS) capacitor c=9.483E-16
    I_C927 (XI132_I9_p1 VSS) capacitor c=5.857E-16
    I_C928 (XI132_I9_n2 VSS) capacitor c=7.662E-18
    I_C929 (XI132_I9_Bn VSS) capacitor c=1.088E-15
    I_C930 (XI132_I9_An VSS) capacitor c=9.577E-16
    I_C931 (XI120_I37_p1 VSS) capacitor c=5.218E-16
    I_C932 (XI120_I37_n1 VSS) capacitor c=3.153E-18
    I_C933 (XI120_I37_n2 VSS) capacitor c=8.362E-18
    I_C934 (XI120_I37_Bn VSS) capacitor c=1.060E-15
    I_C935 (XI120_I37_An VSS) capacitor c=9.644E-16
    I_C936 (XI120_I8_p1 VSS) capacitor c=5.663E-16
    I_C937 (XI120_I8_n1 VSS) capacitor c=2.918E-18
    I_C938 (XI120_I8_n2 VSS) capacitor c=8.325E-18
    I_C939 (XI120_I8_Bn VSS) capacitor c=1.069E-15
    I_C940 (XI120_I8_An VSS) capacitor c=9.235E-16
    I_C941 (XI4_p1 VSS) capacitor c=5.712E-16
    I_C942 (XI4_n1 VSS) capacitor c=3.927E-19
    I_C943 (XI4_n2 VSS) capacitor c=9.409E-18
    I_C944 (XI4_Bn VSS) capacitor c=1.091E-15
    I_C945 (XI4_An VSS) capacitor c=9.294E-16
    I_C946 (XI7_p1 VSS) capacitor c=5.564E-16
    I_C947 (XI7_n1 VSS) capacitor c=2.092E-18
    I_C948 (XI7_n2 VSS) capacitor c=1.081E-17
    I_C949 (XI7_Bn VSS) capacitor c=1.088E-15
    I_C950 (XI7_An VSS) capacitor c=9.482E-16
    I_C951 (XI96_I37_p1 VSS) capacitor c=5.597E-16
    I_C952 (XI96_I37_n1 VSS) capacitor c=3.820E-19
    I_C953 (XI96_I37_n2 VSS) capacitor c=7.185E-18
    I_C954 (XI96_I37_Bn VSS) capacitor c=1.081E-15
    I_C955 (XI96_I37_An VSS) capacitor c=9.337E-16
    I_C956 (XI96_I8_p1 VSS) capacitor c=5.317E-16
    I_C957 (XI96_I8_n1 VSS) capacitor c=1.149E-18
    I_C958 (XI96_I8_n2 VSS) capacitor c=1.212E-17
    I_C959 (XI96_I8_Bn VSS) capacitor c=1.099E-15
    I_C960 (XI96_I8_An VSS) capacitor c=9.509E-16
    I_C961 (XI96_I10_p1 VSS) capacitor c=5.491E-16
    I_C962 (XI96_I10_n1 VSS) capacitor c=4.807E-19
    I_C963 (XI96_I10_n2 VSS) capacitor c=1.092E-17
    I_C964 (XI96_I10_Bn VSS) capacitor c=1.101E-15
    I_C965 (XI96_I10_An VSS) capacitor c=9.093E-16
    I_C966 (XI96_I14_p1 VSS) capacitor c=5.776E-16
    I_C967 (XI96_I14_n1 VSS) capacitor c=5.963E-19
    I_C968 (XI96_I14_n2 VSS) capacitor c=1.486E-17
    I_C969 (XI96_I14_Bn VSS) capacitor c=1.088E-15
    I_C970 (XI96_I14_An VSS) capacitor c=9.066E-16
    I_C971 (XI152_I12_p1 VSS) capacitor c=5.635E-16
    I_C972 (XI152_I12_n1 VSS) capacitor c=6.438E-18
    I_C973 (XI152_I12_n2 VSS) capacitor c=9.036E-18
    I_C974 (XI152_I12_Bn VSS) capacitor c=1.059E-15
    I_C975 (XI152_I12_An VSS) capacitor c=9.170E-16
    I_C976 (XI152_I11_p1 VSS) capacitor c=5.195E-16
    I_C977 (XI152_I11_n1 VSS) capacitor c=4.996E-19
    I_C978 (XI152_I11_n2 VSS) capacitor c=8.585E-18
    I_C979 (XI152_I11_Bn VSS) capacitor c=1.044E-15
    I_C980 (XI152_I11_An VSS) capacitor c=9.548E-16
    I_C981 (XI132_I38_p1 VSS) capacitor c=5.467E-16
    I_C982 (XI132_I38_n1 VSS) capacitor c=9.354E-19
    I_C983 (XI132_I38_n2 VSS) capacitor c=7.377E-18
    I_C984 (XI132_I38_Bn VSS) capacitor c=1.075E-15
    I_C985 (XI132_I38_An VSS) capacitor c=9.765E-16
    I_C986 (XI132_I37_p1 VSS) capacitor c=5.287E-16
    I_C987 (XI132_I37_n2 VSS) capacitor c=9.495E-18
    I_C988 (XI132_I37_Bn VSS) capacitor c=1.029E-15
    I_C989 (XI132_I37_An VSS) capacitor c=9.342E-16
    I_C990 (XI132_I8_p1 VSS) capacitor c=5.533E-16
    I_C991 (XI132_I8_n2 VSS) capacitor c=6.771E-18
    I_C992 (XI132_I8_Bn VSS) capacitor c=1.056E-15
    I_C993 (XI132_I8_An VSS) capacitor c=9.013E-16
    I_C994 (XI1_p1 VSS) capacitor c=5.156E-16
    I_C995 (XI1_n1 VSS) capacitor c=1.718E-18
    I_C996 (XI1_n2 VSS) capacitor c=6.840E-18
    I_C997 (XI1_Bn VSS) capacitor c=1.037E-15
    I_C998 (XI1_An VSS) capacitor c=9.463E-16
    I_C999 (XI155_p1 VSS) capacitor c=5.405E-16
    I_C1000 (XI155_n1 VSS) capacitor c=9.046E-19
    I_C1001 (XI155_n2 VSS) capacitor c=8.707E-18
    I_C1002 (XI155_Bn VSS) capacitor c=1.104E-15
    I_C1003 (XI155_An VSS) capacitor c=8.971E-16
    I_C1004 (XI158_p1 VSS) capacitor c=5.896E-16
    I_C1005 (XI158_n1 VSS) capacitor c=5.800E-19
    I_C1006 (XI158_n2 VSS) capacitor c=1.009E-17
    I_C1007 (XI158_Bn VSS) capacitor c=1.095E-15
    I_C1008 (XI158_An VSS) capacitor c=9.332E-16
    I_C1009 (XI161_p1 VSS) capacitor c=5.407E-16
    I_C1010 (XI161_n2 VSS) capacitor c=9.326E-18
    I_C1011 (XI161_Bn VSS) capacitor c=1.076E-15
    I_C1012 (XI161_An VSS) capacitor c=9.127E-16
    I_C1013 (XI10_p1 VSS) capacitor c=5.723E-16
    I_C1014 (XI10_n2 VSS) capacitor c=8.455E-18
    I_C1015 (XI10_Bn VSS) capacitor c=1.105E-15
    I_C1016 (XI10_An VSS) capacitor c=9.325E-16
    I_C1017 (XI84_I8_p1 VSS) capacitor c=5.891E-16
    I_C1018 (XI84_I8_n1 VSS) capacitor c=2.428E-19
    I_C1019 (XI84_I8_n2 VSS) capacitor c=9.155E-18
    I_C1020 (XI84_I8_Bn VSS) capacitor c=1.085E-15
    I_C1021 (XI84_I8_An VSS) capacitor c=9.257E-16
    I_C1022 (XI84_I37_p1 VSS) capacitor c=5.611E-16
    I_C1023 (XI84_I37_n1 VSS) capacitor c=1.381E-18
    I_C1024 (XI84_I37_n2 VSS) capacitor c=1.168E-17
    I_C1025 (XI84_I37_Bn VSS) capacitor c=1.093E-15
    I_C1026 (XI84_I37_An VSS) capacitor c=9.233E-16
    I_C1027 (XI96_I11_p1 VSS) capacitor c=5.366E-16
    I_C1028 (XI96_I11_n1 VSS) capacitor c=6.670E-18
    I_C1029 (XI96_I11_n2 VSS) capacitor c=8.296E-18
    I_C1030 (XI96_I11_Bn VSS) capacitor c=1.061E-15
    I_C1031 (XI96_I11_An VSS) capacitor c=9.109E-16
    I_C1032 (XI96_I12_p1 VSS) capacitor c=5.555E-16
    I_C1033 (XI96_I12_n1 VSS) capacitor c=5.117E-18
    I_C1034 (XI96_I12_n2 VSS) capacitor c=9.054E-18
    I_C1035 (XI96_I12_Bn VSS) capacitor c=1.071E-15
    I_C1036 (XI96_I12_An VSS) capacitor c=9.561E-16
    I_C1037 (XI96_I13_p1 VSS) capacitor c=5.521E-16
    I_C1038 (XI96_I13_n1 VSS) capacitor c=6.641E-19
    I_C1039 (XI96_I13_n2 VSS) capacitor c=8.102E-18
    I_C1040 (XI96_I13_Bn VSS) capacitor c=1.099E-15
    I_C1041 (XI96_I13_An VSS) capacitor c=9.478E-16
    I_C1042 (XI152_I10_p1 VSS) capacitor c=5.260E-16
    I_C1043 (XI152_I10_n2 VSS) capacitor c=8.636E-18
    I_C1044 (XI152_I10_Bn VSS) capacitor c=1.078E-15
    I_C1045 (XI152_I10_An VSS) capacitor c=9.587E-16
    I_C1046 (XI152_I8_p1 VSS) capacitor c=5.477E-16
    I_C1047 (XI152_I8_n1 VSS) capacitor c=4.444E-19
    I_C1048 (XI152_I8_n2 VSS) capacitor c=7.159E-18
    I_C1049 (XI152_I8_Bn VSS) capacitor c=1.133E-15
    I_C1050 (XI152_I8_An VSS) capacitor c=9.227E-16
    I_C1051 (XI36_p1 VSS) capacitor c=5.602E-16
    I_C1052 (XI36_n1 VSS) capacitor c=6.026E-18
    I_C1053 (XI36_n2 VSS) capacitor c=9.322E-18
    I_C1054 (XI36_Bn VSS) capacitor c=1.098E-15
    I_C1055 (XI36_An VSS) capacitor c=9.212E-16
    I_C1056 (XI39_p1 VSS) capacitor c=5.691E-16
    I_C1057 (XI39_n1 VSS) capacitor c=5.786E-19
    I_C1058 (XI39_n2 VSS) capacitor c=9.618E-18
    I_C1059 (XI39_Bn VSS) capacitor c=1.104E-15
    I_C1060 (XI39_An VSS) capacitor c=9.381E-16
    I_C1061 (XI167_p1 VSS) capacitor c=5.358E-16
    I_C1062 (XI167_n1 VSS) capacitor c=2.899E-18
    I_C1063 (XI167_n2 VSS) capacitor c=1.055E-17
    I_C1064 (XI167_Bn VSS) capacitor c=1.044E-15
    I_C1065 (XI167_An VSS) capacitor c=9.378E-16
    I_C1066 (XI84_I9_p1 VSS) capacitor c=5.515E-16
    I_C1067 (XI84_I9_n1 VSS) capacitor c=1.203E-18
    I_C1068 (XI84_I9_n2 VSS) capacitor c=8.259E-18
    I_C1069 (XI84_I9_Bn VSS) capacitor c=1.036E-15
    I_C1070 (XI84_I9_An VSS) capacitor c=9.272E-16
    I_C1071 (XI84_I38_p1 VSS) capacitor c=5.578E-16
    I_C1072 (XI84_I38_n1 VSS) capacitor c=8.423E-19
    I_C1073 (XI84_I38_n2 VSS) capacitor c=8.116E-18
    I_C1074 (XI84_I38_Bn VSS) capacitor c=1.072E-15
    I_C1075 (XI84_I38_An VSS) capacitor c=9.007E-16
    I_C1076 (XI84_I42_p1 VSS) capacitor c=5.699E-16
    I_C1077 (XI84_I42_n1 VSS) capacitor c=4.295E-19
    I_C1078 (XI84_I42_n2 VSS) capacitor c=1.727E-17
    I_C1079 (XI84_I42_Bn VSS) capacitor c=1.106E-15
    I_C1080 (XI84_I42_An VSS) capacitor c=9.211E-16
    I_C1081 (XI84_I44_p1 VSS) capacitor c=5.696E-16
    I_C1082 (XI84_I44_n1 VSS) capacitor c=5.037E-18
    I_C1083 (XI84_I44_n2 VSS) capacitor c=6.505E-18
    I_C1084 (XI84_I44_Bn VSS) capacitor c=1.097E-15
    I_C1085 (XI84_I44_An VSS) capacitor c=9.445E-16
    I_C1086 (XI152_I43_p1 VSS) capacitor c=5.477E-16
    I_C1087 (XI152_I43_n1 VSS) capacitor c=1.161E-18
    I_C1088 (XI152_I43_n2 VSS) capacitor c=7.452E-18
    I_C1089 (XI152_I43_Bn VSS) capacitor c=1.068E-15
    I_C1090 (XI152_I43_An VSS) capacitor c=9.451E-16
    I_C1091 (XI152_I9_p1 VSS) capacitor c=5.764E-16
    I_C1092 (XI152_I9_n1 VSS) capacitor c=1.701E-18
    I_C1093 (XI152_I9_n2 VSS) capacitor c=6.483E-18
    I_C1094 (XI152_I9_Bn VSS) capacitor c=1.070E-15
    I_C1095 (XI152_I9_An VSS) capacitor c=9.554E-16
    I_C1096 (XI33_p1 VSS) capacitor c=5.333E-16
    I_C1097 (XI33_n1 VSS) capacitor c=7.148E-18
    I_C1098 (XI33_n2 VSS) capacitor c=7.223E-18
    I_C1099 (XI33_Bn VSS) capacitor c=1.055E-15
    I_C1100 (XI33_An VSS) capacitor c=9.526E-16
    I_C1101 (XI21_p1 VSS) capacitor c=5.412E-16
    I_C1102 (XI21_n2 VSS) capacitor c=7.802E-18
    I_C1103 (XI21_Bn VSS) capacitor c=1.034E-15
    I_C1104 (XI21_An VSS) capacitor c=9.316E-16
    I_C1105 (XI164_p1 VSS) capacitor c=5.439E-16
    I_C1106 (XI164_n1 VSS) capacitor c=1.142E-18
    I_C1107 (XI164_n2 VSS) capacitor c=9.743E-18
    I_C1108 (XI164_Bn VSS) capacitor c=1.055E-15
    I_C1109 (XI164_An VSS) capacitor c=9.315E-16
    I_C1110 (XI170_p1 VSS) capacitor c=5.704E-16
    I_C1111 (XI170_n1 VSS) capacitor c=6.815E-19
    I_C1112 (XI170_n2 VSS) capacitor c=8.002E-18
    I_C1113 (XI170_Bn VSS) capacitor c=1.090E-15
    I_C1114 (XI170_An VSS) capacitor c=9.524E-16
    I_C1115 (XI72_I37_p1 VSS) capacitor c=5.305E-16
    I_C1116 (XI72_I37_n1 VSS) capacitor c=6.357E-19
    I_C1117 (XI72_I37_n2 VSS) capacitor c=7.525E-18
    I_C1118 (XI72_I37_Bn VSS) capacitor c=1.025E-15
    I_C1119 (XI72_I37_An VSS) capacitor c=9.600E-16
    I_C1120 (XI84_I10_p1 VSS) capacitor c=5.539E-16
    I_C1121 (XI84_I10_n1 VSS) capacitor c=8.595E-19
    I_C1122 (XI84_I10_n2 VSS) capacitor c=8.965E-18
    I_C1123 (XI84_I10_Bn VSS) capacitor c=1.064E-15
    I_C1124 (XI84_I10_An VSS) capacitor c=9.653E-16
    I_C1125 (XI84_I39_p1 VSS) capacitor c=5.484E-16
    I_C1126 (XI84_I39_n2 VSS) capacitor c=7.693E-18
    I_C1127 (XI84_I39_Bn VSS) capacitor c=1.073E-15
    I_C1128 (XI84_I39_An VSS) capacitor c=9.754E-16
    I_C1129 (XI84_I43_p1 VSS) capacitor c=5.880E-16
    I_C1130 (XI84_I43_n1 VSS) capacitor c=5.111E-18
    I_C1131 (XI84_I43_n2 VSS) capacitor c=6.220E-18
    I_C1132 (XI84_I43_Bn VSS) capacitor c=1.067E-15
    I_C1133 (XI84_I43_An VSS) capacitor c=9.453E-16
    I_C1134 (XI193_p1 VSS) capacitor c=5.699E-16
    I_C1135 (XI193_n2 VSS) capacitor c=8.846E-18
    I_C1136 (XI193_Bn VSS) capacitor c=1.078E-15
    I_C1137 (XI193_An VSS) capacitor c=9.504E-16
    I_C1138 (XI152_I44_p1 VSS) capacitor c=5.844E-16
    I_C1139 (XI152_I44_n1 VSS) capacitor c=1.724E-18
    I_C1140 (XI152_I44_n2 VSS) capacitor c=9.383E-18
    I_C1141 (XI152_I44_Bn VSS) capacitor c=1.025E-15
    I_C1142 (XI152_I44_An VSS) capacitor c=9.164E-16
    I_C1143 (XI152_I42_p1 VSS) capacitor c=5.388E-16
    I_C1144 (XI152_I42_n2 VSS) capacitor c=7.564E-18
    I_C1145 (XI152_I42_Bn VSS) capacitor c=1.092E-15
    I_C1146 (XI152_I42_An VSS) capacitor c=9.849E-16
    I_C1147 (XI152_I39_p1 VSS) capacitor c=5.358E-16
    I_C1148 (XI152_I39_n1 VSS) capacitor c=1.379E-18
    I_C1149 (XI152_I39_n2 VSS) capacitor c=8.502E-18
    I_C1150 (XI152_I39_Bn VSS) capacitor c=1.070E-15
    I_C1151 (XI152_I39_An VSS) capacitor c=9.519E-16
    I_C1152 (XI152_I38_p1 VSS) capacitor c=5.430E-16
    I_C1153 (XI152_I38_n1 VSS) capacitor c=3.702E-18
    I_C1154 (XI152_I38_n2 VSS) capacitor c=7.217E-18
    I_C1155 (XI152_I38_Bn VSS) capacitor c=1.049E-15
    I_C1156 (XI152_I38_An VSS) capacitor c=9.538E-16
    I_C1157 (XI175_p1 VSS) capacitor c=5.574E-16
    I_C1158 (XI175_n1 VSS) capacitor c=5.828E-19
    I_C1159 (XI175_n2 VSS) capacitor c=8.802E-18
    I_C1160 (XI175_Bn VSS) capacitor c=1.067E-15
    I_C1161 (XI175_An VSS) capacitor c=9.571E-16
    I_C1162 (XI152_I37_p1 VSS) capacitor c=5.801E-16
    I_C1163 (XI152_I37_n1 VSS) capacitor c=3.411E-19
    I_C1164 (XI152_I37_n2 VSS) capacitor c=8.605E-18
    I_C1165 (XI152_I37_Bn VSS) capacitor c=1.077E-15
    I_C1166 (XI152_I37_An VSS) capacitor c=9.329E-16
    I_C1167 (XI24_p1 VSS) capacitor c=5.300E-16
    I_C1168 (XI24_n1 VSS) capacitor c=5.559E-19
    I_C1169 (XI24_n2 VSS) capacitor c=8.548E-18
    I_C1170 (XI24_Bn VSS) capacitor c=1.086E-15
    I_C1171 (XI24_An VSS) capacitor c=9.415E-16
    I_C1172 (XI173_p1 VSS) capacitor c=5.276E-16
    I_C1173 (XI173_n2 VSS) capacitor c=7.011E-18
    I_C1174 (XI173_Bn VSS) capacitor c=1.085E-15
    I_C1175 (XI173_An VSS) capacitor c=9.066E-16
    I_C1176 (XI13_p1 VSS) capacitor c=5.214E-16
    I_C1177 (XI13_n1 VSS) capacitor c=1.226E-18
    I_C1178 (XI13_n2 VSS) capacitor c=1.069E-17
    I_C1179 (XI13_Bn VSS) capacitor c=1.073E-15
    I_C1180 (XI13_An VSS) capacitor c=9.477E-16
    I_C1181 (XI72_I8_p1 VSS) capacitor c=5.442E-16
    I_C1182 (XI72_I8_n1 VSS) capacitor c=1.178E-18
    I_C1183 (XI72_I8_n2 VSS) capacitor c=9.234E-18
    I_C1184 (XI72_I8_Bn VSS) capacitor c=1.061E-15
    I_C1185 (XI72_I8_An VSS) capacitor c=9.065E-16
    I_C1186 (XI72_I38_p1 VSS) capacitor c=5.474E-16
    I_C1187 (XI72_I38_n1 VSS) capacitor c=4.305E-19
    I_C1188 (XI72_I38_n2 VSS) capacitor c=1.224E-17
    I_C1189 (XI72_I38_Bn VSS) capacitor c=1.051E-15
    I_C1190 (XI72_I38_An VSS) capacitor c=9.125E-16
    I_C1191 (XI84_I11_p1 VSS) capacitor c=5.547E-16
    I_C1192 (XI84_I11_n1 VSS) capacitor c=5.786E-19
    I_C1193 (XI84_I11_n2 VSS) capacitor c=9.011E-18
    I_C1194 (XI84_I11_Bn VSS) capacitor c=1.040E-15
    I_C1195 (XI84_I11_An VSS) capacitor c=9.488E-16
    I_C1196 (XI190_p1 VSS) capacitor c=5.138E-16
    I_C1197 (XI190_n1 VSS) capacitor c=3.820E-19
    I_C1198 (XI190_n2 VSS) capacitor c=8.638E-18
    I_C1199 (XI190_Bn VSS) capacitor c=1.048E-15
    I_C1200 (XI190_An VSS) capacitor c=9.805E-16
    I_C1201 (XI184_p1 VSS) capacitor c=5.435E-16
    I_C1202 (XI184_n1 VSS) capacitor c=1.275E-18
    I_C1203 (XI184_n2 VSS) capacitor c=8.566E-18
    I_C1204 (XI184_Bn VSS) capacitor c=1.083E-15
    I_C1205 (XI184_An VSS) capacitor c=9.347E-16
    I_C1206 (XI178_p1 VSS) capacitor c=5.653E-16
    I_C1207 (XI178_n1 VSS) capacitor c=1.827E-18
    I_C1208 (XI178_n2 VSS) capacitor c=9.851E-18
    I_C1209 (XI178_Bn VSS) capacitor c=1.067E-15
    I_C1210 (XI178_An VSS) capacitor c=9.367E-16
    I_C1211 (XI27_p1 VSS) capacitor c=5.485E-16
    I_C1212 (XI27_n1 VSS) capacitor c=3.287E-18
    I_C1213 (XI27_n2 VSS) capacitor c=9.443E-18
    I_C1214 (XI27_Bn VSS) capacitor c=1.040E-15
    I_C1215 (XI27_An VSS) capacitor c=9.621E-16
    I_C1216 (XI30_p1 VSS) capacitor c=5.277E-16
    I_C1217 (XI30_n1 VSS) capacitor c=5.823E-19
    I_C1218 (XI30_n2 VSS) capacitor c=8.879E-18
    I_C1219 (XI30_Bn VSS) capacitor c=1.046E-15
    I_C1220 (XI30_An VSS) capacitor c=8.927E-16
    I_C1221 (XI48_I8_p1 VSS) capacitor c=5.629E-16
    I_C1222 (XI48_I8_n1 VSS) capacitor c=1.073E-17
    I_C1223 (XI48_I8_n2 VSS) capacitor c=5.863E-18
    I_C1224 (XI48_I8_Bn VSS) capacitor c=1.062E-15
    I_C1225 (XI48_I8_An VSS) capacitor c=9.168E-16
    I_C1226 (XI19_p1 VSS) capacitor c=5.457E-16
    I_C1227 (XI19_n1 VSS) capacitor c=3.820E-19
    I_C1228 (XI19_n2 VSS) capacitor c=8.827E-18
    I_C1229 (XI19_Bn VSS) capacitor c=1.054E-15
    I_C1230 (XI19_An VSS) capacitor c=9.137E-16
    I_C1231 (XI16_p1 VSS) capacitor c=5.560E-16
    I_C1232 (XI16_n1 VSS) capacitor c=1.775E-20
    I_C1233 (XI16_n2 VSS) capacitor c=7.991E-18
    I_C1234 (XI16_Bn VSS) capacitor c=1.055E-15
    I_C1235 (XI16_An VSS) capacitor c=8.942E-16
    I_C1236 (XI60_I37_p1 VSS) capacitor c=5.675E-16
    I_C1237 (XI60_I37_n1 VSS) capacitor c=5.786E-19
    I_C1238 (XI60_I37_n2 VSS) capacitor c=9.864E-18
    I_C1239 (XI60_I37_Bn VSS) capacitor c=1.100E-15
    I_C1240 (XI60_I37_An VSS) capacitor c=9.189E-16
    I_C1241 (XI60_I8_p1 VSS) capacitor c=5.560E-16
    I_C1242 (XI60_I8_n1 VSS) capacitor c=2.047E-19
    I_C1243 (XI60_I8_n2 VSS) capacitor c=7.282E-18
    I_C1244 (XI60_I8_Bn VSS) capacitor c=1.090E-15
    I_C1245 (XI60_I8_An VSS) capacitor c=9.482E-16
    I_C1246 (XI72_I9_p1 VSS) capacitor c=5.491E-16
    I_C1247 (XI72_I9_n2 VSS) capacitor c=7.153E-18
    I_C1248 (XI72_I9_Bn VSS) capacitor c=1.101E-15
    I_C1249 (XI72_I9_An VSS) capacitor c=9.258E-16
    I_C1250 (XI84_I12_p1 VSS) capacitor c=5.684E-16
    I_C1251 (XI84_I12_n1 VSS) capacitor c=1.330E-18
    I_C1252 (XI84_I12_n2 VSS) capacitor c=9.549E-18
    I_C1253 (XI84_I12_Bn VSS) capacitor c=1.079E-15
    I_C1254 (XI84_I12_An VSS) capacitor c=9.306E-16
    I_C1255 (XI187_p1 VSS) capacitor c=5.000E-16
    I_C1256 (XI187_n1 VSS) capacitor c=5.786E-19
    I_C1257 (XI187_n2 VSS) capacitor c=8.969E-18
    I_C1258 (XI187_Bn VSS) capacitor c=1.039E-15
    I_C1259 (XI187_An VSS) capacitor c=9.249E-16
    I_C1260 (XI181_p1 VSS) capacitor c=5.055E-16
    I_C1261 (XI181_n1 VSS) capacitor c=5.786E-19
    I_C1262 (XI181_n2 VSS) capacitor c=8.304E-18
    I_C1263 (XI181_Bn VSS) capacitor c=1.027E-15
    I_C1264 (XI181_An VSS) capacitor c=9.049E-16
    I_C1265 (XI48_I11_p1 VSS) capacitor c=5.064E-16
    I_C1266 (XI48_I11_n1 VSS) capacitor c=5.831E-19
    I_C1267 (XI48_I11_n2 VSS) capacitor c=1.088E-17
    I_C1268 (XI48_I11_Bn VSS) capacitor c=9.942E-16
    I_C1269 (XI48_I11_An VSS) capacitor c=8.840E-16
    I_C1270 (XI48_I10_p1 VSS) capacitor c=5.372E-16
    I_C1271 (XI48_I10_n1 VSS) capacitor c=6.266E-18
    I_C1272 (XI48_I10_n2 VSS) capacitor c=9.326E-18
    I_C1273 (XI48_I10_Bn VSS) capacitor c=1.047E-15
    I_C1274 (XI48_I10_An VSS) capacitor c=9.674E-16
    I_C1275 (XI48_I9_p1 VSS) capacitor c=5.203E-16
    I_C1276 (XI48_I9_n1 VSS) capacitor c=5.723E-20
    I_C1277 (XI48_I9_n2 VSS) capacitor c=6.444E-18
    I_C1278 (XI48_I9_Bn VSS) capacitor c=1.022E-15
    I_C1279 (XI48_I9_An VSS) capacitor c=9.918E-16
    I_C1280 (XI48_I37_p1 VSS) capacitor c=5.455E-16
    I_C1281 (XI48_I37_n2 VSS) capacitor c=6.912E-18
    I_C1282 (XI48_I37_Bn VSS) capacitor c=1.064E-15
    I_C1283 (XI48_I37_An VSS) capacitor c=8.865E-16
    I_C1284 (XI60_I9_p1 VSS) capacitor c=5.424E-16
    I_C1285 (XI60_I9_n2 VSS) capacitor c=1.177E-17
    I_C1286 (XI60_I9_Bn VSS) capacitor c=1.063E-15
    I_C1287 (XI60_I9_An VSS) capacitor c=9.464E-16
    I_C1288 (XI60_I38_p1 VSS) capacitor c=5.483E-16
    I_C1289 (XI60_I38_n1 VSS) capacitor c=5.809E-19
    I_C1290 (XI60_I38_n2 VSS) capacitor c=8.504E-18
    I_C1291 (XI60_I38_Bn VSS) capacitor c=1.077E-15
    I_C1292 (XI60_I38_An VSS) capacitor c=9.242E-16
    I_C1293 (XI72_I10_p1 VSS) capacitor c=5.583E-16
    I_C1294 (XI72_I10_n1 VSS) capacitor c=5.059E-18
    I_C1295 (XI72_I10_n2 VSS) capacitor c=9.293E-18
    I_C1296 (XI72_I10_Bn VSS) capacitor c=1.092E-15
    I_C1297 (XI72_I10_An VSS) capacitor c=9.324E-16
    I_C1298 (XI72_I39_p1 VSS) capacitor c=5.331E-16
    I_C1299 (XI72_I39_n2 VSS) capacitor c=8.978E-18
    I_C1300 (XI72_I39_Bn VSS) capacitor c=1.053E-15
    I_C1301 (XI72_I39_An VSS) capacitor c=9.211E-16
    I_C1302 (XI84_I13_p1 VSS) capacitor c=5.846E-16
    I_C1303 (XI84_I13_n1 VSS) capacitor c=3.820E-19
    I_C1304 (XI84_I13_n2 VSS) capacitor c=9.572E-18
    I_C1305 (XI84_I13_Bn VSS) capacitor c=1.055E-15
    I_C1306 (XI84_I13_An VSS) capacitor c=8.933E-16
    I_C1307 (XI48_I12_p1 VSS) capacitor c=5.404E-16
    I_C1308 (XI48_I12_n2 VSS) capacitor c=9.925E-18
    I_C1309 (XI48_I12_Bn VSS) capacitor c=1.066E-15
    I_C1310 (XI48_I12_An VSS) capacitor c=9.499E-16
    I_C1311 (XI48_I38_p1 VSS) capacitor c=5.277E-16
    I_C1312 (XI48_I38_n1 VSS) capacitor c=5.786E-19
    I_C1313 (XI48_I38_n2 VSS) capacitor c=7.729E-18
    I_C1314 (XI48_I38_Bn VSS) capacitor c=1.011E-15
    I_C1315 (XI48_I38_An VSS) capacitor c=9.546E-16
    I_C1316 (XI60_I11_p1 VSS) capacitor c=5.701E-16
    I_C1317 (XI60_I11_n1 VSS) capacitor c=1.610E-18
    I_C1318 (XI60_I11_n2 VSS) capacitor c=9.306E-18
    I_C1319 (XI60_I11_Bn VSS) capacitor c=1.099E-15
    I_C1320 (XI60_I11_An VSS) capacitor c=9.478E-16
    I_C1321 (XI60_I10_p1 VSS) capacitor c=5.437E-16
    I_C1322 (XI60_I10_n2 VSS) capacitor c=6.544E-18
    I_C1323 (XI60_I10_Bn VSS) capacitor c=1.079E-15
    I_C1324 (XI60_I10_An VSS) capacitor c=9.388E-16
    I_C1325 (XI60_I39_p1 VSS) capacitor c=5.530E-16
    I_C1326 (XI60_I39_n1 VSS) capacitor c=5.706E-18
    I_C1327 (XI60_I39_n2 VSS) capacitor c=8.110E-18
    I_C1328 (XI60_I39_Bn VSS) capacitor c=1.056E-15
    I_C1329 (XI60_I39_An VSS) capacitor c=9.521E-16
    I_C1330 (XI72_I11_p1 VSS) capacitor c=5.491E-16
    I_C1331 (XI72_I11_n1 VSS) capacitor c=6.113E-18
    I_C1332 (XI72_I11_n2 VSS) capacitor c=6.450E-18
    I_C1333 (XI72_I11_Bn VSS) capacitor c=1.042E-15
    I_C1334 (XI72_I11_An VSS) capacitor c=9.325E-16
    I_C1335 (XI72_I12_p1 VSS) capacitor c=5.887E-16
    I_C1336 (XI72_I12_n1 VSS) capacitor c=6.481E-19
    I_C1337 (XI72_I12_n2 VSS) capacitor c=8.329E-18
    I_C1338 (XI72_I12_Bn VSS) capacitor c=1.106E-15
    I_C1339 (XI72_I12_An VSS) capacitor c=9.354E-16
    I_C1340 (XI72_I42_p1 VSS) capacitor c=5.430E-16
    I_C1341 (XI72_I42_n1 VSS) capacitor c=1.425E-18
    I_C1342 (XI72_I42_n2 VSS) capacitor c=7.407E-18
    I_C1343 (XI72_I42_Bn VSS) capacitor c=1.058E-15
    I_C1344 (XI72_I42_An VSS) capacitor c=9.433E-16
    I_C1345 (XI84_I14_p1 VSS) capacitor c=5.627E-16
    I_C1346 (XI84_I14_n1 VSS) capacitor c=1.021E-18
    I_C1347 (XI84_I14_n2 VSS) capacitor c=7.437E-18
    I_C1348 (XI84_I14_Bn VSS) capacitor c=1.043E-15
    I_C1349 (XI84_I14_An VSS) capacitor c=9.319E-16
    I_C1350 (XI84_I15_p1 VSS) capacitor c=5.681E-16
    I_C1351 (XI84_I15_n1 VSS) capacitor c=4.064E-18
    I_C1352 (XI84_I15_n2 VSS) capacitor c=9.251E-18
    I_C1353 (XI84_I15_Bn VSS) capacitor c=1.038E-15
    I_C1354 (XI84_I15_An VSS) capacitor c=9.314E-16
    I_C1355 (XI48_I13_p1 VSS) capacitor c=4.890E-16
    I_C1356 (XI48_I13_n1 VSS) capacitor c=5.786E-19
    I_C1357 (XI48_I13_n2 VSS) capacitor c=9.887E-18
    I_C1358 (XI48_I13_Bn VSS) capacitor c=1.041E-15
    I_C1359 (XI48_I13_An VSS) capacitor c=9.143E-16
    I_C1360 (XI48_I42_p1 VSS) capacitor c=5.779E-16
    I_C1361 (XI48_I42_n1 VSS) capacitor c=5.786E-19
    I_C1362 (XI48_I42_n2 VSS) capacitor c=8.277E-18
    I_C1363 (XI48_I42_Bn VSS) capacitor c=1.076E-15
    I_C1364 (XI48_I42_An VSS) capacitor c=9.432E-16
    I_C1365 (XI48_I39_p1 VSS) capacitor c=5.406E-16
    I_C1366 (XI48_I39_n1 VSS) capacitor c=9.257E-20
    I_C1367 (XI48_I39_n2 VSS) capacitor c=9.043E-18
    I_C1368 (XI48_I39_Bn VSS) capacitor c=1.050E-15
    I_C1369 (XI48_I39_An VSS) capacitor c=9.546E-16
    I_C1370 (XI60_I12_p1 VSS) capacitor c=5.532E-16
    I_C1371 (XI60_I12_n2 VSS) capacitor c=6.543E-18
    I_C1372 (XI60_I12_Bn VSS) capacitor c=1.036E-15
    I_C1373 (XI60_I12_An VSS) capacitor c=9.372E-16
    I_C1374 (XI48_I14_p1 VSS) capacitor c=4.995E-16
    I_C1375 (XI48_I14_n1 VSS) capacitor c=5.786E-19
    I_C1376 (XI48_I14_n2 VSS) capacitor c=8.601E-18
    I_C1377 (XI48_I14_Bn VSS) capacitor c=1.033E-15
    I_C1378 (XI48_I14_An VSS) capacitor c=9.102E-16
    I_C1379 (XI48_I43_p1 VSS) capacitor c=5.767E-16
    I_C1380 (XI48_I43_n2 VSS) capacitor c=9.142E-18
    I_C1381 (XI48_I43_Bn VSS) capacitor c=1.084E-15
    I_C1382 (XI48_I43_An VSS) capacitor c=9.555E-16
    I_C1383 (XI60_I13_p1 VSS) capacitor c=5.734E-16
    I_C1384 (XI60_I13_n1 VSS) capacitor c=3.820E-19
    I_C1385 (XI60_I13_n2 VSS) capacitor c=8.721E-18
    I_C1386 (XI60_I13_Bn VSS) capacitor c=1.032E-15
    I_C1387 (XI60_I13_An VSS) capacitor c=9.411E-16
    I_C1388 (XI72_I13_p1 VSS) capacitor c=5.505E-16
    I_C1389 (XI72_I13_n1 VSS) capacitor c=4.318E-19
    I_C1390 (XI72_I13_n2 VSS) capacitor c=5.876E-18
    I_C1391 (XI72_I13_Bn VSS) capacitor c=1.078E-15
    I_C1392 (XI72_I13_An VSS) capacitor c=9.229E-16
    I_C1393 (XI72_I14_p1 VSS) capacitor c=5.401E-16
    I_C1394 (XI72_I14_n2 VSS) capacitor c=6.610E-18
    I_C1395 (XI72_I14_Bn VSS) capacitor c=1.084E-15
    I_C1396 (XI72_I14_An VSS) capacitor c=9.319E-16
    I_C1397 (XI72_I44_p1 VSS) capacitor c=5.496E-16
    I_C1398 (XI72_I44_n1 VSS) capacitor c=5.786E-19
    I_C1399 (XI72_I44_n2 VSS) capacitor c=7.984E-18
    I_C1400 (XI72_I44_Bn VSS) capacitor c=1.069E-15
    I_C1401 (XI72_I44_An VSS) capacitor c=9.749E-16
    I_C1402 (XI72_I43_p1 VSS) capacitor c=5.573E-16
    I_C1403 (XI72_I43_n1 VSS) capacitor c=4.657E-19
    I_C1404 (XI72_I43_n2 VSS) capacitor c=7.199E-18
    I_C1405 (XI72_I43_Bn VSS) capacitor c=1.036E-15
    I_C1406 (XI72_I43_An VSS) capacitor c=9.274E-16
    I_C1407 (XI48_I15_p1 VSS) capacitor c=5.385E-16
    I_C1408 (XI48_I15_n1 VSS) capacitor c=2.134E-18
    I_C1409 (XI48_I15_n2 VSS) capacitor c=9.551E-18
    I_C1410 (XI48_I15_Bn VSS) capacitor c=1.119E-15
    I_C1411 (XI48_I15_An VSS) capacitor c=9.332E-16
    I_C1412 (XI48_I44_p1 VSS) capacitor c=5.124E-16
    I_C1413 (XI48_I44_n1 VSS) capacitor c=4.777E-19
    I_C1414 (XI48_I44_n2 VSS) capacitor c=8.430E-18
    I_C1415 (XI48_I44_Bn VSS) capacitor c=1.077E-15
    I_C1416 (XI48_I44_An VSS) capacitor c=8.939E-16
    I_C1417 (XI60_I14_p1 VSS) capacitor c=5.644E-16
    I_C1418 (XI60_I14_n1 VSS) capacitor c=2.874E-18
    I_C1419 (XI60_I14_n2 VSS) capacitor c=9.286E-18
    I_C1420 (XI60_I14_Bn VSS) capacitor c=1.060E-15
    I_C1421 (XI60_I14_An VSS) capacitor c=9.541E-16
    I_C1422 (XI60_I15_p1 VSS) capacitor c=5.766E-16
    I_C1423 (XI60_I15_n1 VSS) capacitor c=2.047E-19
    I_C1424 (XI60_I15_n2 VSS) capacitor c=9.958E-18
    I_C1425 (XI60_I15_Bn VSS) capacitor c=1.078E-15
    I_C1426 (XI60_I15_An VSS) capacitor c=9.391E-16
    I_C1427 (XI60_I43_p1 VSS) capacitor c=5.801E-16
    I_C1428 (XI60_I43_n1 VSS) capacitor c=5.786E-19
    I_C1429 (XI60_I43_n2 VSS) capacitor c=9.300E-18
    I_C1430 (XI60_I43_Bn VSS) capacitor c=1.086E-15
    I_C1431 (XI60_I43_An VSS) capacitor c=9.238E-16
    I_C1432 (XI60_I42_p1 VSS) capacitor c=5.278E-16
    I_C1433 (XI60_I42_n1 VSS) capacitor c=5.786E-19
    I_C1434 (XI60_I42_n2 VSS) capacitor c=7.991E-18
    I_C1435 (XI60_I42_Bn VSS) capacitor c=1.085E-15
    I_C1436 (XI60_I42_An VSS) capacitor c=9.119E-16
    I_C1437 (XI60_I44_p1 VSS) capacitor c=5.266E-16
    I_C1438 (XI60_I44_n1 VSS) capacitor c=2.292E-18
    I_C1439 (XI60_I44_n2 VSS) capacitor c=6.775E-18
    I_C1440 (XI60_I44_Bn VSS) capacitor c=1.062E-15
    I_C1441 (XI60_I44_An VSS) capacitor c=9.390E-16
    I_C1442 (XI72_I15_p1 VSS) capacitor c=5.864E-16
    I_C1443 (XI72_I15_n1 VSS) capacitor c=5.786E-19
    I_C1444 (XI72_I15_n2 VSS) capacitor c=8.298E-18
    I_C1445 (XI72_I15_Bn VSS) capacitor c=1.083E-15
    I_C1446 (XI72_I15_An VSS) capacitor c=9.073E-16
    I_C1447 (XI120_I31_XG_p1 VSS) capacitor c=2.525E-16
    I_C1448 (XI120_I31_XG_n1 VSS) capacitor c=2.217E-18
    I_C1449 (XI120_I30_XG_p1 VSS) capacitor c=2.521E-16
    I_C1450 (XI120_I29_XG_p1 VSS) capacitor c=2.472E-16
    I_C1451 (XI120_I29_XG_n1 VSS) capacitor c=8.441E-18
    I_C1452 (XI108_I30_XG_p1 VSS) capacitor c=2.535E-16
    I_C1453 (XI108_I30_XG_n1 VSS) capacitor c=6.035E-18
    I_C1454 (XI108_I27_XG_p1 VSS) capacitor c=2.692E-16
    I_C1455 (XI108_I29_XG_p1 VSS) capacitor c=2.531E-16
    I_C1456 (XI108_I29_XG_n1 VSS) capacitor c=2.852E-18
    I_C1457 (XI108_I31_XG_p1 VSS) capacitor c=2.537E-16
    I_C1458 (XI108_I31_XG_n1 VSS) capacitor c=3.043E-19
    I_C1459 (XI132_I31_XG_p1 VSS) capacitor c=2.522E-16
    I_C1460 (XI132_I31_XG_n1 VSS) capacitor c=5.161E-18
    I_C1461 (XI120_I26_XG_p1 VSS) capacitor c=2.605E-16
    I_C1462 (XI120_I28_XG_p1 VSS) capacitor c=2.608E-16
    I_C1463 (XI120_I28_XG_n1 VSS) capacitor c=9.595E-19
    I_C1464 (XI120_I27_XG_p1 VSS) capacitor c=2.650E-16
    I_C1465 (XI120_I27_XG_n1 VSS) capacitor c=2.952E-18
    I_C1466 (XI108_I26_XG_p1 VSS) capacitor c=2.560E-16
    I_C1467 (XI108_I26_XG_n1 VSS) capacitor c=6.306E-19
    I_C1468 (XI108_I28_XG_p1 VSS) capacitor c=2.834E-16
    I_C1469 (XI108_I28_XG_n1 VSS) capacitor c=5.270E-18
    I_C1470 (XI132_I29_XG_p1 VSS) capacitor c=2.640E-16
    I_C1471 (XI132_I29_XG_n1 VSS) capacitor c=3.284E-18
    I_C1472 (XI132_I27_XG_p1 VSS) capacitor c=2.509E-16
    I_C1473 (XI132_I27_XG_n1 VSS) capacitor c=1.486E-18
    I_C1474 (XI132_I30_XG_p1 VSS) capacitor c=2.639E-16
    I_C1475 (XI132_I30_XG_n1 VSS) capacitor c=1.839E-18
    I_C1476 (XI132_I28_XG_p1 VSS) capacitor c=2.599E-16
    I_C1477 (XI132_I28_XG_n1 VSS) capacitor c=3.356E-19
    I_C1478 (XI96_I27_XG_p1 VSS) capacitor c=2.745E-16
    I_C1479 (XI96_I29_XG_p1 VSS) capacitor c=2.586E-16
    I_C1480 (XI96_I29_XG_n1 VSS) capacitor c=5.009E-18
    I_C1481 (XI96_I31_XG_p1 VSS) capacitor c=2.738E-16
    I_C1482 (XI96_I31_XG_n1 VSS) capacitor c=2.700E-18
    I_C1483 (XI132_I26_XG_p1 VSS) capacitor c=2.682E-16
    I_C1484 (XI132_I26_XG_n1 VSS) capacitor c=5.951E-19
    I_C1485 (XI6_p1 VSS) capacitor c=2.642E-16
    I_C1486 (XI96_I26_XG_p1 VSS) capacitor c=2.639E-16
    I_C1487 (XI96_I26_XG_n1 VSS) capacitor c=3.282E-18
    I_C1488 (XI96_I28_XG_p1 VSS) capacitor c=2.569E-16
    I_C1489 (XI96_I28_XG_n1 VSS) capacitor c=1.778E-18
    I_C1490 (XI96_I30_XG_p1 VSS) capacitor c=2.657E-16
    I_C1491 (XI96_I30_XG_n1 VSS) capacitor c=1.086E-18
    I_C1492 (XI152_I31_XG_p1 VSS) capacitor c=2.687E-16
    I_C1493 (XI152_I31_XG_n1 VSS) capacitor c=5.951E-19
    I_C1494 (XI3_p1 VSS) capacitor c=2.820E-16
    I_C1495 (XI160_p1 VSS) capacitor c=2.696E-16
    I_C1496 (XI160_n1 VSS) capacitor c=8.129E-18
    I_C1497 (XI9_p1 VSS) capacitor c=2.565E-16
    I_C1498 (XI9_n1 VSS) capacitor c=1.539E-18
    I_C1499 (XI152_I29_XG_p1 VSS) capacitor c=2.534E-16
    I_C1500 (XI152_I27_XG_p1 VSS) capacitor c=2.387E-16
    I_C1501 (XI152_I27_XG_n1 VSS) capacitor c=2.567E-18
    I_C1502 (XI157_p1 VSS) capacitor c=2.614E-16
    I_C1503 (XI157_n1 VSS) capacitor c=1.018E-17
    I_C1504 (XI163_p1 VSS) capacitor c=2.567E-16
    I_C1505 (XI163_n1 VSS) capacitor c=5.168E-18
    I_C1506 (XI166_p1 VSS) capacitor c=2.598E-16
    I_C1507 (XI166_n1 VSS) capacitor c=4.832E-18
    I_C1508 (XI12_p1 VSS) capacitor c=2.712E-16
    I_C1509 (XI12_n1 VSS) capacitor c=9.914E-20
    I_C1510 (XI84_I26_XG_p1 VSS) capacitor c=2.803E-16
    I_C1511 (XI84_I26_XG_n1 VSS) capacitor c=9.050E-20
    I_C1512 (XI152_I30_XG_p1 VSS) capacitor c=2.497E-16
    I_C1513 (XI152_I30_XG_n1 VSS) capacitor c=1.161E-18
    I_C1514 (XI152_I28_XG_p1 VSS) capacitor c=2.456E-16
    I_C1515 (XI152_I28_XG_n1 VSS) capacitor c=1.604E-18
    I_C1516 (XI35_p1 VSS) capacitor c=2.561E-16
    I_C1517 (XI35_n1 VSS) capacitor c=5.410E-19
    I_C1518 (XI38_p1 VSS) capacitor c=2.433E-16
    I_C1519 (XI23_p1 VSS) capacitor c=2.474E-16
    I_C1520 (XI23_n1 VSS) capacitor c=1.183E-18
    I_C1521 (XI172_p1 VSS) capacitor c=2.629E-16
    I_C1522 (XI172_n1 VSS) capacitor c=5.202E-19
    I_C1523 (XI169_p1 VSS) capacitor c=2.579E-16
    I_C1524 (XI169_n1 VSS) capacitor c=1.822E-18
    I_C1525 (XI84_I28_XG_p1 VSS) capacitor c=2.820E-16
    I_C1526 (XI84_I28_XG_n1 VSS) capacitor c=7.299E-19
    I_C1527 (XI84_I30_XG_p1 VSS) capacitor c=2.602E-16
    I_C1528 (XI84_I30_XG_n1 VSS) capacitor c=6.518E-18
    I_C1529 (XI152_I26_XG_p1 VSS) capacitor c=2.573E-16
    I_C1530 (XI152_I26_XG_n1 VSS) capacitor c=7.814E-18
    I_C1531 (XI29_p1 VSS) capacitor c=2.687E-16
    I_C1532 (XI29_n1 VSS) capacitor c=3.067E-18
    I_C1533 (XI32_p1 VSS) capacitor c=2.644E-16
    I_C1534 (XI32_n1 VSS) capacitor c=3.584E-18
    I_C1535 (XI15_p1 VSS) capacitor c=2.697E-16
    I_C1536 (XI15_n1 VSS) capacitor c=4.474E-18
    I_C1537 (XI84_I27_XG_p1 VSS) capacitor c=2.590E-16
    I_C1538 (XI84_I27_XG_n1 VSS) capacitor c=2.268E-18
    I_C1539 (XI84_I29_XG_p1 VSS) capacitor c=2.657E-16
    I_C1540 (XI84_I29_XG_n1 VSS) capacitor c=3.132E-18
    I_C1541 (XI192_p1 VSS) capacitor c=2.557E-16
    I_C1542 (XI192_n1 VSS) capacitor c=6.395E-19
    I_C1543 (XI183_p1 VSS) capacitor c=2.505E-16
    I_C1544 (XI183_n1 VSS) capacitor c=3.628E-18
    I_C1545 (XI180_p1 VSS) capacitor c=2.539E-16
    I_C1546 (XI180_n1 VSS) capacitor c=5.951E-19
    I_C1547 (XI177_p1 VSS) capacitor c=2.810E-16
    I_C1548 (XI26_p1 VSS) capacitor c=2.745E-16
    I_C1549 (XI26_n1 VSS) capacitor c=4.485E-19
    I_C1550 (XI18_p1 VSS) capacitor c=2.729E-16
    I_C1551 (XI18_n1 VSS) capacitor c=1.686E-18
    I_C1552 (XI84_I31_XG_p1 VSS) capacitor c=2.531E-16
    I_C1553 (XI84_I31_XG_n1 VSS) capacitor c=1.521E-18
    I_C1554 (XI189_p1 VSS) capacitor c=2.393E-16
    I_C1555 (XI189_n1 VSS) capacitor c=2.514E-18
    I_C1556 (XI186_p1 VSS) capacitor c=2.544E-16
    I_C1557 (XI186_n1 VSS) capacitor c=4.222E-18
    I_C1558 (XI72_I26_XG_p1 VSS) capacitor c=2.617E-16
    I_C1559 (XI72_I26_XG_n1 VSS) capacitor c=8.077E-19
    I_C1560 (XI48_I28_XG_p1 VSS) capacitor c=2.476E-16
    I_C1561 (XI48_I28_XG_n1 VSS) capacitor c=4.875E-18
    I_C1562 (XI48_I26_XG_p1 VSS) capacitor c=2.518E-16
    I_C1563 (XI48_I26_XG_n1 VSS) capacitor c=2.646E-18
    I_C1564 (XI72_I28_XG_p1 VSS) capacitor c=2.650E-16
    I_C1565 (XI72_I28_XG_n1 VSS) capacitor c=7.987E-19
    I_C1566 (XI48_I30_XG_p1 VSS) capacitor c=2.545E-16
    I_C1567 (XI48_I30_XG_n1 VSS) capacitor c=5.235E-18
    I_C1568 (XI48_I27_XG_p1 VSS) capacitor c=2.375E-16
    I_C1569 (XI48_I27_XG_n1 VSS) capacitor c=6.926E-19
    I_C1570 (XI60_I27_XG_p1 VSS) capacitor c=2.540E-16
    I_C1571 (XI60_I27_XG_n1 VSS) capacitor c=1.836E-18
    I_C1572 (XI60_I26_XG_p1 VSS) capacitor c=2.541E-16
    I_C1573 (XI60_I28_XG_p1 VSS) capacitor c=2.686E-16
    I_C1574 (XI60_I28_XG_n1 VSS) capacitor c=5.348E-19
    I_C1575 (XI72_I27_XG_p1 VSS) capacitor c=2.676E-16
    I_C1576 (XI72_I27_XG_n1 VSS) capacitor c=7.471E-18
    I_C1577 (XI72_I29_XG_p1 VSS) capacitor c=2.457E-16
    I_C1578 (XI72_I29_XG_n1 VSS) capacitor c=8.800E-19
    I_C1579 (XI48_I31_XG_p1 VSS) capacitor c=2.517E-16
    I_C1580 (XI48_I31_XG_n1 VSS) capacitor c=1.858E-18
    I_C1581 (XI48_I29_XG_p1 VSS) capacitor c=2.675E-16
    I_C1582 (XI60_I29_XG_p1 VSS) capacitor c=2.647E-16
    I_C1583 (XI60_I29_XG_n1 VSS) capacitor c=4.644E-18
    I_C1584 (XI60_I30_XG_p1 VSS) capacitor c=2.694E-16
    I_C1585 (XI60_I30_XG_n1 VSS) capacitor c=3.063E-19
    I_C1586 (XI72_I30_XG_p1 VSS) capacitor c=2.703E-16
    I_C1587 (XI60_I31_XG_p1 VSS) capacitor c=2.610E-16
    I_C1588 (XI72_I31_XG_p1 VSS) capacitor c=2.774E-16
    I_C1589 (XI72_I31_XG_n1 VSS) capacitor c=2.094E-18
    I_C1590 (XI120_I36_XG_p1 VSS) capacitor c=2.956E-18
    I_C1591 (XI120_I36_XG_n1 VSS) capacitor c=3.130E-16
    I_C1592 (XI120_I25_XG_p1 VSS) capacitor c=1.588E-18
    I_C1593 (XI120_I25_XG_n1 VSS) capacitor c=3.076E-16
    I_C1594 (XI108_I35_XG_p1 VSS) capacitor c=1.074E-17
    I_C1595 (XI108_I35_XG_n1 VSS) capacitor c=3.011E-16
    I_C1596 (XI108_I34_XG_p1 VSS) capacitor c=2.190E-18
    I_C1597 (XI108_I34_XG_n1 VSS) capacitor c=2.986E-16
    I_C1598 (XI108_I25_XG_n1 VSS) capacitor c=2.600E-16
    I_C1599 (XI132_I25_XG_p1 VSS) capacitor c=1.897E-17
    I_C1600 (XI132_I25_XG_n1 VSS) capacitor c=3.162E-16
    I_C1601 (XI132_I24_XG_p1 VSS) capacitor c=8.244E-20
    I_C1602 (XI132_I24_XG_n1 VSS) capacitor c=2.733E-16
    I_C1603 (XI120_I35_XG_p1 VSS) capacitor c=9.032E-18
    I_C1604 (XI120_I35_XG_n1 VSS) capacitor c=2.944E-16
    I_C1605 (XI120_I34_XG_p1 VSS) capacitor c=1.359E-17
    I_C1606 (XI120_I34_XG_n1 VSS) capacitor c=3.177E-16
    I_C1607 (XI120_I23_XG_p1 VSS) capacitor c=5.708E-18
    I_C1608 (XI120_I23_XG_n1 VSS) capacitor c=2.871E-16
    I_C1609 (XI120_I24_XG_p1 VSS) capacitor c=2.130E-18
    I_C1610 (XI120_I24_XG_n1 VSS) capacitor c=2.917E-16
    I_C1611 (XI108_I23_XG_p1 VSS) capacitor c=1.969E-18
    I_C1612 (XI108_I23_XG_n1 VSS) capacitor c=2.848E-16
    I_C1613 (XI108_I36_XG_p1 VSS) capacitor c=5.667E-18
    I_C1614 (XI108_I36_XG_n1 VSS) capacitor c=3.226E-16
    I_C1615 (XI108_I24_XG_p1 VSS) capacitor c=3.150E-18
    I_C1616 (XI108_I24_XG_n1 VSS) capacitor c=2.972E-16
    I_C1617 (XI132_I36_XG_p1 VSS) capacitor c=5.535E-18
    I_C1618 (XI132_I36_XG_n1 VSS) capacitor c=3.158E-16
    I_C1619 (XI132_I23_XG_p1 VSS) capacitor c=4.760E-18
    I_C1620 (XI132_I23_XG_n1 VSS) capacitor c=2.814E-16
    I_C1621 (XI132_I22_XG_p1 VSS) capacitor c=2.137E-18
    I_C1622 (XI132_I22_XG_n1 VSS) capacitor c=2.985E-16
    I_C1623 (XI120_I32_XG_p1 VSS) capacitor c=2.204E-19
    I_C1624 (XI120_I32_XG_n1 VSS) capacitor c=3.123E-16
    I_C1625 (XI120_I22_XG_p1 VSS) capacitor c=8.627E-18
    I_C1626 (XI120_I22_XG_n1 VSS) capacitor c=2.944E-16
    I_C1627 (XI120_I21_XG_p1 VSS) capacitor c=1.453E-17
    I_C1628 (XI120_I21_XG_n1 VSS) capacitor c=3.093E-16
    I_C1629 (XI108_I32_XG_p1 VSS) capacitor c=1.445E-18
    I_C1630 (XI108_I32_XG_n1 VSS) capacitor c=3.034E-16
    I_C1631 (XI108_I21_XG_p1 VSS) capacitor c=5.081E-18
    I_C1632 (XI108_I21_XG_n1 VSS) capacitor c=3.200E-16
    I_C1633 (XI108_I22_XG_p1 VSS) capacitor c=1.845E-18
    I_C1634 (XI108_I22_XG_n1 VSS) capacitor c=3.074E-16
    I_C1635 (XI132_I34_XG_p1 VSS) capacitor c=4.122E-18
    I_C1636 (XI132_I34_XG_n1 VSS) capacitor c=2.793E-16
    I_C1637 (XI132_I35_XG_p1 VSS) capacitor c=1.308E-17
    I_C1638 (XI132_I35_XG_n1 VSS) capacitor c=3.097E-16
    I_C1639 (XI132_I21_XG_p1 VSS) capacitor c=5.983E-18
    I_C1640 (XI132_I21_XG_n1 VSS) capacitor c=3.477E-16
    I_C1641 (XI120_I19_XG_p1 VSS) capacitor c=1.454E-17
    I_C1642 (XI120_I19_XG_n1 VSS) capacitor c=3.159E-16
    I_C1643 (XI120_I20_XG_p1 VSS) capacitor c=8.504E-18
    I_C1644 (XI120_I20_XG_n1 VSS) capacitor c=2.973E-16
    I_C1645 (XI108_I19_XG_p1 VSS) capacitor c=8.711E-18
    I_C1646 (XI108_I19_XG_n1 VSS) capacitor c=3.167E-16
    I_C1647 (XI108_I20_XG_p1 VSS) capacitor c=3.248E-18
    I_C1648 (XI108_I20_XG_n1 VSS) capacitor c=2.810E-16
    I_C1649 (XI96_I34_XG_p1 VSS) capacitor c=9.946E-20
    I_C1650 (XI96_I34_XG_n1 VSS) capacitor c=3.524E-16
    I_C1651 (XI96_I36_XG_p1 VSS) capacitor c=1.219E-17
    I_C1652 (XI96_I36_XG_n1 VSS) capacitor c=3.101E-16
    I_C1653 (XI132_I32_XG_p1 VSS) capacitor c=7.079E-19
    I_C1654 (XI132_I32_XG_n1 VSS) capacitor c=3.140E-16
    I_C1655 (XI132_I20_XG_p1 VSS) capacitor c=6.556E-19
    I_C1656 (XI132_I20_XG_n1 VSS) capacitor c=2.961E-16
    I_C1657 (XI120_I17_XG_p1 VSS) capacitor c=7.995E-18
    I_C1658 (XI120_I17_XG_n1 VSS) capacitor c=2.915E-16
    I_C1659 (XI108_I17_XG_p1 VSS) capacitor c=7.169E-19
    I_C1660 (XI108_I17_XG_n1 VSS) capacitor c=3.215E-16
    I_C1661 (XI96_I19_XG_p1 VSS) capacitor c=7.011E-18
    I_C1662 (XI96_I19_XG_n1 VSS) capacitor c=2.995E-16
    I_C1663 (XI96_I32_XG_p1 VSS) capacitor c=1.437E-18
    I_C1664 (XI96_I32_XG_n1 VSS) capacitor c=2.987E-16
    I_C1665 (XI96_I35_XG_p1 VSS) capacitor c=4.150E-19
    I_C1666 (XI96_I35_XG_n1 VSS) capacitor c=2.909E-16
    I_C1667 (XI96_I25_XG_p1 VSS) capacitor c=2.051E-18
    I_C1668 (XI96_I25_XG_n1 VSS) capacitor c=2.973E-16
    I_C1669 (XI152_I25_XG_n1 VSS) capacitor c=3.193E-16
    I_C1670 (XI152_I24_XG_p1 VSS) capacitor c=1.372E-17
    I_C1671 (XI152_I24_XG_n1 VSS) capacitor c=2.969E-16
    I_C1672 (XI132_I19_XG_p1 VSS) capacitor c=4.786E-18
    I_C1673 (XI132_I19_XG_n1 VSS) capacitor c=3.079E-16
    I_C1674 (XI96_I17_XG_p1 VSS) capacitor c=2.763E-18
    I_C1675 (XI96_I17_XG_n1 VSS) capacitor c=3.295E-16
    I_C1676 (XI96_I20_XG_p1 VSS) capacitor c=1.467E-18
    I_C1677 (XI96_I20_XG_n1 VSS) capacitor c=3.109E-16
    I_C1678 (XI96_I21_XG_p1 VSS) capacitor c=2.672E-18
    I_C1679 (XI96_I21_XG_n1 VSS) capacitor c=2.838E-16
    I_C1680 (XI96_I22_XG_p1 VSS) capacitor c=6.419E-18
    I_C1681 (XI96_I22_XG_n1 VSS) capacitor c=3.138E-16
    I_C1682 (XI96_I23_XG_p1 VSS) capacitor c=1.008E-17
    I_C1683 (XI96_I23_XG_n1 VSS) capacitor c=2.853E-16
    I_C1684 (XI96_I24_XG_p1 VSS) capacitor c=4.685E-18
    I_C1685 (XI96_I24_XG_n1 VSS) capacitor c=3.154E-16
    I_C1686 (XI152_I36_XG_p1 VSS) capacitor c=9.705E-18
    I_C1687 (XI152_I36_XG_n1 VSS) capacitor c=2.964E-16
    I_C1688 (XI152_I23_XG_p1 VSS) capacitor c=1.903E-19
    I_C1689 (XI152_I23_XG_n1 VSS) capacitor c=2.674E-16
    I_C1690 (XI152_I22_XG_n1 VSS) capacitor c=3.064E-16
    I_C1691 (XI132_I17_XG_p1 VSS) capacitor c=1.233E-17
    I_C1692 (XI132_I17_XG_n1 VSS) capacitor c=3.023E-16
    I_C1693 (XI152_I34_XG_p1 VSS) capacitor c=8.559E-18
    I_C1694 (XI152_I34_XG_n1 VSS) capacitor c=2.997E-16
    I_C1695 (XI152_I21_XG_p1 VSS) capacitor c=5.450E-18
    I_C1696 (XI152_I21_XG_n1 VSS) capacitor c=2.864E-16
    I_C1697 (XI84_I17_XG_p1 VSS) capacitor c=1.207E-17
    I_C1698 (XI84_I17_XG_n1 VSS) capacitor c=2.974E-16
    I_C1699 (XI84_I32_XG_p1 VSS) capacitor c=5.821E-18
    I_C1700 (XI84_I32_XG_n1 VSS) capacitor c=2.935E-16
    I_C1701 (XI84_I35_XG_n1 VSS) capacitor c=3.253E-16
    I_C1702 (XI152_I32_XG_p1 VSS) capacitor c=1.474E-19
    I_C1703 (XI152_I32_XG_n1 VSS) capacitor c=3.338E-16
    I_C1704 (XI152_I20_XG_p1 VSS) capacitor c=9.521E-18
    I_C1705 (XI152_I20_XG_n1 VSS) capacitor c=3.034E-16
    I_C1706 (XI152_I19_XG_p1 VSS) capacitor c=8.127E-20
    I_C1707 (XI152_I19_XG_n1 VSS) capacitor c=3.475E-16
    I_C1708 (XI152_I17_XG_p1 VSS) capacitor c=1.051E-17
    I_C1709 (XI152_I17_XG_n1 VSS) capacitor c=3.420E-16
    I_C1710 (XI84_I19_XG_p1 VSS) capacitor c=6.652E-18
    I_C1711 (XI84_I19_XG_n1 VSS) capacitor c=3.143E-16
    I_C1712 (XI84_I20_XG_p1 VSS) capacitor c=2.940E-19
    I_C1713 (XI84_I20_XG_n1 VSS) capacitor c=3.293E-16
    I_C1714 (XI152_I35_XG_p1 VSS) capacitor c=1.042E-18
    I_C1715 (XI152_I35_XG_n1 VSS) capacitor c=2.868E-16
    I_C1716 (XI72_I17_XG_p1 VSS) capacitor c=2.611E-18
    I_C1717 (XI72_I17_XG_n1 VSS) capacitor c=2.921E-16
    I_C1718 (XI84_I21_XG_p1 VSS) capacitor c=1.442E-17
    I_C1719 (XI84_I21_XG_n1 VSS) capacitor c=3.405E-16
    I_C1720 (XI84_I22_XG_p1 VSS) capacitor c=3.436E-18
    I_C1721 (XI84_I22_XG_n1 VSS) capacitor c=2.898E-16
    I_C1722 (XI84_I34_XG_p1 VSS) capacitor c=3.215E-18
    I_C1723 (XI84_I34_XG_n1 VSS) capacitor c=3.404E-16
    I_C1724 (XI60_I17_XG_p1 VSS) capacitor c=7.532E-18
    I_C1725 (XI60_I17_XG_n1 VSS) capacitor c=3.106E-16
    I_C1726 (XI84_I23_XG_p1 VSS) capacitor c=1.122E-17
    I_C1727 (XI84_I23_XG_n1 VSS) capacitor c=2.676E-16
    I_C1728 (XI84_I36_XG_p1 VSS) capacitor c=9.296E-18
    I_C1729 (XI84_I36_XG_n1 VSS) capacitor c=3.479E-16
    I_C1730 (XI48_I20_XG_p1 VSS) capacitor c=3.863E-18
    I_C1731 (XI48_I20_XG_n1 VSS) capacitor c=2.778E-16
    I_C1732 (XI48_I17_XG_p1 VSS) capacitor c=3.090E-18
    I_C1733 (XI48_I17_XG_n1 VSS) capacitor c=2.864E-16
    I_C1734 (XI72_I20_XG_p1 VSS) capacitor c=3.225E-18
    I_C1735 (XI72_I20_XG_n1 VSS) capacitor c=2.957E-16
    I_C1736 (XI72_I19_XG_p1 VSS) capacitor c=1.198E-17
    I_C1737 (XI72_I19_XG_n1 VSS) capacitor c=3.299E-16
    I_C1738 (XI84_I24_XG_p1 VSS) capacitor c=2.280E-18
    I_C1739 (XI84_I24_XG_n1 VSS) capacitor c=2.835E-16
    I_C1740 (XI84_I25_XG_p1 VSS) capacitor c=1.658E-19
    I_C1741 (XI84_I25_XG_n1 VSS) capacitor c=2.943E-16
    I_C1742 (XI48_I22_XG_p1 VSS) capacitor c=2.360E-18
    I_C1743 (XI48_I22_XG_n1 VSS) capacitor c=2.698E-16
    I_C1744 (XI48_I21_XG_p1 VSS) capacitor c=3.073E-18
    I_C1745 (XI48_I21_XG_n1 VSS) capacitor c=3.252E-16
    I_C1746 (XI48_I32_XG_p1 VSS) capacitor c=4.843E-18
    I_C1747 (XI48_I32_XG_n1 VSS) capacitor c=2.755E-16
    I_C1748 (XI48_I19_XG_n1 VSS) capacitor c=3.139E-16
    I_C1749 (XI60_I20_XG_p1 VSS) capacitor c=1.985E-17
    I_C1750 (XI60_I20_XG_n1 VSS) capacitor c=3.222E-16
    I_C1751 (XI60_I19_XG_p1 VSS) capacitor c=2.682E-18
    I_C1752 (XI60_I19_XG_n1 VSS) capacitor c=2.990E-16
    I_C1753 (XI72_I21_XG_p1 VSS) capacitor c=8.763E-18
    I_C1754 (XI72_I21_XG_n1 VSS) capacitor c=2.839E-16
    I_C1755 (XI72_I32_XG_p1 VSS) capacitor c=9.829E-18
    I_C1756 (XI72_I32_XG_n1 VSS) capacitor c=3.238E-16
    I_C1757 (XI48_I23_XG_p1 VSS) capacitor c=1.010E-17
    I_C1758 (XI48_I23_XG_n1 VSS) capacitor c=3.001E-16
    I_C1759 (XI48_I24_XG_p1 VSS) capacitor c=1.248E-17
    I_C1760 (XI48_I24_XG_n1 VSS) capacitor c=3.099E-16
    I_C1761 (XI48_I35_XG_p1 VSS) capacitor c=3.307E-18
    I_C1762 (XI48_I35_XG_n1 VSS) capacitor c=3.036E-16
    I_C1763 (XI60_I21_XG_p1 VSS) capacitor c=1.030E-17
    I_C1764 (XI60_I21_XG_n1 VSS) capacitor c=3.071E-16
    I_C1765 (XI60_I22_XG_p1 VSS) capacitor c=4.616E-18
    I_C1766 (XI60_I22_XG_n1 VSS) capacitor c=2.915E-16
    I_C1767 (XI60_I32_XG_p1 VSS) capacitor c=1.503E-17
    I_C1768 (XI60_I32_XG_n1 VSS) capacitor c=3.019E-16
    I_C1769 (XI72_I23_XG_p1 VSS) capacitor c=5.103E-18
    I_C1770 (XI72_I23_XG_n1 VSS) capacitor c=3.078E-16
    I_C1771 (XI72_I22_XG_p1 VSS) capacitor c=1.283E-18
    I_C1772 (XI72_I22_XG_n1 VSS) capacitor c=2.904E-16
    I_C1773 (XI72_I34_XG_p1 VSS) capacitor c=1.583E-18
    I_C1774 (XI72_I34_XG_n1 VSS) capacitor c=2.773E-16
    I_C1775 (XI48_I25_XG_p1 VSS) capacitor c=2.574E-17
    I_C1776 (XI48_I25_XG_n1 VSS) capacitor c=3.258E-16
    I_C1777 (XI48_I36_XG_p1 VSS) capacitor c=4.028E-18
    I_C1778 (XI48_I36_XG_n1 VSS) capacitor c=2.782E-16
    I_C1779 (XI48_I34_XG_p1 VSS) capacitor c=9.495E-18
    I_C1780 (XI48_I34_XG_n1 VSS) capacitor c=2.957E-16
    I_C1781 (XI60_I24_XG_p1 VSS) capacitor c=2.681E-18
    I_C1782 (XI60_I24_XG_n1 VSS) capacitor c=2.974E-16
    I_C1783 (XI60_I23_XG_p1 VSS) capacitor c=2.243E-17
    I_C1784 (XI60_I23_XG_n1 VSS) capacitor c=3.179E-16
    I_C1785 (XI60_I34_XG_p1 VSS) capacitor c=1.065E-17
    I_C1786 (XI60_I34_XG_n1 VSS) capacitor c=3.376E-16
    I_C1787 (XI60_I35_XG_p1 VSS) capacitor c=1.719E-17
    I_C1788 (XI60_I35_XG_n1 VSS) capacitor c=3.001E-16
    I_C1789 (XI72_I24_XG_p1 VSS) capacitor c=4.721E-19
    I_C1790 (XI72_I24_XG_n1 VSS) capacitor c=3.160E-16
    I_C1791 (XI72_I35_XG_p1 VSS) capacitor c=1.840E-19
    I_C1792 (XI72_I35_XG_n1 VSS) capacitor c=2.911E-16
    I_C1793 (XI60_I25_XG_p1 VSS) capacitor c=5.624E-19
    I_C1794 (XI60_I25_XG_n1 VSS) capacitor c=3.043E-16
    I_C1795 (XI60_I36_XG_p1 VSS) capacitor c=1.168E-17
    I_C1796 (XI60_I36_XG_n1 VSS) capacitor c=3.097E-16
    I_C1797 (XI72_I25_XG_p1 VSS) capacitor c=1.547E-18
    I_C1798 (XI72_I25_XG_n1 VSS) capacitor c=3.066E-16
    I_C1799 (XI72_I36_XG_p1 VSS) capacitor c=4.793E-18
    I_C1800 (XI72_I36_XG_n1 VSS) capacitor c=2.981E-16
    I_C1801 (XI132_I7_n1 VSS) capacitor c=6.333E-19
    I_C1802 (XI132_I5_n1 VSS) capacitor c=5.872E-19
    I_C1803 (XI120_I31_XP_n1 VSS) capacitor c=4.674E-18
    I_C1804 (XI120_I7_n1 VSS) capacitor c=3.986E-18
    I_C1805 (XI108_I29_XP_n1 VSS) capacitor c=1.464E-18
    I_C1806 (XI108_I7_n1 VSS) capacitor c=2.132E-18
    I_C1807 (XI132_I6_n1 VSS) capacitor c=4.328E-18
    I_C1808 (XI120_I29_XP_n1 VSS) capacitor c=6.961E-18
    I_C1809 (XI120_I5_n1 VSS) capacitor c=6.732E-19
    I_C1810 (XI120_I6_n1 VSS) capacitor c=1.304E-18
    I_C1811 (XI108_I30_XP_n1 VSS) capacitor c=1.222E-18
    I_C1812 (XI108_I31_XP_n1 VSS) capacitor c=2.753E-18
    I_C1813 (XI108_I5_n1 VSS) capacitor c=4.144E-18
    I_C1814 (XI108_I6_n1 VSS) capacitor c=8.379E-19
    I_C1815 (XI132_I31_XP_n1 VSS) capacitor c=5.160E-18
    I_C1816 (XI132_I4_n1 VSS) capacitor c=2.444E-19
    I_C1817 (XI120_I28_XP_n1 VSS) capacitor c=1.015E-18
    I_C1818 (XI120_I4_n1 VSS) capacitor c=7.769E-19
    I_C1819 (XI108_I28_XP_n1 VSS) capacitor c=4.813E-18
    I_C1820 (XI108_I3_n1 VSS) capacitor c=2.048E-18
    I_C1821 (XI108_I4_n1 VSS) capacitor c=6.306E-19
    I_C1822 (XI132_I29_XP_n1 VSS) capacitor c=4.373E-18
    I_C1823 (XI132_I30_XP_n1 VSS) capacitor c=4.553E-18
    I_C1824 (XI132_I3_n1 VSS) capacitor c=2.729E-18
    I_C1825 (XI96_I29_XP_n1 VSS) capacitor c=1.447E-18
    I_C1826 (XI96_I31_XP_n1 VSS) capacitor c=2.855E-18
    I_C1827 (XI148_n1 VSS) capacitor c=2.959E-19
    I_C1828 (XI132_I28_XP_n1 VSS) capacitor c=7.558E-18
    I_C1829 (XI132_I2_n1 VSS) capacitor c=2.069E-18
    I_C1830 (XI120_I0_n1 VSS) capacitor c=3.853E-19
    I_C1831 (XI108_I1_n1 VSS) capacitor c=5.111E-18
    I_C1832 (XI96_I28_XP_n1 VSS) capacitor c=3.277E-18
    I_C1833 (XI96_I30_XP_n1 VSS) capacitor c=3.820E-19
    I_C1834 (XI96_I7_n1 VSS) capacitor c=1.303E-19
    I_C1835 (XI152_I6_n1 VSS) capacitor c=5.910E-19
    I_C1836 (XI152_I5_n1 VSS) capacitor c=1.570E-20
    I_C1837 (XI152_I4_n1 VSS) capacitor c=3.721E-18
    I_C1838 (XI146_n1 VSS) capacitor c=1.870E-18
    I_C1839 (XI144_n1 VSS) capacitor c=2.091E-18
    I_C1840 (XI132_I1_n1 VSS) capacitor c=1.160E-18
    I_C1841 (XI132_I0_n1 VSS) capacitor c=1.252E-19
    I_C1842 (XI96_I0_n1 VSS) capacitor c=6.094E-18
    I_C1843 (XI96_I1_n1 VSS) capacitor c=1.187E-18
    I_C1844 (XI152_I31_XP_n1 VSS) capacitor c=1.320E-17
    I_C1845 (XI152_I3_n1 VSS) capacitor c=7.447E-19
    I_C1846 (XI142_n1 VSS) capacitor c=2.587E-18
    I_C1847 (XI0_n1 VSS) capacitor c=3.936E-18
    I_C1848 (XI96_I2_n1 VSS) capacitor c=6.130E-19
    I_C1849 (XI96_I3_n1 VSS) capacitor c=5.305E-19
    I_C1850 (XI96_I4_n1 VSS) capacitor c=7.471E-18
    I_C1851 (XI96_I5_n1 VSS) capacitor c=4.274E-18
    I_C1852 (XI96_I6_n1 VSS) capacitor c=4.146E-18
    I_C1853 (XI152_I29_XP_n1 VSS) capacitor c=5.937E-18
    I_C1854 (XI152_I2_n1 VSS) capacitor c=1.401E-18
    I_C1855 (XI152_I0_n1 VSS) capacitor c=2.772E-18
    I_C1856 (XI138_n1 VSS) capacitor c=6.489E-18
    I_C1857 (XI140_n1 VSS) capacitor c=6.306E-19
    I_C1858 (XI136_n1 VSS) capacitor c=3.930E-18
    I_C1859 (XI154_n1 VSS) capacitor c=4.367E-18
    I_C1860 (XI84_I0_n1 VSS) capacitor c=2.921E-18
    I_C1861 (XI152_I30_XP_n1 VSS) capacitor c=2.943E-18
    I_C1862 (XI152_I28_XP_n1 VSS) capacitor c=3.668E-18
    I_C1863 (XI152_I1_n1 VSS) capacitor c=3.410E-18
    I_C1864 (XI20_n1 VSS) capacitor c=4.295E-18
    I_C1865 (XI84_I1_n1 VSS) capacitor c=1.067E-18
    I_C1866 (XI84_I30_XP_n1 VSS) capacitor c=6.245E-18
    I_C1867 (XI199_n1 VSS) capacitor c=4.207E-18
    I_C1868 (XI198_n1 VSS) capacitor c=9.678E-20
    I_C1869 (XI72_I0_n1 VSS) capacitor c=5.004E-19
    I_C1870 (XI84_I29_XP_n1 VSS) capacitor c=2.725E-18
    I_C1871 (XI60_I0_n1 VSS) capacitor c=5.137E-19
    I_C1872 (XI72_I1_n1 VSS) capacitor c=1.841E-18
    I_C1873 (XI84_I4_n1 VSS) capacitor c=6.293E-18
    I_C1874 (XI84_I31_XP_n1 VSS) capacitor c=4.155E-18
    I_C1875 (XI48_I3_n1 VSS) capacitor c=4.047E-18
    I_C1876 (XI48_I2_n1 VSS) capacitor c=1.258E-18
    I_C1877 (XI60_I1_n1 VSS) capacitor c=4.530E-18
    I_C1878 (XI72_I2_n1 VSS) capacitor c=5.863E-19
    I_C1879 (XI48_I4_n1 VSS) capacitor c=5.364E-18
    I_C1880 (XI48_I28_XP_n1 VSS) capacitor c=2.834E-18
    I_C1881 (XI60_I3_n1 VSS) capacitor c=2.996E-18
    I_C1882 (XI60_I2_n1 VSS) capacitor c=4.397E-18
    I_C1883 (XI72_I3_n1 VSS) capacitor c=1.416E-17
    I_C1884 (XI72_I28_XP_n1 VSS) capacitor c=1.439E-18
    I_C1885 (XI84_I6_n1 VSS) capacitor c=1.501E-18
    I_C1886 (XI48_I5_n1 VSS) capacitor c=2.527E-18
    I_C1887 (XI48_I30_XP_n1 VSS) capacitor c=5.972E-18
    I_C1888 (XI60_I4_n1 VSS) capacitor c=4.709E-18
    I_C1889 (XI60_I28_XP_n1 VSS) capacitor c=5.896E-18
    I_C1890 (XI72_I30_XP_n1 VSS) capacitor c=3.026E-18
    I_C1891 (XI72_I29_XP_n1 VSS) capacitor c=2.132E-18
    I_C1892 (XI84_I7_n1 VSS) capacitor c=3.810E-18
    I_C1893 (XI48_I6_n1 VSS) capacitor c=7.384E-18
    I_C1894 (XI48_I31_XP_n1 VSS) capacitor c=4.113E-18
    I_C1895 (XI60_I6_n1 VSS) capacitor c=3.322E-18
    I_C1896 (XI60_I29_XP_n1 VSS) capacitor c=5.194E-19
    I_C1897 (XI60_I31_XP_n1 VSS) capacitor c=3.372E-18
    I_C1898 (XI60_I30_XP_n1 VSS) capacitor c=3.820E-19
    I_C1899 (XI48_I7_n1 VSS) capacitor c=3.759E-18
    I_C1900 (XI60_I7_n1 VSS) capacitor c=2.250E-18
    I_C1901 (XI72_I6_n1 VSS) capacitor c=2.679E-18
    I_C1902 (XI72_I7_n1 VSS) capacitor c=7.418E-18
    I_C1903 (XI120_I25_XP_p1 VSS) capacitor c=7.898E-18
    I_C1904 (XI120_I24_XP_p1 VSS) capacitor c=7.249E-18
    I_C1905 (XI120_I23_XP_p1 VSS) capacitor c=3.480E-18
    I_C1906 (XI108_I24_XP_p1 VSS) capacitor c=1.421E-17
    I_C1907 (XI108_I23_XP_p1 VSS) capacitor c=1.288E-18
    I_C1908 (XI132_I23_XP_p1 VSS) capacitor c=5.326E-18
    I_C1909 (XI132_I24_XP_p1 VSS) capacitor c=4.626E-18
    I_C1910 (XI120_I20_XP_p1 VSS) capacitor c=1.073E-18
    I_C1911 (XI120_I22_XP_p1 VSS) capacitor c=2.698E-18
    I_C1912 (XI120_I21_XP_p1 VSS) capacitor c=8.754E-18
    I_C1913 (XI108_I20_XP_p1 VSS) capacitor c=9.174E-18
    I_C1914 (XI108_I21_XP_p1 VSS) capacitor c=9.913E-18
    I_C1915 (XI108_I22_XP_p1 VSS) capacitor c=5.037E-18
    I_C1916 (XI132_I21_XP_p1 VSS) capacitor c=7.773E-19
    I_C1917 (XI132_I22_XP_p1 VSS) capacitor c=2.213E-17
    I_C1918 (XI96_I23_XP_p1 VSS) capacitor c=7.387E-18
    I_C1919 (XI96_I20_XP_p1 VSS) capacitor c=3.427E-18
    I_C1920 (XI96_I22_XP_p1 VSS) capacitor c=6.501E-18
    I_C1921 (XI96_I25_XP_p1 VSS) capacitor c=1.047E-17
    I_C1922 (XI132_I20_XP_p1 VSS) capacitor c=5.830E-18
    I_C1923 (XI96_I24_XP_p1 VSS) capacitor c=4.787E-19
    I_C1924 (XI152_I25_XP_p1 VSS) capacitor c=8.884E-18
    I_C1925 (XI152_I23_XP_p1 VSS) capacitor c=8.691E-18
    I_C1926 (XI152_I22_XP_p1 VSS) capacitor c=4.415E-19
    I_C1927 (XI152_I21_XP_p1 VSS) capacitor c=1.430E-17
    I_C1928 (XI152_I24_XP_p1 VSS) capacitor c=3.711E-18
    I_C1929 (XI197_p1 VSS) capacitor c=5.609E-18
    I_C1930 (XI194_p1 VSS) capacitor c=1.191E-18
    I_C1931 (XI84_I22_XP_p1 VSS) capacitor c=7.806E-18
    I_C1932 (XI84_I20_XP_p1 VSS) capacitor c=5.077E-18
    I_C1933 (XI84_I24_XP_p1 VSS) capacitor c=5.344E-19
    I_C1934 (XI152_I20_XP_p1 VSS) capacitor c=2.873E-18
    I_C1935 (XI196_p1 VSS) capacitor c=1.316E-17
    I_C1936 (XI195_p1 VSS) capacitor c=6.279E-19
    I_C1937 (XI200_p1 VSS) capacitor c=7.317E-18
    I_C1938 (XI203_p1 VSS) capacitor c=5.078E-18
    I_C1939 (XI84_I21_XP_p1 VSS) capacitor c=6.784E-18
    I_C1940 (XI84_I23_XP_p1 VSS) capacitor c=7.256E-18
    I_C1941 (XI84_I25_XP_p1 VSS) capacitor c=7.538E-19
    I_C1942 (XI72_I20_XP_p1 VSS) capacitor c=7.485E-18
    I_C1943 (XI48_I22_XP_p1 VSS) capacitor c=5.109E-18
    I_C1944 (XI60_I20_XP_p1 VSS) capacitor c=7.377E-19
    I_C1945 (XI72_I21_XP_p1 VSS) capacitor c=1.579E-18
    I_C1946 (XI72_I22_XP_p1 VSS) capacitor c=3.663E-18
    I_C1947 (XI48_I24_XP_p1 VSS) capacitor c=1.200E-17
    I_C1948 (XI48_I23_XP_p1 VSS) capacitor c=6.497E-18
    I_C1949 (XI60_I21_XP_p1 VSS) capacitor c=2.990E-18
    I_C1950 (XI60_I22_XP_p1 VSS) capacitor c=2.480E-18
    I_C1951 (XI72_I23_XP_p1 VSS) capacitor c=5.831E-18
    I_C1952 (XI48_I25_XP_p1 VSS) capacitor c=1.112E-18
    I_C1953 (XI60_I23_XP_p1 VSS) capacitor c=8.640E-18
    I_C1954 (XI60_I24_XP_p1 VSS) capacitor c=1.430E-18
    I_C1955 (XI72_I24_XP_p1 VSS) capacitor c=6.345E-18
    I_C1956 (XI72_I25_XP_p1 VSS) capacitor c=4.698E-18
    I_C1957 (XI60_I25_XP_p1 VSS) capacitor c=4.041E-18
    I_C1958 (XI131_p1 VSS) capacitor c=5.237E-16
    I_C1959 (XI131_n1 VSS) capacitor c=1.215E-18
    I_C1960 (XI131_n2 VSS) capacitor c=8.054E-18
    I_C1961 (XI131_An VSS) capacitor c=1.013E-15
    I_C1962 (XI131_Bn VSS) capacitor c=7.987E-16
    I_C1963 (XI130_p1 VSS) capacitor c=5.833E-16
    I_C1964 (XI130_n2 VSS) capacitor c=8.537E-18
    I_C1965 (XI130_An VSS) capacitor c=9.857E-16
    I_C1966 (XI130_Bn VSS) capacitor c=8.060E-16
    I_C1967 (XI120_I41_p1 VSS) capacitor c=5.305E-16
    I_C1968 (XI120_I41_n2 VSS) capacitor c=1.043E-17
    I_C1969 (XI120_I41_An VSS) capacitor c=1.018E-15
    I_C1970 (XI120_I41_Bn VSS) capacitor c=7.876E-16
    I_C1971 (XI122_p1 VSS) capacitor c=5.465E-16
    I_C1972 (XI122_n1 VSS) capacitor c=3.820E-19
    I_C1973 (XI122_n2 VSS) capacitor c=6.658E-18
    I_C1974 (XI122_An VSS) capacitor c=9.749E-16
    I_C1975 (XI122_Bn VSS) capacitor c=7.859E-16
    I_C1976 (XI119_p1 VSS) capacitor c=5.826E-16
    I_C1977 (XI119_n2 VSS) capacitor c=7.531E-18
    I_C1978 (XI119_An VSS) capacitor c=9.771E-16
    I_C1979 (XI119_Bn VSS) capacitor c=8.074E-16
    I_C1980 (XI121_p1 VSS) capacitor c=5.187E-16
    I_C1981 (XI121_n2 VSS) capacitor c=6.370E-18
    I_C1982 (XI121_An VSS) capacitor c=9.783E-16
    I_C1983 (XI121_Bn VSS) capacitor c=8.148E-16
    I_C1984 (XI110_p1 VSS) capacitor c=5.447E-16
    I_C1985 (XI110_n2 VSS) capacitor c=9.266E-18
    I_C1986 (XI110_An VSS) capacitor c=9.750E-16
    I_C1987 (XI110_Bn VSS) capacitor c=7.705E-16
    I_C1988 (XI107_p1 VSS) capacitor c=5.275E-16
    I_C1989 (XI107_n1 VSS) capacitor c=7.414E-20
    I_C1990 (XI107_n2 VSS) capacitor c=7.812E-18
    I_C1991 (XI107_An VSS) capacitor c=9.967E-16
    I_C1992 (XI107_Bn VSS) capacitor c=7.957E-16
    I_C1993 (XI133_p1 VSS) capacitor c=5.775E-16
    I_C1994 (XI133_n2 VSS) capacitor c=7.707E-18
    I_C1995 (XI133_An VSS) capacitor c=9.367E-16
    I_C1996 (XI133_Bn VSS) capacitor c=7.995E-16
    I_C1997 (XI129_p1 VSS) capacitor c=5.026E-16
    I_C1998 (XI129_n2 VSS) capacitor c=7.835E-18
    I_C1999 (XI129_An VSS) capacitor c=9.608E-16
    I_C2000 (XI129_Bn VSS) capacitor c=8.253E-16
    I_C2001 (XI118_p1 VSS) capacitor c=5.331E-16
    I_C2002 (XI118_n1 VSS) capacitor c=2.843E-18
    I_C2003 (XI118_n2 VSS) capacitor c=8.112E-18
    I_C2004 (XI118_An VSS) capacitor c=9.676E-16
    I_C2005 (XI118_Bn VSS) capacitor c=8.252E-16
    I_C2006 (XI108_I41_p1 VSS) capacitor c=5.655E-16
    I_C2007 (XI108_I41_n2 VSS) capacitor c=6.499E-18
    I_C2008 (XI108_I41_An VSS) capacitor c=9.928E-16
    I_C2009 (XI108_I41_Bn VSS) capacitor c=7.992E-16
    I_C2010 (XI109_p1 VSS) capacitor c=5.452E-16
    I_C2011 (XI109_n1 VSS) capacitor c=1.116E-18
    I_C2012 (XI109_n2 VSS) capacitor c=7.667E-18
    I_C2013 (XI109_An VSS) capacitor c=1.011E-15
    I_C2014 (XI109_Bn VSS) capacitor c=7.765E-16
    I_C2015 (XI106_p1 VSS) capacitor c=5.802E-16
    I_C2016 (XI106_n2 VSS) capacitor c=9.049E-18
    I_C2017 (XI106_An VSS) capacitor c=9.939E-16
    I_C2018 (XI106_Bn VSS) capacitor c=7.785E-16
    I_C2019 (XI134_p1 VSS) capacitor c=5.374E-16
    I_C2020 (XI134_n1 VSS) capacitor c=1.035E-18
    I_C2021 (XI134_n2 VSS) capacitor c=6.288E-18
    I_C2022 (XI134_An VSS) capacitor c=9.780E-16
    I_C2023 (XI134_Bn VSS) capacitor c=7.787E-16
    I_C2024 (XI120_I40_p1 VSS) capacitor c=5.640E-16
    I_C2025 (XI120_I40_n2 VSS) capacitor c=7.966E-18
    I_C2026 (XI120_I40_An VSS) capacitor c=1.022E-15
    I_C2027 (XI120_I40_Bn VSS) capacitor c=8.408E-16
    I_C2028 (XI128_p1 VSS) capacitor c=5.390E-16
    I_C2029 (XI128_n2 VSS) capacitor c=7.954E-18
    I_C2030 (XI128_An VSS) capacitor c=9.489E-16
    I_C2031 (XI128_Bn VSS) capacitor c=7.885E-16
    I_C2032 (XI117_p1 VSS) capacitor c=5.692E-16
    I_C2033 (XI117_n2 VSS) capacitor c=8.626E-18
    I_C2034 (XI117_An VSS) capacitor c=9.857E-16
    I_C2035 (XI117_Bn VSS) capacitor c=7.907E-16
    I_C2036 (XI108_I40_p1 VSS) capacitor c=5.543E-16
    I_C2037 (XI108_I40_n1 VSS) capacitor c=3.525E-18
    I_C2038 (XI108_I40_n2 VSS) capacitor c=1.438E-17
    I_C2039 (XI108_I40_An VSS) capacitor c=1.010E-15
    I_C2040 (XI108_I40_Bn VSS) capacitor c=7.903E-16
    I_C2041 (XI104_p1 VSS) capacitor c=5.746E-16
    I_C2042 (XI104_n1 VSS) capacitor c=4.699E-18
    I_C2043 (XI104_n2 VSS) capacitor c=6.640E-18
    I_C2044 (XI104_An VSS) capacitor c=9.752E-16
    I_C2045 (XI104_Bn VSS) capacitor c=8.314E-16
    I_C2046 (XI96_I41_p1 VSS) capacitor c=5.616E-16
    I_C2047 (XI96_I41_n1 VSS) capacitor c=1.739E-19
    I_C2048 (XI96_I41_n2 VSS) capacitor c=7.112E-18
    I_C2049 (XI96_I41_An VSS) capacitor c=9.602E-16
    I_C2050 (XI96_I41_Bn VSS) capacitor c=7.963E-16
    I_C2051 (XI105_p1 VSS) capacitor c=5.579E-16
    I_C2052 (XI105_n1 VSS) capacitor c=1.762E-18
    I_C2053 (XI105_n2 VSS) capacitor c=1.012E-17
    I_C2054 (XI105_An VSS) capacitor c=1.022E-15
    I_C2055 (XI105_Bn VSS) capacitor c=7.741E-16
    I_C2056 (XI98_p1 VSS) capacitor c=5.300E-16
    I_C2057 (XI98_n2 VSS) capacitor c=1.085E-17
    I_C2058 (XI98_An VSS) capacitor c=9.447E-16
    I_C2059 (XI98_Bn VSS) capacitor c=7.658E-16
    I_C2060 (XI127_p1 VSS) capacitor c=5.685E-16
    I_C2061 (XI127_n2 VSS) capacitor c=7.710E-18
    I_C2062 (XI127_An VSS) capacitor c=9.809E-16
    I_C2063 (XI127_Bn VSS) capacitor c=7.721E-16
    I_C2064 (XI115_p1 VSS) capacitor c=5.669E-16
    I_C2065 (XI115_n2 VSS) capacitor c=8.416E-18
    I_C2066 (XI115_An VSS) capacitor c=9.979E-16
    I_C2067 (XI115_Bn VSS) capacitor c=7.939E-16
    I_C2068 (XI116_p1 VSS) capacitor c=5.475E-16
    I_C2069 (XI116_n1 VSS) capacitor c=9.024E-19
    I_C2070 (XI116_n2 VSS) capacitor c=6.625E-18
    I_C2071 (XI116_An VSS) capacitor c=9.982E-16
    I_C2072 (XI116_Bn VSS) capacitor c=8.162E-16
    I_C2073 (XI103_p1 VSS) capacitor c=5.144E-16
    I_C2074 (XI103_n2 VSS) capacitor c=1.006E-17
    I_C2075 (XI103_An VSS) capacitor c=9.586E-16
    I_C2076 (XI103_Bn VSS) capacitor c=7.634E-16
    I_C2077 (XI96_I40_p1 VSS) capacitor c=5.446E-16
    I_C2078 (XI96_I40_n1 VSS) capacitor c=3.820E-19
    I_C2079 (XI96_I40_n2 VSS) capacitor c=1.225E-17
    I_C2080 (XI96_I40_An VSS) capacitor c=1.001E-15
    I_C2081 (XI96_I40_Bn VSS) capacitor c=7.258E-16
    I_C2082 (XI132_I41_p1 VSS) capacitor c=5.306E-16
    I_C2083 (XI132_I41_n2 VSS) capacitor c=7.533E-18
    I_C2084 (XI132_I41_An VSS) capacitor c=9.511E-16
    I_C2085 (XI132_I41_Bn VSS) capacitor c=7.555E-16
    I_C2086 (XI132_I40_p1 VSS) capacitor c=5.742E-16
    I_C2087 (XI132_I40_n2 VSS) capacitor c=4.931E-18
    I_C2088 (XI132_I40_An VSS) capacitor c=1.022E-15
    I_C2089 (XI132_I40_Bn VSS) capacitor c=7.972E-16
    I_C2090 (XI126_p1 VSS) capacitor c=5.188E-16
    I_C2091 (XI126_n1 VSS) capacitor c=3.471E-18
    I_C2092 (XI126_n2 VSS) capacitor c=8.215E-18
    I_C2093 (XI126_An VSS) capacitor c=1.014E-15
    I_C2094 (XI126_Bn VSS) capacitor c=8.048E-16
    I_C2095 (XI113_p1 VSS) capacitor c=5.352E-16
    I_C2096 (XI113_n2 VSS) capacitor c=7.563E-18
    I_C2097 (XI113_An VSS) capacitor c=9.675E-16
    I_C2098 (XI113_Bn VSS) capacitor c=7.922E-16
    I_C2099 (XI114_p1 VSS) capacitor c=5.535E-16
    I_C2100 (XI114_n1 VSS) capacitor c=6.135E-18
    I_C2101 (XI114_n2 VSS) capacitor c=8.558E-18
    I_C2102 (XI114_An VSS) capacitor c=9.538E-16
    I_C2103 (XI114_Bn VSS) capacitor c=7.809E-16
    I_C2104 (XI101_p1 VSS) capacitor c=5.654E-16
    I_C2105 (XI101_n1 VSS) capacitor c=5.085E-19
    I_C2106 (XI101_n2 VSS) capacitor c=9.176E-18
    I_C2107 (XI101_An VSS) capacitor c=1.014E-15
    I_C2108 (XI101_Bn VSS) capacitor c=8.151E-16
    I_C2109 (XI102_p1 VSS) capacitor c=5.365E-16
    I_C2110 (XI102_n1 VSS) capacitor c=1.739E-19
    I_C2111 (XI102_n2 VSS) capacitor c=9.026E-18
    I_C2112 (XI102_An VSS) capacitor c=9.764E-16
    I_C2113 (XI102_Bn VSS) capacitor c=8.268E-16
    I_C2114 (XI125_p1 VSS) capacitor c=5.476E-16
    I_C2115 (XI125_n1 VSS) capacitor c=3.820E-19
    I_C2116 (XI125_n2 VSS) capacitor c=5.710E-18
    I_C2117 (XI125_An VSS) capacitor c=9.734E-16
    I_C2118 (XI125_Bn VSS) capacitor c=7.884E-16
    I_C2119 (XI112_p1 VSS) capacitor c=5.582E-16
    I_C2120 (XI112_n1 VSS) capacitor c=4.570E-18
    I_C2121 (XI112_n2 VSS) capacitor c=7.589E-18
    I_C2122 (XI112_An VSS) capacitor c=9.773E-16
    I_C2123 (XI112_Bn VSS) capacitor c=8.166E-16
    I_C2124 (XI100_p1 VSS) capacitor c=5.849E-16
    I_C2125 (XI100_n2 VSS) capacitor c=7.379E-18
    I_C2126 (XI100_An VSS) capacitor c=9.855E-16
    I_C2127 (XI100_Bn VSS) capacitor c=7.958E-16
    I_C2128 (XI89_p1 VSS) capacitor c=5.469E-16
    I_C2129 (XI89_n1 VSS) capacitor c=3.757E-18
    I_C2130 (XI89_n2 VSS) capacitor c=8.184E-18
    I_C2131 (XI89_An VSS) capacitor c=9.797E-16
    I_C2132 (XI89_Bn VSS) capacitor c=8.134E-16
    I_C2133 (XI95_p1 VSS) capacitor c=5.947E-16
    I_C2134 (XI95_n2 VSS) capacitor c=8.526E-18
    I_C2135 (XI95_An VSS) capacitor c=9.963E-16
    I_C2136 (XI95_Bn VSS) capacitor c=7.813E-16
    I_C2137 (XI124_p1 VSS) capacitor c=5.593E-16
    I_C2138 (XI124_n2 VSS) capacitor c=5.952E-18
    I_C2139 (XI124_An VSS) capacitor c=9.620E-16
    I_C2140 (XI124_Bn VSS) capacitor c=7.979E-16
    I_C2141 (XI88_p1 VSS) capacitor c=5.753E-16
    I_C2142 (XI88_n2 VSS) capacitor c=6.589E-18
    I_C2143 (XI88_An VSS) capacitor c=9.634E-16
    I_C2144 (XI88_Bn VSS) capacitor c=7.447E-16
    I_C2145 (XI90_p1 VSS) capacitor c=5.382E-16
    I_C2146 (XI90_n2 VSS) capacitor c=5.748E-18
    I_C2147 (XI90_An VSS) capacitor c=9.574E-16
    I_C2148 (XI90_Bn VSS) capacitor c=7.715E-16
    I_C2149 (XI91_p1 VSS) capacitor c=5.789E-16
    I_C2150 (XI91_n1 VSS) capacitor c=4.748E-18
    I_C2151 (XI91_n2 VSS) capacitor c=9.078E-18
    I_C2152 (XI91_An VSS) capacitor c=9.966E-16
    I_C2153 (XI91_Bn VSS) capacitor c=8.211E-16
    I_C2154 (XI92_p1 VSS) capacitor c=5.460E-16
    I_C2155 (XI92_n2 VSS) capacitor c=7.369E-18
    I_C2156 (XI92_An VSS) capacitor c=1.008E-15
    I_C2157 (XI92_Bn VSS) capacitor c=8.219E-16
    I_C2158 (XI94_p1 VSS) capacitor c=5.741E-16
    I_C2159 (XI94_n1 VSS) capacitor c=4.597E-19
    I_C2160 (XI94_n2 VSS) capacitor c=9.113E-18
    I_C2161 (XI94_An VSS) capacitor c=1.016E-15
    I_C2162 (XI94_Bn VSS) capacitor c=7.682E-16
    I_C2163 (XI97_p1 VSS) capacitor c=5.811E-16
    I_C2164 (XI97_n1 VSS) capacitor c=2.047E-19
    I_C2165 (XI97_n2 VSS) capacitor c=8.440E-18
    I_C2166 (XI97_An VSS) capacitor c=9.487E-16
    I_C2167 (XI97_Bn VSS) capacitor c=7.567E-16
    I_C2168 (XI152_I41_p1 VSS) capacitor c=5.775E-16
    I_C2169 (XI152_I41_n1 VSS) capacitor c=8.559E-19
    I_C2170 (XI152_I41_n2 VSS) capacitor c=7.419E-18
    I_C2171 (XI152_I41_An VSS) capacitor c=1.019E-15
    I_C2172 (XI152_I41_Bn VSS) capacitor c=7.830E-16
    I_C2173 (XI153_p1 VSS) capacitor c=5.650E-16
    I_C2174 (XI153_n2 VSS) capacitor c=7.071E-18
    I_C2175 (XI153_An VSS) capacitor c=9.831E-16
    I_C2176 (XI153_Bn VSS) capacitor c=8.041E-16
    I_C2177 (XI76_p1 VSS) capacitor c=5.589E-16
    I_C2178 (XI76_n2 VSS) capacitor c=1.007E-17
    I_C2179 (XI76_An VSS) capacitor c=9.761E-16
    I_C2180 (XI76_Bn VSS) capacitor c=8.044E-16
    I_C2181 (XI84_I40_p1 VSS) capacitor c=5.553E-16
    I_C2182 (XI84_I40_n1 VSS) capacitor c=9.602E-19
    I_C2183 (XI84_I40_n2 VSS) capacitor c=9.377E-18
    I_C2184 (XI84_I40_An VSS) capacitor c=9.674E-16
    I_C2185 (XI84_I40_Bn VSS) capacitor c=8.086E-16
    I_C2186 (XI93_p1 VSS) capacitor c=5.683E-16
    I_C2187 (XI93_n1 VSS) capacitor c=1.867E-18
    I_C2188 (XI93_n2 VSS) capacitor c=6.046E-18
    I_C2189 (XI93_An VSS) capacitor c=9.797E-16
    I_C2190 (XI93_Bn VSS) capacitor c=7.840E-16
    I_C2191 (XI64_p1 VSS) capacitor c=6.068E-16
    I_C2192 (XI64_n2 VSS) capacitor c=7.340E-18
    I_C2193 (XI64_An VSS) capacitor c=9.981E-16
    I_C2194 (XI64_Bn VSS) capacitor c=8.270E-16
    I_C2195 (XI77_p1 VSS) capacitor c=5.713E-16
    I_C2196 (XI77_n1 VSS) capacitor c=1.396E-18
    I_C2197 (XI77_n2 VSS) capacitor c=8.050E-18
    I_C2198 (XI77_An VSS) capacitor c=1.019E-15
    I_C2199 (XI77_Bn VSS) capacitor c=7.717E-16
    I_C2200 (XI152_I40_p1 VSS) capacitor c=5.454E-16
    I_C2201 (XI152_I40_n2 VSS) capacitor c=9.511E-18
    I_C2202 (XI152_I40_An VSS) capacitor c=9.904E-16
    I_C2203 (XI152_I40_Bn VSS) capacitor c=8.056E-16
    I_C2204 (XI40_p1 VSS) capacitor c=5.843E-16
    I_C2205 (XI40_n1 VSS) capacitor c=2.255E-18
    I_C2206 (XI40_n2 VSS) capacitor c=1.000E-17
    I_C2207 (XI40_An VSS) capacitor c=1.031E-15
    I_C2208 (XI40_Bn VSS) capacitor c=8.284E-16
    I_C2209 (XI52_p1 VSS) capacitor c=5.637E-16
    I_C2210 (XI52_n1 VSS) capacitor c=6.529E-18
    I_C2211 (XI52_n2 VSS) capacitor c=7.406E-18
    I_C2212 (XI52_An VSS) capacitor c=9.747E-16
    I_C2213 (XI52_Bn VSS) capacitor c=7.898E-16
    I_C2214 (XI78_p1 VSS) capacitor c=5.029E-16
    I_C2215 (XI78_n2 VSS) capacitor c=7.090E-18
    I_C2216 (XI78_An VSS) capacitor c=9.493E-16
    I_C2217 (XI78_Bn VSS) capacitor c=7.477E-16
    I_C2218 (XI84_I41_p1 VSS) capacitor c=5.336E-16
    I_C2219 (XI84_I41_n2 VSS) capacitor c=8.408E-18
    I_C2220 (XI84_I41_An VSS) capacitor c=1.020E-15
    I_C2221 (XI84_I41_Bn VSS) capacitor c=8.111E-16
    I_C2222 (XI43_p1 VSS) capacitor c=5.512E-16
    I_C2223 (XI43_n1 VSS) capacitor c=4.225E-19
    I_C2224 (XI43_n2 VSS) capacitor c=8.165E-18
    I_C2225 (XI43_An VSS) capacitor c=9.843E-16
    I_C2226 (XI43_Bn VSS) capacitor c=7.985E-16
    I_C2227 (XI42_p1 VSS) capacitor c=5.463E-16
    I_C2228 (XI42_n1 VSS) capacitor c=9.020E-19
    I_C2229 (XI42_n2 VSS) capacitor c=6.113E-18
    I_C2230 (XI42_An VSS) capacitor c=9.585E-16
    I_C2231 (XI42_Bn VSS) capacitor c=8.069E-16
    I_C2232 (XI41_p1 VSS) capacitor c=5.639E-16
    I_C2233 (XI41_n2 VSS) capacitor c=1.057E-17
    I_C2234 (XI41_An VSS) capacitor c=9.786E-16
    I_C2235 (XI41_Bn VSS) capacitor c=7.773E-16
    I_C2236 (XI53_p1 VSS) capacitor c=5.805E-16
    I_C2237 (XI53_n2 VSS) capacitor c=6.375E-18
    I_C2238 (XI53_An VSS) capacitor c=9.446E-16
    I_C2239 (XI53_Bn VSS) capacitor c=8.080E-16
    I_C2240 (XI65_p1 VSS) capacitor c=5.343E-16
    I_C2241 (XI65_n1 VSS) capacitor c=1.498E-19
    I_C2242 (XI65_n2 VSS) capacitor c=6.260E-18
    I_C2243 (XI65_An VSS) capacitor c=9.895E-16
    I_C2244 (XI65_Bn VSS) capacitor c=7.950E-16
    I_C2245 (XI79_p1 VSS) capacitor c=5.290E-16
    I_C2246 (XI79_n1 VSS) capacitor c=3.820E-19
    I_C2247 (XI79_n2 VSS) capacitor c=7.008E-18
    I_C2248 (XI79_An VSS) capacitor c=9.500E-16
    I_C2249 (XI79_Bn VSS) capacitor c=7.936E-16
    I_C2250 (XI80_p1 VSS) capacitor c=5.274E-16
    I_C2251 (XI80_n1 VSS) capacitor c=4.329E-19
    I_C2252 (XI80_n2 VSS) capacitor c=7.787E-18
    I_C2253 (XI80_An VSS) capacitor c=9.486E-16
    I_C2254 (XI80_Bn VSS) capacitor c=7.703E-16
    I_C2255 (XI44_p1 VSS) capacitor c=5.401E-16
    I_C2256 (XI44_n2 VSS) capacitor c=7.396E-18
    I_C2257 (XI44_An VSS) capacitor c=9.652E-16
    I_C2258 (XI44_Bn VSS) capacitor c=8.126E-16
    I_C2259 (XI55_p1 VSS) capacitor c=5.855E-16
    I_C2260 (XI55_n1 VSS) capacitor c=3.820E-19
    I_C2261 (XI55_n2 VSS) capacitor c=8.081E-18
    I_C2262 (XI55_An VSS) capacitor c=9.934E-16
    I_C2263 (XI55_Bn VSS) capacitor c=7.753E-16
    I_C2264 (XI54_p1 VSS) capacitor c=5.910E-16
    I_C2265 (XI54_n2 VSS) capacitor c=1.013E-17
    I_C2266 (XI54_An VSS) capacitor c=9.706E-16
    I_C2267 (XI54_Bn VSS) capacitor c=8.085E-16
    I_C2268 (XI67_p1 VSS) capacitor c=5.453E-16
    I_C2269 (XI67_n2 VSS) capacitor c=1.110E-17
    I_C2270 (XI67_An VSS) capacitor c=1.032E-15
    I_C2271 (XI67_Bn VSS) capacitor c=8.520E-16
    I_C2272 (XI66_p1 VSS) capacitor c=5.258E-16
    I_C2273 (XI66_n2 VSS) capacitor c=8.086E-18
    I_C2274 (XI66_An VSS) capacitor c=9.345E-16
    I_C2275 (XI66_Bn VSS) capacitor c=7.981E-16
    I_C2276 (XI72_I40_p1 VSS) capacitor c=5.796E-16
    I_C2277 (XI72_I40_n1 VSS) capacitor c=6.303E-19
    I_C2278 (XI72_I40_n2 VSS) capacitor c=1.170E-17
    I_C2279 (XI72_I40_An VSS) capacitor c=9.566E-16
    I_C2280 (XI72_I40_Bn VSS) capacitor c=8.345E-16
    I_C2281 (XI81_p1 VSS) capacitor c=5.200E-16
    I_C2282 (XI81_n1 VSS) capacitor c=5.377E-19
    I_C2283 (XI81_n2 VSS) capacitor c=8.661E-18
    I_C2284 (XI81_An VSS) capacitor c=1.012E-15
    I_C2285 (XI81_Bn VSS) capacitor c=7.795E-16
    I_C2286 (XI86_p1 VSS) capacitor c=5.384E-16
    I_C2287 (XI86_n1 VSS) capacitor c=2.410E-18
    I_C2288 (XI86_n2 VSS) capacitor c=3.864E-18
    I_C2289 (XI86_An VSS) capacitor c=9.715E-16
    I_C2290 (XI86_Bn VSS) capacitor c=7.400E-16
    I_C2291 (XI45_p1 VSS) capacitor c=5.167E-16
    I_C2292 (XI45_n1 VSS) capacitor c=5.152E-18
    I_C2293 (XI45_n2 VSS) capacitor c=1.502E-17
    I_C2294 (XI45_An VSS) capacitor c=9.761E-16
    I_C2295 (XI45_Bn VSS) capacitor c=7.861E-16
    I_C2296 (XI56_p1 VSS) capacitor c=5.716E-16
    I_C2297 (XI56_n1 VSS) capacitor c=1.696E-18
    I_C2298 (XI56_n2 VSS) capacitor c=7.517E-18
    I_C2299 (XI56_An VSS) capacitor c=9.820E-16
    I_C2300 (XI56_Bn VSS) capacitor c=8.036E-16
    I_C2301 (XI68_p1 VSS) capacitor c=5.384E-16
    I_C2302 (XI68_n1 VSS) capacitor c=1.200E-18
    I_C2303 (XI68_n2 VSS) capacitor c=8.469E-18
    I_C2304 (XI68_An VSS) capacitor c=9.528E-16
    I_C2305 (XI68_Bn VSS) capacitor c=7.722E-16
    I_C2306 (XI72_I41_p1 VSS) capacitor c=5.885E-16
    I_C2307 (XI72_I41_n1 VSS) capacitor c=7.219E-19
    I_C2308 (XI72_I41_n2 VSS) capacitor c=8.124E-18
    I_C2309 (XI72_I41_An VSS) capacitor c=9.705E-16
    I_C2310 (XI72_I41_Bn VSS) capacitor c=8.122E-16
    I_C2311 (XI82_p1 VSS) capacitor c=5.766E-16
    I_C2312 (XI82_n2 VSS) capacitor c=9.030E-18
    I_C2313 (XI82_An VSS) capacitor c=9.918E-16
    I_C2314 (XI82_Bn VSS) capacitor c=8.140E-16
    I_C2315 (XI48_I40_p1 VSS) capacitor c=5.546E-16
    I_C2316 (XI48_I40_n2 VSS) capacitor c=5.392E-18
    I_C2317 (XI48_I40_An VSS) capacitor c=1.015E-15
    I_C2318 (XI48_I40_Bn VSS) capacitor c=8.313E-16
    I_C2319 (XI57_p1 VSS) capacitor c=5.687E-16
    I_C2320 (XI57_n1 VSS) capacitor c=2.398E-18
    I_C2321 (XI57_n2 VSS) capacitor c=4.877E-18
    I_C2322 (XI57_An VSS) capacitor c=1.028E-15
    I_C2323 (XI57_Bn VSS) capacitor c=8.242E-16
    I_C2324 (XI60_I40_p1 VSS) capacitor c=5.555E-16
    I_C2325 (XI60_I40_n1 VSS) capacitor c=3.820E-19
    I_C2326 (XI60_I40_n2 VSS) capacitor c=1.435E-17
    I_C2327 (XI60_I40_An VSS) capacitor c=1.001E-15
    I_C2328 (XI60_I40_Bn VSS) capacitor c=7.722E-16
    I_C2329 (XI69_p1 VSS) capacitor c=5.723E-16
    I_C2330 (XI69_n2 VSS) capacitor c=5.816E-18
    I_C2331 (XI69_An VSS) capacitor c=9.814E-16
    I_C2332 (XI69_Bn VSS) capacitor c=7.668E-16
    I_C2333 (XI83_p1 VSS) capacitor c=5.873E-16
    I_C2334 (XI83_n1 VSS) capacitor c=1.741E-18
    I_C2335 (XI83_n2 VSS) capacitor c=8.903E-18
    I_C2336 (XI83_An VSS) capacitor c=1.014E-15
    I_C2337 (XI83_Bn VSS) capacitor c=7.745E-16
    I_C2338 (XI46_p1 VSS) capacitor c=5.446E-16
    I_C2339 (XI46_n2 VSS) capacitor c=7.982E-18
    I_C2340 (XI46_An VSS) capacitor c=9.744E-16
    I_C2341 (XI46_Bn VSS) capacitor c=7.958E-16
    I_C2342 (XI48_I41_p1 VSS) capacitor c=6.050E-16
    I_C2343 (XI48_I41_n2 VSS) capacitor c=7.139E-18
    I_C2344 (XI48_I41_An VSS) capacitor c=9.679E-16
    I_C2345 (XI48_I41_Bn VSS) capacitor c=8.257E-16
    I_C2346 (XI58_p1 VSS) capacitor c=5.270E-16
    I_C2347 (XI58_n2 VSS) capacitor c=6.927E-18
    I_C2348 (XI58_An VSS) capacitor c=9.560E-16
    I_C2349 (XI58_Bn VSS) capacitor c=7.616E-16
    I_C2350 (XI60_I41_p1 VSS) capacitor c=5.762E-16
    I_C2351 (XI60_I41_n2 VSS) capacitor c=1.115E-17
    I_C2352 (XI60_I41_An VSS) capacitor c=1.006E-15
    I_C2353 (XI60_I41_Bn VSS) capacitor c=7.923E-16
    I_C2354 (XI70_p1 VSS) capacitor c=5.644E-16
    I_C2355 (XI70_n1 VSS) capacitor c=1.087E-18
    I_C2356 (XI70_n2 VSS) capacitor c=7.170E-18
    I_C2357 (XI70_An VSS) capacitor c=1.009E-15
    I_C2358 (XI70_Bn VSS) capacitor c=8.402E-16
    I_C2359 (XI85_p1 VSS) capacitor c=5.080E-16
    I_C2360 (XI85_n1 VSS) capacitor c=4.368E-19
    I_C2361 (XI85_n2 VSS) capacitor c=7.304E-18
    I_C2362 (XI85_An VSS) capacitor c=1.002E-15
    I_C2363 (XI85_Bn VSS) capacitor c=8.216E-16
    I_C2364 (XI47_p1 VSS) capacitor c=5.175E-16
    I_C2365 (XI47_n2 VSS) capacitor c=7.457E-18
    I_C2366 (XI47_An VSS) capacitor c=1.031E-15
    I_C2367 (XI47_Bn VSS) capacitor c=7.919E-16
    I_C2368 (XI49_p1 VSS) capacitor c=5.916E-16
    I_C2369 (XI49_n1 VSS) capacitor c=1.195E-19
    I_C2370 (XI49_n2 VSS) capacitor c=8.991E-18
    I_C2371 (XI49_An VSS) capacitor c=9.917E-16
    I_C2372 (XI49_Bn VSS) capacitor c=8.006E-16
    I_C2373 (XI50_p1 VSS) capacitor c=5.210E-16
    I_C2374 (XI50_n1 VSS) capacitor c=5.580E-18
    I_C2375 (XI50_n2 VSS) capacitor c=8.263E-18
    I_C2376 (XI50_An VSS) capacitor c=9.682E-16
    I_C2377 (XI50_Bn VSS) capacitor c=7.893E-16
    I_C2378 (XI61_p1 VSS) capacitor c=5.545E-16
    I_C2379 (XI61_n2 VSS) capacitor c=5.957E-18
    I_C2380 (XI61_An VSS) capacitor c=9.641E-16
    I_C2381 (XI61_Bn VSS) capacitor c=8.241E-16
    I_C2382 (XI59_p1 VSS) capacitor c=5.885E-16
    I_C2383 (XI59_n1 VSS) capacitor c=2.258E-18
    I_C2384 (XI59_n2 VSS) capacitor c=7.016E-18
    I_C2385 (XI59_An VSS) capacitor c=1.007E-15
    I_C2386 (XI59_Bn VSS) capacitor c=8.161E-16
    I_C2387 (XI62_p1 VSS) capacitor c=5.772E-16
    I_C2388 (XI62_n1 VSS) capacitor c=3.820E-19
    I_C2389 (XI62_n2 VSS) capacitor c=7.192E-18
    I_C2390 (XI62_An VSS) capacitor c=9.718E-16
    I_C2391 (XI62_Bn VSS) capacitor c=8.164E-16
    I_C2392 (XI73_p1 VSS) capacitor c=5.692E-16
    I_C2393 (XI73_n1 VSS) capacitor c=1.547E-18
    I_C2394 (XI73_n2 VSS) capacitor c=9.278E-18
    I_C2395 (XI73_An VSS) capacitor c=1.029E-15
    I_C2396 (XI73_Bn VSS) capacitor c=7.914E-16
    I_C2397 (XI74_p1 VSS) capacitor c=5.287E-16
    I_C2398 (XI74_n2 VSS) capacitor c=1.151E-17
    I_C2399 (XI74_An VSS) capacitor c=1.003E-15
    I_C2400 (XI74_Bn VSS) capacitor c=8.097E-16
    I_C2401 (XI71_p1 VSS) capacitor c=6.061E-16
    I_C2402 (XI71_n2 VSS) capacitor c=1.006E-17
    I_C2403 (XI71_An VSS) capacitor c=9.937E-16
    I_C2404 (XI71_Bn VSS) capacitor c=7.989E-16
ends DIV8K
