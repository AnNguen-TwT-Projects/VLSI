// DIV8K sau layout (RCX), corner NN
simulator lang=spectre
include "/home/buet/cadence/gpdk090_v4.6/models/spectre/gpdk090.scs" section=NN
include "../../cells/A/cells_A.scs"
include "DIV8K_rcx.scs"
include "../../blocks/ALU_DIV/tb/tb_DIV8K_p0.scs"
