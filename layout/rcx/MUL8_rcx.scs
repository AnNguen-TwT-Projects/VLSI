// MUL8 sau layout: Assura RCX -> layout/rcx2scs.py - khong sua tay
simulator lang=spectre
subckt MUL8 A_0 A_1 A_2 A_3 A_4 A_5 A_6 A_7 B_0 B_1 B_2 B_3 B_4 B_5 B_6 B_7 P_0 P_1 P_2 P_3 P_4 P_5 P_6 P_7 P_8 P_9 P_10 P_11 P_12 P_13 P_14 P_15 VDD VSS
    I_MXI77_I33_MN0 (I77_G1_0n I77_G1_0 VSS VSS) gpdk090_nmos1v w=0.12u l=0.1u ad=0.0696p as=0.0696p pd=1.16u ps=1.16u
    I_MXI77_I18_MN0 (I77_G0_0n I77_G0_0 VSS VSS) gpdk090_nmos1v w=0.12u l=0.1u ad=0.0696p as=0.0696p pd=1.16u ps=1.16u
    I_MXI77_I16_MN0 (I77_cinn rc8 VSS VSS) gpdk090_nmos1v w=0.12u l=0.1u ad=0.0696p as=0.0696p pd=1.16u ps=1.16u
    I_MXI10_MN0 (sn0 pp0_8 VSS VSS) gpdk090_nmos1v w=0.12u l=0.1u ad=0.0696p as=0.0696p pd=1.16u ps=1.16u
    I_MXI21_MN0 (sn1 pp1_8 VSS VSS) gpdk090_nmos1v w=0.12u l=0.1u ad=0.0696p as=0.0696p pd=1.16u ps=1.16u
    I_MXI32_MN0 (sn2 pp2_8 VSS VSS) gpdk090_nmos1v w=0.12u l=0.1u ad=0.0696p as=0.0696p pd=1.16u ps=1.16u
    I_MXI43_MN0 (sn3 pp3_8 VSS VSS) gpdk090_nmos1v w=0.12u l=0.1u ad=0.0696p as=0.0696p pd=1.16u ps=1.16u
    I_MXI77_I39_MN1 (XI77_I39_Bn I77_G1_0 VSS VSS) gpdk090_nmos1v w=0.12u l=0.1u ad=0.0696p as=0.0696p pd=1.16u ps=1.16u
    I_MXI77_I39_MN5 (XI77_I39_n2 I77_G1_0 VSS VSS) gpdk090_nmos1v w=0.24u l=0.1u ad=0.0528p as=0.0816p pd=0.68u ps=1.16u
    I_MXI77_I39_MN4 (P_10 XI77_I39_An XI77_I39_n2 VSS) gpdk090_nmos1v w=0.24u l=0.1u ad=0.0528p as=0.0528p pd=0.68u ps=0.68u
    I_MXI77_I39_MN2 (XI77_I39_n1 I77_pn2 P_10 VSS) gpdk090_nmos1v w=0.24u l=0.1u ad=0.0528p as=0.0528p pd=0.68u ps=0.68u
    I_MXI77_I39_MN3 (VSS XI77_I39_Bn XI77_I39_n1 VSS) gpdk090_nmos1v w=0.24u l=0.1u ad=0.0816p as=0.0528p pd=1.16u ps=0.68u
    I_MXI77_I39_MN0 (XI77_I39_An I77_pn2 VSS VSS) gpdk090_nmos1v w=0.12u l=0.1u ad=0.0696p as=0.0696p pd=1.16u ps=1.16u
    I_MXI77_I38_MN1 (XI77_I38_Bn I77_G0_0 VSS VSS) gpdk090_nmos1v w=0.12u l=0.1u ad=0.0696p as=0.0696p pd=1.16u ps=1.16u
    I_MXI77_I38_MN5 (XI77_I38_n2 I77_G0_0 VSS VSS) gpdk090_nmos1v w=0.24u l=0.1u ad=0.0528p as=0.0816p pd=0.68u ps=1.16u
    I_MXI77_I38_MN4 (P_9 XI77_I38_An XI77_I38_n2 VSS) gpdk090_nmos1v w=0.24u l=0.1u ad=0.0528p as=0.0528p pd=0.68u ps=0.68u
    I_MXI77_I38_MN2 (XI77_I38_n1 I77_pn1 P_9 VSS) gpdk090_nmos1v w=0.24u l=0.1u ad=0.0528p as=0.0528p pd=0.68u ps=0.68u
    I_MXI77_I38_MN3 (VSS XI77_I38_Bn XI77_I38_n1 VSS) gpdk090_nmos1v w=0.24u l=0.1u ad=0.0816p as=0.0528p pd=1.16u ps=0.68u
    I_MXI77_I38_MN0 (XI77_I38_An I77_pn1 VSS VSS) gpdk090_nmos1v w=0.12u l=0.1u ad=0.0696p as=0.0696p pd=1.16u ps=1.16u
    I_MXI77_I37_MN1 (XI77_I37_Bn rc8 VSS VSS) gpdk090_nmos1v w=0.12u l=0.1u ad=0.0696p as=0.0696p pd=1.16u ps=1.16u
    I_MXI77_I37_MN5 (XI77_I37_n2 rc8 VSS VSS) gpdk090_nmos1v w=0.24u l=0.1u ad=0.0528p as=0.0816p pd=0.68u ps=1.16u
    I_MXI77_I37_MN4 (P_8 XI77_I37_An XI77_I37_n2 VSS) gpdk090_nmos1v w=0.24u l=0.1u ad=0.0528p as=0.0528p pd=0.68u ps=0.68u
    I_MXI77_I37_MN2 (XI77_I37_n1 I77_pn0 P_8 VSS) gpdk090_nmos1v w=0.24u l=0.1u ad=0.0528p as=0.0528p pd=0.68u ps=0.68u
    I_MXI77_I37_MN3 (VSS XI77_I37_Bn XI77_I37_n1 VSS) gpdk090_nmos1v w=0.24u l=0.1u ad=0.0816p as=0.0528p pd=1.16u ps=0.68u
    I_MXI77_I37_MN0 (XI77_I37_An I77_pn0 VSS VSS) gpdk090_nmos1v w=0.12u l=0.1u ad=0.0696p as=0.0696p pd=1.16u ps=1.16u
    I_MXI77_I43_MN1 (XI77_I43_Bn I77_G5_0 VSS VSS) gpdk090_nmos1v w=0.12u l=0.1u ad=0.0696p as=0.0696p pd=1.16u ps=1.16u
    I_MXI77_I43_MN5 (XI77_I43_n2 I77_G5_0 VSS VSS) gpdk090_nmos1v w=0.24u l=0.1u ad=0.0528p as=0.0816p pd=0.68u ps=1.16u
    I_MXI77_I43_MN4 (P_14 XI77_I43_An XI77_I43_n2 VSS) gpdk090_nmos1v w=0.24u l=0.1u ad=0.0528p as=0.0528p pd=0.68u ps=0.68u
    I_MXI77_I43_MN2 (XI77_I43_n1 I77_pn6 P_14 VSS) gpdk090_nmos1v w=0.24u l=0.1u ad=0.0528p as=0.0528p pd=0.68u ps=0.68u
    I_MXI77_I43_MN3 (VSS XI77_I43_Bn XI77_I43_n1 VSS) gpdk090_nmos1v w=0.24u l=0.1u ad=0.0816p as=0.0528p pd=1.16u ps=0.68u
    I_MXI77_I43_MN0 (XI77_I43_An I77_pn6 VSS VSS) gpdk090_nmos1v w=0.12u l=0.1u ad=0.0696p as=0.0696p pd=1.16u ps=1.16u
    I_MXI77_I42_MN1 (XI77_I42_Bn I77_G4_0 VSS VSS) gpdk090_nmos1v w=0.12u l=0.1u ad=0.0696p as=0.0696p pd=1.16u ps=1.16u
    I_MXI77_I42_MN5 (XI77_I42_n2 I77_G4_0 VSS VSS) gpdk090_nmos1v w=0.24u l=0.1u ad=0.0528p as=0.0816p pd=0.68u ps=1.16u
    I_MXI77_I42_MN4 (P_13 XI77_I42_An XI77_I42_n2 VSS) gpdk090_nmos1v w=0.24u l=0.1u ad=0.0528p as=0.0528p pd=0.68u ps=0.68u
    I_MXI77_I42_MN2 (XI77_I42_n1 I77_pn5 P_13 VSS) gpdk090_nmos1v w=0.24u l=0.1u ad=0.0528p as=0.0528p pd=0.68u ps=0.68u
    I_MXI77_I42_MN3 (VSS XI77_I42_Bn XI77_I42_n1 VSS) gpdk090_nmos1v w=0.24u l=0.1u ad=0.0816p as=0.0528p pd=1.16u ps=0.68u
    I_MXI77_I42_MN0 (XI77_I42_An I77_pn5 VSS VSS) gpdk090_nmos1v w=0.12u l=0.1u ad=0.0696p as=0.0696p pd=1.16u ps=1.16u
    I_MXI77_I9_MN1 (XI77_I9_Bn ha19_0 VSS VSS) gpdk090_nmos1v w=0.12u l=0.1u ad=0.0696p as=0.0696p pd=1.16u ps=1.16u
    I_MXI77_I9_MN5 (XI77_I9_n2 ha19_0 VSS VSS) gpdk090_nmos1v w=0.24u l=0.1u ad=0.0528p as=0.0816p pd=0.68u ps=1.16u
    I_MXI77_I9_MN4 (I77_pn1 XI77_I9_An XI77_I9_n2 VSS) gpdk090_nmos1v w=0.24u l=0.1u ad=0.0528p as=0.0528p pd=0.68u ps=0.68u
    I_MXI77_I9_MN2 (XI77_I9_n1 ha18_1 I77_pn1 VSS) gpdk090_nmos1v w=0.24u l=0.1u ad=0.0528p as=0.0528p pd=0.68u ps=0.68u
    I_MXI77_I9_MN3 (VSS XI77_I9_Bn XI77_I9_n1 VSS) gpdk090_nmos1v w=0.24u l=0.1u ad=0.0816p as=0.0528p pd=1.16u ps=0.68u
    I_MXI77_I9_MN0 (XI77_I9_An ha18_1 VSS VSS) gpdk090_nmos1v w=0.12u l=0.1u ad=0.0696p as=0.0696p pd=1.16u ps=1.16u
    I_MXI77_I8_MN1 (XI77_I8_Bn ha18_0 VSS VSS) gpdk090_nmos1v w=0.12u l=0.1u ad=0.0696p as=0.0696p pd=1.16u ps=1.16u
    I_MXI77_I8_MN5 (XI77_I8_n2 ha18_0 VSS VSS) gpdk090_nmos1v w=0.24u l=0.1u ad=0.0528p as=0.0816p pd=0.68u ps=1.16u
    I_MXI77_I8_MN4 (I77_pn0 XI77_I8_An XI77_I8_n2 VSS) gpdk090_nmos1v w=0.24u l=0.1u ad=0.0528p as=0.0528p pd=0.68u ps=0.68u
    I_MXI77_I8_MN2 (XI77_I8_n1 ha17_1 I77_pn0 VSS) gpdk090_nmos1v w=0.24u l=0.1u ad=0.0528p as=0.0528p pd=0.68u ps=0.68u
    I_MXI77_I8_MN3 (VSS XI77_I8_Bn XI77_I8_n1 VSS) gpdk090_nmos1v w=0.24u l=0.1u ad=0.0816p as=0.0528p pd=1.16u ps=0.68u
    I_MXI77_I8_MN0 (XI77_I8_An ha17_1 VSS VSS) gpdk090_nmos1v w=0.12u l=0.1u ad=0.0696p as=0.0696p pd=1.16u ps=1.16u
    I_MXI77_I10_MN1 (XI77_I10_Bn ha20_0 VSS VSS) gpdk090_nmos1v w=0.12u l=0.1u ad=0.0696p as=0.0696p pd=1.16u ps=1.16u
    I_MXI77_I10_MN5 (XI77_I10_n2 ha20_0 VSS VSS) gpdk090_nmos1v w=0.24u l=0.1u ad=0.0528p as=0.0816p pd=0.68u ps=1.16u
    I_MXI77_I10_MN4 (I77_pn2 XI77_I10_An XI77_I10_n2 VSS) gpdk090_nmos1v w=0.24u l=0.1u ad=0.0528p as=0.0528p pd=0.68u ps=0.68u
    I_MXI77_I10_MN2 (XI77_I10_n1 ha19_1 I77_pn2 VSS) gpdk090_nmos1v w=0.24u l=0.1u ad=0.0528p as=0.0528p pd=0.68u ps=0.68u
    I_MXI77_I10_MN3 (VSS XI77_I10_Bn XI77_I10_n1 VSS) gpdk090_nmos1v w=0.24u l=0.1u ad=0.0816p as=0.0528p pd=1.16u ps=0.68u
    I_MXI77_I10_MN0 (XI77_I10_An ha19_1 VSS VSS) gpdk090_nmos1v w=0.12u l=0.1u ad=0.0696p as=0.0696p pd=1.16u ps=1.16u
    I_MXI77_I11_MN1 (XI77_I11_Bn ha21_0 VSS VSS) gpdk090_nmos1v w=0.12u l=0.1u ad=0.0696p as=0.0696p pd=1.16u ps=1.16u
    I_MXI77_I11_MN5 (XI77_I11_n2 ha21_0 VSS VSS) gpdk090_nmos1v w=0.24u l=0.1u ad=0.0528p as=0.0816p pd=0.68u ps=1.16u
    I_MXI77_I11_MN4 (I77_pn3 XI77_I11_An XI77_I11_n2 VSS) gpdk090_nmos1v w=0.24u l=0.1u ad=0.0528p as=0.0528p pd=0.68u ps=0.68u
    I_MXI77_I11_MN2 (XI77_I11_n1 ha20_1 I77_pn3 VSS) gpdk090_nmos1v w=0.24u l=0.1u ad=0.0528p as=0.0528p pd=0.68u ps=0.68u
    I_MXI77_I11_MN3 (VSS XI77_I11_Bn XI77_I11_n1 VSS) gpdk090_nmos1v w=0.24u l=0.1u ad=0.0816p as=0.0528p pd=1.16u ps=0.68u
    I_MXI77_I11_MN0 (XI77_I11_An ha20_1 VSS VSS) gpdk090_nmos1v w=0.12u l=0.1u ad=0.0696p as=0.0696p pd=1.16u ps=1.16u
    I_MXI77_I44_MN1 (XI77_I44_Bn kc7 VSS VSS) gpdk090_nmos1v w=0.12u l=0.1u ad=0.0696p as=0.0696p pd=1.16u ps=1.16u
    I_MXI77_I44_MN5 (XI77_I44_n2 kc7 VSS VSS) gpdk090_nmos1v w=0.24u l=0.1u ad=0.0528p as=0.0816p pd=0.68u ps=1.16u
    I_MXI77_I44_MN4 (P_15 XI77_I44_An XI77_I44_n2 VSS) gpdk090_nmos1v w=0.24u l=0.1u ad=0.0528p as=0.0528p pd=0.68u ps=0.68u
    I_MXI77_I44_MN2 (XI77_I44_n1 I77_pn7 P_15 VSS) gpdk090_nmos1v w=0.24u l=0.1u ad=0.0528p as=0.0528p pd=0.68u ps=0.68u
    I_MXI77_I44_MN3 (VSS XI77_I44_Bn XI77_I44_n1 VSS) gpdk090_nmos1v w=0.24u l=0.1u ad=0.0816p as=0.0528p pd=1.16u ps=0.68u
    I_MXI77_I44_MN0 (XI77_I44_An I77_pn7 VSS VSS) gpdk090_nmos1v w=0.12u l=0.1u ad=0.0696p as=0.0696p pd=1.16u ps=1.16u
    I_MXI77_I12_MN1 (XI77_I12_Bn ha22_0 VSS VSS) gpdk090_nmos1v w=0.12u l=0.1u ad=0.0696p as=0.0696p pd=1.16u ps=1.16u
    I_MXI77_I12_MN5 (XI77_I12_n2 ha22_0 VSS VSS) gpdk090_nmos1v w=0.24u l=0.1u ad=0.0528p as=0.0816p pd=0.68u ps=1.16u
    I_MXI77_I12_MN4 (I77_pn4 XI77_I12_An XI77_I12_n2 VSS) gpdk090_nmos1v w=0.24u l=0.1u ad=0.0528p as=0.0528p pd=0.68u ps=0.68u
    I_MXI77_I12_MN2 (XI77_I12_n1 ha21_1 I77_pn4 VSS) gpdk090_nmos1v w=0.24u l=0.1u ad=0.0528p as=0.0528p pd=0.68u ps=0.68u
    I_MXI77_I12_MN3 (VSS XI77_I12_Bn XI77_I12_n1 VSS) gpdk090_nmos1v w=0.24u l=0.1u ad=0.0816p as=0.0528p pd=1.16u ps=0.68u
    I_MXI77_I12_MN0 (XI77_I12_An ha21_1 VSS VSS) gpdk090_nmos1v w=0.12u l=0.1u ad=0.0696p as=0.0696p pd=1.16u ps=1.16u
    I_MXI77_I13_MN1 (XI77_I13_Bn ha23_0 VSS VSS) gpdk090_nmos1v w=0.12u l=0.1u ad=0.0696p as=0.0696p pd=1.16u ps=1.16u
    I_MXI77_I13_MN5 (XI77_I13_n2 ha23_0 VSS VSS) gpdk090_nmos1v w=0.24u l=0.1u ad=0.0528p as=0.0816p pd=0.68u ps=1.16u
    I_MXI77_I13_MN4 (I77_pn5 XI77_I13_An XI77_I13_n2 VSS) gpdk090_nmos1v w=0.24u l=0.1u ad=0.0528p as=0.0528p pd=0.68u ps=0.68u
    I_MXI77_I13_MN2 (XI77_I13_n1 ha22_1 I77_pn5 VSS) gpdk090_nmos1v w=0.24u l=0.1u ad=0.0528p as=0.0528p pd=0.68u ps=0.68u
    I_MXI77_I13_MN3 (VSS XI77_I13_Bn XI77_I13_n1 VSS) gpdk090_nmos1v w=0.24u l=0.1u ad=0.0816p as=0.0528p pd=1.16u ps=0.68u
    I_MXI77_I13_MN0 (XI77_I13_An ha22_1 VSS VSS) gpdk090_nmos1v w=0.12u l=0.1u ad=0.0696p as=0.0696p pd=1.16u ps=1.16u
    I_MXI77_I15_MN1 (XI77_I15_Bn ha25_0 VSS VSS) gpdk090_nmos1v w=0.12u l=0.1u ad=0.0696p as=0.0696p pd=1.16u ps=1.16u
    I_MXI77_I15_MN5 (XI77_I15_n2 ha25_0 VSS VSS) gpdk090_nmos1v w=0.24u l=0.1u ad=0.0528p as=0.0816p pd=0.68u ps=1.16u
    I_MXI77_I15_MN4 (I77_pn7 XI77_I15_An XI77_I15_n2 VSS) gpdk090_nmos1v w=0.24u l=0.1u ad=0.0528p as=0.0528p pd=0.68u ps=0.68u
    I_MXI77_I15_MN2 (XI77_I15_n1 ha24_1 I77_pn7 VSS) gpdk090_nmos1v w=0.24u l=0.1u ad=0.0528p as=0.0528p pd=0.68u ps=0.68u
    I_MXI77_I15_MN3 (VSS XI77_I15_Bn XI77_I15_n1 VSS) gpdk090_nmos1v w=0.24u l=0.1u ad=0.0816p as=0.0528p pd=1.16u ps=0.68u
    I_MXI77_I15_MN0 (XI77_I15_An ha24_1 VSS VSS) gpdk090_nmos1v w=0.12u l=0.1u ad=0.0696p as=0.0696p pd=1.16u ps=1.16u
    I_MXI77_I14_MN1 (XI77_I14_Bn ha24_0 VSS VSS) gpdk090_nmos1v w=0.12u l=0.1u ad=0.0696p as=0.0696p pd=1.16u ps=1.16u
    I_MXI77_I14_MN5 (XI77_I14_n2 ha24_0 VSS VSS) gpdk090_nmos1v w=0.24u l=0.1u ad=0.0528p as=0.0816p pd=0.68u ps=1.16u
    I_MXI77_I14_MN4 (I77_pn6 XI77_I14_An XI77_I14_n2 VSS) gpdk090_nmos1v w=0.24u l=0.1u ad=0.0528p as=0.0528p pd=0.68u ps=0.68u
    I_MXI77_I14_MN2 (XI77_I14_n1 ha23_1 I77_pn6 VSS) gpdk090_nmos1v w=0.24u l=0.1u ad=0.0528p as=0.0528p pd=0.68u ps=0.68u
    I_MXI77_I14_MN3 (VSS XI77_I14_Bn XI77_I14_n1 VSS) gpdk090_nmos1v w=0.24u l=0.1u ad=0.0816p as=0.0528p pd=1.16u ps=0.68u
    I_MXI77_I14_MN0 (XI77_I14_An ha23_1 VSS VSS) gpdk090_nmos1v w=0.12u l=0.1u ad=0.0696p as=0.0696p pd=1.16u ps=1.16u
    I_MXI59_MN5 (ha16_0 fa4_1 XI59_xn1 VSS) gpdk090_nmos1v w=0.24u l=0.1u ad=0.0528p as=0.0816p pd=0.68u ps=1.16u
    I_MXI59_MN7 (XI59_xn2 XI59_xan ha16_0 VSS) gpdk090_nmos1v w=0.24u l=0.1u ad=0.0528p as=0.0528p pd=0.68u ps=0.68u
    I_MXI59_MN8 (VSS XI59_xbn XI59_xn2 VSS) gpdk090_nmos1v w=0.24u l=0.1u ad=0.0528p as=0.0528p pd=0.68u ps=0.68u
    I_MXI59_MN6 (XI59_xn1 cm5_0 VSS VSS) gpdk090_nmos1v w=0.24u l=0.1u ad=0.0816p as=0.0528p pd=1.16u ps=0.68u
    I_MXI59_MN1 (VSS fa4_1 XI59_xan VSS) gpdk090_nmos1v w=0.12u l=0.1u ad=0.0468p as=0.0696p pd=0.68u ps=1.16u
    I_MXI59_MN14 (XI59_an cm5_0 VSS VSS) gpdk090_nmos1v w=0.24u l=0.1u ad=0.0528p as=0.0468p pd=0.68u ps=0.68u
    I_MXI59_MN13 (XI59_con fa4_1 XI59_an VSS) gpdk090_nmos1v w=0.24u l=0.1u ad=0.0816p as=0.0528p pd=1.16u ps=0.68u
    I_MXI59_MN17 (ha16_1 XI59_con VSS VSS) gpdk090_nmos1v w=0.12u l=0.1u ad=0.0696p as=0.0696p pd=1.16u ps=1.16u
    I_MXI59_MN3 (VSS cm5_0 XI59_xbn VSS) gpdk090_nmos1v w=0.12u l=0.1u ad=0.0696p as=0.0696p pd=1.16u ps=1.16u
    I_MXI62_MN5 (ha19_0 cm7_1 XI62_xn1 VSS) gpdk090_nmos1v w=0.24u l=0.1u ad=0.0528p as=0.0816p pd=0.68u ps=1.16u
    I_MXI62_MN7 (XI62_xn2 XI62_xan ha19_0 VSS) gpdk090_nmos1v w=0.24u l=0.1u ad=0.0528p as=0.0528p pd=0.68u ps=0.68u
    I_MXI62_MN8 (VSS XI62_xbn XI62_xn2 VSS) gpdk090_nmos1v w=0.24u l=0.1u ad=0.0528p as=0.0528p pd=0.68u ps=0.68u
    I_MXI62_MN6 (XI62_xn1 cm8_0 VSS VSS) gpdk090_nmos1v w=0.24u l=0.1u ad=0.0816p as=0.0528p pd=1.16u ps=0.68u
    I_MXI62_MN1 (VSS cm7_1 XI62_xan VSS) gpdk090_nmos1v w=0.12u l=0.1u ad=0.0468p as=0.0696p pd=0.68u ps=1.16u
    I_MXI62_MN14 (XI62_an cm8_0 VSS VSS) gpdk090_nmos1v w=0.24u l=0.1u ad=0.0528p as=0.0468p pd=0.68u ps=0.68u
    I_MXI62_MN13 (XI62_con cm7_1 XI62_an VSS) gpdk090_nmos1v w=0.24u l=0.1u ad=0.0816p as=0.0528p pd=1.16u ps=0.68u
    I_MXI62_MN17 (ha19_1 XI62_con VSS VSS) gpdk090_nmos1v w=0.12u l=0.1u ad=0.0696p as=0.0696p pd=1.16u ps=1.16u
    I_MXI62_MN3 (VSS cm8_0 XI62_xbn VSS) gpdk090_nmos1v w=0.12u l=0.1u ad=0.0696p as=0.0696p pd=1.16u ps=1.16u
    I_MXI61_MN5 (ha18_0 cm6_1 XI61_xn1 VSS) gpdk090_nmos1v w=0.24u l=0.1u ad=0.0528p as=0.0816p pd=0.68u ps=1.16u
    I_MXI61_MN7 (XI61_xn2 XI61_xan ha18_0 VSS) gpdk090_nmos1v w=0.24u l=0.1u ad=0.0528p as=0.0528p pd=0.68u ps=0.68u
    I_MXI61_MN8 (VSS XI61_xbn XI61_xn2 VSS) gpdk090_nmos1v w=0.24u l=0.1u ad=0.0528p as=0.0528p pd=0.68u ps=0.68u
    I_MXI61_MN6 (XI61_xn1 cm7_0 VSS VSS) gpdk090_nmos1v w=0.24u l=0.1u ad=0.0816p as=0.0528p pd=1.16u ps=0.68u
    I_MXI61_MN1 (VSS cm6_1 XI61_xan VSS) gpdk090_nmos1v w=0.12u l=0.1u ad=0.0468p as=0.0696p pd=0.68u ps=1.16u
    I_MXI61_MN14 (XI61_an cm7_0 VSS VSS) gpdk090_nmos1v w=0.24u l=0.1u ad=0.0528p as=0.0468p pd=0.68u ps=0.68u
    I_MXI61_MN13 (XI61_con cm6_1 XI61_an VSS) gpdk090_nmos1v w=0.24u l=0.1u ad=0.0816p as=0.0528p pd=1.16u ps=0.68u
    I_MXI61_MN17 (ha18_1 XI61_con VSS VSS) gpdk090_nmos1v w=0.12u l=0.1u ad=0.0696p as=0.0696p pd=1.16u ps=1.16u
    I_MXI61_MN3 (VSS cm7_0 XI61_xbn VSS) gpdk090_nmos1v w=0.12u l=0.1u ad=0.0696p as=0.0696p pd=1.16u ps=1.16u
    I_MXI60_MN5 (ha17_0 cm5_1 XI60_xn1 VSS) gpdk090_nmos1v w=0.24u l=0.1u ad=0.0528p as=0.0816p pd=0.68u ps=1.16u
    I_MXI60_MN7 (XI60_xn2 XI60_xan ha17_0 VSS) gpdk090_nmos1v w=0.24u l=0.1u ad=0.0528p as=0.0528p pd=0.68u ps=0.68u
    I_MXI60_MN8 (VSS XI60_xbn XI60_xn2 VSS) gpdk090_nmos1v w=0.24u l=0.1u ad=0.0528p as=0.0528p pd=0.68u ps=0.68u
    I_MXI60_MN6 (XI60_xn1 cm6_0 VSS VSS) gpdk090_nmos1v w=0.24u l=0.1u ad=0.0816p as=0.0528p pd=1.16u ps=0.68u
    I_MXI60_MN1 (VSS cm5_1 XI60_xan VSS) gpdk090_nmos1v w=0.12u l=0.1u ad=0.0468p as=0.0696p pd=0.68u ps=1.16u
    I_MXI60_MN14 (XI60_an cm6_0 VSS VSS) gpdk090_nmos1v w=0.24u l=0.1u ad=0.0528p as=0.0468p pd=0.68u ps=0.68u
    I_MXI60_MN13 (XI60_con cm5_1 XI60_an VSS) gpdk090_nmos1v w=0.24u l=0.1u ad=0.0816p as=0.0528p pd=1.16u ps=0.68u
    I_MXI60_MN17 (ha17_1 XI60_con VSS VSS) gpdk090_nmos1v w=0.12u l=0.1u ad=0.0696p as=0.0696p pd=1.16u ps=1.16u
    I_MXI60_MN3 (VSS cm6_0 XI60_xbn VSS) gpdk090_nmos1v w=0.12u l=0.1u ad=0.0696p as=0.0696p pd=1.16u ps=1.16u
    I_MXI58_MN5 (ha15_0 fa3_1 XI58_xn1 VSS) gpdk090_nmos1v w=0.24u l=0.1u ad=0.0528p as=0.0816p pd=0.68u ps=1.16u
    I_MXI58_MN7 (XI58_xn2 XI58_xan ha15_0 VSS) gpdk090_nmos1v w=0.24u l=0.1u ad=0.0528p as=0.0528p pd=0.68u ps=0.68u
    I_MXI58_MN8 (VSS XI58_xbn XI58_xn2 VSS) gpdk090_nmos1v w=0.24u l=0.1u ad=0.0528p as=0.0528p pd=0.68u ps=0.68u
    I_MXI58_MN6 (XI58_xn1 fa4_0 VSS VSS) gpdk090_nmos1v w=0.24u l=0.1u ad=0.0816p as=0.0528p pd=1.16u ps=0.68u
    I_MXI58_MN1 (VSS fa3_1 XI58_xan VSS) gpdk090_nmos1v w=0.12u l=0.1u ad=0.0468p as=0.0696p pd=0.68u ps=1.16u
    I_MXI58_MN14 (XI58_an fa4_0 VSS VSS) gpdk090_nmos1v w=0.24u l=0.1u ad=0.0528p as=0.0468p pd=0.68u ps=0.68u
    I_MXI58_MN13 (XI58_con fa3_1 XI58_an VSS) gpdk090_nmos1v w=0.24u l=0.1u ad=0.0816p as=0.0528p pd=1.16u ps=0.68u
    I_MXI58_MN17 (ha15_1 XI58_con VSS VSS) gpdk090_nmos1v w=0.12u l=0.1u ad=0.0696p as=0.0696p pd=1.16u ps=1.16u
    I_MXI58_MN3 (VSS fa4_0 XI58_xbn VSS) gpdk090_nmos1v w=0.12u l=0.1u ad=0.0696p as=0.0696p pd=1.16u ps=1.16u
    I_MXI73_MN5 (P_4 fa14_0 XI73_xn1 VSS) gpdk090_nmos1v w=0.24u l=0.1u ad=0.0528p as=0.0816p pd=0.68u ps=1.16u
    I_MXI73_MN7 (XI73_xn2 XI73_xan P_4 VSS) gpdk090_nmos1v w=0.24u l=0.1u ad=0.0528p as=0.0528p pd=0.68u ps=0.68u
    I_MXI73_MN8 (VSS XI73_xbn XI73_xn2 VSS) gpdk090_nmos1v w=0.24u l=0.1u ad=0.0528p as=0.0528p pd=0.68u ps=0.68u
    I_MXI73_MN6 (XI73_xn1 rc4 VSS VSS) gpdk090_nmos1v w=0.24u l=0.1u ad=0.0816p as=0.0528p pd=1.16u ps=0.68u
    I_MXI73_MN1 (VSS fa14_0 XI73_xan VSS) gpdk090_nmos1v w=0.12u l=0.1u ad=0.0468p as=0.0696p pd=0.68u ps=1.16u
    I_MXI73_MN14 (XI73_an rc4 VSS VSS) gpdk090_nmos1v w=0.24u l=0.1u ad=0.0528p as=0.0468p pd=0.68u ps=0.68u
    I_MXI73_MN13 (XI73_con fa14_0 XI73_an VSS) gpdk090_nmos1v w=0.24u l=0.1u ad=0.0816p as=0.0528p pd=1.16u ps=0.68u
    I_MXI73_MN17 (rc5 XI73_con VSS VSS) gpdk090_nmos1v w=0.12u l=0.1u ad=0.0696p as=0.0696p pd=1.16u ps=1.16u
    I_MXI73_MN3 (VSS rc4 XI73_xbn VSS) gpdk090_nmos1v w=0.12u l=0.1u ad=0.0696p as=0.0696p pd=1.16u ps=1.16u
    I_MXI63_MN5 (ha20_0 cm8_1 XI63_xn1 VSS) gpdk090_nmos1v w=0.24u l=0.1u ad=0.0528p as=0.0816p pd=0.68u ps=1.16u
    I_MXI63_MN7 (XI63_xn2 XI63_xan ha20_0 VSS) gpdk090_nmos1v w=0.24u l=0.1u ad=0.0528p as=0.0528p pd=0.68u ps=0.68u
    I_MXI63_MN8 (VSS XI63_xbn XI63_xn2 VSS) gpdk090_nmos1v w=0.24u l=0.1u ad=0.0528p as=0.0528p pd=0.68u ps=0.68u
    I_MXI63_MN6 (XI63_xn1 cm9_0 VSS VSS) gpdk090_nmos1v w=0.24u l=0.1u ad=0.0816p as=0.0528p pd=1.16u ps=0.68u
    I_MXI63_MN1 (VSS cm8_1 XI63_xan VSS) gpdk090_nmos1v w=0.12u l=0.1u ad=0.0468p as=0.0696p pd=0.68u ps=1.16u
    I_MXI63_MN14 (XI63_an cm9_0 VSS VSS) gpdk090_nmos1v w=0.24u l=0.1u ad=0.0528p as=0.0468p pd=0.68u ps=0.68u
    I_MXI63_MN13 (XI63_con cm8_1 XI63_an VSS) gpdk090_nmos1v w=0.24u l=0.1u ad=0.0816p as=0.0528p pd=1.16u ps=0.68u
    I_MXI63_MN17 (ha20_1 XI63_con VSS VSS) gpdk090_nmos1v w=0.12u l=0.1u ad=0.0696p as=0.0696p pd=1.16u ps=1.16u
    I_MXI63_MN3 (VSS cm9_0 XI63_xbn VSS) gpdk090_nmos1v w=0.12u l=0.1u ad=0.0696p as=0.0696p pd=1.16u ps=1.16u
    I_MXI64_MN5 (ha21_0 cm9_1 XI64_xn1 VSS) gpdk090_nmos1v w=0.24u l=0.1u ad=0.0528p as=0.0816p pd=0.68u ps=1.16u
    I_MXI64_MN7 (XI64_xn2 XI64_xan ha21_0 VSS) gpdk090_nmos1v w=0.24u l=0.1u ad=0.0528p as=0.0528p pd=0.68u ps=0.68u
    I_MXI64_MN8 (VSS XI64_xbn XI64_xn2 VSS) gpdk090_nmos1v w=0.24u l=0.1u ad=0.0528p as=0.0528p pd=0.68u ps=0.68u
    I_MXI64_MN6 (XI64_xn1 cm10_0 VSS VSS) gpdk090_nmos1v w=0.24u l=0.1u ad=0.0816p as=0.0528p pd=1.16u ps=0.68u
    I_MXI64_MN1 (VSS cm9_1 XI64_xan VSS) gpdk090_nmos1v w=0.12u l=0.1u ad=0.0468p as=0.0696p pd=0.68u ps=1.16u
    I_MXI64_MN14 (XI64_an cm10_0 VSS VSS) gpdk090_nmos1v w=0.24u l=0.1u ad=0.0528p as=0.0468p pd=0.68u ps=0.68u
    I_MXI64_MN13 (XI64_con cm9_1 XI64_an VSS) gpdk090_nmos1v w=0.24u l=0.1u ad=0.0816p as=0.0528p pd=1.16u ps=0.68u
    I_MXI64_MN17 (ha21_1 XI64_con VSS VSS) gpdk090_nmos1v w=0.12u l=0.1u ad=0.0696p as=0.0696p pd=1.16u ps=1.16u
    I_MXI64_MN3 (VSS cm10_0 XI64_xbn VSS) gpdk090_nmos1v w=0.12u l=0.1u ad=0.0696p as=0.0696p pd=1.16u ps=1.16u
    I_MXI65_MN5 (ha22_0 cm10_1 XI65_xn1 VSS) gpdk090_nmos1v w=0.24u l=0.1u ad=0.0528p as=0.0816p pd=0.68u ps=1.16u
    I_MXI65_MN7 (XI65_xn2 XI65_xan ha22_0 VSS) gpdk090_nmos1v w=0.24u l=0.1u ad=0.0528p as=0.0528p pd=0.68u ps=0.68u
    I_MXI65_MN8 (VSS XI65_xbn XI65_xn2 VSS) gpdk090_nmos1v w=0.24u l=0.1u ad=0.0528p as=0.0528p pd=0.68u ps=0.68u
    I_MXI65_MN6 (XI65_xn1 cm11_0 VSS VSS) gpdk090_nmos1v w=0.24u l=0.1u ad=0.0816p as=0.0528p pd=1.16u ps=0.68u
    I_MXI65_MN1 (VSS cm10_1 XI65_xan VSS) gpdk090_nmos1v w=0.12u l=0.1u ad=0.0468p as=0.0696p pd=0.68u ps=1.16u
    I_MXI65_MN14 (XI65_an cm11_0 VSS VSS) gpdk090_nmos1v w=0.24u l=0.1u ad=0.0528p as=0.0468p pd=0.68u ps=0.68u
    I_MXI65_MN13 (XI65_con cm10_1 XI65_an VSS) gpdk090_nmos1v w=0.24u l=0.1u ad=0.0816p as=0.0528p pd=1.16u ps=0.68u
    I_MXI65_MN17 (ha22_1 XI65_con VSS VSS) gpdk090_nmos1v w=0.12u l=0.1u ad=0.0696p as=0.0696p pd=1.16u ps=1.16u
    I_MXI65_MN3 (VSS cm11_0 XI65_xbn VSS) gpdk090_nmos1v w=0.12u l=0.1u ad=0.0696p as=0.0696p pd=1.16u ps=1.16u
    I_MXI45_MN5 (ha2_0 pp0_3 XI45_xn1 VSS) gpdk090_nmos1v w=0.24u l=0.1u ad=0.0528p as=0.0816p pd=0.68u ps=1.16u
    I_MXI45_MN7 (XI45_xn2 XI45_xan ha2_0 VSS) gpdk090_nmos1v w=0.24u l=0.1u ad=0.0528p as=0.0528p pd=0.68u ps=0.68u
    I_MXI45_MN8 (VSS XI45_xbn XI45_xn2 VSS) gpdk090_nmos1v w=0.24u l=0.1u ad=0.0528p as=0.0528p pd=0.68u ps=0.68u
    I_MXI45_MN6 (XI45_xn1 pp1_1 VSS VSS) gpdk090_nmos1v w=0.24u l=0.1u ad=0.0816p as=0.0528p pd=1.16u ps=0.68u
    I_MXI45_MN1 (VSS pp0_3 XI45_xan VSS) gpdk090_nmos1v w=0.12u l=0.1u ad=0.0468p as=0.0696p pd=0.68u ps=1.16u
    I_MXI45_MN14 (XI45_an pp1_1 VSS VSS) gpdk090_nmos1v w=0.24u l=0.1u ad=0.0528p as=0.0468p pd=0.68u ps=0.68u
    I_MXI45_MN13 (XI45_con pp0_3 XI45_an VSS) gpdk090_nmos1v w=0.24u l=0.1u ad=0.0816p as=0.0528p pd=1.16u ps=0.68u
    I_MXI45_MN17 (ha2_1 XI45_con VSS VSS) gpdk090_nmos1v w=0.12u l=0.1u ad=0.0696p as=0.0696p pd=1.16u ps=1.16u
    I_MXI45_MN3 (VSS pp1_1 XI45_xbn VSS) gpdk090_nmos1v w=0.12u l=0.1u ad=0.0696p as=0.0696p pd=1.16u ps=1.16u
    I_MXI66_MN5 (ha23_0 cm11_1 XI66_xn1 VSS) gpdk090_nmos1v w=0.24u l=0.1u ad=0.0528p as=0.0816p pd=0.68u ps=1.16u
    I_MXI66_MN7 (XI66_xn2 XI66_xan ha23_0 VSS) gpdk090_nmos1v w=0.24u l=0.1u ad=0.0528p as=0.0528p pd=0.68u ps=0.68u
    I_MXI66_MN8 (VSS XI66_xbn XI66_xn2 VSS) gpdk090_nmos1v w=0.24u l=0.1u ad=0.0528p as=0.0528p pd=0.68u ps=0.68u
    I_MXI66_MN6 (XI66_xn1 fa12_0 VSS VSS) gpdk090_nmos1v w=0.24u l=0.1u ad=0.0816p as=0.0528p pd=1.16u ps=0.68u
    I_MXI66_MN1 (VSS cm11_1 XI66_xan VSS) gpdk090_nmos1v w=0.12u l=0.1u ad=0.0468p as=0.0696p pd=0.68u ps=1.16u
    I_MXI66_MN14 (XI66_an fa12_0 VSS VSS) gpdk090_nmos1v w=0.24u l=0.1u ad=0.0528p as=0.0468p pd=0.68u ps=0.68u
    I_MXI66_MN13 (XI66_con cm11_1 XI66_an VSS) gpdk090_nmos1v w=0.24u l=0.1u ad=0.0816p as=0.0528p pd=1.16u ps=0.68u
    I_MXI66_MN17 (ha23_1 XI66_con VSS VSS) gpdk090_nmos1v w=0.12u l=0.1u ad=0.0696p as=0.0696p pd=1.16u ps=1.16u
    I_MXI66_MN3 (VSS fa12_0 XI66_xbn VSS) gpdk090_nmos1v w=0.12u l=0.1u ad=0.0696p as=0.0696p pd=1.16u ps=1.16u
    I_MXI67_MN5 (ha24_0 fa12_1 XI67_xn1 VSS) gpdk090_nmos1v w=0.24u l=0.1u ad=0.0528p as=0.0816p pd=0.68u ps=1.16u
    I_MXI67_MN7 (XI67_xn2 XI67_xan ha24_0 VSS) gpdk090_nmos1v w=0.24u l=0.1u ad=0.0528p as=0.0528p pd=0.68u ps=0.68u
    I_MXI67_MN8 (VSS XI67_xbn XI67_xn2 VSS) gpdk090_nmos1v w=0.24u l=0.1u ad=0.0528p as=0.0528p pd=0.68u ps=0.68u
    I_MXI67_MN6 (XI67_xn1 ha13_0 VSS VSS) gpdk090_nmos1v w=0.24u l=0.1u ad=0.0816p as=0.0528p pd=1.16u ps=0.68u
    I_MXI67_MN1 (VSS fa12_1 XI67_xan VSS) gpdk090_nmos1v w=0.12u l=0.1u ad=0.0468p as=0.0696p pd=0.68u ps=1.16u
    I_MXI67_MN14 (XI67_an ha13_0 VSS VSS) gpdk090_nmos1v w=0.24u l=0.1u ad=0.0528p as=0.0468p pd=0.68u ps=0.68u
    I_MXI67_MN13 (XI67_con fa12_1 XI67_an VSS) gpdk090_nmos1v w=0.24u l=0.1u ad=0.0816p as=0.0528p pd=1.16u ps=0.68u
    I_MXI67_MN17 (ha24_1 XI67_con VSS VSS) gpdk090_nmos1v w=0.12u l=0.1u ad=0.0696p as=0.0696p pd=1.16u ps=1.16u
    I_MXI67_MN3 (VSS ha13_0 XI67_xbn VSS) gpdk090_nmos1v w=0.12u l=0.1u ad=0.0696p as=0.0696p pd=1.16u ps=1.16u
    I_MXI71_MN5 (P_2 fa1_0 XI71_xn1 VSS) gpdk090_nmos1v w=0.24u l=0.1u ad=0.0528p as=0.0816p pd=0.68u ps=1.16u
    I_MXI71_MN7 (XI71_xn2 XI71_xan P_2 VSS) gpdk090_nmos1v w=0.24u l=0.1u ad=0.0528p as=0.0528p pd=0.68u ps=0.68u
    I_MXI71_MN8 (VSS XI71_xbn XI71_xn2 VSS) gpdk090_nmos1v w=0.24u l=0.1u ad=0.0528p as=0.0528p pd=0.68u ps=0.68u
    I_MXI71_MN6 (XI71_xn1 rc2 VSS VSS) gpdk090_nmos1v w=0.24u l=0.1u ad=0.0816p as=0.0528p pd=1.16u ps=0.68u
    I_MXI71_MN1 (VSS fa1_0 XI71_xan VSS) gpdk090_nmos1v w=0.12u l=0.1u ad=0.0468p as=0.0696p pd=0.68u ps=1.16u
    I_MXI71_MN14 (XI71_an rc2 VSS VSS) gpdk090_nmos1v w=0.24u l=0.1u ad=0.0528p as=0.0468p pd=0.68u ps=0.68u
    I_MXI71_MN13 (XI71_con fa1_0 XI71_an VSS) gpdk090_nmos1v w=0.24u l=0.1u ad=0.0816p as=0.0528p pd=1.16u ps=0.68u
    I_MXI71_MN17 (rc3 XI71_con VSS VSS) gpdk090_nmos1v w=0.12u l=0.1u ad=0.0696p as=0.0696p pd=1.16u ps=1.16u
    I_MXI71_MN3 (VSS rc2 XI71_xbn VSS) gpdk090_nmos1v w=0.12u l=0.1u ad=0.0696p as=0.0696p pd=1.16u ps=1.16u
    I_MXI68_MN5 (ha25_0 ha13_1 XI68_xn1 VSS) gpdk090_nmos1v w=0.24u l=0.1u ad=0.0528p as=0.0816p pd=0.68u ps=1.16u
    I_MXI68_MN7 (XI68_xn2 XI68_xan ha25_0 VSS) gpdk090_nmos1v w=0.24u l=0.1u ad=0.0528p as=0.0528p pd=0.68u ps=0.68u
    I_MXI68_MN8 (VSS XI68_xbn XI68_xn2 VSS) gpdk090_nmos1v w=0.24u l=0.1u ad=0.0528p as=0.0528p pd=0.68u ps=0.68u
    I_MXI68_MN6 (XI68_xn1 sn3 VSS VSS) gpdk090_nmos1v w=0.24u l=0.1u ad=0.0816p as=0.0528p pd=1.16u ps=0.68u
    I_MXI68_MN1 (VSS ha13_1 XI68_xan VSS) gpdk090_nmos1v w=0.12u l=0.1u ad=0.0468p as=0.0696p pd=0.68u ps=1.16u
    I_MXI68_MN14 (XI68_an sn3 VSS VSS) gpdk090_nmos1v w=0.24u l=0.1u ad=0.0528p as=0.0468p pd=0.68u ps=0.68u
    I_MXI68_MN13 (XI68_con ha13_1 XI68_an VSS) gpdk090_nmos1v w=0.24u l=0.1u ad=0.0816p as=0.0528p pd=1.16u ps=0.68u
    I_MXI68_MN17 (ha25_1 XI68_con VSS VSS) gpdk090_nmos1v w=0.12u l=0.1u ad=0.0696p as=0.0696p pd=1.16u ps=1.16u
    I_MXI68_MN3 (VSS sn3 XI68_xbn VSS) gpdk090_nmos1v w=0.12u l=0.1u ad=0.0696p as=0.0696p pd=1.16u ps=1.16u
    I_MXI70_MN5 (P_1 pp0_1 XI70_xn1 VSS) gpdk090_nmos1v w=0.24u l=0.1u ad=0.0528p as=0.0816p pd=0.68u ps=1.16u
    I_MXI70_MN7 (XI70_xn2 XI70_xan P_1 VSS) gpdk090_nmos1v w=0.24u l=0.1u ad=0.0528p as=0.0528p pd=0.68u ps=0.68u
    I_MXI70_MN8 (VSS XI70_xbn XI70_xn2 VSS) gpdk090_nmos1v w=0.24u l=0.1u ad=0.0528p as=0.0528p pd=0.68u ps=0.68u
    I_MXI70_MN6 (XI70_xn1 rc1 VSS VSS) gpdk090_nmos1v w=0.24u l=0.1u ad=0.0816p as=0.0528p pd=1.16u ps=0.68u
    I_MXI70_MN1 (VSS pp0_1 XI70_xan VSS) gpdk090_nmos1v w=0.12u l=0.1u ad=0.0468p as=0.0696p pd=0.68u ps=1.16u
    I_MXI70_MN14 (XI70_an rc1 VSS VSS) gpdk090_nmos1v w=0.24u l=0.1u ad=0.0528p as=0.0468p pd=0.68u ps=0.68u
    I_MXI70_MN13 (XI70_con pp0_1 XI70_an VSS) gpdk090_nmos1v w=0.24u l=0.1u ad=0.0816p as=0.0528p pd=1.16u ps=0.68u
    I_MXI70_MN17 (rc2 XI70_con VSS VSS) gpdk090_nmos1v w=0.12u l=0.1u ad=0.0696p as=0.0696p pd=1.16u ps=1.16u
    I_MXI70_MN3 (VSS rc1 XI70_xbn VSS) gpdk090_nmos1v w=0.12u l=0.1u ad=0.0696p as=0.0696p pd=1.16u ps=1.16u
    I_MXI56_MN5 (ha13_0 VDD XI56_xn1 VSS) gpdk090_nmos1v w=0.24u l=0.1u ad=0.0528p as=0.0816p pd=0.68u ps=1.16u
    I_MXI56_MN7 (XI56_xn2 XI56_xan ha13_0 VSS) gpdk090_nmos1v w=0.24u l=0.1u ad=0.0528p as=0.0528p pd=0.68u ps=0.68u
    I_MXI56_MN8 (VSS XI56_xbn XI56_xn2 VSS) gpdk090_nmos1v w=0.24u l=0.1u ad=0.0528p as=0.0528p pd=0.68u ps=0.68u
    I_MXI56_MN6 (XI56_xn1 pp3_8 VSS VSS) gpdk090_nmos1v w=0.24u l=0.1u ad=0.0816p as=0.0528p pd=1.16u ps=0.68u
    I_MXI56_MN1 (VSS VDD XI56_xan VSS) gpdk090_nmos1v w=0.12u l=0.1u ad=0.0468p as=0.0696p pd=0.68u ps=1.16u
    I_MXI56_MN14 (XI56_an pp3_8 VSS VSS) gpdk090_nmos1v w=0.24u l=0.1u ad=0.0528p as=0.0468p pd=0.68u ps=0.68u
    I_MXI56_MN13 (XI56_con VDD XI56_an VSS) gpdk090_nmos1v w=0.24u l=0.1u ad=0.0816p as=0.0528p pd=1.16u ps=0.68u
    I_MXI56_MN17 (ha13_1 XI56_con VSS VSS) gpdk090_nmos1v w=0.12u l=0.1u ad=0.0696p as=0.0696p pd=1.16u ps=1.16u
    I_MXI56_MN3 (VSS pp3_8 XI56_xbn VSS) gpdk090_nmos1v w=0.12u l=0.1u ad=0.0696p as=0.0696p pd=1.16u ps=1.16u
    I_MXI69_MN5 (P_0 pp0_0 XI69_xn1 VSS) gpdk090_nmos1v w=0.24u l=0.1u ad=0.0528p as=0.0816p pd=0.68u ps=1.16u
    I_MXI69_MN7 (XI69_xn2 XI69_xan P_0 VSS) gpdk090_nmos1v w=0.24u l=0.1u ad=0.0528p as=0.0528p pd=0.68u ps=0.68u
    I_MXI69_MN8 (VSS XI69_xbn XI69_xn2 VSS) gpdk090_nmos1v w=0.24u l=0.1u ad=0.0528p as=0.0528p pd=0.68u ps=0.68u
    I_MXI69_MN6 (XI69_xn1 B_1 VSS VSS) gpdk090_nmos1v w=0.24u l=0.1u ad=0.0816p as=0.0528p pd=1.16u ps=0.68u
    I_MXI69_MN1 (VSS pp0_0 XI69_xan VSS) gpdk090_nmos1v w=0.12u l=0.1u ad=0.0468p as=0.0696p pd=0.68u ps=1.16u
    I_MXI69_MN14 (XI69_an B_1 VSS VSS) gpdk090_nmos1v w=0.24u l=0.1u ad=0.0528p as=0.0468p pd=0.68u ps=0.68u
    I_MXI69_MN13 (XI69_con pp0_0 XI69_an VSS) gpdk090_nmos1v w=0.24u l=0.1u ad=0.0816p as=0.0528p pd=1.16u ps=0.68u
    I_MXI69_MN17 (rc1 XI69_con VSS VSS) gpdk090_nmos1v w=0.12u l=0.1u ad=0.0696p as=0.0696p pd=1.16u ps=1.16u
    I_MXI69_MN3 (VSS B_1 XI69_xbn VSS) gpdk090_nmos1v w=0.12u l=0.1u ad=0.0696p as=0.0696p pd=1.16u ps=1.16u
    I_MXI77_I27_XG_MN2 (I77_G3_0n I77_G3_2 VSS VSS) gpdk090_nmos1v w=0.12u l=0.1u ad=0.0468p as=0.0696p pd=0.68u ps=1.16u
    I_MXI77_I27_XG_MN0 (XI77_I27_XG_n1 I77_P3_2 I77_G3_0n VSS) gpdk090_nmos1v w=0.24u l=0.1u ad=0.0528p as=0.0468p pd=0.68u ps=0.68u
    I_MXI77_I27_XG_MN1 (VSS I77_G1_0 XI77_I27_XG_n1 VSS) gpdk090_nmos1v w=0.24u l=0.1u ad=0.0816p as=0.0528p pd=1.16u ps=0.68u
    I_MXI77_I28_XG_MN2 (I77_G4_1n I77_G4_3 VSS VSS) gpdk090_nmos1v w=0.12u l=0.1u ad=0.0468p as=0.0696p pd=0.68u ps=1.16u
    I_MXI77_I28_XG_MN0 (XI77_I28_XG_n1 I77_P4_3 I77_G4_1n VSS) gpdk090_nmos1v w=0.24u l=0.1u ad=0.0528p as=0.0468p pd=0.68u ps=0.68u
    I_MXI77_I28_XG_MN1 (VSS I77_G2_1 XI77_I28_XG_n1 VSS) gpdk090_nmos1v w=0.24u l=0.1u ad=0.0816p as=0.0528p pd=1.16u ps=0.68u
    I_MXI77_I26_XG_MN2 (I77_G2_0n I77_G2_1 VSS VSS) gpdk090_nmos1v w=0.12u l=0.1u ad=0.0468p as=0.0696p pd=0.68u ps=1.16u
    I_MXI77_I26_XG_MN0 (XI77_I26_XG_n1 I77_P2_1 I77_G2_0n VSS) gpdk090_nmos1v w=0.24u l=0.1u ad=0.0528p as=0.0468p pd=0.68u ps=0.68u
    I_MXI77_I26_XG_MN1 (VSS I77_G0_0 XI77_I26_XG_n1 VSS) gpdk090_nmos1v w=0.24u l=0.1u ad=0.0816p as=0.0528p pd=1.16u ps=0.68u
    I_MXI77_I29_XG_MN2 (I77_G5_2n I77_G5_4 VSS VSS) gpdk090_nmos1v w=0.12u l=0.1u ad=0.0468p as=0.0696p pd=0.68u ps=1.16u
    I_MXI77_I29_XG_MN0 (XI77_I29_XG_n1 I77_P5_4 I77_G5_2n VSS) gpdk090_nmos1v w=0.24u l=0.1u ad=0.0528p as=0.0468p pd=0.68u ps=0.68u
    I_MXI77_I29_XG_MN1 (VSS I77_G3_2 XI77_I29_XG_n1 VSS) gpdk090_nmos1v w=0.24u l=0.1u ad=0.0816p as=0.0528p pd=1.16u ps=0.68u
    I_MXI77_I30_XG_MN2 (I77_G6_3n I77_G6_5 VSS VSS) gpdk090_nmos1v w=0.12u l=0.1u ad=0.0468p as=0.0696p pd=0.68u ps=1.16u
    I_MXI77_I30_XG_MN0 (XI77_I30_XG_n1 I77_P6_5 I77_G6_3n VSS) gpdk090_nmos1v w=0.24u l=0.1u ad=0.0528p as=0.0468p pd=0.68u ps=0.68u
    I_MXI77_I30_XG_MN1 (VSS I77_G4_3 XI77_I30_XG_n1 VSS) gpdk090_nmos1v w=0.24u l=0.1u ad=0.0816p as=0.0528p pd=1.16u ps=0.68u
    I_MXI77_I31_XG_MN2 (I77_G7_4n I77_G7_6 VSS VSS) gpdk090_nmos1v w=0.12u l=0.1u ad=0.0468p as=0.0696p pd=0.68u ps=1.16u
    I_MXI77_I31_XG_MN0 (XI77_I31_XG_n1 I77_P7_6 I77_G7_4n VSS) gpdk090_nmos1v w=0.24u l=0.1u ad=0.0528p as=0.0468p pd=0.68u ps=0.68u
    I_MXI77_I31_XG_MN1 (VSS I77_G5_4 XI77_I31_XG_n1 VSS) gpdk090_nmos1v w=0.24u l=0.1u ad=0.0816p as=0.0528p pd=1.16u ps=0.68u
    I_MXI75_MN12 (XI75_sn rc6 XI75_n5 VSS) gpdk090_nmos1v w=0.18u l=0.1u ad=0.0756p as=0.0468p pd=1.16u ps=0.68u
    I_MXI75_MN25 (P_6 XI75_sn VSS VSS) gpdk090_nmos1v w=0.12u l=0.1u ad=0.0696p as=0.0696p pd=1.16u ps=1.16u
    I_MXI75_MN5 (XI75_con rc6 XI75_n2 VSS) gpdk090_nmos1v w=0.24u l=0.1u ad=0.0528p as=0.0816p pd=0.68u ps=1.16u
    I_MXI75_MN2 (XI75_n1 ha16_0 XI75_con VSS) gpdk090_nmos1v w=0.24u l=0.1u ad=0.0528p as=0.0528p pd=0.68u ps=0.68u
    I_MXI75_MN1 (VSS ha15_1 XI75_n1 VSS) gpdk090_nmos1v w=0.24u l=0.1u ad=0.0528p as=0.0528p pd=0.68u ps=0.68u
    I_MXI75_MN3 (XI75_n2 ha15_1 VSS VSS) gpdk090_nmos1v w=0.24u l=0.1u ad=0.0528p as=0.0528p pd=0.68u ps=0.68u
    I_MXI75_MN4 (VSS ha16_0 XI75_n2 VSS) gpdk090_nmos1v w=0.24u l=0.1u ad=0.0468p as=0.0528p pd=0.68u ps=0.68u
    I_MXI75_MN27 (rc7 XI75_con VSS VSS) gpdk090_nmos1v w=0.12u l=0.1u ad=0.0696p as=0.0468p pd=1.16u ps=0.68u
    I_MXI75_MN10 (XI75_n4 ha15_1 VSS VSS) gpdk090_nmos1v w=0.18u l=0.1u ad=0.0468p as=0.0756p pd=0.68u ps=1.16u
    I_MXI75_MN11 (XI75_n5 ha16_0 XI75_n4 VSS) gpdk090_nmos1v w=0.18u l=0.1u ad=0.0468p as=0.0468p pd=0.68u ps=0.68u
    I_MXI75_MN11_1 (XI75_n4 ha16_0 XI75_n5 VSS) gpdk090_nmos1v w=0.18u l=0.1u ad=0.0468p as=0.0468p pd=0.68u ps=0.68u
    I_MXI75_MN10_1 (VSS ha15_1 XI75_n4 VSS) gpdk090_nmos1v w=0.18u l=0.1u ad=0.0498p as=0.0468p pd=0.68u ps=0.68u
    I_MXI75_MN6 (XI75_n3 ha15_1 VSS VSS) gpdk090_nmos1v w=0.24u l=0.1u ad=0.0528p as=0.0498p pd=0.68u ps=0.68u
    I_MXI75_MN7 (VSS ha16_0 XI75_n3 VSS) gpdk090_nmos1v w=0.24u l=0.1u ad=0.1176p as=0.0528p pd=1.22u ps=0.68u
    I_MXI75_MN8 (XI75_n3 rc6 VSS VSS) gpdk090_nmos1v w=0.24u l=0.1u ad=0.0528p as=0.1176p pd=0.68u ps=1.22u
    I_MXI75_MN9 (XI75_sn XI75_con XI75_n3 VSS) gpdk090_nmos1v w=0.24u l=0.1u ad=0.0498p as=0.0528p pd=0.68u ps=0.68u
    I_MXI75_MN12_1 (XI75_n5 rc6 XI75_sn VSS) gpdk090_nmos1v w=0.18u l=0.1u ad=0.0468p as=0.0498p pd=0.68u ps=0.68u
    I_MXI74_MN12 (XI74_sn rc5 XI74_n5 VSS) gpdk090_nmos1v w=0.18u l=0.1u ad=0.0756p as=0.0468p pd=1.16u ps=0.68u
    I_MXI74_MN25 (P_5 XI74_sn VSS VSS) gpdk090_nmos1v w=0.12u l=0.1u ad=0.0696p as=0.0696p pd=1.16u ps=1.16u
    I_MXI74_MN5 (XI74_con rc5 XI74_n2 VSS) gpdk090_nmos1v w=0.24u l=0.1u ad=0.0528p as=0.0816p pd=0.68u ps=1.16u
    I_MXI74_MN2 (XI74_n1 ha15_0 XI74_con VSS) gpdk090_nmos1v w=0.24u l=0.1u ad=0.0528p as=0.0528p pd=0.68u ps=0.68u
    I_MXI74_MN1 (VSS fa14_1 XI74_n1 VSS) gpdk090_nmos1v w=0.24u l=0.1u ad=0.0528p as=0.0528p pd=0.68u ps=0.68u
    I_MXI74_MN3 (XI74_n2 fa14_1 VSS VSS) gpdk090_nmos1v w=0.24u l=0.1u ad=0.0528p as=0.0528p pd=0.68u ps=0.68u
    I_MXI74_MN4 (VSS ha15_0 XI74_n2 VSS) gpdk090_nmos1v w=0.24u l=0.1u ad=0.0468p as=0.0528p pd=0.68u ps=0.68u
    I_MXI74_MN27 (rc6 XI74_con VSS VSS) gpdk090_nmos1v w=0.12u l=0.1u ad=0.0696p as=0.0468p pd=1.16u ps=0.68u
    I_MXI74_MN10 (XI74_n4 fa14_1 VSS VSS) gpdk090_nmos1v w=0.18u l=0.1u ad=0.0468p as=0.0756p pd=0.68u ps=1.16u
    I_MXI74_MN11 (XI74_n5 ha15_0 XI74_n4 VSS) gpdk090_nmos1v w=0.18u l=0.1u ad=0.0468p as=0.0468p pd=0.68u ps=0.68u
    I_MXI74_MN11_1 (XI74_n4 ha15_0 XI74_n5 VSS) gpdk090_nmos1v w=0.18u l=0.1u ad=0.0468p as=0.0468p pd=0.68u ps=0.68u
    I_MXI74_MN10_1 (VSS fa14_1 XI74_n4 VSS) gpdk090_nmos1v w=0.18u l=0.1u ad=0.0498p as=0.0468p pd=0.68u ps=0.68u
    I_MXI74_MN6 (XI74_n3 fa14_1 VSS VSS) gpdk090_nmos1v w=0.24u l=0.1u ad=0.0528p as=0.0498p pd=0.68u ps=0.68u
    I_MXI74_MN7 (VSS ha15_0 XI74_n3 VSS) gpdk090_nmos1v w=0.24u l=0.1u ad=0.1176p as=0.0528p pd=1.22u ps=0.68u
    I_MXI74_MN8 (XI74_n3 rc5 VSS VSS) gpdk090_nmos1v w=0.24u l=0.1u ad=0.0528p as=0.1176p pd=0.68u ps=1.22u
    I_MXI74_MN9 (XI74_sn XI74_con XI74_n3 VSS) gpdk090_nmos1v w=0.24u l=0.1u ad=0.0498p as=0.0528p pd=0.68u ps=0.68u
    I_MXI74_MN12_1 (XI74_n5 rc5 XI74_sn VSS) gpdk090_nmos1v w=0.18u l=0.1u ad=0.0468p as=0.0498p pd=0.68u ps=0.68u
    I_MXI76_MN12 (XI76_sn rc7 XI76_n5 VSS) gpdk090_nmos1v w=0.18u l=0.1u ad=0.0756p as=0.0468p pd=1.16u ps=0.68u
    I_MXI76_MN25 (P_7 XI76_sn VSS VSS) gpdk090_nmos1v w=0.12u l=0.1u ad=0.0696p as=0.0696p pd=1.16u ps=1.16u
    I_MXI76_MN5 (XI76_con rc7 XI76_n2 VSS) gpdk090_nmos1v w=0.24u l=0.1u ad=0.0528p as=0.0816p pd=0.68u ps=1.16u
    I_MXI76_MN2 (XI76_n1 ha17_0 XI76_con VSS) gpdk090_nmos1v w=0.24u l=0.1u ad=0.0528p as=0.0528p pd=0.68u ps=0.68u
    I_MXI76_MN1 (VSS ha16_1 XI76_n1 VSS) gpdk090_nmos1v w=0.24u l=0.1u ad=0.0528p as=0.0528p pd=0.68u ps=0.68u
    I_MXI76_MN3 (XI76_n2 ha16_1 VSS VSS) gpdk090_nmos1v w=0.24u l=0.1u ad=0.0528p as=0.0528p pd=0.68u ps=0.68u
    I_MXI76_MN4 (VSS ha17_0 XI76_n2 VSS) gpdk090_nmos1v w=0.24u l=0.1u ad=0.0468p as=0.0528p pd=0.68u ps=0.68u
    I_MXI76_MN27 (rc8 XI76_con VSS VSS) gpdk090_nmos1v w=0.12u l=0.1u ad=0.0696p as=0.0468p pd=1.16u ps=0.68u
    I_MXI76_MN10 (XI76_n4 ha16_1 VSS VSS) gpdk090_nmos1v w=0.18u l=0.1u ad=0.0468p as=0.0756p pd=0.68u ps=1.16u
    I_MXI76_MN11 (XI76_n5 ha17_0 XI76_n4 VSS) gpdk090_nmos1v w=0.18u l=0.1u ad=0.0468p as=0.0468p pd=0.68u ps=0.68u
    I_MXI76_MN11_1 (XI76_n4 ha17_0 XI76_n5 VSS) gpdk090_nmos1v w=0.18u l=0.1u ad=0.0468p as=0.0468p pd=0.68u ps=0.68u
    I_MXI76_MN10_1 (VSS ha16_1 XI76_n4 VSS) gpdk090_nmos1v w=0.18u l=0.1u ad=0.0498p as=0.0468p pd=0.68u ps=0.68u
    I_MXI76_MN6 (XI76_n3 ha16_1 VSS VSS) gpdk090_nmos1v w=0.24u l=0.1u ad=0.0528p as=0.0498p pd=0.68u ps=0.68u
    I_MXI76_MN7 (VSS ha17_0 XI76_n3 VSS) gpdk090_nmos1v w=0.24u l=0.1u ad=0.1176p as=0.0528p pd=1.22u ps=0.68u
    I_MXI76_MN8 (XI76_n3 rc7 VSS VSS) gpdk090_nmos1v w=0.24u l=0.1u ad=0.0528p as=0.1176p pd=0.68u ps=1.22u
    I_MXI76_MN9 (XI76_sn XI76_con XI76_n3 VSS) gpdk090_nmos1v w=0.24u l=0.1u ad=0.0498p as=0.0528p pd=0.68u ps=0.68u
    I_MXI76_MN12_1 (XI76_n5 rc7 XI76_sn VSS) gpdk090_nmos1v w=0.18u l=0.1u ad=0.0468p as=0.0498p pd=0.68u ps=0.68u
    I_MXI47_MN12 (XI47_sn pp2_1 XI47_n5 VSS) gpdk090_nmos1v w=0.18u l=0.1u ad=0.0756p as=0.0468p pd=1.16u ps=0.68u
    I_MXI47_MN25 (fa4_0 XI47_sn VSS VSS) gpdk090_nmos1v w=0.12u l=0.1u ad=0.0696p as=0.0696p pd=1.16u ps=1.16u
    I_MXI47_MN5 (XI47_con pp2_1 XI47_n2 VSS) gpdk090_nmos1v w=0.24u l=0.1u ad=0.0528p as=0.0816p pd=0.68u ps=1.16u
    I_MXI47_MN2 (XI47_n1 pp1_3 XI47_con VSS) gpdk090_nmos1v w=0.24u l=0.1u ad=0.0528p as=0.0528p pd=0.68u ps=0.68u
    I_MXI47_MN1 (VSS pp0_5 XI47_n1 VSS) gpdk090_nmos1v w=0.24u l=0.1u ad=0.0528p as=0.0528p pd=0.68u ps=0.68u
    I_MXI47_MN3 (XI47_n2 pp0_5 VSS VSS) gpdk090_nmos1v w=0.24u l=0.1u ad=0.0528p as=0.0528p pd=0.68u ps=0.68u
    I_MXI47_MN4 (VSS pp1_3 XI47_n2 VSS) gpdk090_nmos1v w=0.24u l=0.1u ad=0.0468p as=0.0528p pd=0.68u ps=0.68u
    I_MXI47_MN27 (fa4_1 XI47_con VSS VSS) gpdk090_nmos1v w=0.12u l=0.1u ad=0.0696p as=0.0468p pd=1.16u ps=0.68u
    I_MXI47_MN10 (XI47_n4 pp0_5 VSS VSS) gpdk090_nmos1v w=0.18u l=0.1u ad=0.0468p as=0.0756p pd=0.68u ps=1.16u
    I_MXI47_MN11 (XI47_n5 pp1_3 XI47_n4 VSS) gpdk090_nmos1v w=0.18u l=0.1u ad=0.0468p as=0.0468p pd=0.68u ps=0.68u
    I_MXI47_MN11_1 (XI47_n4 pp1_3 XI47_n5 VSS) gpdk090_nmos1v w=0.18u l=0.1u ad=0.0468p as=0.0468p pd=0.68u ps=0.68u
    I_MXI47_MN10_1 (VSS pp0_5 XI47_n4 VSS) gpdk090_nmos1v w=0.18u l=0.1u ad=0.0498p as=0.0468p pd=0.68u ps=0.68u
    I_MXI47_MN6 (XI47_n3 pp0_5 VSS VSS) gpdk090_nmos1v w=0.24u l=0.1u ad=0.0528p as=0.0498p pd=0.68u ps=0.68u
    I_MXI47_MN7 (VSS pp1_3 XI47_n3 VSS) gpdk090_nmos1v w=0.24u l=0.1u ad=0.1176p as=0.0528p pd=1.22u ps=0.68u
    I_MXI47_MN8 (XI47_n3 pp2_1 VSS VSS) gpdk090_nmos1v w=0.24u l=0.1u ad=0.0528p as=0.1176p pd=0.68u ps=1.22u
    I_MXI47_MN9 (XI47_sn XI47_con XI47_n3 VSS) gpdk090_nmos1v w=0.24u l=0.1u ad=0.0498p as=0.0528p pd=0.68u ps=0.68u
    I_MXI47_MN12_1 (XI47_n5 pp2_1 XI47_sn VSS) gpdk090_nmos1v w=0.18u l=0.1u ad=0.0468p as=0.0498p pd=0.68u ps=0.68u
    I_MXI46_MN12 (XI46_sn pp2_0 XI46_n5 VSS) gpdk090_nmos1v w=0.18u l=0.1u ad=0.0756p as=0.0468p pd=1.16u ps=0.68u
    I_MXI46_MN25 (fa3_0 XI46_sn VSS VSS) gpdk090_nmos1v w=0.12u l=0.1u ad=0.0696p as=0.0696p pd=1.16u ps=1.16u
    I_MXI46_MN5 (XI46_con pp2_0 XI46_n2 VSS) gpdk090_nmos1v w=0.24u l=0.1u ad=0.0528p as=0.0816p pd=0.68u ps=1.16u
    I_MXI46_MN2 (XI46_n1 pp1_2 XI46_con VSS) gpdk090_nmos1v w=0.24u l=0.1u ad=0.0528p as=0.0528p pd=0.68u ps=0.68u
    I_MXI46_MN1 (VSS pp0_4 XI46_n1 VSS) gpdk090_nmos1v w=0.24u l=0.1u ad=0.0528p as=0.0528p pd=0.68u ps=0.68u
    I_MXI46_MN3 (XI46_n2 pp0_4 VSS VSS) gpdk090_nmos1v w=0.24u l=0.1u ad=0.0528p as=0.0528p pd=0.68u ps=0.68u
    I_MXI46_MN4 (VSS pp1_2 XI46_n2 VSS) gpdk090_nmos1v w=0.24u l=0.1u ad=0.0468p as=0.0528p pd=0.68u ps=0.68u
    I_MXI46_MN27 (fa3_1 XI46_con VSS VSS) gpdk090_nmos1v w=0.12u l=0.1u ad=0.0696p as=0.0468p pd=1.16u ps=0.68u
    I_MXI46_MN10 (XI46_n4 pp0_4 VSS VSS) gpdk090_nmos1v w=0.18u l=0.1u ad=0.0468p as=0.0756p pd=0.68u ps=1.16u
    I_MXI46_MN11 (XI46_n5 pp1_2 XI46_n4 VSS) gpdk090_nmos1v w=0.18u l=0.1u ad=0.0468p as=0.0468p pd=0.68u ps=0.68u
    I_MXI46_MN11_1 (XI46_n4 pp1_2 XI46_n5 VSS) gpdk090_nmos1v w=0.18u l=0.1u ad=0.0468p as=0.0468p pd=0.68u ps=0.68u
    I_MXI46_MN10_1 (VSS pp0_4 XI46_n4 VSS) gpdk090_nmos1v w=0.18u l=0.1u ad=0.0498p as=0.0468p pd=0.68u ps=0.68u
    I_MXI46_MN6 (XI46_n3 pp0_4 VSS VSS) gpdk090_nmos1v w=0.24u l=0.1u ad=0.0528p as=0.0498p pd=0.68u ps=0.68u
    I_MXI46_MN7 (VSS pp1_2 XI46_n3 VSS) gpdk090_nmos1v w=0.24u l=0.1u ad=0.1176p as=0.0528p pd=1.22u ps=0.68u
    I_MXI46_MN8 (XI46_n3 pp2_0 VSS VSS) gpdk090_nmos1v w=0.24u l=0.1u ad=0.0528p as=0.1176p pd=0.68u ps=1.22u
    I_MXI46_MN9 (XI46_sn XI46_con XI46_n3 VSS) gpdk090_nmos1v w=0.24u l=0.1u ad=0.0498p as=0.0528p pd=0.68u ps=0.68u
    I_MXI46_MN12_1 (XI46_n5 pp2_0 XI46_sn VSS) gpdk090_nmos1v w=0.18u l=0.1u ad=0.0468p as=0.0498p pd=0.68u ps=0.68u
    I_MXI57_MN12 (XI57_sn B_5 XI57_n5 VSS) gpdk090_nmos1v w=0.18u l=0.1u ad=0.0756p as=0.0468p pd=1.16u ps=0.68u
    I_MXI57_MN25 (fa14_0 XI57_sn VSS VSS) gpdk090_nmos1v w=0.12u l=0.1u ad=0.0696p as=0.0696p pd=1.16u ps=1.16u
    I_MXI57_MN5 (XI57_con B_5 XI57_n2 VSS) gpdk090_nmos1v w=0.24u l=0.1u ad=0.0528p as=0.0816p pd=0.68u ps=1.16u
    I_MXI57_MN2 (XI57_n1 fa3_0 XI57_con VSS) gpdk090_nmos1v w=0.24u l=0.1u ad=0.0528p as=0.0528p pd=0.68u ps=0.68u
    I_MXI57_MN1 (VSS ha2_1 XI57_n1 VSS) gpdk090_nmos1v w=0.24u l=0.1u ad=0.0528p as=0.0528p pd=0.68u ps=0.68u
    I_MXI57_MN3 (XI57_n2 ha2_1 VSS VSS) gpdk090_nmos1v w=0.24u l=0.1u ad=0.0528p as=0.0528p pd=0.68u ps=0.68u
    I_MXI57_MN4 (VSS fa3_0 XI57_n2 VSS) gpdk090_nmos1v w=0.24u l=0.1u ad=0.0468p as=0.0528p pd=0.68u ps=0.68u
    I_MXI57_MN27 (fa14_1 XI57_con VSS VSS) gpdk090_nmos1v w=0.12u l=0.1u ad=0.0696p as=0.0468p pd=1.16u ps=0.68u
    I_MXI57_MN10 (XI57_n4 ha2_1 VSS VSS) gpdk090_nmos1v w=0.18u l=0.1u ad=0.0468p as=0.0756p pd=0.68u ps=1.16u
    I_MXI57_MN11 (XI57_n5 fa3_0 XI57_n4 VSS) gpdk090_nmos1v w=0.18u l=0.1u ad=0.0468p as=0.0468p pd=0.68u ps=0.68u
    I_MXI57_MN11_1 (XI57_n4 fa3_0 XI57_n5 VSS) gpdk090_nmos1v w=0.18u l=0.1u ad=0.0468p as=0.0468p pd=0.68u ps=0.68u
    I_MXI57_MN10_1 (VSS ha2_1 XI57_n4 VSS) gpdk090_nmos1v w=0.18u l=0.1u ad=0.0498p as=0.0468p pd=0.68u ps=0.68u
    I_MXI57_MN6 (XI57_n3 ha2_1 VSS VSS) gpdk090_nmos1v w=0.24u l=0.1u ad=0.0528p as=0.0498p pd=0.68u ps=0.68u
    I_MXI57_MN7 (VSS fa3_0 XI57_n3 VSS) gpdk090_nmos1v w=0.24u l=0.1u ad=0.1176p as=0.0528p pd=1.22u ps=0.68u
    I_MXI57_MN8 (XI57_n3 B_5 VSS VSS) gpdk090_nmos1v w=0.24u l=0.1u ad=0.0528p as=0.1176p pd=0.68u ps=1.22u
    I_MXI57_MN9 (XI57_sn XI57_con XI57_n3 VSS) gpdk090_nmos1v w=0.24u l=0.1u ad=0.0498p as=0.0528p pd=0.68u ps=0.68u
    I_MXI57_MN12_1 (XI57_n5 B_5 XI57_sn VSS) gpdk090_nmos1v w=0.18u l=0.1u ad=0.0468p as=0.0498p pd=0.68u ps=0.68u
    I_MXI55_MN12 (XI55_sn cm11_2 XI55_n5 VSS) gpdk090_nmos1v w=0.18u l=0.1u ad=0.0756p as=0.0468p pd=1.16u ps=0.68u
    I_MXI55_MN25 (fa12_0 XI55_sn VSS VSS) gpdk090_nmos1v w=0.12u l=0.1u ad=0.0696p as=0.0696p pd=1.16u ps=1.16u
    I_MXI55_MN5 (XI55_con cm11_2 XI55_n2 VSS) gpdk090_nmos1v w=0.24u l=0.1u ad=0.0528p as=0.0816p pd=0.68u ps=1.16u
    I_MXI55_MN2 (XI55_n1 pp3_7 XI55_con VSS) gpdk090_nmos1v w=0.24u l=0.1u ad=0.0528p as=0.0528p pd=0.68u ps=0.68u
    I_MXI55_MN1 (VSS sn2 XI55_n1 VSS) gpdk090_nmos1v w=0.24u l=0.1u ad=0.0528p as=0.0528p pd=0.68u ps=0.68u
    I_MXI55_MN3 (XI55_n2 sn2 VSS VSS) gpdk090_nmos1v w=0.24u l=0.1u ad=0.0528p as=0.0528p pd=0.68u ps=0.68u
    I_MXI55_MN4 (VSS pp3_7 XI55_n2 VSS) gpdk090_nmos1v w=0.24u l=0.1u ad=0.0468p as=0.0528p pd=0.68u ps=0.68u
    I_MXI55_MN27 (fa12_1 XI55_con VSS VSS) gpdk090_nmos1v w=0.12u l=0.1u ad=0.0696p as=0.0468p pd=1.16u ps=0.68u
    I_MXI55_MN10 (XI55_n4 sn2 VSS VSS) gpdk090_nmos1v w=0.18u l=0.1u ad=0.0468p as=0.0756p pd=0.68u ps=1.16u
    I_MXI55_MN11 (XI55_n5 pp3_7 XI55_n4 VSS) gpdk090_nmos1v w=0.18u l=0.1u ad=0.0468p as=0.0468p pd=0.68u ps=0.68u
    I_MXI55_MN11_1 (XI55_n4 pp3_7 XI55_n5 VSS) gpdk090_nmos1v w=0.18u l=0.1u ad=0.0468p as=0.0468p pd=0.68u ps=0.68u
    I_MXI55_MN10_1 (VSS sn2 XI55_n4 VSS) gpdk090_nmos1v w=0.18u l=0.1u ad=0.0498p as=0.0468p pd=0.68u ps=0.68u
    I_MXI55_MN6 (XI55_n3 sn2 VSS VSS) gpdk090_nmos1v w=0.24u l=0.1u ad=0.0528p as=0.0498p pd=0.68u ps=0.68u
    I_MXI55_MN7 (VSS pp3_7 XI55_n3 VSS) gpdk090_nmos1v w=0.24u l=0.1u ad=0.1176p as=0.0528p pd=1.22u ps=0.68u
    I_MXI55_MN8 (XI55_n3 cm11_2 VSS VSS) gpdk090_nmos1v w=0.24u l=0.1u ad=0.0528p as=0.1176p pd=0.68u ps=1.22u
    I_MXI55_MN9 (XI55_sn XI55_con XI55_n3 VSS) gpdk090_nmos1v w=0.24u l=0.1u ad=0.0498p as=0.0528p pd=0.68u ps=0.68u
    I_MXI55_MN12_1 (XI55_n5 cm11_2 XI55_sn VSS) gpdk090_nmos1v w=0.18u l=0.1u ad=0.0468p as=0.0498p pd=0.68u ps=0.68u
    I_MXI44_MN12 (XI44_sn B_3 XI44_n5 VSS) gpdk090_nmos1v w=0.18u l=0.1u ad=0.0756p as=0.0468p pd=1.16u ps=0.68u
    I_MXI44_MN25 (fa1_0 XI44_sn VSS VSS) gpdk090_nmos1v w=0.12u l=0.1u ad=0.0696p as=0.0696p pd=1.16u ps=1.16u
    I_MXI44_MN5 (XI44_con B_3 XI44_n2 VSS) gpdk090_nmos1v w=0.24u l=0.1u ad=0.0528p as=0.0816p pd=0.68u ps=1.16u
    I_MXI44_MN2 (XI44_n1 pp1_0 XI44_con VSS) gpdk090_nmos1v w=0.24u l=0.1u ad=0.0528p as=0.0528p pd=0.68u ps=0.68u
    I_MXI44_MN1 (VSS pp0_2 XI44_n1 VSS) gpdk090_nmos1v w=0.24u l=0.1u ad=0.0528p as=0.0528p pd=0.68u ps=0.68u
    I_MXI44_MN3 (XI44_n2 pp0_2 VSS VSS) gpdk090_nmos1v w=0.24u l=0.1u ad=0.0528p as=0.0528p pd=0.68u ps=0.68u
    I_MXI44_MN4 (VSS pp1_0 XI44_n2 VSS) gpdk090_nmos1v w=0.24u l=0.1u ad=0.0468p as=0.0528p pd=0.68u ps=0.68u
    I_MXI44_MN27 (fa1_1 XI44_con VSS VSS) gpdk090_nmos1v w=0.12u l=0.1u ad=0.0696p as=0.0468p pd=1.16u ps=0.68u
    I_MXI44_MN10 (XI44_n4 pp0_2 VSS VSS) gpdk090_nmos1v w=0.18u l=0.1u ad=0.0468p as=0.0756p pd=0.68u ps=1.16u
    I_MXI44_MN11 (XI44_n5 pp1_0 XI44_n4 VSS) gpdk090_nmos1v w=0.18u l=0.1u ad=0.0468p as=0.0468p pd=0.68u ps=0.68u
    I_MXI44_MN11_1 (XI44_n4 pp1_0 XI44_n5 VSS) gpdk090_nmos1v w=0.18u l=0.1u ad=0.0468p as=0.0468p pd=0.68u ps=0.68u
    I_MXI44_MN10_1 (VSS pp0_2 XI44_n4 VSS) gpdk090_nmos1v w=0.18u l=0.1u ad=0.0498p as=0.0468p pd=0.68u ps=0.68u
    I_MXI44_MN6 (XI44_n3 pp0_2 VSS VSS) gpdk090_nmos1v w=0.24u l=0.1u ad=0.0528p as=0.0498p pd=0.68u ps=0.68u
    I_MXI44_MN7 (VSS pp1_0 XI44_n3 VSS) gpdk090_nmos1v w=0.24u l=0.1u ad=0.1176p as=0.0528p pd=1.22u ps=0.68u
    I_MXI44_MN8 (XI44_n3 B_3 VSS VSS) gpdk090_nmos1v w=0.24u l=0.1u ad=0.0528p as=0.1176p pd=0.68u ps=1.22u
    I_MXI44_MN9 (XI44_sn XI44_con XI44_n3 VSS) gpdk090_nmos1v w=0.24u l=0.1u ad=0.0498p as=0.0528p pd=0.68u ps=0.68u
    I_MXI44_MN12_1 (XI44_n5 B_3 XI44_sn VSS) gpdk090_nmos1v w=0.18u l=0.1u ad=0.0468p as=0.0498p pd=0.68u ps=0.68u
    I_MXI72_MN12 (XI72_sn rc3 XI72_n5 VSS) gpdk090_nmos1v w=0.18u l=0.1u ad=0.0756p as=0.0468p pd=1.16u ps=0.68u
    I_MXI72_MN25 (P_3 XI72_sn VSS VSS) gpdk090_nmos1v w=0.12u l=0.1u ad=0.0696p as=0.0696p pd=1.16u ps=1.16u
    I_MXI72_MN5 (XI72_con rc3 XI72_n2 VSS) gpdk090_nmos1v w=0.24u l=0.1u ad=0.0528p as=0.0816p pd=0.68u ps=1.16u
    I_MXI72_MN2 (XI72_n1 ha2_0 XI72_con VSS) gpdk090_nmos1v w=0.24u l=0.1u ad=0.0528p as=0.0528p pd=0.68u ps=0.68u
    I_MXI72_MN1 (VSS fa1_1 XI72_n1 VSS) gpdk090_nmos1v w=0.24u l=0.1u ad=0.0528p as=0.0528p pd=0.68u ps=0.68u
    I_MXI72_MN3 (XI72_n2 fa1_1 VSS VSS) gpdk090_nmos1v w=0.24u l=0.1u ad=0.0528p as=0.0528p pd=0.68u ps=0.68u
    I_MXI72_MN4 (VSS ha2_0 XI72_n2 VSS) gpdk090_nmos1v w=0.24u l=0.1u ad=0.0468p as=0.0528p pd=0.68u ps=0.68u
    I_MXI72_MN27 (rc4 XI72_con VSS VSS) gpdk090_nmos1v w=0.12u l=0.1u ad=0.0696p as=0.0468p pd=1.16u ps=0.68u
    I_MXI72_MN10 (XI72_n4 fa1_1 VSS VSS) gpdk090_nmos1v w=0.18u l=0.1u ad=0.0468p as=0.0756p pd=0.68u ps=1.16u
    I_MXI72_MN11 (XI72_n5 ha2_0 XI72_n4 VSS) gpdk090_nmos1v w=0.18u l=0.1u ad=0.0468p as=0.0468p pd=0.68u ps=0.68u
    I_MXI72_MN11_1 (XI72_n4 ha2_0 XI72_n5 VSS) gpdk090_nmos1v w=0.18u l=0.1u ad=0.0468p as=0.0468p pd=0.68u ps=0.68u
    I_MXI72_MN10_1 (VSS fa1_1 XI72_n4 VSS) gpdk090_nmos1v w=0.18u l=0.1u ad=0.0498p as=0.0468p pd=0.68u ps=0.68u
    I_MXI72_MN6 (XI72_n3 fa1_1 VSS VSS) gpdk090_nmos1v w=0.24u l=0.1u ad=0.0528p as=0.0498p pd=0.68u ps=0.68u
    I_MXI72_MN7 (VSS ha2_0 XI72_n3 VSS) gpdk090_nmos1v w=0.24u l=0.1u ad=0.1176p as=0.0528p pd=1.22u ps=0.68u
    I_MXI72_MN8 (XI72_n3 rc3 VSS VSS) gpdk090_nmos1v w=0.24u l=0.1u ad=0.0528p as=0.1176p pd=0.68u ps=1.22u
    I_MXI72_MN9 (XI72_sn XI72_con XI72_n3 VSS) gpdk090_nmos1v w=0.24u l=0.1u ad=0.0498p as=0.0528p pd=0.68u ps=0.68u
    I_MXI72_MN12_1 (XI72_n5 rc3 XI72_sn VSS) gpdk090_nmos1v w=0.18u l=0.1u ad=0.0468p as=0.0498p pd=0.68u ps=0.68u
    I_MXI77_I34_XG_MN2 (XI77_I34_XG_n1 I77_G5_2n VSS VSS) gpdk090_nmos1v w=0.24u l=0.1u ad=0.0528p as=0.0816p pd=0.68u ps=1.16u
    I_MXI77_I34_XG_MN0 (I77_G5_0 I77_P5_2n XI77_I34_XG_n1 VSS) gpdk090_nmos1v w=0.24u l=0.1u ad=0.0528p as=0.0528p pd=0.68u ps=0.68u
    I_MXI77_I34_XG_MN1 (XI77_I34_XG_n1 I77_G1_0n I77_G5_0 VSS) gpdk090_nmos1v w=0.24u l=0.1u ad=0.0816p as=0.0528p pd=1.16u ps=0.68u
    I_MXI77_I32_XG_MN2 (XI77_I32_XG_n1 I77_G4_1n VSS VSS) gpdk090_nmos1v w=0.24u l=0.1u ad=0.0528p as=0.0816p pd=0.68u ps=1.16u
    I_MXI77_I32_XG_MN0 (I77_G4_0 I77_P4_1n XI77_I32_XG_n1 VSS) gpdk090_nmos1v w=0.24u l=0.1u ad=0.0528p as=0.0528p pd=0.68u ps=0.68u
    I_MXI77_I32_XG_MN1 (XI77_I32_XG_n1 I77_G0_0n I77_G4_0 VSS) gpdk090_nmos1v w=0.24u l=0.1u ad=0.0816p as=0.0528p pd=1.16u ps=0.68u
    I_MXI77_I20_XG_MN2 (XI77_I20_XG_n1 I77_gn2 VSS VSS) gpdk090_nmos1v w=0.24u l=0.1u ad=0.0528p as=0.0816p pd=0.68u ps=1.16u
    I_MXI77_I20_XG_MN0 (I77_G2_1 I77_pn2 XI77_I20_XG_n1 VSS) gpdk090_nmos1v w=0.24u l=0.1u ad=0.0528p as=0.0528p pd=0.68u ps=0.68u
    I_MXI77_I20_XG_MN1 (XI77_I20_XG_n1 I77_gn1 I77_G2_1 VSS) gpdk090_nmos1v w=0.24u l=0.1u ad=0.0816p as=0.0528p pd=1.16u ps=0.68u
    I_MXI77_I19_XG_MN2 (XI77_I19_XG_n1 I77_gn1 VSS VSS) gpdk090_nmos1v w=0.24u l=0.1u ad=0.0528p as=0.0816p pd=0.68u ps=1.16u
    I_MXI77_I19_XG_MN0 (I77_G1_0 I77_pn1 XI77_I19_XG_n1 VSS) gpdk090_nmos1v w=0.24u l=0.1u ad=0.0528p as=0.0528p pd=0.68u ps=0.68u
    I_MXI77_I19_XG_MN1 (XI77_I19_XG_n1 I77_G0_0n I77_G1_0 VSS) gpdk090_nmos1v w=0.24u l=0.1u ad=0.0816p as=0.0528p pd=1.16u ps=0.68u
    I_MXI77_I17_XG_MN2 (XI77_I17_XG_n1 I77_gn0 VSS VSS) gpdk090_nmos1v w=0.24u l=0.1u ad=0.0528p as=0.0816p pd=0.68u ps=1.16u
    I_MXI77_I17_XG_MN0 (I77_G0_0 I77_pn0 XI77_I17_XG_n1 VSS) gpdk090_nmos1v w=0.24u l=0.1u ad=0.0528p as=0.0528p pd=0.68u ps=0.68u
    I_MXI77_I17_XG_MN1 (XI77_I17_XG_n1 I77_cinn I77_G0_0 VSS) gpdk090_nmos1v w=0.24u l=0.1u ad=0.0816p as=0.0528p pd=1.16u ps=0.68u
    I_MXI77_I35_XG_MN2 (XI77_I35_XG_n1 I77_G6_3n VSS VSS) gpdk090_nmos1v w=0.24u l=0.1u ad=0.0528p as=0.0816p pd=0.68u ps=1.16u
    I_MXI77_I35_XG_MN0 (kc7 I77_P6_3n XI77_I35_XG_n1 VSS) gpdk090_nmos1v w=0.24u l=0.1u ad=0.0528p as=0.0528p pd=0.68u ps=0.68u
    I_MXI77_I35_XG_MN1 (XI77_I35_XG_n1 I77_G2_0n kc7 VSS) gpdk090_nmos1v w=0.24u l=0.1u ad=0.0816p as=0.0528p pd=1.16u ps=0.68u
    I_MXI77_I21_XG_MN2 (XI77_I21_XG_n1 I77_gn3 VSS VSS) gpdk090_nmos1v w=0.24u l=0.1u ad=0.0528p as=0.0816p pd=0.68u ps=1.16u
    I_MXI77_I21_XG_MN0 (I77_G3_2 I77_pn3 XI77_I21_XG_n1 VSS) gpdk090_nmos1v w=0.24u l=0.1u ad=0.0528p as=0.0528p pd=0.68u ps=0.68u
    I_MXI77_I21_XG_MN1 (XI77_I21_XG_n1 I77_gn2 I77_G3_2 VSS) gpdk090_nmos1v w=0.24u l=0.1u ad=0.0816p as=0.0528p pd=1.16u ps=0.68u
    I_MXI77_I22_XG_MN2 (XI77_I22_XG_n1 I77_gn4 VSS VSS) gpdk090_nmos1v w=0.24u l=0.1u ad=0.0528p as=0.0816p pd=0.68u ps=1.16u
    I_MXI77_I22_XG_MN0 (I77_G4_3 I77_pn4 XI77_I22_XG_n1 VSS) gpdk090_nmos1v w=0.24u l=0.1u ad=0.0528p as=0.0528p pd=0.68u ps=0.68u
    I_MXI77_I22_XG_MN1 (XI77_I22_XG_n1 I77_gn3 I77_G4_3 VSS) gpdk090_nmos1v w=0.24u l=0.1u ad=0.0816p as=0.0528p pd=1.16u ps=0.68u
    I_MXI77_I36_XG_MN2 (XI77_I36_XG_n1 I77_G7_4n VSS VSS) gpdk090_nmos1v w=0.24u l=0.1u ad=0.0528p as=0.0816p pd=0.68u ps=1.16u
    I_MXI77_I36_XG_MN0 (kc8 I77_P7_4n XI77_I36_XG_n1 VSS) gpdk090_nmos1v w=0.24u l=0.1u ad=0.0528p as=0.0528p pd=0.68u ps=0.68u
    I_MXI77_I36_XG_MN1 (XI77_I36_XG_n1 I77_G3_0n kc8 VSS) gpdk090_nmos1v w=0.24u l=0.1u ad=0.0816p as=0.0528p pd=1.16u ps=0.68u
    I_MXI77_I23_XG_MN2 (XI77_I23_XG_n1 I77_gn5 VSS VSS) gpdk090_nmos1v w=0.24u l=0.1u ad=0.0528p as=0.0816p pd=0.68u ps=1.16u
    I_MXI77_I23_XG_MN0 (I77_G5_4 I77_pn5 XI77_I23_XG_n1 VSS) gpdk090_nmos1v w=0.24u l=0.1u ad=0.0528p as=0.0528p pd=0.68u ps=0.68u
    I_MXI77_I23_XG_MN1 (XI77_I23_XG_n1 I77_gn4 I77_G5_4 VSS) gpdk090_nmos1v w=0.24u l=0.1u ad=0.0816p as=0.0528p pd=1.16u ps=0.68u
    I_MXI77_I25_XG_MN2 (XI77_I25_XG_n1 I77_gn7 VSS VSS) gpdk090_nmos1v w=0.24u l=0.1u ad=0.0528p as=0.0816p pd=0.68u ps=1.16u
    I_MXI77_I25_XG_MN0 (I77_G7_6 I77_pn7 XI77_I25_XG_n1 VSS) gpdk090_nmos1v w=0.24u l=0.1u ad=0.0528p as=0.0528p pd=0.68u ps=0.68u
    I_MXI77_I25_XG_MN1 (XI77_I25_XG_n1 I77_gn6 I77_G7_6 VSS) gpdk090_nmos1v w=0.24u l=0.1u ad=0.0816p as=0.0528p pd=1.16u ps=0.68u
    I_MXI77_I24_XG_MN2 (XI77_I24_XG_n1 I77_gn6 VSS VSS) gpdk090_nmos1v w=0.24u l=0.1u ad=0.0528p as=0.0816p pd=0.68u ps=1.16u
    I_MXI77_I24_XG_MN0 (I77_G6_5 I77_pn6 XI77_I24_XG_n1 VSS) gpdk090_nmos1v w=0.24u l=0.1u ad=0.0528p as=0.0528p pd=0.68u ps=0.68u
    I_MXI77_I24_XG_MN1 (XI77_I24_XG_n1 I77_gn5 I77_G6_5 VSS) gpdk090_nmos1v w=0.24u l=0.1u ad=0.0816p as=0.0528p pd=1.16u ps=0.68u
    I_MXI26_MN11 (VSS B_5 XI26_xbn VSS) gpdk090_nmos1v w=0.12u l=0.1u ad=0.0696p as=0.0696p pd=1.16u ps=1.16u
    I_MXI26_MN14 (VSS XI26_xbn XI26_xn1 VSS) gpdk090_nmos1v w=0.24u l=0.1u ad=0.0528p as=0.0816p pd=0.68u ps=1.16u
    I_MXI26_MN16 (XI26_xn2 B_5 VSS VSS) gpdk090_nmos1v w=0.24u l=0.1u ad=0.0528p as=0.0528p pd=0.68u ps=0.68u
    I_MXI26_MN15 (pp2_3 XI26_xan XI26_xn2 VSS) gpdk090_nmos1v w=0.24u l=0.1u ad=0.0528p as=0.0528p pd=0.68u ps=0.68u
    I_MXI26_MN13 (XI26_xn1 XI26_xn pp2_3 VSS) gpdk090_nmos1v w=0.24u l=0.1u ad=0.0816p as=0.0528p pd=1.16u ps=0.68u
    I_MXI26_MN2 (VSS A_3 XI26_n1 VSS) gpdk090_nmos1v w=0.24u l=0.1u ad=0.0528p as=0.0816p pd=0.68u ps=1.16u
    I_MXI26_MN4 (XI26_n2 A_2 VSS VSS) gpdk090_nmos1v w=0.24u l=0.1u ad=0.0528p as=0.0528p pd=0.68u ps=0.68u
    I_MXI26_MN3 (XI26_xn two2 XI26_n2 VSS) gpdk090_nmos1v w=0.24u l=0.1u ad=0.0528p as=0.0528p pd=0.68u ps=0.68u
    I_MXI26_MN1 (XI26_n1 one2 XI26_xn VSS) gpdk090_nmos1v w=0.24u l=0.1u ad=0.0816p as=0.0528p pd=1.16u ps=0.68u
    I_MXI26_MN9 (VSS XI26_xn XI26_xan VSS) gpdk090_nmos1v w=0.12u l=0.1u ad=0.0696p as=0.0696p pd=1.16u ps=1.16u
    I_MXI15_MN11 (VSS B_3 XI15_xbn VSS) gpdk090_nmos1v w=0.12u l=0.1u ad=0.0696p as=0.0696p pd=1.16u ps=1.16u
    I_MXI15_MN14 (VSS XI15_xbn XI15_xn1 VSS) gpdk090_nmos1v w=0.24u l=0.1u ad=0.0528p as=0.0816p pd=0.68u ps=1.16u
    I_MXI15_MN16 (XI15_xn2 B_3 VSS VSS) gpdk090_nmos1v w=0.24u l=0.1u ad=0.0528p as=0.0528p pd=0.68u ps=0.68u
    I_MXI15_MN15 (pp1_3 XI15_xan XI15_xn2 VSS) gpdk090_nmos1v w=0.24u l=0.1u ad=0.0528p as=0.0528p pd=0.68u ps=0.68u
    I_MXI15_MN13 (XI15_xn1 XI15_xn pp1_3 VSS) gpdk090_nmos1v w=0.24u l=0.1u ad=0.0816p as=0.0528p pd=1.16u ps=0.68u
    I_MXI15_MN2 (VSS A_3 XI15_n1 VSS) gpdk090_nmos1v w=0.24u l=0.1u ad=0.0528p as=0.0816p pd=0.68u ps=1.16u
    I_MXI15_MN4 (XI15_n2 A_2 VSS VSS) gpdk090_nmos1v w=0.24u l=0.1u ad=0.0528p as=0.0528p pd=0.68u ps=0.68u
    I_MXI15_MN3 (XI15_xn two1 XI15_n2 VSS) gpdk090_nmos1v w=0.24u l=0.1u ad=0.0528p as=0.0528p pd=0.68u ps=0.68u
    I_MXI15_MN1 (XI15_n1 one1 XI15_xn VSS) gpdk090_nmos1v w=0.24u l=0.1u ad=0.0816p as=0.0528p pd=1.16u ps=0.68u
    I_MXI15_MN9 (VSS XI15_xn XI15_xan VSS) gpdk090_nmos1v w=0.12u l=0.1u ad=0.0696p as=0.0696p pd=1.16u ps=1.16u
    I_MXI23_MN11 (VSS B_5 XI23_xbn VSS) gpdk090_nmos1v w=0.12u l=0.1u ad=0.0696p as=0.0696p pd=1.16u ps=1.16u
    I_MXI23_MN14 (VSS XI23_xbn XI23_xn1 VSS) gpdk090_nmos1v w=0.24u l=0.1u ad=0.0528p as=0.0816p pd=0.68u ps=1.16u
    I_MXI23_MN16 (XI23_xn2 B_5 VSS VSS) gpdk090_nmos1v w=0.24u l=0.1u ad=0.0528p as=0.0528p pd=0.68u ps=0.68u
    I_MXI23_MN15 (pp2_0 XI23_xan XI23_xn2 VSS) gpdk090_nmos1v w=0.24u l=0.1u ad=0.0528p as=0.0528p pd=0.68u ps=0.68u
    I_MXI23_MN13 (XI23_xn1 XI23_xn pp2_0 VSS) gpdk090_nmos1v w=0.24u l=0.1u ad=0.0816p as=0.0528p pd=1.16u ps=0.68u
    I_MXI23_MN2 (VSS A_0 XI23_n1 VSS) gpdk090_nmos1v w=0.24u l=0.1u ad=0.0528p as=0.0816p pd=0.68u ps=1.16u
    I_MXI23_MN4 (XI23_n2 VSS VSS VSS) gpdk090_nmos1v w=0.24u l=0.1u ad=0.0528p as=0.0528p pd=0.68u ps=0.68u
    I_MXI23_MN3 (XI23_xn two2 XI23_n2 VSS) gpdk090_nmos1v w=0.24u l=0.1u ad=0.0528p as=0.0528p pd=0.68u ps=0.68u
    I_MXI23_MN1 (XI23_n1 one2 XI23_xn VSS) gpdk090_nmos1v w=0.24u l=0.1u ad=0.0816p as=0.0528p pd=1.16u ps=0.68u
    I_MXI23_MN9 (VSS XI23_xn XI23_xan VSS) gpdk090_nmos1v w=0.12u l=0.1u ad=0.0696p as=0.0696p pd=1.16u ps=1.16u
    I_MXI14_MN11 (VSS B_3 XI14_xbn VSS) gpdk090_nmos1v w=0.12u l=0.1u ad=0.0696p as=0.0696p pd=1.16u ps=1.16u
    I_MXI14_MN14 (VSS XI14_xbn XI14_xn1 VSS) gpdk090_nmos1v w=0.24u l=0.1u ad=0.0528p as=0.0816p pd=0.68u ps=1.16u
    I_MXI14_MN16 (XI14_xn2 B_3 VSS VSS) gpdk090_nmos1v w=0.24u l=0.1u ad=0.0528p as=0.0528p pd=0.68u ps=0.68u
    I_MXI14_MN15 (pp1_2 XI14_xan XI14_xn2 VSS) gpdk090_nmos1v w=0.24u l=0.1u ad=0.0528p as=0.0528p pd=0.68u ps=0.68u
    I_MXI14_MN13 (XI14_xn1 XI14_xn pp1_2 VSS) gpdk090_nmos1v w=0.24u l=0.1u ad=0.0816p as=0.0528p pd=1.16u ps=0.68u
    I_MXI14_MN2 (VSS A_2 XI14_n1 VSS) gpdk090_nmos1v w=0.24u l=0.1u ad=0.0528p as=0.0816p pd=0.68u ps=1.16u
    I_MXI14_MN4 (XI14_n2 A_1 VSS VSS) gpdk090_nmos1v w=0.24u l=0.1u ad=0.0528p as=0.0528p pd=0.68u ps=0.68u
    I_MXI14_MN3 (XI14_xn two1 XI14_n2 VSS) gpdk090_nmos1v w=0.24u l=0.1u ad=0.0528p as=0.0528p pd=0.68u ps=0.68u
    I_MXI14_MN1 (XI14_n1 one1 XI14_xn VSS) gpdk090_nmos1v w=0.24u l=0.1u ad=0.0816p as=0.0528p pd=1.16u ps=0.68u
    I_MXI14_MN9 (VSS XI14_xn XI14_xan VSS) gpdk090_nmos1v w=0.12u l=0.1u ad=0.0696p as=0.0696p pd=1.16u ps=1.16u
    I_MXI28_MN11 (VSS B_5 XI28_xbn VSS) gpdk090_nmos1v w=0.12u l=0.1u ad=0.0696p as=0.0696p pd=1.16u ps=1.16u
    I_MXI28_MN14 (VSS XI28_xbn XI28_xn1 VSS) gpdk090_nmos1v w=0.24u l=0.1u ad=0.0528p as=0.0816p pd=0.68u ps=1.16u
    I_MXI28_MN16 (XI28_xn2 B_5 VSS VSS) gpdk090_nmos1v w=0.24u l=0.1u ad=0.0528p as=0.0528p pd=0.68u ps=0.68u
    I_MXI28_MN15 (pp2_5 XI28_xan XI28_xn2 VSS) gpdk090_nmos1v w=0.24u l=0.1u ad=0.0528p as=0.0528p pd=0.68u ps=0.68u
    I_MXI28_MN13 (XI28_xn1 XI28_xn pp2_5 VSS) gpdk090_nmos1v w=0.24u l=0.1u ad=0.0816p as=0.0528p pd=1.16u ps=0.68u
    I_MXI28_MN2 (VSS A_5 XI28_n1 VSS) gpdk090_nmos1v w=0.24u l=0.1u ad=0.0528p as=0.0816p pd=0.68u ps=1.16u
    I_MXI28_MN4 (XI28_n2 A_4 VSS VSS) gpdk090_nmos1v w=0.24u l=0.1u ad=0.0528p as=0.0528p pd=0.68u ps=0.68u
    I_MXI28_MN3 (XI28_xn two2 XI28_n2 VSS) gpdk090_nmos1v w=0.24u l=0.1u ad=0.0528p as=0.0528p pd=0.68u ps=0.68u
    I_MXI28_MN1 (XI28_n1 one2 XI28_xn VSS) gpdk090_nmos1v w=0.24u l=0.1u ad=0.0816p as=0.0528p pd=1.16u ps=0.68u
    I_MXI28_MN9 (VSS XI28_xn XI28_xan VSS) gpdk090_nmos1v w=0.12u l=0.1u ad=0.0696p as=0.0696p pd=1.16u ps=1.16u
    I_MXI27_MN11 (VSS B_5 XI27_xbn VSS) gpdk090_nmos1v w=0.12u l=0.1u ad=0.0696p as=0.0696p pd=1.16u ps=1.16u
    I_MXI27_MN14 (VSS XI27_xbn XI27_xn1 VSS) gpdk090_nmos1v w=0.24u l=0.1u ad=0.0528p as=0.0816p pd=0.68u ps=1.16u
    I_MXI27_MN16 (XI27_xn2 B_5 VSS VSS) gpdk090_nmos1v w=0.24u l=0.1u ad=0.0528p as=0.0528p pd=0.68u ps=0.68u
    I_MXI27_MN15 (pp2_4 XI27_xan XI27_xn2 VSS) gpdk090_nmos1v w=0.24u l=0.1u ad=0.0528p as=0.0528p pd=0.68u ps=0.68u
    I_MXI27_MN13 (XI27_xn1 XI27_xn pp2_4 VSS) gpdk090_nmos1v w=0.24u l=0.1u ad=0.0816p as=0.0528p pd=1.16u ps=0.68u
    I_MXI27_MN2 (VSS A_4 XI27_n1 VSS) gpdk090_nmos1v w=0.24u l=0.1u ad=0.0528p as=0.0816p pd=0.68u ps=1.16u
    I_MXI27_MN4 (XI27_n2 A_3 VSS VSS) gpdk090_nmos1v w=0.24u l=0.1u ad=0.0528p as=0.0528p pd=0.68u ps=0.68u
    I_MXI27_MN3 (XI27_xn two2 XI27_n2 VSS) gpdk090_nmos1v w=0.24u l=0.1u ad=0.0528p as=0.0528p pd=0.68u ps=0.68u
    I_MXI27_MN1 (XI27_n1 one2 XI27_xn VSS) gpdk090_nmos1v w=0.24u l=0.1u ad=0.0816p as=0.0528p pd=1.16u ps=0.68u
    I_MXI27_MN9 (VSS XI27_xn XI27_xan VSS) gpdk090_nmos1v w=0.12u l=0.1u ad=0.0696p as=0.0696p pd=1.16u ps=1.16u
    I_MXI19_MN11 (VSS B_3 XI19_xbn VSS) gpdk090_nmos1v w=0.12u l=0.1u ad=0.0696p as=0.0696p pd=1.16u ps=1.16u
    I_MXI19_MN14 (VSS XI19_xbn XI19_xn1 VSS) gpdk090_nmos1v w=0.24u l=0.1u ad=0.0528p as=0.0816p pd=0.68u ps=1.16u
    I_MXI19_MN16 (XI19_xn2 B_3 VSS VSS) gpdk090_nmos1v w=0.24u l=0.1u ad=0.0528p as=0.0528p pd=0.68u ps=0.68u
    I_MXI19_MN15 (pp1_7 XI19_xan XI19_xn2 VSS) gpdk090_nmos1v w=0.24u l=0.1u ad=0.0528p as=0.0528p pd=0.68u ps=0.68u
    I_MXI19_MN13 (XI19_xn1 XI19_xn pp1_7 VSS) gpdk090_nmos1v w=0.24u l=0.1u ad=0.0816p as=0.0528p pd=1.16u ps=0.68u
    I_MXI19_MN2 (VSS A_7 XI19_n1 VSS) gpdk090_nmos1v w=0.24u l=0.1u ad=0.0528p as=0.0816p pd=0.68u ps=1.16u
    I_MXI19_MN4 (XI19_n2 A_6 VSS VSS) gpdk090_nmos1v w=0.24u l=0.1u ad=0.0528p as=0.0528p pd=0.68u ps=0.68u
    I_MXI19_MN3 (XI19_xn two1 XI19_n2 VSS) gpdk090_nmos1v w=0.24u l=0.1u ad=0.0528p as=0.0528p pd=0.68u ps=0.68u
    I_MXI19_MN1 (XI19_n1 one1 XI19_xn VSS) gpdk090_nmos1v w=0.24u l=0.1u ad=0.0816p as=0.0528p pd=1.16u ps=0.68u
    I_MXI19_MN9 (VSS XI19_xn XI19_xan VSS) gpdk090_nmos1v w=0.12u l=0.1u ad=0.0696p as=0.0696p pd=1.16u ps=1.16u
    I_MXI18_MN11 (VSS B_3 XI18_xbn VSS) gpdk090_nmos1v w=0.12u l=0.1u ad=0.0696p as=0.0696p pd=1.16u ps=1.16u
    I_MXI18_MN14 (VSS XI18_xbn XI18_xn1 VSS) gpdk090_nmos1v w=0.24u l=0.1u ad=0.0528p as=0.0816p pd=0.68u ps=1.16u
    I_MXI18_MN16 (XI18_xn2 B_3 VSS VSS) gpdk090_nmos1v w=0.24u l=0.1u ad=0.0528p as=0.0528p pd=0.68u ps=0.68u
    I_MXI18_MN15 (pp1_6 XI18_xan XI18_xn2 VSS) gpdk090_nmos1v w=0.24u l=0.1u ad=0.0528p as=0.0528p pd=0.68u ps=0.68u
    I_MXI18_MN13 (XI18_xn1 XI18_xn pp1_6 VSS) gpdk090_nmos1v w=0.24u l=0.1u ad=0.0816p as=0.0528p pd=1.16u ps=0.68u
    I_MXI18_MN2 (VSS A_6 XI18_n1 VSS) gpdk090_nmos1v w=0.24u l=0.1u ad=0.0528p as=0.0816p pd=0.68u ps=1.16u
    I_MXI18_MN4 (XI18_n2 A_5 VSS VSS) gpdk090_nmos1v w=0.24u l=0.1u ad=0.0528p as=0.0528p pd=0.68u ps=0.68u
    I_MXI18_MN3 (XI18_xn two1 XI18_n2 VSS) gpdk090_nmos1v w=0.24u l=0.1u ad=0.0528p as=0.0528p pd=0.68u ps=0.68u
    I_MXI18_MN1 (XI18_n1 one1 XI18_xn VSS) gpdk090_nmos1v w=0.24u l=0.1u ad=0.0816p as=0.0528p pd=1.16u ps=0.68u
    I_MXI18_MN9 (VSS XI18_xn XI18_xan VSS) gpdk090_nmos1v w=0.12u l=0.1u ad=0.0696p as=0.0696p pd=1.16u ps=1.16u
    I_MXI17_MN11 (VSS B_3 XI17_xbn VSS) gpdk090_nmos1v w=0.12u l=0.1u ad=0.0696p as=0.0696p pd=1.16u ps=1.16u
    I_MXI17_MN14 (VSS XI17_xbn XI17_xn1 VSS) gpdk090_nmos1v w=0.24u l=0.1u ad=0.0528p as=0.0816p pd=0.68u ps=1.16u
    I_MXI17_MN16 (XI17_xn2 B_3 VSS VSS) gpdk090_nmos1v w=0.24u l=0.1u ad=0.0528p as=0.0528p pd=0.68u ps=0.68u
    I_MXI17_MN15 (pp1_5 XI17_xan XI17_xn2 VSS) gpdk090_nmos1v w=0.24u l=0.1u ad=0.0528p as=0.0528p pd=0.68u ps=0.68u
    I_MXI17_MN13 (XI17_xn1 XI17_xn pp1_5 VSS) gpdk090_nmos1v w=0.24u l=0.1u ad=0.0816p as=0.0528p pd=1.16u ps=0.68u
    I_MXI17_MN2 (VSS A_5 XI17_n1 VSS) gpdk090_nmos1v w=0.24u l=0.1u ad=0.0528p as=0.0816p pd=0.68u ps=1.16u
    I_MXI17_MN4 (XI17_n2 A_4 VSS VSS) gpdk090_nmos1v w=0.24u l=0.1u ad=0.0528p as=0.0528p pd=0.68u ps=0.68u
    I_MXI17_MN3 (XI17_xn two1 XI17_n2 VSS) gpdk090_nmos1v w=0.24u l=0.1u ad=0.0528p as=0.0528p pd=0.68u ps=0.68u
    I_MXI17_MN1 (XI17_n1 one1 XI17_xn VSS) gpdk090_nmos1v w=0.24u l=0.1u ad=0.0816p as=0.0528p pd=1.16u ps=0.68u
    I_MXI17_MN9 (VSS XI17_xn XI17_xan VSS) gpdk090_nmos1v w=0.12u l=0.1u ad=0.0696p as=0.0696p pd=1.16u ps=1.16u
    I_MXI24_MN11 (VSS B_5 XI24_xbn VSS) gpdk090_nmos1v w=0.12u l=0.1u ad=0.0696p as=0.0696p pd=1.16u ps=1.16u
    I_MXI24_MN14 (VSS XI24_xbn XI24_xn1 VSS) gpdk090_nmos1v w=0.24u l=0.1u ad=0.0528p as=0.0816p pd=0.68u ps=1.16u
    I_MXI24_MN16 (XI24_xn2 B_5 VSS VSS) gpdk090_nmos1v w=0.24u l=0.1u ad=0.0528p as=0.0528p pd=0.68u ps=0.68u
    I_MXI24_MN15 (pp2_1 XI24_xan XI24_xn2 VSS) gpdk090_nmos1v w=0.24u l=0.1u ad=0.0528p as=0.0528p pd=0.68u ps=0.68u
    I_MXI24_MN13 (XI24_xn1 XI24_xn pp2_1 VSS) gpdk090_nmos1v w=0.24u l=0.1u ad=0.0816p as=0.0528p pd=1.16u ps=0.68u
    I_MXI24_MN2 (VSS A_1 XI24_n1 VSS) gpdk090_nmos1v w=0.24u l=0.1u ad=0.0528p as=0.0816p pd=0.68u ps=1.16u
    I_MXI24_MN4 (XI24_n2 A_0 VSS VSS) gpdk090_nmos1v w=0.24u l=0.1u ad=0.0528p as=0.0528p pd=0.68u ps=0.68u
    I_MXI24_MN3 (XI24_xn two2 XI24_n2 VSS) gpdk090_nmos1v w=0.24u l=0.1u ad=0.0528p as=0.0528p pd=0.68u ps=0.68u
    I_MXI24_MN1 (XI24_n1 one2 XI24_xn VSS) gpdk090_nmos1v w=0.24u l=0.1u ad=0.0816p as=0.0528p pd=1.16u ps=0.68u
    I_MXI24_MN9 (VSS XI24_xn XI24_xan VSS) gpdk090_nmos1v w=0.12u l=0.1u ad=0.0696p as=0.0696p pd=1.16u ps=1.16u
    I_MXI30_MN11 (VSS B_5 XI30_xbn VSS) gpdk090_nmos1v w=0.12u l=0.1u ad=0.0696p as=0.0696p pd=1.16u ps=1.16u
    I_MXI30_MN14 (VSS XI30_xbn XI30_xn1 VSS) gpdk090_nmos1v w=0.24u l=0.1u ad=0.0528p as=0.0816p pd=0.68u ps=1.16u
    I_MXI30_MN16 (XI30_xn2 B_5 VSS VSS) gpdk090_nmos1v w=0.24u l=0.1u ad=0.0528p as=0.0528p pd=0.68u ps=0.68u
    I_MXI30_MN15 (pp2_7 XI30_xan XI30_xn2 VSS) gpdk090_nmos1v w=0.24u l=0.1u ad=0.0528p as=0.0528p pd=0.68u ps=0.68u
    I_MXI30_MN13 (XI30_xn1 XI30_xn pp2_7 VSS) gpdk090_nmos1v w=0.24u l=0.1u ad=0.0816p as=0.0528p pd=1.16u ps=0.68u
    I_MXI30_MN2 (VSS A_7 XI30_n1 VSS) gpdk090_nmos1v w=0.24u l=0.1u ad=0.0528p as=0.0816p pd=0.68u ps=1.16u
    I_MXI30_MN4 (XI30_n2 A_6 VSS VSS) gpdk090_nmos1v w=0.24u l=0.1u ad=0.0528p as=0.0528p pd=0.68u ps=0.68u
    I_MXI30_MN3 (XI30_xn two2 XI30_n2 VSS) gpdk090_nmos1v w=0.24u l=0.1u ad=0.0528p as=0.0528p pd=0.68u ps=0.68u
    I_MXI30_MN1 (XI30_n1 one2 XI30_xn VSS) gpdk090_nmos1v w=0.24u l=0.1u ad=0.0816p as=0.0528p pd=1.16u ps=0.68u
    I_MXI30_MN9 (VSS XI30_xn XI30_xan VSS) gpdk090_nmos1v w=0.12u l=0.1u ad=0.0696p as=0.0696p pd=1.16u ps=1.16u
    I_MXI29_MN11 (VSS B_5 XI29_xbn VSS) gpdk090_nmos1v w=0.12u l=0.1u ad=0.0696p as=0.0696p pd=1.16u ps=1.16u
    I_MXI29_MN14 (VSS XI29_xbn XI29_xn1 VSS) gpdk090_nmos1v w=0.24u l=0.1u ad=0.0528p as=0.0816p pd=0.68u ps=1.16u
    I_MXI29_MN16 (XI29_xn2 B_5 VSS VSS) gpdk090_nmos1v w=0.24u l=0.1u ad=0.0528p as=0.0528p pd=0.68u ps=0.68u
    I_MXI29_MN15 (pp2_6 XI29_xan XI29_xn2 VSS) gpdk090_nmos1v w=0.24u l=0.1u ad=0.0528p as=0.0528p pd=0.68u ps=0.68u
    I_MXI29_MN13 (XI29_xn1 XI29_xn pp2_6 VSS) gpdk090_nmos1v w=0.24u l=0.1u ad=0.0816p as=0.0528p pd=1.16u ps=0.68u
    I_MXI29_MN2 (VSS A_6 XI29_n1 VSS) gpdk090_nmos1v w=0.24u l=0.1u ad=0.0528p as=0.0816p pd=0.68u ps=1.16u
    I_MXI29_MN4 (XI29_n2 A_5 VSS VSS) gpdk090_nmos1v w=0.24u l=0.1u ad=0.0528p as=0.0528p pd=0.68u ps=0.68u
    I_MXI29_MN3 (XI29_xn two2 XI29_n2 VSS) gpdk090_nmos1v w=0.24u l=0.1u ad=0.0528p as=0.0528p pd=0.68u ps=0.68u
    I_MXI29_MN1 (XI29_n1 one2 XI29_xn VSS) gpdk090_nmos1v w=0.24u l=0.1u ad=0.0816p as=0.0528p pd=1.16u ps=0.68u
    I_MXI29_MN9 (VSS XI29_xn XI29_xan VSS) gpdk090_nmos1v w=0.12u l=0.1u ad=0.0696p as=0.0696p pd=1.16u ps=1.16u
    I_MXI20_MN11 (VSS B_3 XI20_xbn VSS) gpdk090_nmos1v w=0.12u l=0.1u ad=0.0696p as=0.0696p pd=1.16u ps=1.16u
    I_MXI20_MN14 (VSS XI20_xbn XI20_xn1 VSS) gpdk090_nmos1v w=0.24u l=0.1u ad=0.0528p as=0.0816p pd=0.68u ps=1.16u
    I_MXI20_MN16 (XI20_xn2 B_3 VSS VSS) gpdk090_nmos1v w=0.24u l=0.1u ad=0.0528p as=0.0528p pd=0.68u ps=0.68u
    I_MXI20_MN15 (pp1_8 XI20_xan XI20_xn2 VSS) gpdk090_nmos1v w=0.24u l=0.1u ad=0.0528p as=0.0528p pd=0.68u ps=0.68u
    I_MXI20_MN13 (XI20_xn1 XI20_xn pp1_8 VSS) gpdk090_nmos1v w=0.24u l=0.1u ad=0.0816p as=0.0528p pd=1.16u ps=0.68u
    I_MXI20_MN2 (VSS A_7 XI20_n1 VSS) gpdk090_nmos1v w=0.24u l=0.1u ad=0.0528p as=0.0816p pd=0.68u ps=1.16u
    I_MXI20_MN4 (XI20_n2 A_7 VSS VSS) gpdk090_nmos1v w=0.24u l=0.1u ad=0.0528p as=0.0528p pd=0.68u ps=0.68u
    I_MXI20_MN3 (XI20_xn two1 XI20_n2 VSS) gpdk090_nmos1v w=0.24u l=0.1u ad=0.0528p as=0.0528p pd=0.68u ps=0.68u
    I_MXI20_MN1 (XI20_n1 one1 XI20_xn VSS) gpdk090_nmos1v w=0.24u l=0.1u ad=0.0816p as=0.0528p pd=1.16u ps=0.68u
    I_MXI20_MN9 (VSS XI20_xn XI20_xan VSS) gpdk090_nmos1v w=0.12u l=0.1u ad=0.0696p as=0.0696p pd=1.16u ps=1.16u
    I_MXI8_MN11 (VSS B_1 XI8_xbn VSS) gpdk090_nmos1v w=0.12u l=0.1u ad=0.0696p as=0.0696p pd=1.16u ps=1.16u
    I_MXI8_MN14 (VSS XI8_xbn XI8_xn1 VSS) gpdk090_nmos1v w=0.24u l=0.1u ad=0.0528p as=0.0816p pd=0.68u ps=1.16u
    I_MXI8_MN16 (XI8_xn2 B_1 VSS VSS) gpdk090_nmos1v w=0.24u l=0.1u ad=0.0528p as=0.0528p pd=0.68u ps=0.68u
    I_MXI8_MN15 (pp0_7 XI8_xan XI8_xn2 VSS) gpdk090_nmos1v w=0.24u l=0.1u ad=0.0528p as=0.0528p pd=0.68u ps=0.68u
    I_MXI8_MN13 (XI8_xn1 XI8_xn pp0_7 VSS) gpdk090_nmos1v w=0.24u l=0.1u ad=0.0816p as=0.0528p pd=1.16u ps=0.68u
    I_MXI8_MN2 (VSS A_7 XI8_n1 VSS) gpdk090_nmos1v w=0.24u l=0.1u ad=0.0528p as=0.0816p pd=0.68u ps=1.16u
    I_MXI8_MN4 (XI8_n2 A_6 VSS VSS) gpdk090_nmos1v w=0.24u l=0.1u ad=0.0528p as=0.0528p pd=0.68u ps=0.68u
    I_MXI8_MN3 (XI8_xn two0 XI8_n2 VSS) gpdk090_nmos1v w=0.24u l=0.1u ad=0.0528p as=0.0528p pd=0.68u ps=0.68u
    I_MXI8_MN1 (XI8_n1 one0 XI8_xn VSS) gpdk090_nmos1v w=0.24u l=0.1u ad=0.0816p as=0.0528p pd=1.16u ps=0.68u
    I_MXI8_MN9 (VSS XI8_xn XI8_xan VSS) gpdk090_nmos1v w=0.12u l=0.1u ad=0.0696p as=0.0696p pd=1.16u ps=1.16u
    I_MXI5_MN11 (VSS B_1 XI5_xbn VSS) gpdk090_nmos1v w=0.12u l=0.1u ad=0.0696p as=0.0696p pd=1.16u ps=1.16u
    I_MXI5_MN14 (VSS XI5_xbn XI5_xn1 VSS) gpdk090_nmos1v w=0.24u l=0.1u ad=0.0528p as=0.0816p pd=0.68u ps=1.16u
    I_MXI5_MN16 (XI5_xn2 B_1 VSS VSS) gpdk090_nmos1v w=0.24u l=0.1u ad=0.0528p as=0.0528p pd=0.68u ps=0.68u
    I_MXI5_MN15 (pp0_4 XI5_xan XI5_xn2 VSS) gpdk090_nmos1v w=0.24u l=0.1u ad=0.0528p as=0.0528p pd=0.68u ps=0.68u
    I_MXI5_MN13 (XI5_xn1 XI5_xn pp0_4 VSS) gpdk090_nmos1v w=0.24u l=0.1u ad=0.0816p as=0.0528p pd=1.16u ps=0.68u
    I_MXI5_MN2 (VSS A_4 XI5_n1 VSS) gpdk090_nmos1v w=0.24u l=0.1u ad=0.0528p as=0.0816p pd=0.68u ps=1.16u
    I_MXI5_MN4 (XI5_n2 A_3 VSS VSS) gpdk090_nmos1v w=0.24u l=0.1u ad=0.0528p as=0.0528p pd=0.68u ps=0.68u
    I_MXI5_MN3 (XI5_xn two0 XI5_n2 VSS) gpdk090_nmos1v w=0.24u l=0.1u ad=0.0528p as=0.0528p pd=0.68u ps=0.68u
    I_MXI5_MN1 (XI5_n1 one0 XI5_xn VSS) gpdk090_nmos1v w=0.24u l=0.1u ad=0.0816p as=0.0528p pd=1.16u ps=0.68u
    I_MXI5_MN9 (VSS XI5_xn XI5_xan VSS) gpdk090_nmos1v w=0.12u l=0.1u ad=0.0696p as=0.0696p pd=1.16u ps=1.16u
    I_MXI13_MN11 (VSS B_3 XI13_xbn VSS) gpdk090_nmos1v w=0.12u l=0.1u ad=0.0696p as=0.0696p pd=1.16u ps=1.16u
    I_MXI13_MN14 (VSS XI13_xbn XI13_xn1 VSS) gpdk090_nmos1v w=0.24u l=0.1u ad=0.0528p as=0.0816p pd=0.68u ps=1.16u
    I_MXI13_MN16 (XI13_xn2 B_3 VSS VSS) gpdk090_nmos1v w=0.24u l=0.1u ad=0.0528p as=0.0528p pd=0.68u ps=0.68u
    I_MXI13_MN15 (pp1_1 XI13_xan XI13_xn2 VSS) gpdk090_nmos1v w=0.24u l=0.1u ad=0.0528p as=0.0528p pd=0.68u ps=0.68u
    I_MXI13_MN13 (XI13_xn1 XI13_xn pp1_1 VSS) gpdk090_nmos1v w=0.24u l=0.1u ad=0.0816p as=0.0528p pd=1.16u ps=0.68u
    I_MXI13_MN2 (VSS A_1 XI13_n1 VSS) gpdk090_nmos1v w=0.24u l=0.1u ad=0.0528p as=0.0816p pd=0.68u ps=1.16u
    I_MXI13_MN4 (XI13_n2 A_0 VSS VSS) gpdk090_nmos1v w=0.24u l=0.1u ad=0.0528p as=0.0528p pd=0.68u ps=0.68u
    I_MXI13_MN3 (XI13_xn two1 XI13_n2 VSS) gpdk090_nmos1v w=0.24u l=0.1u ad=0.0528p as=0.0528p pd=0.68u ps=0.68u
    I_MXI13_MN1 (XI13_n1 one1 XI13_xn VSS) gpdk090_nmos1v w=0.24u l=0.1u ad=0.0816p as=0.0528p pd=1.16u ps=0.68u
    I_MXI13_MN9 (VSS XI13_xn XI13_xan VSS) gpdk090_nmos1v w=0.12u l=0.1u ad=0.0696p as=0.0696p pd=1.16u ps=1.16u
    I_MXI38_MN11 (VSS B_7 XI38_xbn VSS) gpdk090_nmos1v w=0.12u l=0.1u ad=0.0696p as=0.0696p pd=1.16u ps=1.16u
    I_MXI38_MN14 (VSS XI38_xbn XI38_xn1 VSS) gpdk090_nmos1v w=0.24u l=0.1u ad=0.0528p as=0.0816p pd=0.68u ps=1.16u
    I_MXI38_MN16 (XI38_xn2 B_7 VSS VSS) gpdk090_nmos1v w=0.24u l=0.1u ad=0.0528p as=0.0528p pd=0.68u ps=0.68u
    I_MXI38_MN15 (pp3_4 XI38_xan XI38_xn2 VSS) gpdk090_nmos1v w=0.24u l=0.1u ad=0.0528p as=0.0528p pd=0.68u ps=0.68u
    I_MXI38_MN13 (XI38_xn1 XI38_xn pp3_4 VSS) gpdk090_nmos1v w=0.24u l=0.1u ad=0.0816p as=0.0528p pd=1.16u ps=0.68u
    I_MXI38_MN2 (VSS A_4 XI38_n1 VSS) gpdk090_nmos1v w=0.24u l=0.1u ad=0.0528p as=0.0816p pd=0.68u ps=1.16u
    I_MXI38_MN4 (XI38_n2 A_3 VSS VSS) gpdk090_nmos1v w=0.24u l=0.1u ad=0.0528p as=0.0528p pd=0.68u ps=0.68u
    I_MXI38_MN3 (XI38_xn two3 XI38_n2 VSS) gpdk090_nmos1v w=0.24u l=0.1u ad=0.0528p as=0.0528p pd=0.68u ps=0.68u
    I_MXI38_MN1 (XI38_n1 one3 XI38_xn VSS) gpdk090_nmos1v w=0.24u l=0.1u ad=0.0816p as=0.0528p pd=1.16u ps=0.68u
    I_MXI38_MN9 (VSS XI38_xn XI38_xan VSS) gpdk090_nmos1v w=0.12u l=0.1u ad=0.0696p as=0.0696p pd=1.16u ps=1.16u
    I_MXI37_MN11 (VSS B_7 XI37_xbn VSS) gpdk090_nmos1v w=0.12u l=0.1u ad=0.0696p as=0.0696p pd=1.16u ps=1.16u
    I_MXI37_MN14 (VSS XI37_xbn XI37_xn1 VSS) gpdk090_nmos1v w=0.24u l=0.1u ad=0.0528p as=0.0816p pd=0.68u ps=1.16u
    I_MXI37_MN16 (XI37_xn2 B_7 VSS VSS) gpdk090_nmos1v w=0.24u l=0.1u ad=0.0528p as=0.0528p pd=0.68u ps=0.68u
    I_MXI37_MN15 (pp3_3 XI37_xan XI37_xn2 VSS) gpdk090_nmos1v w=0.24u l=0.1u ad=0.0528p as=0.0528p pd=0.68u ps=0.68u
    I_MXI37_MN13 (XI37_xn1 XI37_xn pp3_3 VSS) gpdk090_nmos1v w=0.24u l=0.1u ad=0.0816p as=0.0528p pd=1.16u ps=0.68u
    I_MXI37_MN2 (VSS A_3 XI37_n1 VSS) gpdk090_nmos1v w=0.24u l=0.1u ad=0.0528p as=0.0816p pd=0.68u ps=1.16u
    I_MXI37_MN4 (XI37_n2 A_2 VSS VSS) gpdk090_nmos1v w=0.24u l=0.1u ad=0.0528p as=0.0528p pd=0.68u ps=0.68u
    I_MXI37_MN3 (XI37_xn two3 XI37_n2 VSS) gpdk090_nmos1v w=0.24u l=0.1u ad=0.0528p as=0.0528p pd=0.68u ps=0.68u
    I_MXI37_MN1 (XI37_n1 one3 XI37_xn VSS) gpdk090_nmos1v w=0.24u l=0.1u ad=0.0816p as=0.0528p pd=1.16u ps=0.68u
    I_MXI37_MN9 (VSS XI37_xn XI37_xan VSS) gpdk090_nmos1v w=0.12u l=0.1u ad=0.0696p as=0.0696p pd=1.16u ps=1.16u
    I_MXI25_MN11 (VSS B_5 XI25_xbn VSS) gpdk090_nmos1v w=0.12u l=0.1u ad=0.0696p as=0.0696p pd=1.16u ps=1.16u
    I_MXI25_MN14 (VSS XI25_xbn XI25_xn1 VSS) gpdk090_nmos1v w=0.24u l=0.1u ad=0.0528p as=0.0816p pd=0.68u ps=1.16u
    I_MXI25_MN16 (XI25_xn2 B_5 VSS VSS) gpdk090_nmos1v w=0.24u l=0.1u ad=0.0528p as=0.0528p pd=0.68u ps=0.68u
    I_MXI25_MN15 (pp2_2 XI25_xan XI25_xn2 VSS) gpdk090_nmos1v w=0.24u l=0.1u ad=0.0528p as=0.0528p pd=0.68u ps=0.68u
    I_MXI25_MN13 (XI25_xn1 XI25_xn pp2_2 VSS) gpdk090_nmos1v w=0.24u l=0.1u ad=0.0816p as=0.0528p pd=1.16u ps=0.68u
    I_MXI25_MN2 (VSS A_2 XI25_n1 VSS) gpdk090_nmos1v w=0.24u l=0.1u ad=0.0528p as=0.0816p pd=0.68u ps=1.16u
    I_MXI25_MN4 (XI25_n2 A_1 VSS VSS) gpdk090_nmos1v w=0.24u l=0.1u ad=0.0528p as=0.0528p pd=0.68u ps=0.68u
    I_MXI25_MN3 (XI25_xn two2 XI25_n2 VSS) gpdk090_nmos1v w=0.24u l=0.1u ad=0.0528p as=0.0528p pd=0.68u ps=0.68u
    I_MXI25_MN1 (XI25_n1 one2 XI25_xn VSS) gpdk090_nmos1v w=0.24u l=0.1u ad=0.0816p as=0.0528p pd=1.16u ps=0.68u
    I_MXI25_MN9 (VSS XI25_xn XI25_xan VSS) gpdk090_nmos1v w=0.12u l=0.1u ad=0.0696p as=0.0696p pd=1.16u ps=1.16u
    I_MXI16_MN11 (VSS B_3 XI16_xbn VSS) gpdk090_nmos1v w=0.12u l=0.1u ad=0.0696p as=0.0696p pd=1.16u ps=1.16u
    I_MXI16_MN14 (VSS XI16_xbn XI16_xn1 VSS) gpdk090_nmos1v w=0.24u l=0.1u ad=0.0528p as=0.0816p pd=0.68u ps=1.16u
    I_MXI16_MN16 (XI16_xn2 B_3 VSS VSS) gpdk090_nmos1v w=0.24u l=0.1u ad=0.0528p as=0.0528p pd=0.68u ps=0.68u
    I_MXI16_MN15 (pp1_4 XI16_xan XI16_xn2 VSS) gpdk090_nmos1v w=0.24u l=0.1u ad=0.0528p as=0.0528p pd=0.68u ps=0.68u
    I_MXI16_MN13 (XI16_xn1 XI16_xn pp1_4 VSS) gpdk090_nmos1v w=0.24u l=0.1u ad=0.0816p as=0.0528p pd=1.16u ps=0.68u
    I_MXI16_MN2 (VSS A_4 XI16_n1 VSS) gpdk090_nmos1v w=0.24u l=0.1u ad=0.0528p as=0.0816p pd=0.68u ps=1.16u
    I_MXI16_MN4 (XI16_n2 A_3 VSS VSS) gpdk090_nmos1v w=0.24u l=0.1u ad=0.0528p as=0.0528p pd=0.68u ps=0.68u
    I_MXI16_MN3 (XI16_xn two1 XI16_n2 VSS) gpdk090_nmos1v w=0.24u l=0.1u ad=0.0528p as=0.0528p pd=0.68u ps=0.68u
    I_MXI16_MN1 (XI16_n1 one1 XI16_xn VSS) gpdk090_nmos1v w=0.24u l=0.1u ad=0.0816p as=0.0528p pd=1.16u ps=0.68u
    I_MXI16_MN9 (VSS XI16_xn XI16_xan VSS) gpdk090_nmos1v w=0.12u l=0.1u ad=0.0696p as=0.0696p pd=1.16u ps=1.16u
    I_MXI6_MN11 (VSS B_1 XI6_xbn VSS) gpdk090_nmos1v w=0.12u l=0.1u ad=0.0696p as=0.0696p pd=1.16u ps=1.16u
    I_MXI6_MN14 (VSS XI6_xbn XI6_xn1 VSS) gpdk090_nmos1v w=0.24u l=0.1u ad=0.0528p as=0.0816p pd=0.68u ps=1.16u
    I_MXI6_MN16 (XI6_xn2 B_1 VSS VSS) gpdk090_nmos1v w=0.24u l=0.1u ad=0.0528p as=0.0528p pd=0.68u ps=0.68u
    I_MXI6_MN15 (pp0_5 XI6_xan XI6_xn2 VSS) gpdk090_nmos1v w=0.24u l=0.1u ad=0.0528p as=0.0528p pd=0.68u ps=0.68u
    I_MXI6_MN13 (XI6_xn1 XI6_xn pp0_5 VSS) gpdk090_nmos1v w=0.24u l=0.1u ad=0.0816p as=0.0528p pd=1.16u ps=0.68u
    I_MXI6_MN2 (VSS A_5 XI6_n1 VSS) gpdk090_nmos1v w=0.24u l=0.1u ad=0.0528p as=0.0816p pd=0.68u ps=1.16u
    I_MXI6_MN4 (XI6_n2 A_4 VSS VSS) gpdk090_nmos1v w=0.24u l=0.1u ad=0.0528p as=0.0528p pd=0.68u ps=0.68u
    I_MXI6_MN3 (XI6_xn two0 XI6_n2 VSS) gpdk090_nmos1v w=0.24u l=0.1u ad=0.0528p as=0.0528p pd=0.68u ps=0.68u
    I_MXI6_MN1 (XI6_n1 one0 XI6_xn VSS) gpdk090_nmos1v w=0.24u l=0.1u ad=0.0816p as=0.0528p pd=1.16u ps=0.68u
    I_MXI6_MN9 (VSS XI6_xn XI6_xan VSS) gpdk090_nmos1v w=0.12u l=0.1u ad=0.0696p as=0.0696p pd=1.16u ps=1.16u
    I_MXI4_MN11 (VSS B_1 XI4_xbn VSS) gpdk090_nmos1v w=0.12u l=0.1u ad=0.0696p as=0.0696p pd=1.16u ps=1.16u
    I_MXI4_MN14 (VSS XI4_xbn XI4_xn1 VSS) gpdk090_nmos1v w=0.24u l=0.1u ad=0.0528p as=0.0816p pd=0.68u ps=1.16u
    I_MXI4_MN16 (XI4_xn2 B_1 VSS VSS) gpdk090_nmos1v w=0.24u l=0.1u ad=0.0528p as=0.0528p pd=0.68u ps=0.68u
    I_MXI4_MN15 (pp0_3 XI4_xan XI4_xn2 VSS) gpdk090_nmos1v w=0.24u l=0.1u ad=0.0528p as=0.0528p pd=0.68u ps=0.68u
    I_MXI4_MN13 (XI4_xn1 XI4_xn pp0_3 VSS) gpdk090_nmos1v w=0.24u l=0.1u ad=0.0816p as=0.0528p pd=1.16u ps=0.68u
    I_MXI4_MN2 (VSS A_3 XI4_n1 VSS) gpdk090_nmos1v w=0.24u l=0.1u ad=0.0528p as=0.0816p pd=0.68u ps=1.16u
    I_MXI4_MN4 (XI4_n2 A_2 VSS VSS) gpdk090_nmos1v w=0.24u l=0.1u ad=0.0528p as=0.0528p pd=0.68u ps=0.68u
    I_MXI4_MN3 (XI4_xn two0 XI4_n2 VSS) gpdk090_nmos1v w=0.24u l=0.1u ad=0.0528p as=0.0528p pd=0.68u ps=0.68u
    I_MXI4_MN1 (XI4_n1 one0 XI4_xn VSS) gpdk090_nmos1v w=0.24u l=0.1u ad=0.0816p as=0.0528p pd=1.16u ps=0.68u
    I_MXI4_MN9 (VSS XI4_xn XI4_xan VSS) gpdk090_nmos1v w=0.12u l=0.1u ad=0.0696p as=0.0696p pd=1.16u ps=1.16u
    I_MXI12_MN11 (VSS B_3 XI12_xbn VSS) gpdk090_nmos1v w=0.12u l=0.1u ad=0.0696p as=0.0696p pd=1.16u ps=1.16u
    I_MXI12_MN14 (VSS XI12_xbn XI12_xn1 VSS) gpdk090_nmos1v w=0.24u l=0.1u ad=0.0528p as=0.0816p pd=0.68u ps=1.16u
    I_MXI12_MN16 (XI12_xn2 B_3 VSS VSS) gpdk090_nmos1v w=0.24u l=0.1u ad=0.0528p as=0.0528p pd=0.68u ps=0.68u
    I_MXI12_MN15 (pp1_0 XI12_xan XI12_xn2 VSS) gpdk090_nmos1v w=0.24u l=0.1u ad=0.0528p as=0.0528p pd=0.68u ps=0.68u
    I_MXI12_MN13 (XI12_xn1 XI12_xn pp1_0 VSS) gpdk090_nmos1v w=0.24u l=0.1u ad=0.0816p as=0.0528p pd=1.16u ps=0.68u
    I_MXI12_MN2 (VSS A_0 XI12_n1 VSS) gpdk090_nmos1v w=0.24u l=0.1u ad=0.0528p as=0.0816p pd=0.68u ps=1.16u
    I_MXI12_MN4 (XI12_n2 VSS VSS VSS) gpdk090_nmos1v w=0.24u l=0.1u ad=0.0528p as=0.0528p pd=0.68u ps=0.68u
    I_MXI12_MN3 (XI12_xn two1 XI12_n2 VSS) gpdk090_nmos1v w=0.24u l=0.1u ad=0.0528p as=0.0528p pd=0.68u ps=0.68u
    I_MXI12_MN1 (XI12_n1 one1 XI12_xn VSS) gpdk090_nmos1v w=0.24u l=0.1u ad=0.0816p as=0.0528p pd=1.16u ps=0.68u
    I_MXI12_MN9 (VSS XI12_xn XI12_xan VSS) gpdk090_nmos1v w=0.12u l=0.1u ad=0.0696p as=0.0696p pd=1.16u ps=1.16u
    I_MXI39_MN11 (VSS B_7 XI39_xbn VSS) gpdk090_nmos1v w=0.12u l=0.1u ad=0.0696p as=0.0696p pd=1.16u ps=1.16u
    I_MXI39_MN14 (VSS XI39_xbn XI39_xn1 VSS) gpdk090_nmos1v w=0.24u l=0.1u ad=0.0528p as=0.0816p pd=0.68u ps=1.16u
    I_MXI39_MN16 (XI39_xn2 B_7 VSS VSS) gpdk090_nmos1v w=0.24u l=0.1u ad=0.0528p as=0.0528p pd=0.68u ps=0.68u
    I_MXI39_MN15 (pp3_5 XI39_xan XI39_xn2 VSS) gpdk090_nmos1v w=0.24u l=0.1u ad=0.0528p as=0.0528p pd=0.68u ps=0.68u
    I_MXI39_MN13 (XI39_xn1 XI39_xn pp3_5 VSS) gpdk090_nmos1v w=0.24u l=0.1u ad=0.0816p as=0.0528p pd=1.16u ps=0.68u
    I_MXI39_MN2 (VSS A_5 XI39_n1 VSS) gpdk090_nmos1v w=0.24u l=0.1u ad=0.0528p as=0.0816p pd=0.68u ps=1.16u
    I_MXI39_MN4 (XI39_n2 A_4 VSS VSS) gpdk090_nmos1v w=0.24u l=0.1u ad=0.0528p as=0.0528p pd=0.68u ps=0.68u
    I_MXI39_MN3 (XI39_xn two3 XI39_n2 VSS) gpdk090_nmos1v w=0.24u l=0.1u ad=0.0528p as=0.0528p pd=0.68u ps=0.68u
    I_MXI39_MN1 (XI39_n1 one3 XI39_xn VSS) gpdk090_nmos1v w=0.24u l=0.1u ad=0.0816p as=0.0528p pd=1.16u ps=0.68u
    I_MXI39_MN9 (VSS XI39_xn XI39_xan VSS) gpdk090_nmos1v w=0.12u l=0.1u ad=0.0696p as=0.0696p pd=1.16u ps=1.16u
    I_MXI31_MN11 (VSS B_5 XI31_xbn VSS) gpdk090_nmos1v w=0.12u l=0.1u ad=0.0696p as=0.0696p pd=1.16u ps=1.16u
    I_MXI31_MN14 (VSS XI31_xbn XI31_xn1 VSS) gpdk090_nmos1v w=0.24u l=0.1u ad=0.0528p as=0.0816p pd=0.68u ps=1.16u
    I_MXI31_MN16 (XI31_xn2 B_5 VSS VSS) gpdk090_nmos1v w=0.24u l=0.1u ad=0.0528p as=0.0528p pd=0.68u ps=0.68u
    I_MXI31_MN15 (pp2_8 XI31_xan XI31_xn2 VSS) gpdk090_nmos1v w=0.24u l=0.1u ad=0.0528p as=0.0528p pd=0.68u ps=0.68u
    I_MXI31_MN13 (XI31_xn1 XI31_xn pp2_8 VSS) gpdk090_nmos1v w=0.24u l=0.1u ad=0.0816p as=0.0528p pd=1.16u ps=0.68u
    I_MXI31_MN2 (VSS A_7 XI31_n1 VSS) gpdk090_nmos1v w=0.24u l=0.1u ad=0.0528p as=0.0816p pd=0.68u ps=1.16u
    I_MXI31_MN4 (XI31_n2 A_7 VSS VSS) gpdk090_nmos1v w=0.24u l=0.1u ad=0.0528p as=0.0528p pd=0.68u ps=0.68u
    I_MXI31_MN3 (XI31_xn two2 XI31_n2 VSS) gpdk090_nmos1v w=0.24u l=0.1u ad=0.0528p as=0.0528p pd=0.68u ps=0.68u
    I_MXI31_MN1 (XI31_n1 one2 XI31_xn VSS) gpdk090_nmos1v w=0.24u l=0.1u ad=0.0816p as=0.0528p pd=1.16u ps=0.68u
    I_MXI31_MN9 (VSS XI31_xn XI31_xan VSS) gpdk090_nmos1v w=0.12u l=0.1u ad=0.0696p as=0.0696p pd=1.16u ps=1.16u
    I_MXI35_MN11 (VSS B_7 XI35_xbn VSS) gpdk090_nmos1v w=0.12u l=0.1u ad=0.0696p as=0.0696p pd=1.16u ps=1.16u
    I_MXI35_MN14 (VSS XI35_xbn XI35_xn1 VSS) gpdk090_nmos1v w=0.24u l=0.1u ad=0.0528p as=0.0816p pd=0.68u ps=1.16u
    I_MXI35_MN16 (XI35_xn2 B_7 VSS VSS) gpdk090_nmos1v w=0.24u l=0.1u ad=0.0528p as=0.0528p pd=0.68u ps=0.68u
    I_MXI35_MN15 (pp3_1 XI35_xan XI35_xn2 VSS) gpdk090_nmos1v w=0.24u l=0.1u ad=0.0528p as=0.0528p pd=0.68u ps=0.68u
    I_MXI35_MN13 (XI35_xn1 XI35_xn pp3_1 VSS) gpdk090_nmos1v w=0.24u l=0.1u ad=0.0816p as=0.0528p pd=1.16u ps=0.68u
    I_MXI35_MN2 (VSS A_1 XI35_n1 VSS) gpdk090_nmos1v w=0.24u l=0.1u ad=0.0528p as=0.0816p pd=0.68u ps=1.16u
    I_MXI35_MN4 (XI35_n2 A_0 VSS VSS) gpdk090_nmos1v w=0.24u l=0.1u ad=0.0528p as=0.0528p pd=0.68u ps=0.68u
    I_MXI35_MN3 (XI35_xn two3 XI35_n2 VSS) gpdk090_nmos1v w=0.24u l=0.1u ad=0.0528p as=0.0528p pd=0.68u ps=0.68u
    I_MXI35_MN1 (XI35_n1 one3 XI35_xn VSS) gpdk090_nmos1v w=0.24u l=0.1u ad=0.0816p as=0.0528p pd=1.16u ps=0.68u
    I_MXI35_MN9 (VSS XI35_xn XI35_xan VSS) gpdk090_nmos1v w=0.12u l=0.1u ad=0.0696p as=0.0696p pd=1.16u ps=1.16u
    I_MXI36_MN11 (VSS B_7 XI36_xbn VSS) gpdk090_nmos1v w=0.12u l=0.1u ad=0.0696p as=0.0696p pd=1.16u ps=1.16u
    I_MXI36_MN14 (VSS XI36_xbn XI36_xn1 VSS) gpdk090_nmos1v w=0.24u l=0.1u ad=0.0528p as=0.0816p pd=0.68u ps=1.16u
    I_MXI36_MN16 (XI36_xn2 B_7 VSS VSS) gpdk090_nmos1v w=0.24u l=0.1u ad=0.0528p as=0.0528p pd=0.68u ps=0.68u
    I_MXI36_MN15 (pp3_2 XI36_xan XI36_xn2 VSS) gpdk090_nmos1v w=0.24u l=0.1u ad=0.0528p as=0.0528p pd=0.68u ps=0.68u
    I_MXI36_MN13 (XI36_xn1 XI36_xn pp3_2 VSS) gpdk090_nmos1v w=0.24u l=0.1u ad=0.0816p as=0.0528p pd=1.16u ps=0.68u
    I_MXI36_MN2 (VSS A_2 XI36_n1 VSS) gpdk090_nmos1v w=0.24u l=0.1u ad=0.0528p as=0.0816p pd=0.68u ps=1.16u
    I_MXI36_MN4 (XI36_n2 A_1 VSS VSS) gpdk090_nmos1v w=0.24u l=0.1u ad=0.0528p as=0.0528p pd=0.68u ps=0.68u
    I_MXI36_MN3 (XI36_xn two3 XI36_n2 VSS) gpdk090_nmos1v w=0.24u l=0.1u ad=0.0528p as=0.0528p pd=0.68u ps=0.68u
    I_MXI36_MN1 (XI36_n1 one3 XI36_xn VSS) gpdk090_nmos1v w=0.24u l=0.1u ad=0.0816p as=0.0528p pd=1.16u ps=0.68u
    I_MXI36_MN9 (VSS XI36_xn XI36_xan VSS) gpdk090_nmos1v w=0.12u l=0.1u ad=0.0696p as=0.0696p pd=1.16u ps=1.16u
    I_MXI9_MN11 (VSS B_1 XI9_xbn VSS) gpdk090_nmos1v w=0.12u l=0.1u ad=0.0696p as=0.0696p pd=1.16u ps=1.16u
    I_MXI9_MN14 (VSS XI9_xbn XI9_xn1 VSS) gpdk090_nmos1v w=0.24u l=0.1u ad=0.0528p as=0.0816p pd=0.68u ps=1.16u
    I_MXI9_MN16 (XI9_xn2 B_1 VSS VSS) gpdk090_nmos1v w=0.24u l=0.1u ad=0.0528p as=0.0528p pd=0.68u ps=0.68u
    I_MXI9_MN15 (pp0_8 XI9_xan XI9_xn2 VSS) gpdk090_nmos1v w=0.24u l=0.1u ad=0.0528p as=0.0528p pd=0.68u ps=0.68u
    I_MXI9_MN13 (XI9_xn1 XI9_xn pp0_8 VSS) gpdk090_nmos1v w=0.24u l=0.1u ad=0.0816p as=0.0528p pd=1.16u ps=0.68u
    I_MXI9_MN2 (VSS A_7 XI9_n1 VSS) gpdk090_nmos1v w=0.24u l=0.1u ad=0.0528p as=0.0816p pd=0.68u ps=1.16u
    I_MXI9_MN4 (XI9_n2 A_7 VSS VSS) gpdk090_nmos1v w=0.24u l=0.1u ad=0.0528p as=0.0528p pd=0.68u ps=0.68u
    I_MXI9_MN3 (XI9_xn two0 XI9_n2 VSS) gpdk090_nmos1v w=0.24u l=0.1u ad=0.0528p as=0.0528p pd=0.68u ps=0.68u
    I_MXI9_MN1 (XI9_n1 one0 XI9_xn VSS) gpdk090_nmos1v w=0.24u l=0.1u ad=0.0816p as=0.0528p pd=1.16u ps=0.68u
    I_MXI9_MN9 (VSS XI9_xn XI9_xan VSS) gpdk090_nmos1v w=0.12u l=0.1u ad=0.0696p as=0.0696p pd=1.16u ps=1.16u
    I_MXI7_MN11 (VSS B_1 XI7_xbn VSS) gpdk090_nmos1v w=0.12u l=0.1u ad=0.0696p as=0.0696p pd=1.16u ps=1.16u
    I_MXI7_MN14 (VSS XI7_xbn XI7_xn1 VSS) gpdk090_nmos1v w=0.24u l=0.1u ad=0.0528p as=0.0816p pd=0.68u ps=1.16u
    I_MXI7_MN16 (XI7_xn2 B_1 VSS VSS) gpdk090_nmos1v w=0.24u l=0.1u ad=0.0528p as=0.0528p pd=0.68u ps=0.68u
    I_MXI7_MN15 (pp0_6 XI7_xan XI7_xn2 VSS) gpdk090_nmos1v w=0.24u l=0.1u ad=0.0528p as=0.0528p pd=0.68u ps=0.68u
    I_MXI7_MN13 (XI7_xn1 XI7_xn pp0_6 VSS) gpdk090_nmos1v w=0.24u l=0.1u ad=0.0816p as=0.0528p pd=1.16u ps=0.68u
    I_MXI7_MN2 (VSS A_6 XI7_n1 VSS) gpdk090_nmos1v w=0.24u l=0.1u ad=0.0528p as=0.0816p pd=0.68u ps=1.16u
    I_MXI7_MN4 (XI7_n2 A_5 VSS VSS) gpdk090_nmos1v w=0.24u l=0.1u ad=0.0528p as=0.0528p pd=0.68u ps=0.68u
    I_MXI7_MN3 (XI7_xn two0 XI7_n2 VSS) gpdk090_nmos1v w=0.24u l=0.1u ad=0.0528p as=0.0528p pd=0.68u ps=0.68u
    I_MXI7_MN1 (XI7_n1 one0 XI7_xn VSS) gpdk090_nmos1v w=0.24u l=0.1u ad=0.0816p as=0.0528p pd=1.16u ps=0.68u
    I_MXI7_MN9 (VSS XI7_xn XI7_xan VSS) gpdk090_nmos1v w=0.12u l=0.1u ad=0.0696p as=0.0696p pd=1.16u ps=1.16u
    I_MXI3_MN11 (VSS B_1 XI3_xbn VSS) gpdk090_nmos1v w=0.12u l=0.1u ad=0.0696p as=0.0696p pd=1.16u ps=1.16u
    I_MXI3_MN14 (VSS XI3_xbn XI3_xn1 VSS) gpdk090_nmos1v w=0.24u l=0.1u ad=0.0528p as=0.0816p pd=0.68u ps=1.16u
    I_MXI3_MN16 (XI3_xn2 B_1 VSS VSS) gpdk090_nmos1v w=0.24u l=0.1u ad=0.0528p as=0.0528p pd=0.68u ps=0.68u
    I_MXI3_MN15 (pp0_2 XI3_xan XI3_xn2 VSS) gpdk090_nmos1v w=0.24u l=0.1u ad=0.0528p as=0.0528p pd=0.68u ps=0.68u
    I_MXI3_MN13 (XI3_xn1 XI3_xn pp0_2 VSS) gpdk090_nmos1v w=0.24u l=0.1u ad=0.0816p as=0.0528p pd=1.16u ps=0.68u
    I_MXI3_MN2 (VSS A_2 XI3_n1 VSS) gpdk090_nmos1v w=0.24u l=0.1u ad=0.0528p as=0.0816p pd=0.68u ps=1.16u
    I_MXI3_MN4 (XI3_n2 A_1 VSS VSS) gpdk090_nmos1v w=0.24u l=0.1u ad=0.0528p as=0.0528p pd=0.68u ps=0.68u
    I_MXI3_MN3 (XI3_xn two0 XI3_n2 VSS) gpdk090_nmos1v w=0.24u l=0.1u ad=0.0528p as=0.0528p pd=0.68u ps=0.68u
    I_MXI3_MN1 (XI3_n1 one0 XI3_xn VSS) gpdk090_nmos1v w=0.24u l=0.1u ad=0.0816p as=0.0528p pd=1.16u ps=0.68u
    I_MXI3_MN9 (VSS XI3_xn XI3_xan VSS) gpdk090_nmos1v w=0.12u l=0.1u ad=0.0696p as=0.0696p pd=1.16u ps=1.16u
    I_MXI41_MN11 (VSS B_7 XI41_xbn VSS) gpdk090_nmos1v w=0.12u l=0.1u ad=0.0696p as=0.0696p pd=1.16u ps=1.16u
    I_MXI41_MN14 (VSS XI41_xbn XI41_xn1 VSS) gpdk090_nmos1v w=0.24u l=0.1u ad=0.0528p as=0.0816p pd=0.68u ps=1.16u
    I_MXI41_MN16 (XI41_xn2 B_7 VSS VSS) gpdk090_nmos1v w=0.24u l=0.1u ad=0.0528p as=0.0528p pd=0.68u ps=0.68u
    I_MXI41_MN15 (pp3_7 XI41_xan XI41_xn2 VSS) gpdk090_nmos1v w=0.24u l=0.1u ad=0.0528p as=0.0528p pd=0.68u ps=0.68u
    I_MXI41_MN13 (XI41_xn1 XI41_xn pp3_7 VSS) gpdk090_nmos1v w=0.24u l=0.1u ad=0.0816p as=0.0528p pd=1.16u ps=0.68u
    I_MXI41_MN2 (VSS A_7 XI41_n1 VSS) gpdk090_nmos1v w=0.24u l=0.1u ad=0.0528p as=0.0816p pd=0.68u ps=1.16u
    I_MXI41_MN4 (XI41_n2 A_6 VSS VSS) gpdk090_nmos1v w=0.24u l=0.1u ad=0.0528p as=0.0528p pd=0.68u ps=0.68u
    I_MXI41_MN3 (XI41_xn two3 XI41_n2 VSS) gpdk090_nmos1v w=0.24u l=0.1u ad=0.0528p as=0.0528p pd=0.68u ps=0.68u
    I_MXI41_MN1 (XI41_n1 one3 XI41_xn VSS) gpdk090_nmos1v w=0.24u l=0.1u ad=0.0816p as=0.0528p pd=1.16u ps=0.68u
    I_MXI41_MN9 (VSS XI41_xn XI41_xan VSS) gpdk090_nmos1v w=0.12u l=0.1u ad=0.0696p as=0.0696p pd=1.16u ps=1.16u
    I_MXI40_MN11 (VSS B_7 XI40_xbn VSS) gpdk090_nmos1v w=0.12u l=0.1u ad=0.0696p as=0.0696p pd=1.16u ps=1.16u
    I_MXI40_MN14 (VSS XI40_xbn XI40_xn1 VSS) gpdk090_nmos1v w=0.24u l=0.1u ad=0.0528p as=0.0816p pd=0.68u ps=1.16u
    I_MXI40_MN16 (XI40_xn2 B_7 VSS VSS) gpdk090_nmos1v w=0.24u l=0.1u ad=0.0528p as=0.0528p pd=0.68u ps=0.68u
    I_MXI40_MN15 (pp3_6 XI40_xan XI40_xn2 VSS) gpdk090_nmos1v w=0.24u l=0.1u ad=0.0528p as=0.0528p pd=0.68u ps=0.68u
    I_MXI40_MN13 (XI40_xn1 XI40_xn pp3_6 VSS) gpdk090_nmos1v w=0.24u l=0.1u ad=0.0816p as=0.0528p pd=1.16u ps=0.68u
    I_MXI40_MN2 (VSS A_6 XI40_n1 VSS) gpdk090_nmos1v w=0.24u l=0.1u ad=0.0528p as=0.0816p pd=0.68u ps=1.16u
    I_MXI40_MN4 (XI40_n2 A_5 VSS VSS) gpdk090_nmos1v w=0.24u l=0.1u ad=0.0528p as=0.0528p pd=0.68u ps=0.68u
    I_MXI40_MN3 (XI40_xn two3 XI40_n2 VSS) gpdk090_nmos1v w=0.24u l=0.1u ad=0.0528p as=0.0528p pd=0.68u ps=0.68u
    I_MXI40_MN1 (XI40_n1 one3 XI40_xn VSS) gpdk090_nmos1v w=0.24u l=0.1u ad=0.0816p as=0.0528p pd=1.16u ps=0.68u
    I_MXI40_MN9 (VSS XI40_xn XI40_xan VSS) gpdk090_nmos1v w=0.12u l=0.1u ad=0.0696p as=0.0696p pd=1.16u ps=1.16u
    I_MXI34_MN11 (VSS B_7 XI34_xbn VSS) gpdk090_nmos1v w=0.12u l=0.1u ad=0.0696p as=0.0696p pd=1.16u ps=1.16u
    I_MXI34_MN14 (VSS XI34_xbn XI34_xn1 VSS) gpdk090_nmos1v w=0.24u l=0.1u ad=0.0528p as=0.0816p pd=0.68u ps=1.16u
    I_MXI34_MN16 (XI34_xn2 B_7 VSS VSS) gpdk090_nmos1v w=0.24u l=0.1u ad=0.0528p as=0.0528p pd=0.68u ps=0.68u
    I_MXI34_MN15 (pp3_0 XI34_xan XI34_xn2 VSS) gpdk090_nmos1v w=0.24u l=0.1u ad=0.0528p as=0.0528p pd=0.68u ps=0.68u
    I_MXI34_MN13 (XI34_xn1 XI34_xn pp3_0 VSS) gpdk090_nmos1v w=0.24u l=0.1u ad=0.0816p as=0.0528p pd=1.16u ps=0.68u
    I_MXI34_MN2 (VSS A_0 XI34_n1 VSS) gpdk090_nmos1v w=0.24u l=0.1u ad=0.0528p as=0.0816p pd=0.68u ps=1.16u
    I_MXI34_MN4 (XI34_n2 VSS VSS VSS) gpdk090_nmos1v w=0.24u l=0.1u ad=0.0528p as=0.0528p pd=0.68u ps=0.68u
    I_MXI34_MN3 (XI34_xn two3 XI34_n2 VSS) gpdk090_nmos1v w=0.24u l=0.1u ad=0.0528p as=0.0528p pd=0.68u ps=0.68u
    I_MXI34_MN1 (XI34_n1 one3 XI34_xn VSS) gpdk090_nmos1v w=0.24u l=0.1u ad=0.0816p as=0.0528p pd=1.16u ps=0.68u
    I_MXI34_MN9 (VSS XI34_xn XI34_xan VSS) gpdk090_nmos1v w=0.12u l=0.1u ad=0.0696p as=0.0696p pd=1.16u ps=1.16u
    I_MXI2_MN11 (VSS B_1 XI2_xbn VSS) gpdk090_nmos1v w=0.12u l=0.1u ad=0.0696p as=0.0696p pd=1.16u ps=1.16u
    I_MXI2_MN14 (VSS XI2_xbn XI2_xn1 VSS) gpdk090_nmos1v w=0.24u l=0.1u ad=0.0528p as=0.0816p pd=0.68u ps=1.16u
    I_MXI2_MN16 (XI2_xn2 B_1 VSS VSS) gpdk090_nmos1v w=0.24u l=0.1u ad=0.0528p as=0.0528p pd=0.68u ps=0.68u
    I_MXI2_MN15 (pp0_1 XI2_xan XI2_xn2 VSS) gpdk090_nmos1v w=0.24u l=0.1u ad=0.0528p as=0.0528p pd=0.68u ps=0.68u
    I_MXI2_MN13 (XI2_xn1 XI2_xn pp0_1 VSS) gpdk090_nmos1v w=0.24u l=0.1u ad=0.0816p as=0.0528p pd=1.16u ps=0.68u
    I_MXI2_MN2 (VSS A_1 XI2_n1 VSS) gpdk090_nmos1v w=0.24u l=0.1u ad=0.0528p as=0.0816p pd=0.68u ps=1.16u
    I_MXI2_MN4 (XI2_n2 A_0 VSS VSS) gpdk090_nmos1v w=0.24u l=0.1u ad=0.0528p as=0.0528p pd=0.68u ps=0.68u
    I_MXI2_MN3 (XI2_xn two0 XI2_n2 VSS) gpdk090_nmos1v w=0.24u l=0.1u ad=0.0528p as=0.0528p pd=0.68u ps=0.68u
    I_MXI2_MN1 (XI2_n1 one0 XI2_xn VSS) gpdk090_nmos1v w=0.24u l=0.1u ad=0.0816p as=0.0528p pd=1.16u ps=0.68u
    I_MXI2_MN9 (VSS XI2_xn XI2_xan VSS) gpdk090_nmos1v w=0.12u l=0.1u ad=0.0696p as=0.0696p pd=1.16u ps=1.16u
    I_MXI1_MN11 (VSS B_1 XI1_xbn VSS) gpdk090_nmos1v w=0.12u l=0.1u ad=0.0696p as=0.0696p pd=1.16u ps=1.16u
    I_MXI1_MN14 (VSS XI1_xbn XI1_xn1 VSS) gpdk090_nmos1v w=0.24u l=0.1u ad=0.0528p as=0.0816p pd=0.68u ps=1.16u
    I_MXI1_MN16 (XI1_xn2 B_1 VSS VSS) gpdk090_nmos1v w=0.24u l=0.1u ad=0.0528p as=0.0528p pd=0.68u ps=0.68u
    I_MXI1_MN15 (pp0_0 XI1_xan XI1_xn2 VSS) gpdk090_nmos1v w=0.24u l=0.1u ad=0.0528p as=0.0528p pd=0.68u ps=0.68u
    I_MXI1_MN13 (XI1_xn1 XI1_xn pp0_0 VSS) gpdk090_nmos1v w=0.24u l=0.1u ad=0.0816p as=0.0528p pd=1.16u ps=0.68u
    I_MXI1_MN2 (VSS A_0 XI1_n1 VSS) gpdk090_nmos1v w=0.24u l=0.1u ad=0.0528p as=0.0816p pd=0.68u ps=1.16u
    I_MXI1_MN4 (XI1_n2 VSS VSS VSS) gpdk090_nmos1v w=0.24u l=0.1u ad=0.0528p as=0.0528p pd=0.68u ps=0.68u
    I_MXI1_MN3 (XI1_xn two0 XI1_n2 VSS) gpdk090_nmos1v w=0.24u l=0.1u ad=0.0528p as=0.0528p pd=0.68u ps=0.68u
    I_MXI1_MN1 (XI1_n1 one0 XI1_xn VSS) gpdk090_nmos1v w=0.24u l=0.1u ad=0.0816p as=0.0528p pd=1.16u ps=0.68u
    I_MXI1_MN9 (VSS XI1_xn XI1_xan VSS) gpdk090_nmos1v w=0.12u l=0.1u ad=0.0696p as=0.0696p pd=1.16u ps=1.16u
    I_MXI42_MN11 (VSS B_7 XI42_xbn VSS) gpdk090_nmos1v w=0.12u l=0.1u ad=0.0696p as=0.0696p pd=1.16u ps=1.16u
    I_MXI42_MN14 (VSS XI42_xbn XI42_xn1 VSS) gpdk090_nmos1v w=0.24u l=0.1u ad=0.0528p as=0.0816p pd=0.68u ps=1.16u
    I_MXI42_MN16 (XI42_xn2 B_7 VSS VSS) gpdk090_nmos1v w=0.24u l=0.1u ad=0.0528p as=0.0528p pd=0.68u ps=0.68u
    I_MXI42_MN15 (pp3_8 XI42_xan XI42_xn2 VSS) gpdk090_nmos1v w=0.24u l=0.1u ad=0.0528p as=0.0528p pd=0.68u ps=0.68u
    I_MXI42_MN13 (XI42_xn1 XI42_xn pp3_8 VSS) gpdk090_nmos1v w=0.24u l=0.1u ad=0.0816p as=0.0528p pd=1.16u ps=0.68u
    I_MXI42_MN2 (VSS A_7 XI42_n1 VSS) gpdk090_nmos1v w=0.24u l=0.1u ad=0.0528p as=0.0816p pd=0.68u ps=1.16u
    I_MXI42_MN4 (XI42_n2 A_7 VSS VSS) gpdk090_nmos1v w=0.24u l=0.1u ad=0.0528p as=0.0528p pd=0.68u ps=0.68u
    I_MXI42_MN3 (XI42_xn two3 XI42_n2 VSS) gpdk090_nmos1v w=0.24u l=0.1u ad=0.0528p as=0.0528p pd=0.68u ps=0.68u
    I_MXI42_MN1 (XI42_n1 one3 XI42_xn VSS) gpdk090_nmos1v w=0.24u l=0.1u ad=0.0816p as=0.0528p pd=1.16u ps=0.68u
    I_MXI42_MN9 (VSS XI42_xn XI42_xan VSS) gpdk090_nmos1v w=0.12u l=0.1u ad=0.0696p as=0.0696p pd=1.16u ps=1.16u
    I_MXI77_I29_XP_MN1 (XI77_I29_XP_n1 I77_P3_2 VSS VSS) gpdk090_nmos1v w=0.24u l=0.1u ad=0.0528p as=0.0816p pd=0.68u ps=1.16u
    I_MXI77_I29_XP_MN0 (I77_P5_2n I77_P5_4 XI77_I29_XP_n1 VSS) gpdk090_nmos1v w=0.24u l=0.1u ad=0.0816p as=0.0528p pd=1.16u ps=0.68u
    I_MXI77_I28_XP_MN1 (XI77_I28_XP_n1 I77_P2_1 VSS VSS) gpdk090_nmos1v w=0.24u l=0.1u ad=0.0528p as=0.0816p pd=0.68u ps=1.16u
    I_MXI77_I28_XP_MN0 (I77_P4_1n I77_P4_3 XI77_I28_XP_n1 VSS) gpdk090_nmos1v w=0.24u l=0.1u ad=0.0816p as=0.0528p pd=1.16u ps=0.68u
    I_MXI77_I1_MN1 (XI77_I1_n1 ha19_0 VSS VSS) gpdk090_nmos1v w=0.24u l=0.1u ad=0.0528p as=0.0816p pd=0.68u ps=1.16u
    I_MXI77_I1_MN0 (I77_gn1 ha18_1 XI77_I1_n1 VSS) gpdk090_nmos1v w=0.24u l=0.1u ad=0.0816p as=0.0528p pd=1.16u ps=0.68u
    I_MXI77_I0_MN1 (XI77_I0_n1 ha18_0 VSS VSS) gpdk090_nmos1v w=0.24u l=0.1u ad=0.0528p as=0.0816p pd=0.68u ps=1.16u
    I_MXI77_I0_MN0 (I77_gn0 ha17_1 XI77_I0_n1 VSS) gpdk090_nmos1v w=0.24u l=0.1u ad=0.0816p as=0.0528p pd=1.16u ps=0.68u
    I_MXI77_I30_XP_MN1 (XI77_I30_XP_n1 I77_P4_3 VSS VSS) gpdk090_nmos1v w=0.24u l=0.1u ad=0.0528p as=0.0816p pd=0.68u ps=1.16u
    I_MXI77_I30_XP_MN0 (I77_P6_3n I77_P6_5 XI77_I30_XP_n1 VSS) gpdk090_nmos1v w=0.24u l=0.1u ad=0.0816p as=0.0528p pd=1.16u ps=0.68u
    I_MXI77_I2_MN1 (XI77_I2_n1 ha20_0 VSS VSS) gpdk090_nmos1v w=0.24u l=0.1u ad=0.0528p as=0.0816p pd=0.68u ps=1.16u
    I_MXI77_I2_MN0 (I77_gn2 ha19_1 XI77_I2_n1 VSS) gpdk090_nmos1v w=0.24u l=0.1u ad=0.0816p as=0.0528p pd=1.16u ps=0.68u
    I_MXI77_I31_XP_MN1 (XI77_I31_XP_n1 I77_P5_4 VSS VSS) gpdk090_nmos1v w=0.24u l=0.1u ad=0.0528p as=0.0816p pd=0.68u ps=1.16u
    I_MXI77_I31_XP_MN0 (I77_P7_4n I77_P7_6 XI77_I31_XP_n1 VSS) gpdk090_nmos1v w=0.24u l=0.1u ad=0.0816p as=0.0528p pd=1.16u ps=0.68u
    I_MXI77_I3_MN1 (XI77_I3_n1 ha21_0 VSS VSS) gpdk090_nmos1v w=0.24u l=0.1u ad=0.0528p as=0.0816p pd=0.68u ps=1.16u
    I_MXI77_I3_MN0 (I77_gn3 ha20_1 XI77_I3_n1 VSS) gpdk090_nmos1v w=0.24u l=0.1u ad=0.0816p as=0.0528p pd=1.16u ps=0.68u
    I_MXI77_I4_MN1 (XI77_I4_n1 ha22_0 VSS VSS) gpdk090_nmos1v w=0.24u l=0.1u ad=0.0528p as=0.0816p pd=0.68u ps=1.16u
    I_MXI77_I4_MN0 (I77_gn4 ha21_1 XI77_I4_n1 VSS) gpdk090_nmos1v w=0.24u l=0.1u ad=0.0816p as=0.0528p pd=1.16u ps=0.68u
    I_MXI77_I5_MN1 (XI77_I5_n1 ha23_0 VSS VSS) gpdk090_nmos1v w=0.24u l=0.1u ad=0.0528p as=0.0816p pd=0.68u ps=1.16u
    I_MXI77_I5_MN0 (I77_gn5 ha22_1 XI77_I5_n1 VSS) gpdk090_nmos1v w=0.24u l=0.1u ad=0.0816p as=0.0528p pd=1.16u ps=0.68u
    I_MXI77_I7_MN1 (XI77_I7_n1 ha25_0 VSS VSS) gpdk090_nmos1v w=0.24u l=0.1u ad=0.0528p as=0.0816p pd=0.68u ps=1.16u
    I_MXI77_I7_MN0 (I77_gn7 ha24_1 XI77_I7_n1 VSS) gpdk090_nmos1v w=0.24u l=0.1u ad=0.0816p as=0.0528p pd=1.16u ps=0.68u
    I_MXI77_I6_MN1 (XI77_I6_n1 ha24_0 VSS VSS) gpdk090_nmos1v w=0.24u l=0.1u ad=0.0528p as=0.0816p pd=0.68u ps=1.16u
    I_MXI77_I6_MN0 (I77_gn6 ha23_1 XI77_I6_n1 VSS) gpdk090_nmos1v w=0.24u l=0.1u ad=0.0816p as=0.0528p pd=1.16u ps=0.68u
    I_MXI77_I21_XP_MN0 (I77_P3_2 I77_pn3 VSS VSS) gpdk090_nmos1v w=0.12u l=0.1u ad=0.0408p as=0.0696p pd=0.68u ps=1.16u
    I_MXI77_I21_XP_MN1 (VSS I77_pn2 I77_P3_2 VSS) gpdk090_nmos1v w=0.12u l=0.1u ad=0.0696p as=0.0408p pd=1.16u ps=0.68u
    I_MXI77_I20_XP_MN0 (I77_P2_1 I77_pn2 VSS VSS) gpdk090_nmos1v w=0.12u l=0.1u ad=0.0408p as=0.0696p pd=0.68u ps=1.16u
    I_MXI77_I20_XP_MN1 (VSS I77_pn1 I77_P2_1 VSS) gpdk090_nmos1v w=0.12u l=0.1u ad=0.0696p as=0.0408p pd=1.16u ps=0.68u
    I_MXI77_I24_XP_MN0 (I77_P6_5 I77_pn6 VSS VSS) gpdk090_nmos1v w=0.12u l=0.1u ad=0.0408p as=0.0696p pd=0.68u ps=1.16u
    I_MXI77_I24_XP_MN1 (VSS I77_pn5 I77_P6_5 VSS) gpdk090_nmos1v w=0.12u l=0.1u ad=0.0696p as=0.0408p pd=1.16u ps=0.68u
    I_MXI77_I22_XP_MN0 (I77_P4_3 I77_pn4 VSS VSS) gpdk090_nmos1v w=0.12u l=0.1u ad=0.0408p as=0.0696p pd=0.68u ps=1.16u
    I_MXI77_I22_XP_MN1 (VSS I77_pn3 I77_P4_3 VSS) gpdk090_nmos1v w=0.12u l=0.1u ad=0.0696p as=0.0408p pd=1.16u ps=0.68u
    I_MXI77_I23_XP_MN0 (I77_P5_4 I77_pn5 VSS VSS) gpdk090_nmos1v w=0.12u l=0.1u ad=0.0408p as=0.0696p pd=0.68u ps=1.16u
    I_MXI77_I23_XP_MN1 (VSS I77_pn4 I77_P5_4 VSS) gpdk090_nmos1v w=0.12u l=0.1u ad=0.0696p as=0.0408p pd=1.16u ps=0.68u
    I_MXI77_I25_XP_MN0 (I77_P7_6 I77_pn7 VSS VSS) gpdk090_nmos1v w=0.12u l=0.1u ad=0.0408p as=0.0696p pd=0.68u ps=1.16u
    I_MXI77_I25_XP_MN1 (VSS I77_pn6 I77_P7_6 VSS) gpdk090_nmos1v w=0.12u l=0.1u ad=0.0696p as=0.0408p pd=1.16u ps=0.68u
    I_MXI50_MN34 (XI50_bn3 XI50_s1 VSS VSS) gpdk090_nmos1v w=0.24u l=0.1u ad=0.0528p as=0.0498p pd=0.68u ps=0.68u
    I_MXI50_MN35 (VSS pp3_2 XI50_bn3 VSS) gpdk090_nmos1v w=0.24u l=0.1u ad=0.0528p as=0.0528p pd=0.68u ps=0.68u
    I_MXI50_MN36 (XI50_bn3 cm6_2 VSS VSS) gpdk090_nmos1v w=0.24u l=0.1u ad=0.0528p as=0.0528p pd=0.68u ps=0.68u
    I_MXI50_MN37 (XI50_bsn XI50_bcon XI50_bn3 VSS) gpdk090_nmos1v w=0.24u l=0.1u ad=0.0498p as=0.0528p pd=0.68u ps=0.68u
    I_MXI50_MN40 (XI50_bn5 cm6_2 XI50_bsn VSS) gpdk090_nmos1v w=0.18u l=0.1u ad=0.0468p as=0.0498p pd=0.68u ps=0.68u
    I_MXI50_MN39 (XI50_bn4 pp3_2 XI50_bn5 VSS) gpdk090_nmos1v w=0.18u l=0.1u ad=0.0468p as=0.0468p pd=0.68u ps=0.68u
    I_MXI50_MN39_1 (XI50_bn5 pp3_2 XI50_bn4 VSS) gpdk090_nmos1v w=0.18u l=0.1u ad=0.0468p as=0.0468p pd=0.68u ps=0.68u
    I_MXI50_MN40_1 (XI50_bsn cm6_2 XI50_bn5 VSS) gpdk090_nmos1v w=0.18u l=0.1u ad=0.0756p as=0.0468p pd=1.16u ps=0.68u
    I_MXI50_MN53 (VSS XI50_bsn cm7_0 VSS) gpdk090_nmos1v w=0.12u l=0.1u ad=0.0696p as=0.0696p pd=1.16u ps=1.16u
    I_MXI50_MN29 (XI50_bn1 XI50_s1 VSS VSS) gpdk090_nmos1v w=0.24u l=0.1u ad=0.0528p as=0.0468p pd=0.68u ps=0.68u
    I_MXI50_MN30 (XI50_bcon pp3_2 XI50_bn1 VSS) gpdk090_nmos1v w=0.24u l=0.1u ad=0.0528p as=0.0528p pd=0.68u ps=0.68u
    I_MXI50_MN33 (XI50_bn2 cm6_2 XI50_bcon VSS) gpdk090_nmos1v w=0.24u l=0.1u ad=0.0528p as=0.0528p pd=0.68u ps=0.68u
    I_MXI50_MN31 (VSS XI50_s1 XI50_bn2 VSS) gpdk090_nmos1v w=0.24u l=0.1u ad=0.0528p as=0.0528p pd=0.68u ps=0.68u
    I_MXI50_MN32 (XI50_bn2 pp3_2 VSS VSS) gpdk090_nmos1v w=0.24u l=0.1u ad=0.0816p as=0.0528p pd=1.16u ps=0.68u
    I_MXI50_MN55 (VSS XI50_bcon cm7_1 VSS) gpdk090_nmos1v w=0.12u l=0.1u ad=0.0438p as=0.0696p pd=0.68u ps=1.16u
    I_MXI50_MN38 (XI50_bn4 XI50_s1 VSS VSS) gpdk090_nmos1v w=0.18u l=0.1u ad=0.0954p as=0.0438p pd=1.22u ps=0.68u
    I_MXI50_MN38_1 (VSS XI50_s1 XI50_bn4 VSS) gpdk090_nmos1v w=0.18u l=0.1u ad=0.0498p as=0.0954p pd=0.68u ps=1.22u
    I_MXI50_MN25 (VSS XI50_asn XI50_s1 VSS) gpdk090_nmos1v w=0.12u l=0.1u ad=0.0468p as=0.0696p pd=0.68u ps=1.16u
    I_MXI50_MN10 (VSS pp0_8 XI50_an4 VSS) gpdk090_nmos1v w=0.18u l=0.1u ad=0.0498p as=0.0468p pd=0.68u ps=0.68u
    I_MXI50_MN6 (XI50_an3 pp0_8 VSS VSS) gpdk090_nmos1v w=0.24u l=0.1u ad=0.0528p as=0.0498p pd=0.68u ps=0.68u
    I_MXI50_MN9 (XI50_asn XI50_acon XI50_an3 VSS) gpdk090_nmos1v w=0.24u l=0.1u ad=0.0498p as=0.0528p pd=0.68u ps=0.68u
    I_MXI50_MN12 (XI50_an5 pp2_4 XI50_asn VSS) gpdk090_nmos1v w=0.18u l=0.1u ad=0.0468p as=0.0498p pd=0.68u ps=0.68u
    I_MXI50_MN11 (XI50_an4 pp1_6 XI50_an5 VSS) gpdk090_nmos1v w=0.18u l=0.1u ad=0.144p as=0.0468p pd=1.76u ps=0.68u
    I_MXI50_MN11_1 (XI50_an5 pp1_6 XI50_an4 VSS) gpdk090_nmos1v w=0.18u l=0.1u ad=0.0468p as=0.144p pd=0.68u ps=1.76u
    I_MXI50_MN12_1 (XI50_asn pp2_4 XI50_an5 VSS) gpdk090_nmos1v w=0.18u l=0.1u ad=0.0756p as=0.0468p pd=1.16u ps=0.68u
    I_MXI50_MN10_1 (XI50_an4 pp0_8 VSS VSS) gpdk090_nmos1v w=0.18u l=0.1u ad=0.0468p as=0.0498p pd=0.68u ps=0.68u
    I_MXI50_MN5 (XI50_acon pp2_4 XI50_an2 VSS) gpdk090_nmos1v w=0.24u l=0.1u ad=0.0528p as=0.0816p pd=0.68u ps=1.16u
    I_MXI50_MN2 (XI50_an1 pp1_6 XI50_acon VSS) gpdk090_nmos1v w=0.24u l=0.1u ad=0.0528p as=0.0528p pd=0.68u ps=0.68u
    I_MXI50_MN1 (VSS pp0_8 XI50_an1 VSS) gpdk090_nmos1v w=0.24u l=0.1u ad=0.0528p as=0.0528p pd=0.68u ps=0.68u
    I_MXI50_MN3 (XI50_an2 pp0_8 VSS VSS) gpdk090_nmos1v w=0.24u l=0.1u ad=0.0528p as=0.0528p pd=0.68u ps=0.68u
    I_MXI50_MN4 (VSS pp1_6 XI50_an2 VSS) gpdk090_nmos1v w=0.24u l=0.1u ad=0.0468p as=0.0528p pd=0.68u ps=0.68u
    I_MXI50_MN27 (cm7_2 XI50_acon VSS VSS) gpdk090_nmos1v w=0.12u l=0.1u ad=0.0696p as=0.0468p pd=1.16u ps=0.68u
    I_MXI50_MN7 (XI50_an3 pp1_6 VSS VSS) gpdk090_nmos1v w=0.24u l=0.1u ad=0.0528p as=0.0816p pd=0.68u ps=1.16u
    I_MXI50_MN8 (VSS pp2_4 XI50_an3 VSS) gpdk090_nmos1v w=0.24u l=0.1u ad=0.0498p as=0.0528p pd=0.68u ps=0.68u
    I_MXI51_MN34 (XI51_bn3 XI51_s1 VSS VSS) gpdk090_nmos1v w=0.24u l=0.1u ad=0.0528p as=0.0498p pd=0.68u ps=0.68u
    I_MXI51_MN35 (VSS pp3_3 XI51_bn3 VSS) gpdk090_nmos1v w=0.24u l=0.1u ad=0.0528p as=0.0528p pd=0.68u ps=0.68u
    I_MXI51_MN36 (XI51_bn3 cm7_2 VSS VSS) gpdk090_nmos1v w=0.24u l=0.1u ad=0.0528p as=0.0528p pd=0.68u ps=0.68u
    I_MXI51_MN37 (XI51_bsn XI51_bcon XI51_bn3 VSS) gpdk090_nmos1v w=0.24u l=0.1u ad=0.0498p as=0.0528p pd=0.68u ps=0.68u
    I_MXI51_MN40 (XI51_bn5 cm7_2 XI51_bsn VSS) gpdk090_nmos1v w=0.18u l=0.1u ad=0.0468p as=0.0498p pd=0.68u ps=0.68u
    I_MXI51_MN39 (XI51_bn4 pp3_3 XI51_bn5 VSS) gpdk090_nmos1v w=0.18u l=0.1u ad=0.0468p as=0.0468p pd=0.68u ps=0.68u
    I_MXI51_MN39_1 (XI51_bn5 pp3_3 XI51_bn4 VSS) gpdk090_nmos1v w=0.18u l=0.1u ad=0.0468p as=0.0468p pd=0.68u ps=0.68u
    I_MXI51_MN40_1 (XI51_bsn cm7_2 XI51_bn5 VSS) gpdk090_nmos1v w=0.18u l=0.1u ad=0.0756p as=0.0468p pd=1.16u ps=0.68u
    I_MXI51_MN53 (VSS XI51_bsn cm8_0 VSS) gpdk090_nmos1v w=0.12u l=0.1u ad=0.0696p as=0.0696p pd=1.16u ps=1.16u
    I_MXI51_MN29 (XI51_bn1 XI51_s1 VSS VSS) gpdk090_nmos1v w=0.24u l=0.1u ad=0.0528p as=0.0468p pd=0.68u ps=0.68u
    I_MXI51_MN30 (XI51_bcon pp3_3 XI51_bn1 VSS) gpdk090_nmos1v w=0.24u l=0.1u ad=0.0528p as=0.0528p pd=0.68u ps=0.68u
    I_MXI51_MN33 (XI51_bn2 cm7_2 XI51_bcon VSS) gpdk090_nmos1v w=0.24u l=0.1u ad=0.0528p as=0.0528p pd=0.68u ps=0.68u
    I_MXI51_MN31 (VSS XI51_s1 XI51_bn2 VSS) gpdk090_nmos1v w=0.24u l=0.1u ad=0.0528p as=0.0528p pd=0.68u ps=0.68u
    I_MXI51_MN32 (XI51_bn2 pp3_3 VSS VSS) gpdk090_nmos1v w=0.24u l=0.1u ad=0.0816p as=0.0528p pd=1.16u ps=0.68u
    I_MXI51_MN55 (VSS XI51_bcon cm8_1 VSS) gpdk090_nmos1v w=0.12u l=0.1u ad=0.0438p as=0.0696p pd=0.68u ps=1.16u
    I_MXI51_MN38 (XI51_bn4 XI51_s1 VSS VSS) gpdk090_nmos1v w=0.18u l=0.1u ad=0.0954p as=0.0438p pd=1.22u ps=0.68u
    I_MXI51_MN38_1 (VSS XI51_s1 XI51_bn4 VSS) gpdk090_nmos1v w=0.18u l=0.1u ad=0.0498p as=0.0954p pd=0.68u ps=1.22u
    I_MXI51_MN25 (VSS XI51_asn XI51_s1 VSS) gpdk090_nmos1v w=0.12u l=0.1u ad=0.0468p as=0.0696p pd=0.68u ps=1.16u
    I_MXI51_MN10 (VSS pp0_8 XI51_an4 VSS) gpdk090_nmos1v w=0.18u l=0.1u ad=0.0498p as=0.0468p pd=0.68u ps=0.68u
    I_MXI51_MN6 (XI51_an3 pp0_8 VSS VSS) gpdk090_nmos1v w=0.24u l=0.1u ad=0.0528p as=0.0498p pd=0.68u ps=0.68u
    I_MXI51_MN9 (XI51_asn XI51_acon XI51_an3 VSS) gpdk090_nmos1v w=0.24u l=0.1u ad=0.0498p as=0.0528p pd=0.68u ps=0.68u
    I_MXI51_MN12 (XI51_an5 pp2_5 XI51_asn VSS) gpdk090_nmos1v w=0.18u l=0.1u ad=0.0468p as=0.0498p pd=0.68u ps=0.68u
    I_MXI51_MN11 (XI51_an4 pp1_7 XI51_an5 VSS) gpdk090_nmos1v w=0.18u l=0.1u ad=0.144p as=0.0468p pd=1.76u ps=0.68u
    I_MXI51_MN11_1 (XI51_an5 pp1_7 XI51_an4 VSS) gpdk090_nmos1v w=0.18u l=0.1u ad=0.0468p as=0.144p pd=0.68u ps=1.76u
    I_MXI51_MN12_1 (XI51_asn pp2_5 XI51_an5 VSS) gpdk090_nmos1v w=0.18u l=0.1u ad=0.0756p as=0.0468p pd=1.16u ps=0.68u
    I_MXI51_MN10_1 (XI51_an4 pp0_8 VSS VSS) gpdk090_nmos1v w=0.18u l=0.1u ad=0.0468p as=0.0498p pd=0.68u ps=0.68u
    I_MXI51_MN5 (XI51_acon pp2_5 XI51_an2 VSS) gpdk090_nmos1v w=0.24u l=0.1u ad=0.0528p as=0.0816p pd=0.68u ps=1.16u
    I_MXI51_MN2 (XI51_an1 pp1_7 XI51_acon VSS) gpdk090_nmos1v w=0.24u l=0.1u ad=0.0528p as=0.0528p pd=0.68u ps=0.68u
    I_MXI51_MN1 (VSS pp0_8 XI51_an1 VSS) gpdk090_nmos1v w=0.24u l=0.1u ad=0.0528p as=0.0528p pd=0.68u ps=0.68u
    I_MXI51_MN3 (XI51_an2 pp0_8 VSS VSS) gpdk090_nmos1v w=0.24u l=0.1u ad=0.0528p as=0.0528p pd=0.68u ps=0.68u
    I_MXI51_MN4 (VSS pp1_7 XI51_an2 VSS) gpdk090_nmos1v w=0.24u l=0.1u ad=0.0468p as=0.0528p pd=0.68u ps=0.68u
    I_MXI51_MN27 (cm8_2 XI51_acon VSS VSS) gpdk090_nmos1v w=0.12u l=0.1u ad=0.0696p as=0.0468p pd=1.16u ps=0.68u
    I_MXI51_MN7 (XI51_an3 pp1_7 VSS VSS) gpdk090_nmos1v w=0.24u l=0.1u ad=0.0528p as=0.0816p pd=0.68u ps=1.16u
    I_MXI51_MN8 (VSS pp2_5 XI51_an3 VSS) gpdk090_nmos1v w=0.24u l=0.1u ad=0.0498p as=0.0528p pd=0.68u ps=0.68u
    I_MXI49_MN34 (XI49_bn3 XI49_s1 VSS VSS) gpdk090_nmos1v w=0.24u l=0.1u ad=0.0528p as=0.0498p pd=0.68u ps=0.68u
    I_MXI49_MN35 (VSS pp3_1 XI49_bn3 VSS) gpdk090_nmos1v w=0.24u l=0.1u ad=0.0528p as=0.0528p pd=0.68u ps=0.68u
    I_MXI49_MN36 (XI49_bn3 cm5_2 VSS VSS) gpdk090_nmos1v w=0.24u l=0.1u ad=0.0528p as=0.0528p pd=0.68u ps=0.68u
    I_MXI49_MN37 (XI49_bsn XI49_bcon XI49_bn3 VSS) gpdk090_nmos1v w=0.24u l=0.1u ad=0.0498p as=0.0528p pd=0.68u ps=0.68u
    I_MXI49_MN40 (XI49_bn5 cm5_2 XI49_bsn VSS) gpdk090_nmos1v w=0.18u l=0.1u ad=0.0468p as=0.0498p pd=0.68u ps=0.68u
    I_MXI49_MN39 (XI49_bn4 pp3_1 XI49_bn5 VSS) gpdk090_nmos1v w=0.18u l=0.1u ad=0.0468p as=0.0468p pd=0.68u ps=0.68u
    I_MXI49_MN39_1 (XI49_bn5 pp3_1 XI49_bn4 VSS) gpdk090_nmos1v w=0.18u l=0.1u ad=0.0468p as=0.0468p pd=0.68u ps=0.68u
    I_MXI49_MN40_1 (XI49_bsn cm5_2 XI49_bn5 VSS) gpdk090_nmos1v w=0.18u l=0.1u ad=0.0756p as=0.0468p pd=1.16u ps=0.68u
    I_MXI49_MN53 (VSS XI49_bsn cm6_0 VSS) gpdk090_nmos1v w=0.12u l=0.1u ad=0.0696p as=0.0696p pd=1.16u ps=1.16u
    I_MXI49_MN29 (XI49_bn1 XI49_s1 VSS VSS) gpdk090_nmos1v w=0.24u l=0.1u ad=0.0528p as=0.0468p pd=0.68u ps=0.68u
    I_MXI49_MN30 (XI49_bcon pp3_1 XI49_bn1 VSS) gpdk090_nmos1v w=0.24u l=0.1u ad=0.0528p as=0.0528p pd=0.68u ps=0.68u
    I_MXI49_MN33 (XI49_bn2 cm5_2 XI49_bcon VSS) gpdk090_nmos1v w=0.24u l=0.1u ad=0.0528p as=0.0528p pd=0.68u ps=0.68u
    I_MXI49_MN31 (VSS XI49_s1 XI49_bn2 VSS) gpdk090_nmos1v w=0.24u l=0.1u ad=0.0528p as=0.0528p pd=0.68u ps=0.68u
    I_MXI49_MN32 (XI49_bn2 pp3_1 VSS VSS) gpdk090_nmos1v w=0.24u l=0.1u ad=0.0816p as=0.0528p pd=1.16u ps=0.68u
    I_MXI49_MN55 (VSS XI49_bcon cm6_1 VSS) gpdk090_nmos1v w=0.12u l=0.1u ad=0.0438p as=0.0696p pd=0.68u ps=1.16u
    I_MXI49_MN38 (XI49_bn4 XI49_s1 VSS VSS) gpdk090_nmos1v w=0.18u l=0.1u ad=0.0954p as=0.0438p pd=1.22u ps=0.68u
    I_MXI49_MN38_1 (VSS XI49_s1 XI49_bn4 VSS) gpdk090_nmos1v w=0.18u l=0.1u ad=0.0498p as=0.0954p pd=0.68u ps=1.22u
    I_MXI49_MN25 (VSS XI49_asn XI49_s1 VSS) gpdk090_nmos1v w=0.12u l=0.1u ad=0.0468p as=0.0696p pd=0.68u ps=1.16u
    I_MXI49_MN10 (VSS pp0_7 XI49_an4 VSS) gpdk090_nmos1v w=0.18u l=0.1u ad=0.0498p as=0.0468p pd=0.68u ps=0.68u
    I_MXI49_MN6 (XI49_an3 pp0_7 VSS VSS) gpdk090_nmos1v w=0.24u l=0.1u ad=0.0528p as=0.0498p pd=0.68u ps=0.68u
    I_MXI49_MN9 (XI49_asn XI49_acon XI49_an3 VSS) gpdk090_nmos1v w=0.24u l=0.1u ad=0.0498p as=0.0528p pd=0.68u ps=0.68u
    I_MXI49_MN12 (XI49_an5 pp2_3 XI49_asn VSS) gpdk090_nmos1v w=0.18u l=0.1u ad=0.0468p as=0.0498p pd=0.68u ps=0.68u
    I_MXI49_MN11 (XI49_an4 pp1_5 XI49_an5 VSS) gpdk090_nmos1v w=0.18u l=0.1u ad=0.144p as=0.0468p pd=1.76u ps=0.68u
    I_MXI49_MN11_1 (XI49_an5 pp1_5 XI49_an4 VSS) gpdk090_nmos1v w=0.18u l=0.1u ad=0.0468p as=0.144p pd=0.68u ps=1.76u
    I_MXI49_MN12_1 (XI49_asn pp2_3 XI49_an5 VSS) gpdk090_nmos1v w=0.18u l=0.1u ad=0.0756p as=0.0468p pd=1.16u ps=0.68u
    I_MXI49_MN10_1 (XI49_an4 pp0_7 VSS VSS) gpdk090_nmos1v w=0.18u l=0.1u ad=0.0468p as=0.0498p pd=0.68u ps=0.68u
    I_MXI49_MN5 (XI49_acon pp2_3 XI49_an2 VSS) gpdk090_nmos1v w=0.24u l=0.1u ad=0.0528p as=0.0816p pd=0.68u ps=1.16u
    I_MXI49_MN2 (XI49_an1 pp1_5 XI49_acon VSS) gpdk090_nmos1v w=0.24u l=0.1u ad=0.0528p as=0.0528p pd=0.68u ps=0.68u
    I_MXI49_MN1 (VSS pp0_7 XI49_an1 VSS) gpdk090_nmos1v w=0.24u l=0.1u ad=0.0528p as=0.0528p pd=0.68u ps=0.68u
    I_MXI49_MN3 (XI49_an2 pp0_7 VSS VSS) gpdk090_nmos1v w=0.24u l=0.1u ad=0.0528p as=0.0528p pd=0.68u ps=0.68u
    I_MXI49_MN4 (VSS pp1_5 XI49_an2 VSS) gpdk090_nmos1v w=0.24u l=0.1u ad=0.0468p as=0.0528p pd=0.68u ps=0.68u
    I_MXI49_MN27 (cm6_2 XI49_acon VSS VSS) gpdk090_nmos1v w=0.12u l=0.1u ad=0.0696p as=0.0468p pd=1.16u ps=0.68u
    I_MXI49_MN7 (XI49_an3 pp1_5 VSS VSS) gpdk090_nmos1v w=0.24u l=0.1u ad=0.0528p as=0.0816p pd=0.68u ps=1.16u
    I_MXI49_MN8 (VSS pp2_3 XI49_an3 VSS) gpdk090_nmos1v w=0.24u l=0.1u ad=0.0498p as=0.0528p pd=0.68u ps=0.68u
    I_MXI52_MN34 (XI52_bn3 XI52_s1 VSS VSS) gpdk090_nmos1v w=0.24u l=0.1u ad=0.0528p as=0.0498p pd=0.68u ps=0.68u
    I_MXI52_MN35 (VSS pp3_4 XI52_bn3 VSS) gpdk090_nmos1v w=0.24u l=0.1u ad=0.0528p as=0.0528p pd=0.68u ps=0.68u
    I_MXI52_MN36 (XI52_bn3 cm8_2 VSS VSS) gpdk090_nmos1v w=0.24u l=0.1u ad=0.0528p as=0.0528p pd=0.68u ps=0.68u
    I_MXI52_MN37 (XI52_bsn XI52_bcon XI52_bn3 VSS) gpdk090_nmos1v w=0.24u l=0.1u ad=0.0498p as=0.0528p pd=0.68u ps=0.68u
    I_MXI52_MN40 (XI52_bn5 cm8_2 XI52_bsn VSS) gpdk090_nmos1v w=0.18u l=0.1u ad=0.0468p as=0.0498p pd=0.68u ps=0.68u
    I_MXI52_MN39 (XI52_bn4 pp3_4 XI52_bn5 VSS) gpdk090_nmos1v w=0.18u l=0.1u ad=0.0468p as=0.0468p pd=0.68u ps=0.68u
    I_MXI52_MN39_1 (XI52_bn5 pp3_4 XI52_bn4 VSS) gpdk090_nmos1v w=0.18u l=0.1u ad=0.0468p as=0.0468p pd=0.68u ps=0.68u
    I_MXI52_MN40_1 (XI52_bsn cm8_2 XI52_bn5 VSS) gpdk090_nmos1v w=0.18u l=0.1u ad=0.0756p as=0.0468p pd=1.16u ps=0.68u
    I_MXI52_MN53 (VSS XI52_bsn cm9_0 VSS) gpdk090_nmos1v w=0.12u l=0.1u ad=0.0696p as=0.0696p pd=1.16u ps=1.16u
    I_MXI52_MN29 (XI52_bn1 XI52_s1 VSS VSS) gpdk090_nmos1v w=0.24u l=0.1u ad=0.0528p as=0.0468p pd=0.68u ps=0.68u
    I_MXI52_MN30 (XI52_bcon pp3_4 XI52_bn1 VSS) gpdk090_nmos1v w=0.24u l=0.1u ad=0.0528p as=0.0528p pd=0.68u ps=0.68u
    I_MXI52_MN33 (XI52_bn2 cm8_2 XI52_bcon VSS) gpdk090_nmos1v w=0.24u l=0.1u ad=0.0528p as=0.0528p pd=0.68u ps=0.68u
    I_MXI52_MN31 (VSS XI52_s1 XI52_bn2 VSS) gpdk090_nmos1v w=0.24u l=0.1u ad=0.0528p as=0.0528p pd=0.68u ps=0.68u
    I_MXI52_MN32 (XI52_bn2 pp3_4 VSS VSS) gpdk090_nmos1v w=0.24u l=0.1u ad=0.0816p as=0.0528p pd=1.16u ps=0.68u
    I_MXI52_MN55 (VSS XI52_bcon cm9_1 VSS) gpdk090_nmos1v w=0.12u l=0.1u ad=0.0438p as=0.0696p pd=0.68u ps=1.16u
    I_MXI52_MN38 (XI52_bn4 XI52_s1 VSS VSS) gpdk090_nmos1v w=0.18u l=0.1u ad=0.0954p as=0.0438p pd=1.22u ps=0.68u
    I_MXI52_MN38_1 (VSS XI52_s1 XI52_bn4 VSS) gpdk090_nmos1v w=0.18u l=0.1u ad=0.0498p as=0.0954p pd=0.68u ps=1.22u
    I_MXI52_MN25 (VSS XI52_asn XI52_s1 VSS) gpdk090_nmos1v w=0.12u l=0.1u ad=0.0468p as=0.0696p pd=0.68u ps=1.16u
    I_MXI52_MN10 (VSS pp0_8 XI52_an4 VSS) gpdk090_nmos1v w=0.18u l=0.1u ad=0.0498p as=0.0468p pd=0.68u ps=0.68u
    I_MXI52_MN6 (XI52_an3 pp0_8 VSS VSS) gpdk090_nmos1v w=0.24u l=0.1u ad=0.0528p as=0.0498p pd=0.68u ps=0.68u
    I_MXI52_MN9 (XI52_asn XI52_acon XI52_an3 VSS) gpdk090_nmos1v w=0.24u l=0.1u ad=0.0498p as=0.0528p pd=0.68u ps=0.68u
    I_MXI52_MN12 (XI52_an5 pp2_6 XI52_asn VSS) gpdk090_nmos1v w=0.18u l=0.1u ad=0.0468p as=0.0498p pd=0.68u ps=0.68u
    I_MXI52_MN11 (XI52_an4 pp1_8 XI52_an5 VSS) gpdk090_nmos1v w=0.18u l=0.1u ad=0.144p as=0.0468p pd=1.76u ps=0.68u
    I_MXI52_MN11_1 (XI52_an5 pp1_8 XI52_an4 VSS) gpdk090_nmos1v w=0.18u l=0.1u ad=0.0468p as=0.144p pd=0.68u ps=1.76u
    I_MXI52_MN12_1 (XI52_asn pp2_6 XI52_an5 VSS) gpdk090_nmos1v w=0.18u l=0.1u ad=0.0756p as=0.0468p pd=1.16u ps=0.68u
    I_MXI52_MN10_1 (XI52_an4 pp0_8 VSS VSS) gpdk090_nmos1v w=0.18u l=0.1u ad=0.0468p as=0.0498p pd=0.68u ps=0.68u
    I_MXI52_MN5 (XI52_acon pp2_6 XI52_an2 VSS) gpdk090_nmos1v w=0.24u l=0.1u ad=0.0528p as=0.0816p pd=0.68u ps=1.16u
    I_MXI52_MN2 (XI52_an1 pp1_8 XI52_acon VSS) gpdk090_nmos1v w=0.24u l=0.1u ad=0.0528p as=0.0528p pd=0.68u ps=0.68u
    I_MXI52_MN1 (VSS pp0_8 XI52_an1 VSS) gpdk090_nmos1v w=0.24u l=0.1u ad=0.0528p as=0.0528p pd=0.68u ps=0.68u
    I_MXI52_MN3 (XI52_an2 pp0_8 VSS VSS) gpdk090_nmos1v w=0.24u l=0.1u ad=0.0528p as=0.0528p pd=0.68u ps=0.68u
    I_MXI52_MN4 (VSS pp1_8 XI52_an2 VSS) gpdk090_nmos1v w=0.24u l=0.1u ad=0.0468p as=0.0528p pd=0.68u ps=0.68u
    I_MXI52_MN27 (cm9_2 XI52_acon VSS VSS) gpdk090_nmos1v w=0.12u l=0.1u ad=0.0696p as=0.0468p pd=1.16u ps=0.68u
    I_MXI52_MN7 (XI52_an3 pp1_8 VSS VSS) gpdk090_nmos1v w=0.24u l=0.1u ad=0.0528p as=0.0816p pd=0.68u ps=1.16u
    I_MXI52_MN8 (VSS pp2_6 XI52_an3 VSS) gpdk090_nmos1v w=0.24u l=0.1u ad=0.0498p as=0.0528p pd=0.68u ps=0.68u
    I_MXI48_MN34 (XI48_bn3 XI48_s1 VSS VSS) gpdk090_nmos1v w=0.24u l=0.1u ad=0.0528p as=0.0498p pd=0.68u ps=0.68u
    I_MXI48_MN35 (VSS pp3_0 XI48_bn3 VSS) gpdk090_nmos1v w=0.24u l=0.1u ad=0.0528p as=0.0528p pd=0.68u ps=0.68u
    I_MXI48_MN36 (XI48_bn3 B_7 VSS VSS) gpdk090_nmos1v w=0.24u l=0.1u ad=0.0528p as=0.0528p pd=0.68u ps=0.68u
    I_MXI48_MN37 (XI48_bsn XI48_bcon XI48_bn3 VSS) gpdk090_nmos1v w=0.24u l=0.1u ad=0.0498p as=0.0528p pd=0.68u ps=0.68u
    I_MXI48_MN40 (XI48_bn5 B_7 XI48_bsn VSS) gpdk090_nmos1v w=0.18u l=0.1u ad=0.0468p as=0.0498p pd=0.68u ps=0.68u
    I_MXI48_MN39 (XI48_bn4 pp3_0 XI48_bn5 VSS) gpdk090_nmos1v w=0.18u l=0.1u ad=0.0468p as=0.0468p pd=0.68u ps=0.68u
    I_MXI48_MN39_1 (XI48_bn5 pp3_0 XI48_bn4 VSS) gpdk090_nmos1v w=0.18u l=0.1u ad=0.0468p as=0.0468p pd=0.68u ps=0.68u
    I_MXI48_MN40_1 (XI48_bsn B_7 XI48_bn5 VSS) gpdk090_nmos1v w=0.18u l=0.1u ad=0.0756p as=0.0468p pd=1.16u ps=0.68u
    I_MXI48_MN53 (VSS XI48_bsn cm5_0 VSS) gpdk090_nmos1v w=0.12u l=0.1u ad=0.0696p as=0.0696p pd=1.16u ps=1.16u
    I_MXI48_MN29 (XI48_bn1 XI48_s1 VSS VSS) gpdk090_nmos1v w=0.24u l=0.1u ad=0.0528p as=0.0468p pd=0.68u ps=0.68u
    I_MXI48_MN30 (XI48_bcon pp3_0 XI48_bn1 VSS) gpdk090_nmos1v w=0.24u l=0.1u ad=0.0528p as=0.0528p pd=0.68u ps=0.68u
    I_MXI48_MN33 (XI48_bn2 B_7 XI48_bcon VSS) gpdk090_nmos1v w=0.24u l=0.1u ad=0.0528p as=0.0528p pd=0.68u ps=0.68u
    I_MXI48_MN31 (VSS XI48_s1 XI48_bn2 VSS) gpdk090_nmos1v w=0.24u l=0.1u ad=0.0528p as=0.0528p pd=0.68u ps=0.68u
    I_MXI48_MN32 (XI48_bn2 pp3_0 VSS VSS) gpdk090_nmos1v w=0.24u l=0.1u ad=0.0816p as=0.0528p pd=1.16u ps=0.68u
    I_MXI48_MN55 (VSS XI48_bcon cm5_1 VSS) gpdk090_nmos1v w=0.12u l=0.1u ad=0.0438p as=0.0696p pd=0.68u ps=1.16u
    I_MXI48_MN38 (XI48_bn4 XI48_s1 VSS VSS) gpdk090_nmos1v w=0.18u l=0.1u ad=0.0954p as=0.0438p pd=1.22u ps=0.68u
    I_MXI48_MN38_1 (VSS XI48_s1 XI48_bn4 VSS) gpdk090_nmos1v w=0.18u l=0.1u ad=0.0498p as=0.0954p pd=0.68u ps=1.22u
    I_MXI48_MN25 (VSS XI48_asn XI48_s1 VSS) gpdk090_nmos1v w=0.12u l=0.1u ad=0.0468p as=0.0696p pd=0.68u ps=1.16u
    I_MXI48_MN10 (VSS pp0_6 XI48_an4 VSS) gpdk090_nmos1v w=0.18u l=0.1u ad=0.0498p as=0.0468p pd=0.68u ps=0.68u
    I_MXI48_MN6 (XI48_an3 pp0_6 VSS VSS) gpdk090_nmos1v w=0.24u l=0.1u ad=0.0528p as=0.0498p pd=0.68u ps=0.68u
    I_MXI48_MN9 (XI48_asn XI48_acon XI48_an3 VSS) gpdk090_nmos1v w=0.24u l=0.1u ad=0.0498p as=0.0528p pd=0.68u ps=0.68u
    I_MXI48_MN12 (XI48_an5 pp2_2 XI48_asn VSS) gpdk090_nmos1v w=0.18u l=0.1u ad=0.0468p as=0.0498p pd=0.68u ps=0.68u
    I_MXI48_MN11 (XI48_an4 pp1_4 XI48_an5 VSS) gpdk090_nmos1v w=0.18u l=0.1u ad=0.144p as=0.0468p pd=1.76u ps=0.68u
    I_MXI48_MN11_1 (XI48_an5 pp1_4 XI48_an4 VSS) gpdk090_nmos1v w=0.18u l=0.1u ad=0.0468p as=0.144p pd=0.68u ps=1.76u
    I_MXI48_MN12_1 (XI48_asn pp2_2 XI48_an5 VSS) gpdk090_nmos1v w=0.18u l=0.1u ad=0.0756p as=0.0468p pd=1.16u ps=0.68u
    I_MXI48_MN10_1 (XI48_an4 pp0_6 VSS VSS) gpdk090_nmos1v w=0.18u l=0.1u ad=0.0468p as=0.0498p pd=0.68u ps=0.68u
    I_MXI48_MN5 (XI48_acon pp2_2 XI48_an2 VSS) gpdk090_nmos1v w=0.24u l=0.1u ad=0.0528p as=0.0816p pd=0.68u ps=1.16u
    I_MXI48_MN2 (XI48_an1 pp1_4 XI48_acon VSS) gpdk090_nmos1v w=0.24u l=0.1u ad=0.0528p as=0.0528p pd=0.68u ps=0.68u
    I_MXI48_MN1 (VSS pp0_6 XI48_an1 VSS) gpdk090_nmos1v w=0.24u l=0.1u ad=0.0528p as=0.0528p pd=0.68u ps=0.68u
    I_MXI48_MN3 (XI48_an2 pp0_6 VSS VSS) gpdk090_nmos1v w=0.24u l=0.1u ad=0.0528p as=0.0528p pd=0.68u ps=0.68u
    I_MXI48_MN4 (VSS pp1_4 XI48_an2 VSS) gpdk090_nmos1v w=0.24u l=0.1u ad=0.0468p as=0.0528p pd=0.68u ps=0.68u
    I_MXI48_MN27 (cm5_2 XI48_acon VSS VSS) gpdk090_nmos1v w=0.12u l=0.1u ad=0.0696p as=0.0468p pd=1.16u ps=0.68u
    I_MXI48_MN7 (XI48_an3 pp1_4 VSS VSS) gpdk090_nmos1v w=0.24u l=0.1u ad=0.0528p as=0.0816p pd=0.68u ps=1.16u
    I_MXI48_MN8 (VSS pp2_2 XI48_an3 VSS) gpdk090_nmos1v w=0.24u l=0.1u ad=0.0498p as=0.0528p pd=0.68u ps=0.68u
    I_MXI53_MN34 (XI53_bn3 XI53_s1 VSS VSS) gpdk090_nmos1v w=0.24u l=0.1u ad=0.0528p as=0.0498p pd=0.68u ps=0.68u
    I_MXI53_MN35 (VSS pp3_5 XI53_bn3 VSS) gpdk090_nmos1v w=0.24u l=0.1u ad=0.0528p as=0.0528p pd=0.68u ps=0.68u
    I_MXI53_MN36 (XI53_bn3 cm9_2 VSS VSS) gpdk090_nmos1v w=0.24u l=0.1u ad=0.0528p as=0.0528p pd=0.68u ps=0.68u
    I_MXI53_MN37 (XI53_bsn XI53_bcon XI53_bn3 VSS) gpdk090_nmos1v w=0.24u l=0.1u ad=0.0498p as=0.0528p pd=0.68u ps=0.68u
    I_MXI53_MN40 (XI53_bn5 cm9_2 XI53_bsn VSS) gpdk090_nmos1v w=0.18u l=0.1u ad=0.0468p as=0.0498p pd=0.68u ps=0.68u
    I_MXI53_MN39 (XI53_bn4 pp3_5 XI53_bn5 VSS) gpdk090_nmos1v w=0.18u l=0.1u ad=0.0468p as=0.0468p pd=0.68u ps=0.68u
    I_MXI53_MN39_1 (XI53_bn5 pp3_5 XI53_bn4 VSS) gpdk090_nmos1v w=0.18u l=0.1u ad=0.0468p as=0.0468p pd=0.68u ps=0.68u
    I_MXI53_MN40_1 (XI53_bsn cm9_2 XI53_bn5 VSS) gpdk090_nmos1v w=0.18u l=0.1u ad=0.0756p as=0.0468p pd=1.16u ps=0.68u
    I_MXI53_MN53 (VSS XI53_bsn cm10_0 VSS) gpdk090_nmos1v w=0.12u l=0.1u ad=0.0696p as=0.0696p pd=1.16u ps=1.16u
    I_MXI53_MN29 (XI53_bn1 XI53_s1 VSS VSS) gpdk090_nmos1v w=0.24u l=0.1u ad=0.0528p as=0.0468p pd=0.68u ps=0.68u
    I_MXI53_MN30 (XI53_bcon pp3_5 XI53_bn1 VSS) gpdk090_nmos1v w=0.24u l=0.1u ad=0.0528p as=0.0528p pd=0.68u ps=0.68u
    I_MXI53_MN33 (XI53_bn2 cm9_2 XI53_bcon VSS) gpdk090_nmos1v w=0.24u l=0.1u ad=0.0528p as=0.0528p pd=0.68u ps=0.68u
    I_MXI53_MN31 (VSS XI53_s1 XI53_bn2 VSS) gpdk090_nmos1v w=0.24u l=0.1u ad=0.0528p as=0.0528p pd=0.68u ps=0.68u
    I_MXI53_MN32 (XI53_bn2 pp3_5 VSS VSS) gpdk090_nmos1v w=0.24u l=0.1u ad=0.0816p as=0.0528p pd=1.16u ps=0.68u
    I_MXI53_MN55 (VSS XI53_bcon cm10_1 VSS) gpdk090_nmos1v w=0.12u l=0.1u ad=0.0438p as=0.0696p pd=0.68u ps=1.16u
    I_MXI53_MN38 (XI53_bn4 XI53_s1 VSS VSS) gpdk090_nmos1v w=0.18u l=0.1u ad=0.0954p as=0.0438p pd=1.22u ps=0.68u
    I_MXI53_MN38_1 (VSS XI53_s1 XI53_bn4 VSS) gpdk090_nmos1v w=0.18u l=0.1u ad=0.0498p as=0.0954p pd=0.68u ps=1.22u
    I_MXI53_MN25 (VSS XI53_asn XI53_s1 VSS) gpdk090_nmos1v w=0.12u l=0.1u ad=0.0468p as=0.0696p pd=0.68u ps=1.16u
    I_MXI53_MN10 (VSS sn0 XI53_an4 VSS) gpdk090_nmos1v w=0.18u l=0.1u ad=0.0498p as=0.0468p pd=0.68u ps=0.68u
    I_MXI53_MN6 (XI53_an3 sn0 VSS VSS) gpdk090_nmos1v w=0.24u l=0.1u ad=0.0528p as=0.0498p pd=0.68u ps=0.68u
    I_MXI53_MN9 (XI53_asn XI53_acon XI53_an3 VSS) gpdk090_nmos1v w=0.24u l=0.1u ad=0.0498p as=0.0528p pd=0.68u ps=0.68u
    I_MXI53_MN12 (XI53_an5 pp2_7 XI53_asn VSS) gpdk090_nmos1v w=0.18u l=0.1u ad=0.0468p as=0.0498p pd=0.68u ps=0.68u
    I_MXI53_MN11 (XI53_an4 sn1 XI53_an5 VSS) gpdk090_nmos1v w=0.18u l=0.1u ad=0.144p as=0.0468p pd=1.76u ps=0.68u
    I_MXI53_MN11_1 (XI53_an5 sn1 XI53_an4 VSS) gpdk090_nmos1v w=0.18u l=0.1u ad=0.0468p as=0.144p pd=0.68u ps=1.76u
    I_MXI53_MN12_1 (XI53_asn pp2_7 XI53_an5 VSS) gpdk090_nmos1v w=0.18u l=0.1u ad=0.0756p as=0.0468p pd=1.16u ps=0.68u
    I_MXI53_MN10_1 (XI53_an4 sn0 VSS VSS) gpdk090_nmos1v w=0.18u l=0.1u ad=0.0468p as=0.0498p pd=0.68u ps=0.68u
    I_MXI53_MN5 (XI53_acon pp2_7 XI53_an2 VSS) gpdk090_nmos1v w=0.24u l=0.1u ad=0.0528p as=0.0816p pd=0.68u ps=1.16u
    I_MXI53_MN2 (XI53_an1 sn1 XI53_acon VSS) gpdk090_nmos1v w=0.24u l=0.1u ad=0.0528p as=0.0528p pd=0.68u ps=0.68u
    I_MXI53_MN1 (VSS sn0 XI53_an1 VSS) gpdk090_nmos1v w=0.24u l=0.1u ad=0.0528p as=0.0528p pd=0.68u ps=0.68u
    I_MXI53_MN3 (XI53_an2 sn0 VSS VSS) gpdk090_nmos1v w=0.24u l=0.1u ad=0.0528p as=0.0528p pd=0.68u ps=0.68u
    I_MXI53_MN4 (VSS sn1 XI53_an2 VSS) gpdk090_nmos1v w=0.24u l=0.1u ad=0.0468p as=0.0528p pd=0.68u ps=0.68u
    I_MXI53_MN27 (cm10_2 XI53_acon VSS VSS) gpdk090_nmos1v w=0.12u l=0.1u ad=0.0696p as=0.0468p pd=1.16u ps=0.68u
    I_MXI53_MN7 (XI53_an3 sn1 VSS VSS) gpdk090_nmos1v w=0.24u l=0.1u ad=0.0528p as=0.0816p pd=0.68u ps=1.16u
    I_MXI53_MN8 (VSS pp2_7 XI53_an3 VSS) gpdk090_nmos1v w=0.24u l=0.1u ad=0.0498p as=0.0528p pd=0.68u ps=0.68u
    I_MXI54_MN34 (XI54_bn3 XI54_s1 VSS VSS) gpdk090_nmos1v w=0.24u l=0.1u ad=0.0528p as=0.0498p pd=0.68u ps=0.68u
    I_MXI54_MN35 (VSS VSS XI54_bn3 VSS) gpdk090_nmos1v w=0.24u l=0.1u ad=0.0528p as=0.0528p pd=0.68u ps=0.68u
    I_MXI54_MN36 (XI54_bn3 cm10_2 VSS VSS) gpdk090_nmos1v w=0.24u l=0.1u ad=0.0528p as=0.0528p pd=0.68u ps=0.68u
    I_MXI54_MN37 (XI54_bsn XI54_bcon XI54_bn3 VSS) gpdk090_nmos1v w=0.24u l=0.1u ad=0.0498p as=0.0528p pd=0.68u ps=0.68u
    I_MXI54_MN40 (XI54_bn5 cm10_2 XI54_bsn VSS) gpdk090_nmos1v w=0.18u l=0.1u ad=0.0468p as=0.0498p pd=0.68u ps=0.68u
    I_MXI54_MN39 (XI54_bn4 VSS XI54_bn5 VSS) gpdk090_nmos1v w=0.18u l=0.1u ad=0.0468p as=0.0468p pd=0.68u ps=0.68u
    I_MXI54_MN39_1 (XI54_bn5 VSS XI54_bn4 VSS) gpdk090_nmos1v w=0.18u l=0.1u ad=0.0468p as=0.0468p pd=0.68u ps=0.68u
    I_MXI54_MN40_1 (XI54_bsn cm10_2 XI54_bn5 VSS) gpdk090_nmos1v w=0.18u l=0.1u ad=0.0756p as=0.0468p pd=1.16u ps=0.68u
    I_MXI54_MN53 (VSS XI54_bsn cm11_0 VSS) gpdk090_nmos1v w=0.12u l=0.1u ad=0.0696p as=0.0696p pd=1.16u ps=1.16u
    I_MXI54_MN29 (XI54_bn1 XI54_s1 VSS VSS) gpdk090_nmos1v w=0.24u l=0.1u ad=0.0528p as=0.0468p pd=0.68u ps=0.68u
    I_MXI54_MN30 (XI54_bcon VSS XI54_bn1 VSS) gpdk090_nmos1v w=0.24u l=0.1u ad=0.0528p as=0.0528p pd=0.68u ps=0.68u
    I_MXI54_MN33 (XI54_bn2 cm10_2 XI54_bcon VSS) gpdk090_nmos1v w=0.24u l=0.1u ad=0.0528p as=0.0528p pd=0.68u ps=0.68u
    I_MXI54_MN31 (VSS XI54_s1 XI54_bn2 VSS) gpdk090_nmos1v w=0.24u l=0.1u ad=0.0528p as=0.0528p pd=0.68u ps=0.68u
    I_MXI54_MN32 (XI54_bn2 VSS VSS VSS) gpdk090_nmos1v w=0.24u l=0.1u ad=0.0816p as=0.0528p pd=1.16u ps=0.68u
    I_MXI54_MN55 (VSS XI54_bcon cm11_1 VSS) gpdk090_nmos1v w=0.12u l=0.1u ad=0.0438p as=0.0696p pd=0.68u ps=1.16u
    I_MXI54_MN38 (XI54_bn4 XI54_s1 VSS VSS) gpdk090_nmos1v w=0.18u l=0.1u ad=0.0954p as=0.0438p pd=1.22u ps=0.68u
    I_MXI54_MN38_1 (VSS XI54_s1 XI54_bn4 VSS) gpdk090_nmos1v w=0.18u l=0.1u ad=0.0498p as=0.0954p pd=0.68u ps=1.22u
    I_MXI54_MN25 (VSS XI54_asn XI54_s1 VSS) gpdk090_nmos1v w=0.12u l=0.1u ad=0.0468p as=0.0696p pd=0.68u ps=1.16u
    I_MXI54_MN10 (VSS VDD XI54_an4 VSS) gpdk090_nmos1v w=0.18u l=0.1u ad=0.0498p as=0.0468p pd=0.68u ps=0.68u
    I_MXI54_MN6 (XI54_an3 VDD VSS VSS) gpdk090_nmos1v w=0.24u l=0.1u ad=0.0528p as=0.0498p pd=0.68u ps=0.68u
    I_MXI54_MN9 (XI54_asn XI54_acon XI54_an3 VSS) gpdk090_nmos1v w=0.24u l=0.1u ad=0.0498p as=0.0528p pd=0.68u ps=0.68u
    I_MXI54_MN12 (XI54_an5 pp3_6 XI54_asn VSS) gpdk090_nmos1v w=0.18u l=0.1u ad=0.0468p as=0.0498p pd=0.68u ps=0.68u
    I_MXI54_MN11 (XI54_an4 pp2_8 XI54_an5 VSS) gpdk090_nmos1v w=0.18u l=0.1u ad=0.144p as=0.0468p pd=1.76u ps=0.68u
    I_MXI54_MN11_1 (XI54_an5 pp2_8 XI54_an4 VSS) gpdk090_nmos1v w=0.18u l=0.1u ad=0.0468p as=0.144p pd=0.68u ps=1.76u
    I_MXI54_MN12_1 (XI54_asn pp3_6 XI54_an5 VSS) gpdk090_nmos1v w=0.18u l=0.1u ad=0.0756p as=0.0468p pd=1.16u ps=0.68u
    I_MXI54_MN10_1 (XI54_an4 VDD VSS VSS) gpdk090_nmos1v w=0.18u l=0.1u ad=0.0468p as=0.0498p pd=0.68u ps=0.68u
    I_MXI54_MN5 (XI54_acon pp3_6 XI54_an2 VSS) gpdk090_nmos1v w=0.24u l=0.1u ad=0.0528p as=0.0816p pd=0.68u ps=1.16u
    I_MXI54_MN2 (XI54_an1 pp2_8 XI54_acon VSS) gpdk090_nmos1v w=0.24u l=0.1u ad=0.0528p as=0.0528p pd=0.68u ps=0.68u
    I_MXI54_MN1 (VSS VDD XI54_an1 VSS) gpdk090_nmos1v w=0.24u l=0.1u ad=0.0528p as=0.0528p pd=0.68u ps=0.68u
    I_MXI54_MN3 (XI54_an2 VDD VSS VSS) gpdk090_nmos1v w=0.24u l=0.1u ad=0.0528p as=0.0528p pd=0.68u ps=0.68u
    I_MXI54_MN4 (VSS pp2_8 XI54_an2 VSS) gpdk090_nmos1v w=0.24u l=0.1u ad=0.0468p as=0.0528p pd=0.68u ps=0.68u
    I_MXI54_MN27 (cm11_2 XI54_acon VSS VSS) gpdk090_nmos1v w=0.12u l=0.1u ad=0.0696p as=0.0468p pd=1.16u ps=0.68u
    I_MXI54_MN7 (XI54_an3 pp2_8 VSS VSS) gpdk090_nmos1v w=0.24u l=0.1u ad=0.0528p as=0.0816p pd=0.68u ps=1.16u
    I_MXI54_MN8 (VSS pp3_6 XI54_an3 VSS) gpdk090_nmos1v w=0.24u l=0.1u ad=0.0498p as=0.0528p pd=0.68u ps=0.68u
    I_MXI22_MN5 (one2 B_4 XI22_an1 VSS) gpdk090_nmos1v w=0.24u l=0.1u ad=0.0528p as=0.0816p pd=0.68u ps=1.16u
    I_MXI22_MN7 (XI22_an2 XI22_aan one2 VSS) gpdk090_nmos1v w=0.24u l=0.1u ad=0.0528p as=0.0528p pd=0.68u ps=0.68u
    I_MXI22_MN8 (VSS XI22_abn XI22_an2 VSS) gpdk090_nmos1v w=0.24u l=0.1u ad=0.0528p as=0.0528p pd=0.68u ps=0.68u
    I_MXI22_MN6 (XI22_an1 B_3 VSS VSS) gpdk090_nmos1v w=0.24u l=0.1u ad=0.0816p as=0.0528p pd=1.16u ps=0.68u
    I_MXI22_MN1 (XI22_aan B_4 VSS VSS) gpdk090_nmos1v w=0.12u l=0.1u ad=0.0696p as=0.0696p pd=1.16u ps=1.16u
    I_MXI22_MN3 (VSS B_3 XI22_abn VSS) gpdk090_nmos1v w=0.12u l=0.1u ad=0.0696p as=0.0696p pd=1.16u ps=1.16u
    I_MXI22_MN15 (XI22_bbn B_4 VSS VSS) gpdk090_nmos1v w=0.12u l=0.1u ad=0.0696p as=0.0408p pd=1.16u ps=0.68u
    I_MXI22_MN13 (XI22_ban B_5 VSS VSS) gpdk090_nmos1v w=0.12u l=0.1u ad=0.0696p as=0.0696p pd=1.16u ps=1.16u
    I_MXI22_MN19 (XI22_bn2 XI22_ban XI22_e VSS) gpdk090_nmos1v w=0.24u l=0.1u ad=0.0528p as=0.0816p pd=0.68u ps=1.16u
    I_MXI22_MN20 (VSS B_4 XI22_bn2 VSS) gpdk090_nmos1v w=0.24u l=0.1u ad=0.0528p as=0.0528p pd=0.68u ps=0.68u
    I_MXI22_MN18 (XI22_bn1 XI22_bbn VSS VSS) gpdk090_nmos1v w=0.24u l=0.1u ad=0.0528p as=0.0528p pd=0.68u ps=0.68u
    I_MXI22_MN17 (XI22_e B_5 XI22_bn1 VSS) gpdk090_nmos1v w=0.24u l=0.1u ad=0.0816p as=0.0528p pd=1.16u ps=0.68u
    I_MXI22_MN26 (two2 one2 VSS VSS) gpdk090_nmos1v w=0.12u l=0.1u ad=0.0408p as=0.0696p pd=0.68u ps=1.16u
    I_MXI22_MN25 (VSS XI22_e two2 VSS) gpdk090_nmos1v w=0.12u l=0.1u ad=0.0408p as=0.0408p pd=0.68u ps=0.68u
    I_MXI11_MN5 (one1 B_2 XI11_an1 VSS) gpdk090_nmos1v w=0.24u l=0.1u ad=0.0528p as=0.0816p pd=0.68u ps=1.16u
    I_MXI11_MN7 (XI11_an2 XI11_aan one1 VSS) gpdk090_nmos1v w=0.24u l=0.1u ad=0.0528p as=0.0528p pd=0.68u ps=0.68u
    I_MXI11_MN8 (VSS XI11_abn XI11_an2 VSS) gpdk090_nmos1v w=0.24u l=0.1u ad=0.0528p as=0.0528p pd=0.68u ps=0.68u
    I_MXI11_MN6 (XI11_an1 B_1 VSS VSS) gpdk090_nmos1v w=0.24u l=0.1u ad=0.0816p as=0.0528p pd=1.16u ps=0.68u
    I_MXI11_MN1 (XI11_aan B_2 VSS VSS) gpdk090_nmos1v w=0.12u l=0.1u ad=0.0696p as=0.0696p pd=1.16u ps=1.16u
    I_MXI11_MN3 (VSS B_1 XI11_abn VSS) gpdk090_nmos1v w=0.12u l=0.1u ad=0.0696p as=0.0696p pd=1.16u ps=1.16u
    I_MXI11_MN15 (XI11_bbn B_2 VSS VSS) gpdk090_nmos1v w=0.12u l=0.1u ad=0.0696p as=0.0408p pd=1.16u ps=0.68u
    I_MXI11_MN13 (XI11_ban B_3 VSS VSS) gpdk090_nmos1v w=0.12u l=0.1u ad=0.0696p as=0.0696p pd=1.16u ps=1.16u
    I_MXI11_MN19 (XI11_bn2 XI11_ban XI11_e VSS) gpdk090_nmos1v w=0.24u l=0.1u ad=0.0528p as=0.0816p pd=0.68u ps=1.16u
    I_MXI11_MN20 (VSS B_2 XI11_bn2 VSS) gpdk090_nmos1v w=0.24u l=0.1u ad=0.0528p as=0.0528p pd=0.68u ps=0.68u
    I_MXI11_MN18 (XI11_bn1 XI11_bbn VSS VSS) gpdk090_nmos1v w=0.24u l=0.1u ad=0.0528p as=0.0528p pd=0.68u ps=0.68u
    I_MXI11_MN17 (XI11_e B_3 XI11_bn1 VSS) gpdk090_nmos1v w=0.24u l=0.1u ad=0.0816p as=0.0528p pd=1.16u ps=0.68u
    I_MXI11_MN26 (two1 one1 VSS VSS) gpdk090_nmos1v w=0.12u l=0.1u ad=0.0408p as=0.0696p pd=0.68u ps=1.16u
    I_MXI11_MN25 (VSS XI11_e two1 VSS) gpdk090_nmos1v w=0.12u l=0.1u ad=0.0408p as=0.0408p pd=0.68u ps=0.68u
    I_MXI33_MN5 (one3 B_6 XI33_an1 VSS) gpdk090_nmos1v w=0.24u l=0.1u ad=0.0528p as=0.0816p pd=0.68u ps=1.16u
    I_MXI33_MN7 (XI33_an2 XI33_aan one3 VSS) gpdk090_nmos1v w=0.24u l=0.1u ad=0.0528p as=0.0528p pd=0.68u ps=0.68u
    I_MXI33_MN8 (VSS XI33_abn XI33_an2 VSS) gpdk090_nmos1v w=0.24u l=0.1u ad=0.0528p as=0.0528p pd=0.68u ps=0.68u
    I_MXI33_MN6 (XI33_an1 B_5 VSS VSS) gpdk090_nmos1v w=0.24u l=0.1u ad=0.0816p as=0.0528p pd=1.16u ps=0.68u
    I_MXI33_MN1 (XI33_aan B_6 VSS VSS) gpdk090_nmos1v w=0.12u l=0.1u ad=0.0696p as=0.0696p pd=1.16u ps=1.16u
    I_MXI33_MN3 (VSS B_5 XI33_abn VSS) gpdk090_nmos1v w=0.12u l=0.1u ad=0.0696p as=0.0696p pd=1.16u ps=1.16u
    I_MXI33_MN15 (XI33_bbn B_6 VSS VSS) gpdk090_nmos1v w=0.12u l=0.1u ad=0.0696p as=0.0408p pd=1.16u ps=0.68u
    I_MXI33_MN13 (XI33_ban B_7 VSS VSS) gpdk090_nmos1v w=0.12u l=0.1u ad=0.0696p as=0.0696p pd=1.16u ps=1.16u
    I_MXI33_MN19 (XI33_bn2 XI33_ban XI33_e VSS) gpdk090_nmos1v w=0.24u l=0.1u ad=0.0528p as=0.0816p pd=0.68u ps=1.16u
    I_MXI33_MN20 (VSS B_6 XI33_bn2 VSS) gpdk090_nmos1v w=0.24u l=0.1u ad=0.0528p as=0.0528p pd=0.68u ps=0.68u
    I_MXI33_MN18 (XI33_bn1 XI33_bbn VSS VSS) gpdk090_nmos1v w=0.24u l=0.1u ad=0.0528p as=0.0528p pd=0.68u ps=0.68u
    I_MXI33_MN17 (XI33_e B_7 XI33_bn1 VSS) gpdk090_nmos1v w=0.24u l=0.1u ad=0.0816p as=0.0528p pd=1.16u ps=0.68u
    I_MXI33_MN26 (two3 one3 VSS VSS) gpdk090_nmos1v w=0.12u l=0.1u ad=0.0408p as=0.0696p pd=0.68u ps=1.16u
    I_MXI33_MN25 (VSS XI33_e two3 VSS) gpdk090_nmos1v w=0.12u l=0.1u ad=0.0408p as=0.0408p pd=0.68u ps=0.68u
    I_MXI0_MN5 (one0 B_0 XI0_an1 VSS) gpdk090_nmos1v w=0.24u l=0.1u ad=0.0528p as=0.0816p pd=0.68u ps=1.16u
    I_MXI0_MN7 (XI0_an2 XI0_aan one0 VSS) gpdk090_nmos1v w=0.24u l=0.1u ad=0.0528p as=0.0528p pd=0.68u ps=0.68u
    I_MXI0_MN8 (VSS XI0_abn XI0_an2 VSS) gpdk090_nmos1v w=0.24u l=0.1u ad=0.0528p as=0.0528p pd=0.68u ps=0.68u
    I_MXI0_MN6 (XI0_an1 VSS VSS VSS) gpdk090_nmos1v w=0.24u l=0.1u ad=0.0816p as=0.0528p pd=1.16u ps=0.68u
    I_MXI0_MN1 (XI0_aan B_0 VSS VSS) gpdk090_nmos1v w=0.12u l=0.1u ad=0.0696p as=0.0696p pd=1.16u ps=1.16u
    I_MXI0_MN3 (VSS VSS XI0_abn VSS) gpdk090_nmos1v w=0.12u l=0.1u ad=0.0696p as=0.0696p pd=1.16u ps=1.16u
    I_MXI0_MN15 (XI0_bbn B_0 VSS VSS) gpdk090_nmos1v w=0.12u l=0.1u ad=0.0696p as=0.0408p pd=1.16u ps=0.68u
    I_MXI0_MN13 (XI0_ban B_1 VSS VSS) gpdk090_nmos1v w=0.12u l=0.1u ad=0.0696p as=0.0696p pd=1.16u ps=1.16u
    I_MXI0_MN19 (XI0_bn2 XI0_ban XI0_e VSS) gpdk090_nmos1v w=0.24u l=0.1u ad=0.0528p as=0.0816p pd=0.68u ps=1.16u
    I_MXI0_MN20 (VSS B_0 XI0_bn2 VSS) gpdk090_nmos1v w=0.24u l=0.1u ad=0.0528p as=0.0528p pd=0.68u ps=0.68u
    I_MXI0_MN18 (XI0_bn1 XI0_bbn VSS VSS) gpdk090_nmos1v w=0.24u l=0.1u ad=0.0528p as=0.0528p pd=0.68u ps=0.68u
    I_MXI0_MN17 (XI0_e B_1 XI0_bn1 VSS) gpdk090_nmos1v w=0.24u l=0.1u ad=0.0816p as=0.0528p pd=1.16u ps=0.68u
    I_MXI0_MN26 (two0 one0 VSS VSS) gpdk090_nmos1v w=0.12u l=0.1u ad=0.0408p as=0.0696p pd=0.68u ps=1.16u
    I_MXI0_MN25 (VSS XI0_e two0 VSS) gpdk090_nmos1v w=0.12u l=0.1u ad=0.0408p as=0.0408p pd=0.68u ps=0.68u
    I_MXI77_I40_MN1 (XI77_I40_Bn I77_G2_0n VSS VSS) gpdk090_nmos1v w=0.12u l=0.1u ad=0.0696p as=0.0696p pd=1.16u ps=1.16u
    I_MXI77_I40_MN5 (XI77_I40_n2 XI77_I40_Bn VSS VSS) gpdk090_nmos1v w=0.24u l=0.1u ad=0.0528p as=0.0816p pd=0.68u ps=1.16u
    I_MXI77_I40_MN4 (P_11 XI77_I40_An XI77_I40_n2 VSS) gpdk090_nmos1v w=0.24u l=0.1u ad=0.0528p as=0.0528p pd=0.68u ps=0.68u
    I_MXI77_I40_MN2 (XI77_I40_n1 I77_pn3 P_11 VSS) gpdk090_nmos1v w=0.24u l=0.1u ad=0.0528p as=0.0528p pd=0.68u ps=0.68u
    I_MXI77_I40_MN3 (VSS I77_G2_0n XI77_I40_n1 VSS) gpdk090_nmos1v w=0.24u l=0.1u ad=0.0816p as=0.0528p pd=1.16u ps=0.68u
    I_MXI77_I40_MN0 (XI77_I40_An I77_pn3 VSS VSS) gpdk090_nmos1v w=0.12u l=0.1u ad=0.0696p as=0.0696p pd=1.16u ps=1.16u
    I_MXI77_I41_MN1 (XI77_I41_Bn I77_G3_0n VSS VSS) gpdk090_nmos1v w=0.12u l=0.1u ad=0.0696p as=0.0696p pd=1.16u ps=1.16u
    I_MXI77_I41_MN5 (XI77_I41_n2 XI77_I41_Bn VSS VSS) gpdk090_nmos1v w=0.24u l=0.1u ad=0.0528p as=0.0816p pd=0.68u ps=1.16u
    I_MXI77_I41_MN4 (P_12 XI77_I41_An XI77_I41_n2 VSS) gpdk090_nmos1v w=0.24u l=0.1u ad=0.0528p as=0.0528p pd=0.68u ps=0.68u
    I_MXI77_I41_MN2 (XI77_I41_n1 I77_pn4 P_12 VSS) gpdk090_nmos1v w=0.24u l=0.1u ad=0.0528p as=0.0528p pd=0.68u ps=0.68u
    I_MXI77_I41_MN3 (VSS I77_G3_0n XI77_I41_n1 VSS) gpdk090_nmos1v w=0.24u l=0.1u ad=0.0816p as=0.0528p pd=1.16u ps=0.68u
    I_MXI77_I41_MN0 (XI77_I41_An I77_pn4 VSS VSS) gpdk090_nmos1v w=0.12u l=0.1u ad=0.0696p as=0.0696p pd=1.16u ps=1.16u
    I_MXI77_I33_MP0 (I77_G1_0n I77_G1_0 VDD VDD) gpdk090_pmos1v w=0.24u l=0.1u ad=0.0816p as=0.0816p pd=1.16u ps=1.16u
    I_MXI77_I18_MP0 (I77_G0_0n I77_G0_0 VDD VDD) gpdk090_pmos1v w=0.24u l=0.1u ad=0.0816p as=0.0816p pd=1.16u ps=1.16u
    I_MXI77_I16_MP0 (I77_cinn rc8 VDD VDD) gpdk090_pmos1v w=0.24u l=0.1u ad=0.0816p as=0.0816p pd=1.16u ps=1.16u
    I_MXI10_MP0 (sn0 pp0_8 VDD VDD) gpdk090_pmos1v w=0.24u l=0.1u ad=0.0816p as=0.0816p pd=1.16u ps=1.16u
    I_MXI21_MP0 (sn1 pp1_8 VDD VDD) gpdk090_pmos1v w=0.24u l=0.1u ad=0.0816p as=0.0816p pd=1.16u ps=1.16u
    I_MXI32_MP0 (sn2 pp2_8 VDD VDD) gpdk090_pmos1v w=0.24u l=0.1u ad=0.0816p as=0.0816p pd=1.16u ps=1.16u
    I_MXI43_MP0 (sn3 pp3_8 VDD VDD) gpdk090_pmos1v w=0.24u l=0.1u ad=0.0816p as=0.0816p pd=1.16u ps=1.16u
    I_MXI77_I39_MP1 (VDD I77_G1_0 XI77_I39_Bn VDD) gpdk090_pmos1v w=0.24u l=0.1u ad=0.0816p as=0.0816p pd=1.16u ps=1.16u
    I_MXI77_I39_MP5 (P_10 I77_G1_0 XI77_I39_p1 VDD) gpdk090_pmos1v w=0.48u l=0.1u ad=0.1056p as=0.1632p pd=0.92u ps=1.64u
    I_MXI77_I39_MP4 (XI77_I39_p1 XI77_I39_An P_10 VDD) gpdk090_pmos1v w=0.48u l=0.1u ad=0.1056p as=0.1056p pd=0.92u ps=0.92u
    I_MXI77_I39_MP2 (VDD I77_pn2 XI77_I39_p1 VDD) gpdk090_pmos1v w=0.48u l=0.1u ad=0.1056p as=0.1056p pd=0.92u ps=0.92u
    I_MXI77_I39_MP3 (XI77_I39_p1 XI77_I39_Bn VDD VDD) gpdk090_pmos1v w=0.48u l=0.1u ad=0.1632p as=0.1056p pd=1.64u ps=0.92u
    I_MXI77_I39_MP0 (VDD I77_pn2 XI77_I39_An VDD) gpdk090_pmos1v w=0.24u l=0.1u ad=0.0816p as=0.0816p pd=1.16u ps=1.16u
    I_MXI77_I38_MP1 (VDD I77_G0_0 XI77_I38_Bn VDD) gpdk090_pmos1v w=0.24u l=0.1u ad=0.0816p as=0.0816p pd=1.16u ps=1.16u
    I_MXI77_I38_MP5 (P_9 I77_G0_0 XI77_I38_p1 VDD) gpdk090_pmos1v w=0.48u l=0.1u ad=0.1056p as=0.1632p pd=0.92u ps=1.64u
    I_MXI77_I38_MP4 (XI77_I38_p1 XI77_I38_An P_9 VDD) gpdk090_pmos1v w=0.48u l=0.1u ad=0.1056p as=0.1056p pd=0.92u ps=0.92u
    I_MXI77_I38_MP2 (VDD I77_pn1 XI77_I38_p1 VDD) gpdk090_pmos1v w=0.48u l=0.1u ad=0.1056p as=0.1056p pd=0.92u ps=0.92u
    I_MXI77_I38_MP3 (XI77_I38_p1 XI77_I38_Bn VDD VDD) gpdk090_pmos1v w=0.48u l=0.1u ad=0.1632p as=0.1056p pd=1.64u ps=0.92u
    I_MXI77_I38_MP0 (VDD I77_pn1 XI77_I38_An VDD) gpdk090_pmos1v w=0.24u l=0.1u ad=0.0816p as=0.0816p pd=1.16u ps=1.16u
    I_MXI77_I37_MP1 (VDD rc8 XI77_I37_Bn VDD) gpdk090_pmos1v w=0.24u l=0.1u ad=0.0816p as=0.0816p pd=1.16u ps=1.16u
    I_MXI77_I37_MP5 (P_8 rc8 XI77_I37_p1 VDD) gpdk090_pmos1v w=0.48u l=0.1u ad=0.1056p as=0.1632p pd=0.92u ps=1.64u
    I_MXI77_I37_MP4 (XI77_I37_p1 XI77_I37_An P_8 VDD) gpdk090_pmos1v w=0.48u l=0.1u ad=0.1056p as=0.1056p pd=0.92u ps=0.92u
    I_MXI77_I37_MP2 (VDD I77_pn0 XI77_I37_p1 VDD) gpdk090_pmos1v w=0.48u l=0.1u ad=0.1056p as=0.1056p pd=0.92u ps=0.92u
    I_MXI77_I37_MP3 (XI77_I37_p1 XI77_I37_Bn VDD VDD) gpdk090_pmos1v w=0.48u l=0.1u ad=0.1632p as=0.1056p pd=1.64u ps=0.92u
    I_MXI77_I37_MP0 (VDD I77_pn0 XI77_I37_An VDD) gpdk090_pmos1v w=0.24u l=0.1u ad=0.0816p as=0.0816p pd=1.16u ps=1.16u
    I_MXI77_I43_MP1 (VDD I77_G5_0 XI77_I43_Bn VDD) gpdk090_pmos1v w=0.24u l=0.1u ad=0.0816p as=0.0816p pd=1.16u ps=1.16u
    I_MXI77_I43_MP5 (P_14 I77_G5_0 XI77_I43_p1 VDD) gpdk090_pmos1v w=0.48u l=0.1u ad=0.1056p as=0.1632p pd=0.92u ps=1.64u
    I_MXI77_I43_MP4 (XI77_I43_p1 XI77_I43_An P_14 VDD) gpdk090_pmos1v w=0.48u l=0.1u ad=0.1056p as=0.1056p pd=0.92u ps=0.92u
    I_MXI77_I43_MP2 (VDD I77_pn6 XI77_I43_p1 VDD) gpdk090_pmos1v w=0.48u l=0.1u ad=0.1056p as=0.1056p pd=0.92u ps=0.92u
    I_MXI77_I43_MP3 (XI77_I43_p1 XI77_I43_Bn VDD VDD) gpdk090_pmos1v w=0.48u l=0.1u ad=0.1632p as=0.1056p pd=1.64u ps=0.92u
    I_MXI77_I43_MP0 (VDD I77_pn6 XI77_I43_An VDD) gpdk090_pmos1v w=0.24u l=0.1u ad=0.0816p as=0.0816p pd=1.16u ps=1.16u
    I_MXI77_I42_MP1 (VDD I77_G4_0 XI77_I42_Bn VDD) gpdk090_pmos1v w=0.24u l=0.1u ad=0.0816p as=0.0816p pd=1.16u ps=1.16u
    I_MXI77_I42_MP5 (P_13 I77_G4_0 XI77_I42_p1 VDD) gpdk090_pmos1v w=0.48u l=0.1u ad=0.1056p as=0.1632p pd=0.92u ps=1.64u
    I_MXI77_I42_MP4 (XI77_I42_p1 XI77_I42_An P_13 VDD) gpdk090_pmos1v w=0.48u l=0.1u ad=0.1056p as=0.1056p pd=0.92u ps=0.92u
    I_MXI77_I42_MP2 (VDD I77_pn5 XI77_I42_p1 VDD) gpdk090_pmos1v w=0.48u l=0.1u ad=0.1056p as=0.1056p pd=0.92u ps=0.92u
    I_MXI77_I42_MP3 (XI77_I42_p1 XI77_I42_Bn VDD VDD) gpdk090_pmos1v w=0.48u l=0.1u ad=0.1632p as=0.1056p pd=1.64u ps=0.92u
    I_MXI77_I42_MP0 (VDD I77_pn5 XI77_I42_An VDD) gpdk090_pmos1v w=0.24u l=0.1u ad=0.0816p as=0.0816p pd=1.16u ps=1.16u
    I_MXI77_I9_MP1 (VDD ha19_0 XI77_I9_Bn VDD) gpdk090_pmos1v w=0.24u l=0.1u ad=0.0816p as=0.0816p pd=1.16u ps=1.16u
    I_MXI77_I9_MP5 (I77_pn1 ha19_0 XI77_I9_p1 VDD) gpdk090_pmos1v w=0.48u l=0.1u ad=0.1056p as=0.1632p pd=0.92u ps=1.64u
    I_MXI77_I9_MP4 (XI77_I9_p1 XI77_I9_An I77_pn1 VDD) gpdk090_pmos1v w=0.48u l=0.1u ad=0.1056p as=0.1056p pd=0.92u ps=0.92u
    I_MXI77_I9_MP2 (VDD ha18_1 XI77_I9_p1 VDD) gpdk090_pmos1v w=0.48u l=0.1u ad=0.1056p as=0.1056p pd=0.92u ps=0.92u
    I_MXI77_I9_MP3 (XI77_I9_p1 XI77_I9_Bn VDD VDD) gpdk090_pmos1v w=0.48u l=0.1u ad=0.1632p as=0.1056p pd=1.64u ps=0.92u
    I_MXI77_I9_MP0 (VDD ha18_1 XI77_I9_An VDD) gpdk090_pmos1v w=0.24u l=0.1u ad=0.0816p as=0.0816p pd=1.16u ps=1.16u
    I_MXI77_I8_MP1 (VDD ha18_0 XI77_I8_Bn VDD) gpdk090_pmos1v w=0.24u l=0.1u ad=0.0816p as=0.0816p pd=1.16u ps=1.16u
    I_MXI77_I8_MP5 (I77_pn0 ha18_0 XI77_I8_p1 VDD) gpdk090_pmos1v w=0.48u l=0.1u ad=0.1056p as=0.1632p pd=0.92u ps=1.64u
    I_MXI77_I8_MP4 (XI77_I8_p1 XI77_I8_An I77_pn0 VDD) gpdk090_pmos1v w=0.48u l=0.1u ad=0.1056p as=0.1056p pd=0.92u ps=0.92u
    I_MXI77_I8_MP2 (VDD ha17_1 XI77_I8_p1 VDD) gpdk090_pmos1v w=0.48u l=0.1u ad=0.1056p as=0.1056p pd=0.92u ps=0.92u
    I_MXI77_I8_MP3 (XI77_I8_p1 XI77_I8_Bn VDD VDD) gpdk090_pmos1v w=0.48u l=0.1u ad=0.1632p as=0.1056p pd=1.64u ps=0.92u
    I_MXI77_I8_MP0 (VDD ha17_1 XI77_I8_An VDD) gpdk090_pmos1v w=0.24u l=0.1u ad=0.0816p as=0.0816p pd=1.16u ps=1.16u
    I_MXI77_I10_MP1 (VDD ha20_0 XI77_I10_Bn VDD) gpdk090_pmos1v w=0.24u l=0.1u ad=0.0816p as=0.0816p pd=1.16u ps=1.16u
    I_MXI77_I10_MP5 (I77_pn2 ha20_0 XI77_I10_p1 VDD) gpdk090_pmos1v w=0.48u l=0.1u ad=0.1056p as=0.1632p pd=0.92u ps=1.64u
    I_MXI77_I10_MP4 (XI77_I10_p1 XI77_I10_An I77_pn2 VDD) gpdk090_pmos1v w=0.48u l=0.1u ad=0.1056p as=0.1056p pd=0.92u ps=0.92u
    I_MXI77_I10_MP2 (VDD ha19_1 XI77_I10_p1 VDD) gpdk090_pmos1v w=0.48u l=0.1u ad=0.1056p as=0.1056p pd=0.92u ps=0.92u
    I_MXI77_I10_MP3 (XI77_I10_p1 XI77_I10_Bn VDD VDD) gpdk090_pmos1v w=0.48u l=0.1u ad=0.1632p as=0.1056p pd=1.64u ps=0.92u
    I_MXI77_I10_MP0 (VDD ha19_1 XI77_I10_An VDD) gpdk090_pmos1v w=0.24u l=0.1u ad=0.0816p as=0.0816p pd=1.16u ps=1.16u
    I_MXI77_I11_MP1 (VDD ha21_0 XI77_I11_Bn VDD) gpdk090_pmos1v w=0.24u l=0.1u ad=0.0816p as=0.0816p pd=1.16u ps=1.16u
    I_MXI77_I11_MP5 (I77_pn3 ha21_0 XI77_I11_p1 VDD) gpdk090_pmos1v w=0.48u l=0.1u ad=0.1056p as=0.1632p pd=0.92u ps=1.64u
    I_MXI77_I11_MP4 (XI77_I11_p1 XI77_I11_An I77_pn3 VDD) gpdk090_pmos1v w=0.48u l=0.1u ad=0.1056p as=0.1056p pd=0.92u ps=0.92u
    I_MXI77_I11_MP2 (VDD ha20_1 XI77_I11_p1 VDD) gpdk090_pmos1v w=0.48u l=0.1u ad=0.1056p as=0.1056p pd=0.92u ps=0.92u
    I_MXI77_I11_MP3 (XI77_I11_p1 XI77_I11_Bn VDD VDD) gpdk090_pmos1v w=0.48u l=0.1u ad=0.1632p as=0.1056p pd=1.64u ps=0.92u
    I_MXI77_I11_MP0 (VDD ha20_1 XI77_I11_An VDD) gpdk090_pmos1v w=0.24u l=0.1u ad=0.0816p as=0.0816p pd=1.16u ps=1.16u
    I_MXI77_I44_MP1 (VDD kc7 XI77_I44_Bn VDD) gpdk090_pmos1v w=0.24u l=0.1u ad=0.0816p as=0.0816p pd=1.16u ps=1.16u
    I_MXI77_I44_MP5 (P_15 kc7 XI77_I44_p1 VDD) gpdk090_pmos1v w=0.48u l=0.1u ad=0.1056p as=0.1632p pd=0.92u ps=1.64u
    I_MXI77_I44_MP4 (XI77_I44_p1 XI77_I44_An P_15 VDD) gpdk090_pmos1v w=0.48u l=0.1u ad=0.1056p as=0.1056p pd=0.92u ps=0.92u
    I_MXI77_I44_MP2 (VDD I77_pn7 XI77_I44_p1 VDD) gpdk090_pmos1v w=0.48u l=0.1u ad=0.1056p as=0.1056p pd=0.92u ps=0.92u
    I_MXI77_I44_MP3 (XI77_I44_p1 XI77_I44_Bn VDD VDD) gpdk090_pmos1v w=0.48u l=0.1u ad=0.1632p as=0.1056p pd=1.64u ps=0.92u
    I_MXI77_I44_MP0 (VDD I77_pn7 XI77_I44_An VDD) gpdk090_pmos1v w=0.24u l=0.1u ad=0.0816p as=0.0816p pd=1.16u ps=1.16u
    I_MXI77_I12_MP1 (VDD ha22_0 XI77_I12_Bn VDD) gpdk090_pmos1v w=0.24u l=0.1u ad=0.0816p as=0.0816p pd=1.16u ps=1.16u
    I_MXI77_I12_MP5 (I77_pn4 ha22_0 XI77_I12_p1 VDD) gpdk090_pmos1v w=0.48u l=0.1u ad=0.1056p as=0.1632p pd=0.92u ps=1.64u
    I_MXI77_I12_MP4 (XI77_I12_p1 XI77_I12_An I77_pn4 VDD) gpdk090_pmos1v w=0.48u l=0.1u ad=0.1056p as=0.1056p pd=0.92u ps=0.92u
    I_MXI77_I12_MP2 (VDD ha21_1 XI77_I12_p1 VDD) gpdk090_pmos1v w=0.48u l=0.1u ad=0.1056p as=0.1056p pd=0.92u ps=0.92u
    I_MXI77_I12_MP3 (XI77_I12_p1 XI77_I12_Bn VDD VDD) gpdk090_pmos1v w=0.48u l=0.1u ad=0.1632p as=0.1056p pd=1.64u ps=0.92u
    I_MXI77_I12_MP0 (VDD ha21_1 XI77_I12_An VDD) gpdk090_pmos1v w=0.24u l=0.1u ad=0.0816p as=0.0816p pd=1.16u ps=1.16u
    I_MXI77_I13_MP1 (VDD ha23_0 XI77_I13_Bn VDD) gpdk090_pmos1v w=0.24u l=0.1u ad=0.0816p as=0.0816p pd=1.16u ps=1.16u
    I_MXI77_I13_MP5 (I77_pn5 ha23_0 XI77_I13_p1 VDD) gpdk090_pmos1v w=0.48u l=0.1u ad=0.1056p as=0.1632p pd=0.92u ps=1.64u
    I_MXI77_I13_MP4 (XI77_I13_p1 XI77_I13_An I77_pn5 VDD) gpdk090_pmos1v w=0.48u l=0.1u ad=0.1056p as=0.1056p pd=0.92u ps=0.92u
    I_MXI77_I13_MP2 (VDD ha22_1 XI77_I13_p1 VDD) gpdk090_pmos1v w=0.48u l=0.1u ad=0.1056p as=0.1056p pd=0.92u ps=0.92u
    I_MXI77_I13_MP3 (XI77_I13_p1 XI77_I13_Bn VDD VDD) gpdk090_pmos1v w=0.48u l=0.1u ad=0.1632p as=0.1056p pd=1.64u ps=0.92u
    I_MXI77_I13_MP0 (VDD ha22_1 XI77_I13_An VDD) gpdk090_pmos1v w=0.24u l=0.1u ad=0.0816p as=0.0816p pd=1.16u ps=1.16u
    I_MXI77_I15_MP1 (VDD ha25_0 XI77_I15_Bn VDD) gpdk090_pmos1v w=0.24u l=0.1u ad=0.0816p as=0.0816p pd=1.16u ps=1.16u
    I_MXI77_I15_MP5 (I77_pn7 ha25_0 XI77_I15_p1 VDD) gpdk090_pmos1v w=0.48u l=0.1u ad=0.1056p as=0.1632p pd=0.92u ps=1.64u
    I_MXI77_I15_MP4 (XI77_I15_p1 XI77_I15_An I77_pn7 VDD) gpdk090_pmos1v w=0.48u l=0.1u ad=0.1056p as=0.1056p pd=0.92u ps=0.92u
    I_MXI77_I15_MP2 (VDD ha24_1 XI77_I15_p1 VDD) gpdk090_pmos1v w=0.48u l=0.1u ad=0.1056p as=0.1056p pd=0.92u ps=0.92u
    I_MXI77_I15_MP3 (XI77_I15_p1 XI77_I15_Bn VDD VDD) gpdk090_pmos1v w=0.48u l=0.1u ad=0.1632p as=0.1056p pd=1.64u ps=0.92u
    I_MXI77_I15_MP0 (VDD ha24_1 XI77_I15_An VDD) gpdk090_pmos1v w=0.24u l=0.1u ad=0.0816p as=0.0816p pd=1.16u ps=1.16u
    I_MXI77_I14_MP1 (VDD ha24_0 XI77_I14_Bn VDD) gpdk090_pmos1v w=0.24u l=0.1u ad=0.0816p as=0.0816p pd=1.16u ps=1.16u
    I_MXI77_I14_MP5 (I77_pn6 ha24_0 XI77_I14_p1 VDD) gpdk090_pmos1v w=0.48u l=0.1u ad=0.1056p as=0.1632p pd=0.92u ps=1.64u
    I_MXI77_I14_MP4 (XI77_I14_p1 XI77_I14_An I77_pn6 VDD) gpdk090_pmos1v w=0.48u l=0.1u ad=0.1056p as=0.1056p pd=0.92u ps=0.92u
    I_MXI77_I14_MP2 (VDD ha23_1 XI77_I14_p1 VDD) gpdk090_pmos1v w=0.48u l=0.1u ad=0.1056p as=0.1056p pd=0.92u ps=0.92u
    I_MXI77_I14_MP3 (XI77_I14_p1 XI77_I14_Bn VDD VDD) gpdk090_pmos1v w=0.48u l=0.1u ad=0.1632p as=0.1056p pd=1.64u ps=0.92u
    I_MXI77_I14_MP0 (VDD ha23_1 XI77_I14_An VDD) gpdk090_pmos1v w=0.24u l=0.1u ad=0.0816p as=0.0816p pd=1.16u ps=1.16u
    I_MXI59_MP9 (XI59_xp1 fa4_1 VDD VDD) gpdk090_pmos1v w=0.48u l=0.1u ad=0.1056p as=0.1632p pd=0.92u ps=1.64u
    I_MXI59_MP11 (ha16_0 XI59_xan XI59_xp1 VDD) gpdk090_pmos1v w=0.48u l=0.1u ad=0.1056p as=0.1056p pd=0.92u ps=0.92u
    I_MXI59_MP12 (XI59_xp1 XI59_xbn ha16_0 VDD) gpdk090_pmos1v w=0.48u l=0.1u ad=0.1056p as=0.1056p pd=0.92u ps=0.92u
    I_MXI59_MP10 (VDD cm5_0 XI59_xp1 VDD) gpdk090_pmos1v w=0.48u l=0.1u ad=0.1632p as=0.1056p pd=1.64u ps=0.92u
    I_MXI59_MP2 (VDD fa4_1 XI59_xan VDD) gpdk090_pmos1v w=0.24u l=0.1u ad=0.0528p as=0.0816p pd=0.68u ps=1.16u
    I_MXI59_MP16 (XI59_con cm5_0 VDD VDD) gpdk090_pmos1v w=0.24u l=0.1u ad=0.0528p as=0.0528p pd=0.68u ps=0.68u
    I_MXI59_MP15 (VDD fa4_1 XI59_con VDD) gpdk090_pmos1v w=0.24u l=0.1u ad=0.0816p as=0.0528p pd=1.16u ps=0.68u
    I_MXI59_MP18 (VDD XI59_con ha16_1 VDD) gpdk090_pmos1v w=0.24u l=0.1u ad=0.0816p as=0.0816p pd=1.16u ps=1.16u
    I_MXI59_MP4 (XI59_xbn cm5_0 VDD VDD) gpdk090_pmos1v w=0.24u l=0.1u ad=0.0816p as=0.0816p pd=1.16u ps=1.16u
    I_MXI62_MP9 (XI62_xp1 cm7_1 VDD VDD) gpdk090_pmos1v w=0.48u l=0.1u ad=0.1056p as=0.1632p pd=0.92u ps=1.64u
    I_MXI62_MP11 (ha19_0 XI62_xan XI62_xp1 VDD) gpdk090_pmos1v w=0.48u l=0.1u ad=0.1056p as=0.1056p pd=0.92u ps=0.92u
    I_MXI62_MP12 (XI62_xp1 XI62_xbn ha19_0 VDD) gpdk090_pmos1v w=0.48u l=0.1u ad=0.1056p as=0.1056p pd=0.92u ps=0.92u
    I_MXI62_MP10 (VDD cm8_0 XI62_xp1 VDD) gpdk090_pmos1v w=0.48u l=0.1u ad=0.1632p as=0.1056p pd=1.64u ps=0.92u
    I_MXI62_MP2 (VDD cm7_1 XI62_xan VDD) gpdk090_pmos1v w=0.24u l=0.1u ad=0.0528p as=0.0816p pd=0.68u ps=1.16u
    I_MXI62_MP16 (XI62_con cm8_0 VDD VDD) gpdk090_pmos1v w=0.24u l=0.1u ad=0.0528p as=0.0528p pd=0.68u ps=0.68u
    I_MXI62_MP15 (VDD cm7_1 XI62_con VDD) gpdk090_pmos1v w=0.24u l=0.1u ad=0.0816p as=0.0528p pd=1.16u ps=0.68u
    I_MXI62_MP18 (VDD XI62_con ha19_1 VDD) gpdk090_pmos1v w=0.24u l=0.1u ad=0.0816p as=0.0816p pd=1.16u ps=1.16u
    I_MXI62_MP4 (XI62_xbn cm8_0 VDD VDD) gpdk090_pmos1v w=0.24u l=0.1u ad=0.0816p as=0.0816p pd=1.16u ps=1.16u
    I_MXI61_MP9 (XI61_xp1 cm6_1 VDD VDD) gpdk090_pmos1v w=0.48u l=0.1u ad=0.1056p as=0.1632p pd=0.92u ps=1.64u
    I_MXI61_MP11 (ha18_0 XI61_xan XI61_xp1 VDD) gpdk090_pmos1v w=0.48u l=0.1u ad=0.1056p as=0.1056p pd=0.92u ps=0.92u
    I_MXI61_MP12 (XI61_xp1 XI61_xbn ha18_0 VDD) gpdk090_pmos1v w=0.48u l=0.1u ad=0.1056p as=0.1056p pd=0.92u ps=0.92u
    I_MXI61_MP10 (VDD cm7_0 XI61_xp1 VDD) gpdk090_pmos1v w=0.48u l=0.1u ad=0.1632p as=0.1056p pd=1.64u ps=0.92u
    I_MXI61_MP2 (VDD cm6_1 XI61_xan VDD) gpdk090_pmos1v w=0.24u l=0.1u ad=0.0528p as=0.0816p pd=0.68u ps=1.16u
    I_MXI61_MP16 (XI61_con cm7_0 VDD VDD) gpdk090_pmos1v w=0.24u l=0.1u ad=0.0528p as=0.0528p pd=0.68u ps=0.68u
    I_MXI61_MP15 (VDD cm6_1 XI61_con VDD) gpdk090_pmos1v w=0.24u l=0.1u ad=0.0816p as=0.0528p pd=1.16u ps=0.68u
    I_MXI61_MP18 (VDD XI61_con ha18_1 VDD) gpdk090_pmos1v w=0.24u l=0.1u ad=0.0816p as=0.0816p pd=1.16u ps=1.16u
    I_MXI61_MP4 (XI61_xbn cm7_0 VDD VDD) gpdk090_pmos1v w=0.24u l=0.1u ad=0.0816p as=0.0816p pd=1.16u ps=1.16u
    I_MXI60_MP9 (XI60_xp1 cm5_1 VDD VDD) gpdk090_pmos1v w=0.48u l=0.1u ad=0.1056p as=0.1632p pd=0.92u ps=1.64u
    I_MXI60_MP11 (ha17_0 XI60_xan XI60_xp1 VDD) gpdk090_pmos1v w=0.48u l=0.1u ad=0.1056p as=0.1056p pd=0.92u ps=0.92u
    I_MXI60_MP12 (XI60_xp1 XI60_xbn ha17_0 VDD) gpdk090_pmos1v w=0.48u l=0.1u ad=0.1056p as=0.1056p pd=0.92u ps=0.92u
    I_MXI60_MP10 (VDD cm6_0 XI60_xp1 VDD) gpdk090_pmos1v w=0.48u l=0.1u ad=0.1632p as=0.1056p pd=1.64u ps=0.92u
    I_MXI60_MP2 (VDD cm5_1 XI60_xan VDD) gpdk090_pmos1v w=0.24u l=0.1u ad=0.0528p as=0.0816p pd=0.68u ps=1.16u
    I_MXI60_MP16 (XI60_con cm6_0 VDD VDD) gpdk090_pmos1v w=0.24u l=0.1u ad=0.0528p as=0.0528p pd=0.68u ps=0.68u
    I_MXI60_MP15 (VDD cm5_1 XI60_con VDD) gpdk090_pmos1v w=0.24u l=0.1u ad=0.0816p as=0.0528p pd=1.16u ps=0.68u
    I_MXI60_MP18 (VDD XI60_con ha17_1 VDD) gpdk090_pmos1v w=0.24u l=0.1u ad=0.0816p as=0.0816p pd=1.16u ps=1.16u
    I_MXI60_MP4 (XI60_xbn cm6_0 VDD VDD) gpdk090_pmos1v w=0.24u l=0.1u ad=0.0816p as=0.0816p pd=1.16u ps=1.16u
    I_MXI58_MP9 (XI58_xp1 fa3_1 VDD VDD) gpdk090_pmos1v w=0.48u l=0.1u ad=0.1056p as=0.1632p pd=0.92u ps=1.64u
    I_MXI58_MP11 (ha15_0 XI58_xan XI58_xp1 VDD) gpdk090_pmos1v w=0.48u l=0.1u ad=0.1056p as=0.1056p pd=0.92u ps=0.92u
    I_MXI58_MP12 (XI58_xp1 XI58_xbn ha15_0 VDD) gpdk090_pmos1v w=0.48u l=0.1u ad=0.1056p as=0.1056p pd=0.92u ps=0.92u
    I_MXI58_MP10 (VDD fa4_0 XI58_xp1 VDD) gpdk090_pmos1v w=0.48u l=0.1u ad=0.1632p as=0.1056p pd=1.64u ps=0.92u
    I_MXI58_MP2 (VDD fa3_1 XI58_xan VDD) gpdk090_pmos1v w=0.24u l=0.1u ad=0.0528p as=0.0816p pd=0.68u ps=1.16u
    I_MXI58_MP16 (XI58_con fa4_0 VDD VDD) gpdk090_pmos1v w=0.24u l=0.1u ad=0.0528p as=0.0528p pd=0.68u ps=0.68u
    I_MXI58_MP15 (VDD fa3_1 XI58_con VDD) gpdk090_pmos1v w=0.24u l=0.1u ad=0.0816p as=0.0528p pd=1.16u ps=0.68u
    I_MXI58_MP18 (VDD XI58_con ha15_1 VDD) gpdk090_pmos1v w=0.24u l=0.1u ad=0.0816p as=0.0816p pd=1.16u ps=1.16u
    I_MXI58_MP4 (XI58_xbn fa4_0 VDD VDD) gpdk090_pmos1v w=0.24u l=0.1u ad=0.0816p as=0.0816p pd=1.16u ps=1.16u
    I_MXI73_MP9 (XI73_xp1 fa14_0 VDD VDD) gpdk090_pmos1v w=0.48u l=0.1u ad=0.1056p as=0.1632p pd=0.92u ps=1.64u
    I_MXI73_MP11 (P_4 XI73_xan XI73_xp1 VDD) gpdk090_pmos1v w=0.48u l=0.1u ad=0.1056p as=0.1056p pd=0.92u ps=0.92u
    I_MXI73_MP12 (XI73_xp1 XI73_xbn P_4 VDD) gpdk090_pmos1v w=0.48u l=0.1u ad=0.1056p as=0.1056p pd=0.92u ps=0.92u
    I_MXI73_MP10 (VDD rc4 XI73_xp1 VDD) gpdk090_pmos1v w=0.48u l=0.1u ad=0.1632p as=0.1056p pd=1.64u ps=0.92u
    I_MXI73_MP2 (VDD fa14_0 XI73_xan VDD) gpdk090_pmos1v w=0.24u l=0.1u ad=0.0528p as=0.0816p pd=0.68u ps=1.16u
    I_MXI73_MP16 (XI73_con rc4 VDD VDD) gpdk090_pmos1v w=0.24u l=0.1u ad=0.0528p as=0.0528p pd=0.68u ps=0.68u
    I_MXI73_MP15 (VDD fa14_0 XI73_con VDD) gpdk090_pmos1v w=0.24u l=0.1u ad=0.0816p as=0.0528p pd=1.16u ps=0.68u
    I_MXI73_MP18 (VDD XI73_con rc5 VDD) gpdk090_pmos1v w=0.24u l=0.1u ad=0.0816p as=0.0816p pd=1.16u ps=1.16u
    I_MXI73_MP4 (XI73_xbn rc4 VDD VDD) gpdk090_pmos1v w=0.24u l=0.1u ad=0.0816p as=0.0816p pd=1.16u ps=1.16u
    I_MXI63_MP9 (XI63_xp1 cm8_1 VDD VDD) gpdk090_pmos1v w=0.48u l=0.1u ad=0.1056p as=0.1632p pd=0.92u ps=1.64u
    I_MXI63_MP11 (ha20_0 XI63_xan XI63_xp1 VDD) gpdk090_pmos1v w=0.48u l=0.1u ad=0.1056p as=0.1056p pd=0.92u ps=0.92u
    I_MXI63_MP12 (XI63_xp1 XI63_xbn ha20_0 VDD) gpdk090_pmos1v w=0.48u l=0.1u ad=0.1056p as=0.1056p pd=0.92u ps=0.92u
    I_MXI63_MP10 (VDD cm9_0 XI63_xp1 VDD) gpdk090_pmos1v w=0.48u l=0.1u ad=0.1632p as=0.1056p pd=1.64u ps=0.92u
    I_MXI63_MP2 (VDD cm8_1 XI63_xan VDD) gpdk090_pmos1v w=0.24u l=0.1u ad=0.0528p as=0.0816p pd=0.68u ps=1.16u
    I_MXI63_MP16 (XI63_con cm9_0 VDD VDD) gpdk090_pmos1v w=0.24u l=0.1u ad=0.0528p as=0.0528p pd=0.68u ps=0.68u
    I_MXI63_MP15 (VDD cm8_1 XI63_con VDD) gpdk090_pmos1v w=0.24u l=0.1u ad=0.0816p as=0.0528p pd=1.16u ps=0.68u
    I_MXI63_MP18 (VDD XI63_con ha20_1 VDD) gpdk090_pmos1v w=0.24u l=0.1u ad=0.0816p as=0.0816p pd=1.16u ps=1.16u
    I_MXI63_MP4 (XI63_xbn cm9_0 VDD VDD) gpdk090_pmos1v w=0.24u l=0.1u ad=0.0816p as=0.0816p pd=1.16u ps=1.16u
    I_MXI64_MP9 (XI64_xp1 cm9_1 VDD VDD) gpdk090_pmos1v w=0.48u l=0.1u ad=0.1056p as=0.1632p pd=0.92u ps=1.64u
    I_MXI64_MP11 (ha21_0 XI64_xan XI64_xp1 VDD) gpdk090_pmos1v w=0.48u l=0.1u ad=0.1056p as=0.1056p pd=0.92u ps=0.92u
    I_MXI64_MP12 (XI64_xp1 XI64_xbn ha21_0 VDD) gpdk090_pmos1v w=0.48u l=0.1u ad=0.1056p as=0.1056p pd=0.92u ps=0.92u
    I_MXI64_MP10 (VDD cm10_0 XI64_xp1 VDD) gpdk090_pmos1v w=0.48u l=0.1u ad=0.1632p as=0.1056p pd=1.64u ps=0.92u
    I_MXI64_MP2 (VDD cm9_1 XI64_xan VDD) gpdk090_pmos1v w=0.24u l=0.1u ad=0.0528p as=0.0816p pd=0.68u ps=1.16u
    I_MXI64_MP16 (XI64_con cm10_0 VDD VDD) gpdk090_pmos1v w=0.24u l=0.1u ad=0.0528p as=0.0528p pd=0.68u ps=0.68u
    I_MXI64_MP15 (VDD cm9_1 XI64_con VDD) gpdk090_pmos1v w=0.24u l=0.1u ad=0.0816p as=0.0528p pd=1.16u ps=0.68u
    I_MXI64_MP18 (VDD XI64_con ha21_1 VDD) gpdk090_pmos1v w=0.24u l=0.1u ad=0.0816p as=0.0816p pd=1.16u ps=1.16u
    I_MXI64_MP4 (XI64_xbn cm10_0 VDD VDD) gpdk090_pmos1v w=0.24u l=0.1u ad=0.0816p as=0.0816p pd=1.16u ps=1.16u
    I_MXI65_MP9 (XI65_xp1 cm10_1 VDD VDD) gpdk090_pmos1v w=0.48u l=0.1u ad=0.1056p as=0.1632p pd=0.92u ps=1.64u
    I_MXI65_MP11 (ha22_0 XI65_xan XI65_xp1 VDD) gpdk090_pmos1v w=0.48u l=0.1u ad=0.1056p as=0.1056p pd=0.92u ps=0.92u
    I_MXI65_MP12 (XI65_xp1 XI65_xbn ha22_0 VDD) gpdk090_pmos1v w=0.48u l=0.1u ad=0.1056p as=0.1056p pd=0.92u ps=0.92u
    I_MXI65_MP10 (VDD cm11_0 XI65_xp1 VDD) gpdk090_pmos1v w=0.48u l=0.1u ad=0.1632p as=0.1056p pd=1.64u ps=0.92u
    I_MXI65_MP2 (VDD cm10_1 XI65_xan VDD) gpdk090_pmos1v w=0.24u l=0.1u ad=0.0528p as=0.0816p pd=0.68u ps=1.16u
    I_MXI65_MP16 (XI65_con cm11_0 VDD VDD) gpdk090_pmos1v w=0.24u l=0.1u ad=0.0528p as=0.0528p pd=0.68u ps=0.68u
    I_MXI65_MP15 (VDD cm10_1 XI65_con VDD) gpdk090_pmos1v w=0.24u l=0.1u ad=0.0816p as=0.0528p pd=1.16u ps=0.68u
    I_MXI65_MP18 (VDD XI65_con ha22_1 VDD) gpdk090_pmos1v w=0.24u l=0.1u ad=0.0816p as=0.0816p pd=1.16u ps=1.16u
    I_MXI65_MP4 (XI65_xbn cm11_0 VDD VDD) gpdk090_pmos1v w=0.24u l=0.1u ad=0.0816p as=0.0816p pd=1.16u ps=1.16u
    I_MXI45_MP9 (XI45_xp1 pp0_3 VDD VDD) gpdk090_pmos1v w=0.48u l=0.1u ad=0.1056p as=0.1632p pd=0.92u ps=1.64u
    I_MXI45_MP11 (ha2_0 XI45_xan XI45_xp1 VDD) gpdk090_pmos1v w=0.48u l=0.1u ad=0.1056p as=0.1056p pd=0.92u ps=0.92u
    I_MXI45_MP12 (XI45_xp1 XI45_xbn ha2_0 VDD) gpdk090_pmos1v w=0.48u l=0.1u ad=0.1056p as=0.1056p pd=0.92u ps=0.92u
    I_MXI45_MP10 (VDD pp1_1 XI45_xp1 VDD) gpdk090_pmos1v w=0.48u l=0.1u ad=0.1632p as=0.1056p pd=1.64u ps=0.92u
    I_MXI45_MP2 (VDD pp0_3 XI45_xan VDD) gpdk090_pmos1v w=0.24u l=0.1u ad=0.0528p as=0.0816p pd=0.68u ps=1.16u
    I_MXI45_MP16 (XI45_con pp1_1 VDD VDD) gpdk090_pmos1v w=0.24u l=0.1u ad=0.0528p as=0.0528p pd=0.68u ps=0.68u
    I_MXI45_MP15 (VDD pp0_3 XI45_con VDD) gpdk090_pmos1v w=0.24u l=0.1u ad=0.0816p as=0.0528p pd=1.16u ps=0.68u
    I_MXI45_MP18 (VDD XI45_con ha2_1 VDD) gpdk090_pmos1v w=0.24u l=0.1u ad=0.0816p as=0.0816p pd=1.16u ps=1.16u
    I_MXI45_MP4 (XI45_xbn pp1_1 VDD VDD) gpdk090_pmos1v w=0.24u l=0.1u ad=0.0816p as=0.0816p pd=1.16u ps=1.16u
    I_MXI66_MP9 (XI66_xp1 cm11_1 VDD VDD) gpdk090_pmos1v w=0.48u l=0.1u ad=0.1056p as=0.1632p pd=0.92u ps=1.64u
    I_MXI66_MP11 (ha23_0 XI66_xan XI66_xp1 VDD) gpdk090_pmos1v w=0.48u l=0.1u ad=0.1056p as=0.1056p pd=0.92u ps=0.92u
    I_MXI66_MP12 (XI66_xp1 XI66_xbn ha23_0 VDD) gpdk090_pmos1v w=0.48u l=0.1u ad=0.1056p as=0.1056p pd=0.92u ps=0.92u
    I_MXI66_MP10 (VDD fa12_0 XI66_xp1 VDD) gpdk090_pmos1v w=0.48u l=0.1u ad=0.1632p as=0.1056p pd=1.64u ps=0.92u
    I_MXI66_MP2 (VDD cm11_1 XI66_xan VDD) gpdk090_pmos1v w=0.24u l=0.1u ad=0.0528p as=0.0816p pd=0.68u ps=1.16u
    I_MXI66_MP16 (XI66_con fa12_0 VDD VDD) gpdk090_pmos1v w=0.24u l=0.1u ad=0.0528p as=0.0528p pd=0.68u ps=0.68u
    I_MXI66_MP15 (VDD cm11_1 XI66_con VDD) gpdk090_pmos1v w=0.24u l=0.1u ad=0.0816p as=0.0528p pd=1.16u ps=0.68u
    I_MXI66_MP18 (VDD XI66_con ha23_1 VDD) gpdk090_pmos1v w=0.24u l=0.1u ad=0.0816p as=0.0816p pd=1.16u ps=1.16u
    I_MXI66_MP4 (XI66_xbn fa12_0 VDD VDD) gpdk090_pmos1v w=0.24u l=0.1u ad=0.0816p as=0.0816p pd=1.16u ps=1.16u
    I_MXI67_MP9 (XI67_xp1 fa12_1 VDD VDD) gpdk090_pmos1v w=0.48u l=0.1u ad=0.1056p as=0.1632p pd=0.92u ps=1.64u
    I_MXI67_MP11 (ha24_0 XI67_xan XI67_xp1 VDD) gpdk090_pmos1v w=0.48u l=0.1u ad=0.1056p as=0.1056p pd=0.92u ps=0.92u
    I_MXI67_MP12 (XI67_xp1 XI67_xbn ha24_0 VDD) gpdk090_pmos1v w=0.48u l=0.1u ad=0.1056p as=0.1056p pd=0.92u ps=0.92u
    I_MXI67_MP10 (VDD ha13_0 XI67_xp1 VDD) gpdk090_pmos1v w=0.48u l=0.1u ad=0.1632p as=0.1056p pd=1.64u ps=0.92u
    I_MXI67_MP2 (VDD fa12_1 XI67_xan VDD) gpdk090_pmos1v w=0.24u l=0.1u ad=0.0528p as=0.0816p pd=0.68u ps=1.16u
    I_MXI67_MP16 (XI67_con ha13_0 VDD VDD) gpdk090_pmos1v w=0.24u l=0.1u ad=0.0528p as=0.0528p pd=0.68u ps=0.68u
    I_MXI67_MP15 (VDD fa12_1 XI67_con VDD) gpdk090_pmos1v w=0.24u l=0.1u ad=0.0816p as=0.0528p pd=1.16u ps=0.68u
    I_MXI67_MP18 (VDD XI67_con ha24_1 VDD) gpdk090_pmos1v w=0.24u l=0.1u ad=0.0816p as=0.0816p pd=1.16u ps=1.16u
    I_MXI67_MP4 (XI67_xbn ha13_0 VDD VDD) gpdk090_pmos1v w=0.24u l=0.1u ad=0.0816p as=0.0816p pd=1.16u ps=1.16u
    I_MXI71_MP9 (XI71_xp1 fa1_0 VDD VDD) gpdk090_pmos1v w=0.48u l=0.1u ad=0.1056p as=0.1632p pd=0.92u ps=1.64u
    I_MXI71_MP11 (P_2 XI71_xan XI71_xp1 VDD) gpdk090_pmos1v w=0.48u l=0.1u ad=0.1056p as=0.1056p pd=0.92u ps=0.92u
    I_MXI71_MP12 (XI71_xp1 XI71_xbn P_2 VDD) gpdk090_pmos1v w=0.48u l=0.1u ad=0.1056p as=0.1056p pd=0.92u ps=0.92u
    I_MXI71_MP10 (VDD rc2 XI71_xp1 VDD) gpdk090_pmos1v w=0.48u l=0.1u ad=0.1632p as=0.1056p pd=1.64u ps=0.92u
    I_MXI71_MP2 (VDD fa1_0 XI71_xan VDD) gpdk090_pmos1v w=0.24u l=0.1u ad=0.0528p as=0.0816p pd=0.68u ps=1.16u
    I_MXI71_MP16 (XI71_con rc2 VDD VDD) gpdk090_pmos1v w=0.24u l=0.1u ad=0.0528p as=0.0528p pd=0.68u ps=0.68u
    I_MXI71_MP15 (VDD fa1_0 XI71_con VDD) gpdk090_pmos1v w=0.24u l=0.1u ad=0.0816p as=0.0528p pd=1.16u ps=0.68u
    I_MXI71_MP18 (VDD XI71_con rc3 VDD) gpdk090_pmos1v w=0.24u l=0.1u ad=0.0816p as=0.0816p pd=1.16u ps=1.16u
    I_MXI71_MP4 (XI71_xbn rc2 VDD VDD) gpdk090_pmos1v w=0.24u l=0.1u ad=0.0816p as=0.0816p pd=1.16u ps=1.16u
    I_MXI68_MP9 (XI68_xp1 ha13_1 VDD VDD) gpdk090_pmos1v w=0.48u l=0.1u ad=0.1056p as=0.1632p pd=0.92u ps=1.64u
    I_MXI68_MP11 (ha25_0 XI68_xan XI68_xp1 VDD) gpdk090_pmos1v w=0.48u l=0.1u ad=0.1056p as=0.1056p pd=0.92u ps=0.92u
    I_MXI68_MP12 (XI68_xp1 XI68_xbn ha25_0 VDD) gpdk090_pmos1v w=0.48u l=0.1u ad=0.1056p as=0.1056p pd=0.92u ps=0.92u
    I_MXI68_MP10 (VDD sn3 XI68_xp1 VDD) gpdk090_pmos1v w=0.48u l=0.1u ad=0.1632p as=0.1056p pd=1.64u ps=0.92u
    I_MXI68_MP2 (VDD ha13_1 XI68_xan VDD) gpdk090_pmos1v w=0.24u l=0.1u ad=0.0528p as=0.0816p pd=0.68u ps=1.16u
    I_MXI68_MP16 (XI68_con sn3 VDD VDD) gpdk090_pmos1v w=0.24u l=0.1u ad=0.0528p as=0.0528p pd=0.68u ps=0.68u
    I_MXI68_MP15 (VDD ha13_1 XI68_con VDD) gpdk090_pmos1v w=0.24u l=0.1u ad=0.0816p as=0.0528p pd=1.16u ps=0.68u
    I_MXI68_MP18 (VDD XI68_con ha25_1 VDD) gpdk090_pmos1v w=0.24u l=0.1u ad=0.0816p as=0.0816p pd=1.16u ps=1.16u
    I_MXI68_MP4 (XI68_xbn sn3 VDD VDD) gpdk090_pmos1v w=0.24u l=0.1u ad=0.0816p as=0.0816p pd=1.16u ps=1.16u
    I_MXI70_MP9 (XI70_xp1 pp0_1 VDD VDD) gpdk090_pmos1v w=0.48u l=0.1u ad=0.1056p as=0.1632p pd=0.92u ps=1.64u
    I_MXI70_MP11 (P_1 XI70_xan XI70_xp1 VDD) gpdk090_pmos1v w=0.48u l=0.1u ad=0.1056p as=0.1056p pd=0.92u ps=0.92u
    I_MXI70_MP12 (XI70_xp1 XI70_xbn P_1 VDD) gpdk090_pmos1v w=0.48u l=0.1u ad=0.1056p as=0.1056p pd=0.92u ps=0.92u
    I_MXI70_MP10 (VDD rc1 XI70_xp1 VDD) gpdk090_pmos1v w=0.48u l=0.1u ad=0.1632p as=0.1056p pd=1.64u ps=0.92u
    I_MXI70_MP2 (VDD pp0_1 XI70_xan VDD) gpdk090_pmos1v w=0.24u l=0.1u ad=0.0528p as=0.0816p pd=0.68u ps=1.16u
    I_MXI70_MP16 (XI70_con rc1 VDD VDD) gpdk090_pmos1v w=0.24u l=0.1u ad=0.0528p as=0.0528p pd=0.68u ps=0.68u
    I_MXI70_MP15 (VDD pp0_1 XI70_con VDD) gpdk090_pmos1v w=0.24u l=0.1u ad=0.0816p as=0.0528p pd=1.16u ps=0.68u
    I_MXI70_MP18 (VDD XI70_con rc2 VDD) gpdk090_pmos1v w=0.24u l=0.1u ad=0.0816p as=0.0816p pd=1.16u ps=1.16u
    I_MXI70_MP4 (XI70_xbn rc1 VDD VDD) gpdk090_pmos1v w=0.24u l=0.1u ad=0.0816p as=0.0816p pd=1.16u ps=1.16u
    I_MXI56_MP9 (XI56_xp1 VDD VDD VDD) gpdk090_pmos1v w=0.48u l=0.1u ad=0.1056p as=0.1632p pd=0.92u ps=1.64u
    I_MXI56_MP11 (ha13_0 XI56_xan XI56_xp1 VDD) gpdk090_pmos1v w=0.48u l=0.1u ad=0.1056p as=0.1056p pd=0.92u ps=0.92u
    I_MXI56_MP12 (XI56_xp1 XI56_xbn ha13_0 VDD) gpdk090_pmos1v w=0.48u l=0.1u ad=0.1056p as=0.1056p pd=0.92u ps=0.92u
    I_MXI56_MP10 (VDD pp3_8 XI56_xp1 VDD) gpdk090_pmos1v w=0.48u l=0.1u ad=0.1632p as=0.1056p pd=1.64u ps=0.92u
    I_MXI56_MP2 (VDD VDD XI56_xan VDD) gpdk090_pmos1v w=0.24u l=0.1u ad=0.0528p as=0.0816p pd=0.68u ps=1.16u
    I_MXI56_MP16 (XI56_con pp3_8 VDD VDD) gpdk090_pmos1v w=0.24u l=0.1u ad=0.0528p as=0.0528p pd=0.68u ps=0.68u
    I_MXI56_MP15 (VDD VDD XI56_con VDD) gpdk090_pmos1v w=0.24u l=0.1u ad=0.0816p as=0.0528p pd=1.16u ps=0.68u
    I_MXI56_MP18 (VDD XI56_con ha13_1 VDD) gpdk090_pmos1v w=0.24u l=0.1u ad=0.0816p as=0.0816p pd=1.16u ps=1.16u
    I_MXI56_MP4 (XI56_xbn pp3_8 VDD VDD) gpdk090_pmos1v w=0.24u l=0.1u ad=0.0816p as=0.0816p pd=1.16u ps=1.16u
    I_MXI69_MP9 (XI69_xp1 pp0_0 VDD VDD) gpdk090_pmos1v w=0.48u l=0.1u ad=0.1056p as=0.1632p pd=0.92u ps=1.64u
    I_MXI69_MP11 (P_0 XI69_xan XI69_xp1 VDD) gpdk090_pmos1v w=0.48u l=0.1u ad=0.1056p as=0.1056p pd=0.92u ps=0.92u
    I_MXI69_MP12 (XI69_xp1 XI69_xbn P_0 VDD) gpdk090_pmos1v w=0.48u l=0.1u ad=0.1056p as=0.1056p pd=0.92u ps=0.92u
    I_MXI69_MP10 (VDD B_1 XI69_xp1 VDD) gpdk090_pmos1v w=0.48u l=0.1u ad=0.1632p as=0.1056p pd=1.64u ps=0.92u
    I_MXI69_MP2 (VDD pp0_0 XI69_xan VDD) gpdk090_pmos1v w=0.24u l=0.1u ad=0.0528p as=0.0816p pd=0.68u ps=1.16u
    I_MXI69_MP16 (XI69_con B_1 VDD VDD) gpdk090_pmos1v w=0.24u l=0.1u ad=0.0528p as=0.0528p pd=0.68u ps=0.68u
    I_MXI69_MP15 (VDD pp0_0 XI69_con VDD) gpdk090_pmos1v w=0.24u l=0.1u ad=0.0816p as=0.0528p pd=1.16u ps=0.68u
    I_MXI69_MP18 (VDD XI69_con rc1 VDD) gpdk090_pmos1v w=0.24u l=0.1u ad=0.0816p as=0.0816p pd=1.16u ps=1.16u
    I_MXI69_MP4 (XI69_xbn B_1 VDD VDD) gpdk090_pmos1v w=0.24u l=0.1u ad=0.0816p as=0.0816p pd=1.16u ps=1.16u
    I_MXI77_I27_XG_MP2 (XI77_I27_XG_p1 I77_G3_2 I77_G3_0n VDD) gpdk090_pmos1v w=0.48u l=0.1u ad=0.1056p as=0.1632p pd=0.92u ps=1.64u
    I_MXI77_I27_XG_MP0 (VDD I77_P3_2 XI77_I27_XG_p1 VDD) gpdk090_pmos1v w=0.48u l=0.1u ad=0.1056p as=0.1056p pd=0.92u ps=0.92u
    I_MXI77_I27_XG_MP1 (XI77_I27_XG_p1 I77_G1_0 VDD VDD) gpdk090_pmos1v w=0.48u l=0.1u ad=0.1632p as=0.1056p pd=1.64u ps=0.92u
    I_MXI77_I28_XG_MP2 (XI77_I28_XG_p1 I77_G4_3 I77_G4_1n VDD) gpdk090_pmos1v w=0.48u l=0.1u ad=0.1056p as=0.1632p pd=0.92u ps=1.64u
    I_MXI77_I28_XG_MP0 (VDD I77_P4_3 XI77_I28_XG_p1 VDD) gpdk090_pmos1v w=0.48u l=0.1u ad=0.1056p as=0.1056p pd=0.92u ps=0.92u
    I_MXI77_I28_XG_MP1 (XI77_I28_XG_p1 I77_G2_1 VDD VDD) gpdk090_pmos1v w=0.48u l=0.1u ad=0.1632p as=0.1056p pd=1.64u ps=0.92u
    I_MXI77_I26_XG_MP2 (XI77_I26_XG_p1 I77_G2_1 I77_G2_0n VDD) gpdk090_pmos1v w=0.48u l=0.1u ad=0.1056p as=0.1632p pd=0.92u ps=1.64u
    I_MXI77_I26_XG_MP0 (VDD I77_P2_1 XI77_I26_XG_p1 VDD) gpdk090_pmos1v w=0.48u l=0.1u ad=0.1056p as=0.1056p pd=0.92u ps=0.92u
    I_MXI77_I26_XG_MP1 (XI77_I26_XG_p1 I77_G0_0 VDD VDD) gpdk090_pmos1v w=0.48u l=0.1u ad=0.1632p as=0.1056p pd=1.64u ps=0.92u
    I_MXI77_I29_XG_MP2 (XI77_I29_XG_p1 I77_G5_4 I77_G5_2n VDD) gpdk090_pmos1v w=0.48u l=0.1u ad=0.1056p as=0.1632p pd=0.92u ps=1.64u
    I_MXI77_I29_XG_MP0 (VDD I77_P5_4 XI77_I29_XG_p1 VDD) gpdk090_pmos1v w=0.48u l=0.1u ad=0.1056p as=0.1056p pd=0.92u ps=0.92u
    I_MXI77_I29_XG_MP1 (XI77_I29_XG_p1 I77_G3_2 VDD VDD) gpdk090_pmos1v w=0.48u l=0.1u ad=0.1632p as=0.1056p pd=1.64u ps=0.92u
    I_MXI77_I30_XG_MP2 (XI77_I30_XG_p1 I77_G6_5 I77_G6_3n VDD) gpdk090_pmos1v w=0.48u l=0.1u ad=0.1056p as=0.1632p pd=0.92u ps=1.64u
    I_MXI77_I30_XG_MP0 (VDD I77_P6_5 XI77_I30_XG_p1 VDD) gpdk090_pmos1v w=0.48u l=0.1u ad=0.1056p as=0.1056p pd=0.92u ps=0.92u
    I_MXI77_I30_XG_MP1 (XI77_I30_XG_p1 I77_G4_3 VDD VDD) gpdk090_pmos1v w=0.48u l=0.1u ad=0.1632p as=0.1056p pd=1.64u ps=0.92u
    I_MXI77_I31_XG_MP2 (XI77_I31_XG_p1 I77_G7_6 I77_G7_4n VDD) gpdk090_pmos1v w=0.48u l=0.1u ad=0.1056p as=0.1632p pd=0.92u ps=1.64u
    I_MXI77_I31_XG_MP0 (VDD I77_P7_6 XI77_I31_XG_p1 VDD) gpdk090_pmos1v w=0.48u l=0.1u ad=0.1056p as=0.1056p pd=0.92u ps=0.92u
    I_MXI77_I31_XG_MP1 (XI77_I31_XG_p1 I77_G5_4 VDD VDD) gpdk090_pmos1v w=0.48u l=0.1u ad=0.1632p as=0.1056p pd=1.64u ps=0.92u
    I_MXI75_MP24 (XI75_sn rc6 XI75_p5 VDD) gpdk090_pmos1v w=0.36u l=0.1u ad=0.1224p as=0.0792p pd=1.4u ps=0.8u
    I_MXI75_MP26 (VDD XI75_sn P_6 VDD) gpdk090_pmos1v w=0.24u l=0.1u ad=0.0816p as=0.0816p pd=1.16u ps=1.16u
    I_MXI75_MP17 (XI75_con rc6 XI75_p2 VDD) gpdk090_pmos1v w=0.48u l=0.1u ad=0.1056p as=0.1632p pd=0.92u ps=1.64u
    I_MXI75_MP14 (XI75_p1 ha16_0 XI75_con VDD) gpdk090_pmos1v w=0.48u l=0.1u ad=0.1056p as=0.1056p pd=0.92u ps=0.92u
    I_MXI75_MP13 (VDD ha15_1 XI75_p1 VDD) gpdk090_pmos1v w=0.48u l=0.1u ad=0.1056p as=0.1056p pd=0.92u ps=0.92u
    I_MXI75_MP15 (XI75_p2 ha15_1 VDD VDD) gpdk090_pmos1v w=0.48u l=0.1u ad=0.1056p as=0.1056p pd=0.92u ps=0.92u
    I_MXI75_MP16 (VDD ha16_0 XI75_p2 VDD) gpdk090_pmos1v w=0.48u l=0.1u ad=0.0936p as=0.1056p pd=0.92u ps=0.92u
    I_MXI75_MP28 (rc7 XI75_con VDD VDD) gpdk090_pmos1v w=0.24u l=0.1u ad=0.0816p as=0.0936p pd=1.16u ps=0.92u
    I_MXI75_MP22 (XI75_p4 ha15_1 VDD VDD) gpdk090_pmos1v w=0.36u l=0.1u ad=0.0792p as=0.1224p pd=0.8u ps=1.4u
    I_MXI75_MP23 (XI75_p5 ha16_0 XI75_p4 VDD) gpdk090_pmos1v w=0.36u l=0.1u ad=0.0792p as=0.0792p pd=0.8u ps=0.8u
    I_MXI75_MP23_1 (XI75_p4 ha16_0 XI75_p5 VDD) gpdk090_pmos1v w=0.36u l=0.1u ad=0.0792p as=0.0792p pd=0.8u ps=0.8u
    I_MXI75_MP22_1 (VDD ha15_1 XI75_p4 VDD) gpdk090_pmos1v w=0.36u l=0.1u ad=0.1968p as=0.0792p pd=1.46u ps=0.8u
    I_MXI75_MP19 (XI75_p3 ha16_0 VDD VDD) gpdk090_pmos1v w=0.48u l=0.1u ad=0.1056p as=0.1968p pd=0.92u ps=1.46u
    I_MXI75_MP18 (VDD ha15_1 XI75_p3 VDD) gpdk090_pmos1v w=0.48u l=0.1u ad=0.1056p as=0.1056p pd=0.92u ps=0.92u
    I_MXI75_MP20 (XI75_p3 rc6 VDD VDD) gpdk090_pmos1v w=0.48u l=0.1u ad=0.1056p as=0.1056p pd=0.92u ps=0.92u
    I_MXI75_MP21 (XI75_sn XI75_con XI75_p3 VDD) gpdk090_pmos1v w=0.48u l=0.1u ad=0.0996p as=0.1056p pd=0.92u ps=0.92u
    I_MXI75_MP24_1 (XI75_p5 rc6 XI75_sn VDD) gpdk090_pmos1v w=0.36u l=0.1u ad=0.0792p as=0.0996p pd=0.8u ps=0.92u
    I_MXI74_MP24 (XI74_sn rc5 XI74_p5 VDD) gpdk090_pmos1v w=0.36u l=0.1u ad=0.1224p as=0.0792p pd=1.4u ps=0.8u
    I_MXI74_MP26 (VDD XI74_sn P_5 VDD) gpdk090_pmos1v w=0.24u l=0.1u ad=0.0816p as=0.0816p pd=1.16u ps=1.16u
    I_MXI74_MP17 (XI74_con rc5 XI74_p2 VDD) gpdk090_pmos1v w=0.48u l=0.1u ad=0.1056p as=0.1632p pd=0.92u ps=1.64u
    I_MXI74_MP14 (XI74_p1 ha15_0 XI74_con VDD) gpdk090_pmos1v w=0.48u l=0.1u ad=0.1056p as=0.1056p pd=0.92u ps=0.92u
    I_MXI74_MP13 (VDD fa14_1 XI74_p1 VDD) gpdk090_pmos1v w=0.48u l=0.1u ad=0.1056p as=0.1056p pd=0.92u ps=0.92u
    I_MXI74_MP15 (XI74_p2 fa14_1 VDD VDD) gpdk090_pmos1v w=0.48u l=0.1u ad=0.1056p as=0.1056p pd=0.92u ps=0.92u
    I_MXI74_MP16 (VDD ha15_0 XI74_p2 VDD) gpdk090_pmos1v w=0.48u l=0.1u ad=0.0936p as=0.1056p pd=0.92u ps=0.92u
    I_MXI74_MP28 (rc6 XI74_con VDD VDD) gpdk090_pmos1v w=0.24u l=0.1u ad=0.0816p as=0.0936p pd=1.16u ps=0.92u
    I_MXI74_MP22 (XI74_p4 fa14_1 VDD VDD) gpdk090_pmos1v w=0.36u l=0.1u ad=0.0792p as=0.1224p pd=0.8u ps=1.4u
    I_MXI74_MP23 (XI74_p5 ha15_0 XI74_p4 VDD) gpdk090_pmos1v w=0.36u l=0.1u ad=0.0792p as=0.0792p pd=0.8u ps=0.8u
    I_MXI74_MP23_1 (XI74_p4 ha15_0 XI74_p5 VDD) gpdk090_pmos1v w=0.36u l=0.1u ad=0.0792p as=0.0792p pd=0.8u ps=0.8u
    I_MXI74_MP22_1 (VDD fa14_1 XI74_p4 VDD) gpdk090_pmos1v w=0.36u l=0.1u ad=0.1968p as=0.0792p pd=1.46u ps=0.8u
    I_MXI74_MP19 (XI74_p3 ha15_0 VDD VDD) gpdk090_pmos1v w=0.48u l=0.1u ad=0.1056p as=0.1968p pd=0.92u ps=1.46u
    I_MXI74_MP18 (VDD fa14_1 XI74_p3 VDD) gpdk090_pmos1v w=0.48u l=0.1u ad=0.1056p as=0.1056p pd=0.92u ps=0.92u
    I_MXI74_MP20 (XI74_p3 rc5 VDD VDD) gpdk090_pmos1v w=0.48u l=0.1u ad=0.1056p as=0.1056p pd=0.92u ps=0.92u
    I_MXI74_MP21 (XI74_sn XI74_con XI74_p3 VDD) gpdk090_pmos1v w=0.48u l=0.1u ad=0.0996p as=0.1056p pd=0.92u ps=0.92u
    I_MXI74_MP24_1 (XI74_p5 rc5 XI74_sn VDD) gpdk090_pmos1v w=0.36u l=0.1u ad=0.0792p as=0.0996p pd=0.8u ps=0.92u
    I_MXI76_MP24 (XI76_sn rc7 XI76_p5 VDD) gpdk090_pmos1v w=0.36u l=0.1u ad=0.1224p as=0.0792p pd=1.4u ps=0.8u
    I_MXI76_MP26 (VDD XI76_sn P_7 VDD) gpdk090_pmos1v w=0.24u l=0.1u ad=0.0816p as=0.0816p pd=1.16u ps=1.16u
    I_MXI76_MP17 (XI76_con rc7 XI76_p2 VDD) gpdk090_pmos1v w=0.48u l=0.1u ad=0.1056p as=0.1632p pd=0.92u ps=1.64u
    I_MXI76_MP14 (XI76_p1 ha17_0 XI76_con VDD) gpdk090_pmos1v w=0.48u l=0.1u ad=0.1056p as=0.1056p pd=0.92u ps=0.92u
    I_MXI76_MP13 (VDD ha16_1 XI76_p1 VDD) gpdk090_pmos1v w=0.48u l=0.1u ad=0.1056p as=0.1056p pd=0.92u ps=0.92u
    I_MXI76_MP15 (XI76_p2 ha16_1 VDD VDD) gpdk090_pmos1v w=0.48u l=0.1u ad=0.1056p as=0.1056p pd=0.92u ps=0.92u
    I_MXI76_MP16 (VDD ha17_0 XI76_p2 VDD) gpdk090_pmos1v w=0.48u l=0.1u ad=0.0936p as=0.1056p pd=0.92u ps=0.92u
    I_MXI76_MP28 (rc8 XI76_con VDD VDD) gpdk090_pmos1v w=0.24u l=0.1u ad=0.0816p as=0.0936p pd=1.16u ps=0.92u
    I_MXI76_MP22 (XI76_p4 ha16_1 VDD VDD) gpdk090_pmos1v w=0.36u l=0.1u ad=0.0792p as=0.1224p pd=0.8u ps=1.4u
    I_MXI76_MP23 (XI76_p5 ha17_0 XI76_p4 VDD) gpdk090_pmos1v w=0.36u l=0.1u ad=0.0792p as=0.0792p pd=0.8u ps=0.8u
    I_MXI76_MP23_1 (XI76_p4 ha17_0 XI76_p5 VDD) gpdk090_pmos1v w=0.36u l=0.1u ad=0.0792p as=0.0792p pd=0.8u ps=0.8u
    I_MXI76_MP22_1 (VDD ha16_1 XI76_p4 VDD) gpdk090_pmos1v w=0.36u l=0.1u ad=0.1968p as=0.0792p pd=1.46u ps=0.8u
    I_MXI76_MP19 (XI76_p3 ha17_0 VDD VDD) gpdk090_pmos1v w=0.48u l=0.1u ad=0.1056p as=0.1968p pd=0.92u ps=1.46u
    I_MXI76_MP18 (VDD ha16_1 XI76_p3 VDD) gpdk090_pmos1v w=0.48u l=0.1u ad=0.1056p as=0.1056p pd=0.92u ps=0.92u
    I_MXI76_MP20 (XI76_p3 rc7 VDD VDD) gpdk090_pmos1v w=0.48u l=0.1u ad=0.1056p as=0.1056p pd=0.92u ps=0.92u
    I_MXI76_MP21 (XI76_sn XI76_con XI76_p3 VDD) gpdk090_pmos1v w=0.48u l=0.1u ad=0.0996p as=0.1056p pd=0.92u ps=0.92u
    I_MXI76_MP24_1 (XI76_p5 rc7 XI76_sn VDD) gpdk090_pmos1v w=0.36u l=0.1u ad=0.0792p as=0.0996p pd=0.8u ps=0.92u
    I_MXI47_MP24 (XI47_sn pp2_1 XI47_p5 VDD) gpdk090_pmos1v w=0.36u l=0.1u ad=0.1224p as=0.0792p pd=1.4u ps=0.8u
    I_MXI47_MP26 (VDD XI47_sn fa4_0 VDD) gpdk090_pmos1v w=0.24u l=0.1u ad=0.0816p as=0.0816p pd=1.16u ps=1.16u
    I_MXI47_MP17 (XI47_con pp2_1 XI47_p2 VDD) gpdk090_pmos1v w=0.48u l=0.1u ad=0.1056p as=0.1632p pd=0.92u ps=1.64u
    I_MXI47_MP14 (XI47_p1 pp1_3 XI47_con VDD) gpdk090_pmos1v w=0.48u l=0.1u ad=0.1056p as=0.1056p pd=0.92u ps=0.92u
    I_MXI47_MP13 (VDD pp0_5 XI47_p1 VDD) gpdk090_pmos1v w=0.48u l=0.1u ad=0.1056p as=0.1056p pd=0.92u ps=0.92u
    I_MXI47_MP15 (XI47_p2 pp0_5 VDD VDD) gpdk090_pmos1v w=0.48u l=0.1u ad=0.1056p as=0.1056p pd=0.92u ps=0.92u
    I_MXI47_MP16 (VDD pp1_3 XI47_p2 VDD) gpdk090_pmos1v w=0.48u l=0.1u ad=0.0936p as=0.1056p pd=0.92u ps=0.92u
    I_MXI47_MP28 (fa4_1 XI47_con VDD VDD) gpdk090_pmos1v w=0.24u l=0.1u ad=0.0816p as=0.0936p pd=1.16u ps=0.92u
    I_MXI47_MP22 (XI47_p4 pp0_5 VDD VDD) gpdk090_pmos1v w=0.36u l=0.1u ad=0.0792p as=0.1224p pd=0.8u ps=1.4u
    I_MXI47_MP23 (XI47_p5 pp1_3 XI47_p4 VDD) gpdk090_pmos1v w=0.36u l=0.1u ad=0.0792p as=0.0792p pd=0.8u ps=0.8u
    I_MXI47_MP23_1 (XI47_p4 pp1_3 XI47_p5 VDD) gpdk090_pmos1v w=0.36u l=0.1u ad=0.0792p as=0.0792p pd=0.8u ps=0.8u
    I_MXI47_MP22_1 (VDD pp0_5 XI47_p4 VDD) gpdk090_pmos1v w=0.36u l=0.1u ad=0.1968p as=0.0792p pd=1.46u ps=0.8u
    I_MXI47_MP19 (XI47_p3 pp1_3 VDD VDD) gpdk090_pmos1v w=0.48u l=0.1u ad=0.1056p as=0.1968p pd=0.92u ps=1.46u
    I_MXI47_MP18 (VDD pp0_5 XI47_p3 VDD) gpdk090_pmos1v w=0.48u l=0.1u ad=0.1056p as=0.1056p pd=0.92u ps=0.92u
    I_MXI47_MP20 (XI47_p3 pp2_1 VDD VDD) gpdk090_pmos1v w=0.48u l=0.1u ad=0.1056p as=0.1056p pd=0.92u ps=0.92u
    I_MXI47_MP21 (XI47_sn XI47_con XI47_p3 VDD) gpdk090_pmos1v w=0.48u l=0.1u ad=0.0996p as=0.1056p pd=0.92u ps=0.92u
    I_MXI47_MP24_1 (XI47_p5 pp2_1 XI47_sn VDD) gpdk090_pmos1v w=0.36u l=0.1u ad=0.0792p as=0.0996p pd=0.8u ps=0.92u
    I_MXI46_MP24 (XI46_sn pp2_0 XI46_p5 VDD) gpdk090_pmos1v w=0.36u l=0.1u ad=0.1224p as=0.0792p pd=1.4u ps=0.8u
    I_MXI46_MP26 (VDD XI46_sn fa3_0 VDD) gpdk090_pmos1v w=0.24u l=0.1u ad=0.0816p as=0.0816p pd=1.16u ps=1.16u
    I_MXI46_MP17 (XI46_con pp2_0 XI46_p2 VDD) gpdk090_pmos1v w=0.48u l=0.1u ad=0.1056p as=0.1632p pd=0.92u ps=1.64u
    I_MXI46_MP14 (XI46_p1 pp1_2 XI46_con VDD) gpdk090_pmos1v w=0.48u l=0.1u ad=0.1056p as=0.1056p pd=0.92u ps=0.92u
    I_MXI46_MP13 (VDD pp0_4 XI46_p1 VDD) gpdk090_pmos1v w=0.48u l=0.1u ad=0.1056p as=0.1056p pd=0.92u ps=0.92u
    I_MXI46_MP15 (XI46_p2 pp0_4 VDD VDD) gpdk090_pmos1v w=0.48u l=0.1u ad=0.1056p as=0.1056p pd=0.92u ps=0.92u
    I_MXI46_MP16 (VDD pp1_2 XI46_p2 VDD) gpdk090_pmos1v w=0.48u l=0.1u ad=0.0936p as=0.1056p pd=0.92u ps=0.92u
    I_MXI46_MP28 (fa3_1 XI46_con VDD VDD) gpdk090_pmos1v w=0.24u l=0.1u ad=0.0816p as=0.0936p pd=1.16u ps=0.92u
    I_MXI46_MP22 (XI46_p4 pp0_4 VDD VDD) gpdk090_pmos1v w=0.36u l=0.1u ad=0.0792p as=0.1224p pd=0.8u ps=1.4u
    I_MXI46_MP23 (XI46_p5 pp1_2 XI46_p4 VDD) gpdk090_pmos1v w=0.36u l=0.1u ad=0.0792p as=0.0792p pd=0.8u ps=0.8u
    I_MXI46_MP23_1 (XI46_p4 pp1_2 XI46_p5 VDD) gpdk090_pmos1v w=0.36u l=0.1u ad=0.0792p as=0.0792p pd=0.8u ps=0.8u
    I_MXI46_MP22_1 (VDD pp0_4 XI46_p4 VDD) gpdk090_pmos1v w=0.36u l=0.1u ad=0.1968p as=0.0792p pd=1.46u ps=0.8u
    I_MXI46_MP19 (XI46_p3 pp1_2 VDD VDD) gpdk090_pmos1v w=0.48u l=0.1u ad=0.1056p as=0.1968p pd=0.92u ps=1.46u
    I_MXI46_MP18 (VDD pp0_4 XI46_p3 VDD) gpdk090_pmos1v w=0.48u l=0.1u ad=0.1056p as=0.1056p pd=0.92u ps=0.92u
    I_MXI46_MP20 (XI46_p3 pp2_0 VDD VDD) gpdk090_pmos1v w=0.48u l=0.1u ad=0.1056p as=0.1056p pd=0.92u ps=0.92u
    I_MXI46_MP21 (XI46_sn XI46_con XI46_p3 VDD) gpdk090_pmos1v w=0.48u l=0.1u ad=0.0996p as=0.1056p pd=0.92u ps=0.92u
    I_MXI46_MP24_1 (XI46_p5 pp2_0 XI46_sn VDD) gpdk090_pmos1v w=0.36u l=0.1u ad=0.0792p as=0.0996p pd=0.8u ps=0.92u
    I_MXI57_MP24 (XI57_sn B_5 XI57_p5 VDD) gpdk090_pmos1v w=0.36u l=0.1u ad=0.1224p as=0.0792p pd=1.4u ps=0.8u
    I_MXI57_MP26 (VDD XI57_sn fa14_0 VDD) gpdk090_pmos1v w=0.24u l=0.1u ad=0.0816p as=0.0816p pd=1.16u ps=1.16u
    I_MXI57_MP17 (XI57_con B_5 XI57_p2 VDD) gpdk090_pmos1v w=0.48u l=0.1u ad=0.1056p as=0.1632p pd=0.92u ps=1.64u
    I_MXI57_MP14 (XI57_p1 fa3_0 XI57_con VDD) gpdk090_pmos1v w=0.48u l=0.1u ad=0.1056p as=0.1056p pd=0.92u ps=0.92u
    I_MXI57_MP13 (VDD ha2_1 XI57_p1 VDD) gpdk090_pmos1v w=0.48u l=0.1u ad=0.1056p as=0.1056p pd=0.92u ps=0.92u
    I_MXI57_MP15 (XI57_p2 ha2_1 VDD VDD) gpdk090_pmos1v w=0.48u l=0.1u ad=0.1056p as=0.1056p pd=0.92u ps=0.92u
    I_MXI57_MP16 (VDD fa3_0 XI57_p2 VDD) gpdk090_pmos1v w=0.48u l=0.1u ad=0.0936p as=0.1056p pd=0.92u ps=0.92u
    I_MXI57_MP28 (fa14_1 XI57_con VDD VDD) gpdk090_pmos1v w=0.24u l=0.1u ad=0.0816p as=0.0936p pd=1.16u ps=0.92u
    I_MXI57_MP22 (XI57_p4 ha2_1 VDD VDD) gpdk090_pmos1v w=0.36u l=0.1u ad=0.0792p as=0.1224p pd=0.8u ps=1.4u
    I_MXI57_MP23 (XI57_p5 fa3_0 XI57_p4 VDD) gpdk090_pmos1v w=0.36u l=0.1u ad=0.0792p as=0.0792p pd=0.8u ps=0.8u
    I_MXI57_MP23_1 (XI57_p4 fa3_0 XI57_p5 VDD) gpdk090_pmos1v w=0.36u l=0.1u ad=0.0792p as=0.0792p pd=0.8u ps=0.8u
    I_MXI57_MP22_1 (VDD ha2_1 XI57_p4 VDD) gpdk090_pmos1v w=0.36u l=0.1u ad=0.1968p as=0.0792p pd=1.46u ps=0.8u
    I_MXI57_MP19 (XI57_p3 fa3_0 VDD VDD) gpdk090_pmos1v w=0.48u l=0.1u ad=0.1056p as=0.1968p pd=0.92u ps=1.46u
    I_MXI57_MP18 (VDD ha2_1 XI57_p3 VDD) gpdk090_pmos1v w=0.48u l=0.1u ad=0.1056p as=0.1056p pd=0.92u ps=0.92u
    I_MXI57_MP20 (XI57_p3 B_5 VDD VDD) gpdk090_pmos1v w=0.48u l=0.1u ad=0.1056p as=0.1056p pd=0.92u ps=0.92u
    I_MXI57_MP21 (XI57_sn XI57_con XI57_p3 VDD) gpdk090_pmos1v w=0.48u l=0.1u ad=0.0996p as=0.1056p pd=0.92u ps=0.92u
    I_MXI57_MP24_1 (XI57_p5 B_5 XI57_sn VDD) gpdk090_pmos1v w=0.36u l=0.1u ad=0.0792p as=0.0996p pd=0.8u ps=0.92u
    I_MXI55_MP24 (XI55_sn cm11_2 XI55_p5 VDD) gpdk090_pmos1v w=0.36u l=0.1u ad=0.1224p as=0.0792p pd=1.4u ps=0.8u
    I_MXI55_MP26 (VDD XI55_sn fa12_0 VDD) gpdk090_pmos1v w=0.24u l=0.1u ad=0.0816p as=0.0816p pd=1.16u ps=1.16u
    I_MXI55_MP17 (XI55_con cm11_2 XI55_p2 VDD) gpdk090_pmos1v w=0.48u l=0.1u ad=0.1056p as=0.1632p pd=0.92u ps=1.64u
    I_MXI55_MP14 (XI55_p1 pp3_7 XI55_con VDD) gpdk090_pmos1v w=0.48u l=0.1u ad=0.1056p as=0.1056p pd=0.92u ps=0.92u
    I_MXI55_MP13 (VDD sn2 XI55_p1 VDD) gpdk090_pmos1v w=0.48u l=0.1u ad=0.1056p as=0.1056p pd=0.92u ps=0.92u
    I_MXI55_MP15 (XI55_p2 sn2 VDD VDD) gpdk090_pmos1v w=0.48u l=0.1u ad=0.1056p as=0.1056p pd=0.92u ps=0.92u
    I_MXI55_MP16 (VDD pp3_7 XI55_p2 VDD) gpdk090_pmos1v w=0.48u l=0.1u ad=0.0936p as=0.1056p pd=0.92u ps=0.92u
    I_MXI55_MP28 (fa12_1 XI55_con VDD VDD) gpdk090_pmos1v w=0.24u l=0.1u ad=0.0816p as=0.0936p pd=1.16u ps=0.92u
    I_MXI55_MP22 (XI55_p4 sn2 VDD VDD) gpdk090_pmos1v w=0.36u l=0.1u ad=0.0792p as=0.1224p pd=0.8u ps=1.4u
    I_MXI55_MP23 (XI55_p5 pp3_7 XI55_p4 VDD) gpdk090_pmos1v w=0.36u l=0.1u ad=0.0792p as=0.0792p pd=0.8u ps=0.8u
    I_MXI55_MP23_1 (XI55_p4 pp3_7 XI55_p5 VDD) gpdk090_pmos1v w=0.36u l=0.1u ad=0.0792p as=0.0792p pd=0.8u ps=0.8u
    I_MXI55_MP22_1 (VDD sn2 XI55_p4 VDD) gpdk090_pmos1v w=0.36u l=0.1u ad=0.1968p as=0.0792p pd=1.46u ps=0.8u
    I_MXI55_MP19 (XI55_p3 pp3_7 VDD VDD) gpdk090_pmos1v w=0.48u l=0.1u ad=0.1056p as=0.1968p pd=0.92u ps=1.46u
    I_MXI55_MP18 (VDD sn2 XI55_p3 VDD) gpdk090_pmos1v w=0.48u l=0.1u ad=0.1056p as=0.1056p pd=0.92u ps=0.92u
    I_MXI55_MP20 (XI55_p3 cm11_2 VDD VDD) gpdk090_pmos1v w=0.48u l=0.1u ad=0.1056p as=0.1056p pd=0.92u ps=0.92u
    I_MXI55_MP21 (XI55_sn XI55_con XI55_p3 VDD) gpdk090_pmos1v w=0.48u l=0.1u ad=0.0996p as=0.1056p pd=0.92u ps=0.92u
    I_MXI55_MP24_1 (XI55_p5 cm11_2 XI55_sn VDD) gpdk090_pmos1v w=0.36u l=0.1u ad=0.0792p as=0.0996p pd=0.8u ps=0.92u
    I_MXI44_MP24 (XI44_sn B_3 XI44_p5 VDD) gpdk090_pmos1v w=0.36u l=0.1u ad=0.1224p as=0.0792p pd=1.4u ps=0.8u
    I_MXI44_MP26 (VDD XI44_sn fa1_0 VDD) gpdk090_pmos1v w=0.24u l=0.1u ad=0.0816p as=0.0816p pd=1.16u ps=1.16u
    I_MXI44_MP17 (XI44_con B_3 XI44_p2 VDD) gpdk090_pmos1v w=0.48u l=0.1u ad=0.1056p as=0.1632p pd=0.92u ps=1.64u
    I_MXI44_MP14 (XI44_p1 pp1_0 XI44_con VDD) gpdk090_pmos1v w=0.48u l=0.1u ad=0.1056p as=0.1056p pd=0.92u ps=0.92u
    I_MXI44_MP13 (VDD pp0_2 XI44_p1 VDD) gpdk090_pmos1v w=0.48u l=0.1u ad=0.1056p as=0.1056p pd=0.92u ps=0.92u
    I_MXI44_MP15 (XI44_p2 pp0_2 VDD VDD) gpdk090_pmos1v w=0.48u l=0.1u ad=0.1056p as=0.1056p pd=0.92u ps=0.92u
    I_MXI44_MP16 (VDD pp1_0 XI44_p2 VDD) gpdk090_pmos1v w=0.48u l=0.1u ad=0.0936p as=0.1056p pd=0.92u ps=0.92u
    I_MXI44_MP28 (fa1_1 XI44_con VDD VDD) gpdk090_pmos1v w=0.24u l=0.1u ad=0.0816p as=0.0936p pd=1.16u ps=0.92u
    I_MXI44_MP22 (XI44_p4 pp0_2 VDD VDD) gpdk090_pmos1v w=0.36u l=0.1u ad=0.0792p as=0.1224p pd=0.8u ps=1.4u
    I_MXI44_MP23 (XI44_p5 pp1_0 XI44_p4 VDD) gpdk090_pmos1v w=0.36u l=0.1u ad=0.0792p as=0.0792p pd=0.8u ps=0.8u
    I_MXI44_MP23_1 (XI44_p4 pp1_0 XI44_p5 VDD) gpdk090_pmos1v w=0.36u l=0.1u ad=0.0792p as=0.0792p pd=0.8u ps=0.8u
    I_MXI44_MP22_1 (VDD pp0_2 XI44_p4 VDD) gpdk090_pmos1v w=0.36u l=0.1u ad=0.1968p as=0.0792p pd=1.46u ps=0.8u
    I_MXI44_MP19 (XI44_p3 pp1_0 VDD VDD) gpdk090_pmos1v w=0.48u l=0.1u ad=0.1056p as=0.1968p pd=0.92u ps=1.46u
    I_MXI44_MP18 (VDD pp0_2 XI44_p3 VDD) gpdk090_pmos1v w=0.48u l=0.1u ad=0.1056p as=0.1056p pd=0.92u ps=0.92u
    I_MXI44_MP20 (XI44_p3 B_3 VDD VDD) gpdk090_pmos1v w=0.48u l=0.1u ad=0.1056p as=0.1056p pd=0.92u ps=0.92u
    I_MXI44_MP21 (XI44_sn XI44_con XI44_p3 VDD) gpdk090_pmos1v w=0.48u l=0.1u ad=0.0996p as=0.1056p pd=0.92u ps=0.92u
    I_MXI44_MP24_1 (XI44_p5 B_3 XI44_sn VDD) gpdk090_pmos1v w=0.36u l=0.1u ad=0.0792p as=0.0996p pd=0.8u ps=0.92u
    I_MXI72_MP24 (XI72_sn rc3 XI72_p5 VDD) gpdk090_pmos1v w=0.36u l=0.1u ad=0.1224p as=0.0792p pd=1.4u ps=0.8u
    I_MXI72_MP26 (VDD XI72_sn P_3 VDD) gpdk090_pmos1v w=0.24u l=0.1u ad=0.0816p as=0.0816p pd=1.16u ps=1.16u
    I_MXI72_MP17 (XI72_con rc3 XI72_p2 VDD) gpdk090_pmos1v w=0.48u l=0.1u ad=0.1056p as=0.1632p pd=0.92u ps=1.64u
    I_MXI72_MP14 (XI72_p1 ha2_0 XI72_con VDD) gpdk090_pmos1v w=0.48u l=0.1u ad=0.1056p as=0.1056p pd=0.92u ps=0.92u
    I_MXI72_MP13 (VDD fa1_1 XI72_p1 VDD) gpdk090_pmos1v w=0.48u l=0.1u ad=0.1056p as=0.1056p pd=0.92u ps=0.92u
    I_MXI72_MP15 (XI72_p2 fa1_1 VDD VDD) gpdk090_pmos1v w=0.48u l=0.1u ad=0.1056p as=0.1056p pd=0.92u ps=0.92u
    I_MXI72_MP16 (VDD ha2_0 XI72_p2 VDD) gpdk090_pmos1v w=0.48u l=0.1u ad=0.0936p as=0.1056p pd=0.92u ps=0.92u
    I_MXI72_MP28 (rc4 XI72_con VDD VDD) gpdk090_pmos1v w=0.24u l=0.1u ad=0.0816p as=0.0936p pd=1.16u ps=0.92u
    I_MXI72_MP22 (XI72_p4 fa1_1 VDD VDD) gpdk090_pmos1v w=0.36u l=0.1u ad=0.0792p as=0.1224p pd=0.8u ps=1.4u
    I_MXI72_MP23 (XI72_p5 ha2_0 XI72_p4 VDD) gpdk090_pmos1v w=0.36u l=0.1u ad=0.0792p as=0.0792p pd=0.8u ps=0.8u
    I_MXI72_MP23_1 (XI72_p4 ha2_0 XI72_p5 VDD) gpdk090_pmos1v w=0.36u l=0.1u ad=0.0792p as=0.0792p pd=0.8u ps=0.8u
    I_MXI72_MP22_1 (VDD fa1_1 XI72_p4 VDD) gpdk090_pmos1v w=0.36u l=0.1u ad=0.1968p as=0.0792p pd=1.46u ps=0.8u
    I_MXI72_MP19 (XI72_p3 ha2_0 VDD VDD) gpdk090_pmos1v w=0.48u l=0.1u ad=0.1056p as=0.1968p pd=0.92u ps=1.46u
    I_MXI72_MP18 (VDD fa1_1 XI72_p3 VDD) gpdk090_pmos1v w=0.48u l=0.1u ad=0.1056p as=0.1056p pd=0.92u ps=0.92u
    I_MXI72_MP20 (XI72_p3 rc3 VDD VDD) gpdk090_pmos1v w=0.48u l=0.1u ad=0.1056p as=0.1056p pd=0.92u ps=0.92u
    I_MXI72_MP21 (XI72_sn XI72_con XI72_p3 VDD) gpdk090_pmos1v w=0.48u l=0.1u ad=0.0996p as=0.1056p pd=0.92u ps=0.92u
    I_MXI72_MP24_1 (XI72_p5 rc3 XI72_sn VDD) gpdk090_pmos1v w=0.36u l=0.1u ad=0.0792p as=0.0996p pd=0.8u ps=0.92u
    I_MXI77_I34_XG_MP2 (VDD I77_G5_2n I77_G5_0 VDD) gpdk090_pmos1v w=0.24u l=0.1u ad=0.0936p as=0.0816p pd=0.92u ps=1.16u
    I_MXI77_I34_XG_MP0 (XI77_I34_XG_p1 I77_P5_2n VDD VDD) gpdk090_pmos1v w=0.48u l=0.1u ad=0.1056p as=0.0936p pd=0.92u ps=0.92u
    I_MXI77_I34_XG_MP1 (I77_G5_0 I77_G1_0n XI77_I34_XG_p1 VDD) gpdk090_pmos1v w=0.48u l=0.1u ad=0.1632p as=0.1056p pd=1.64u ps=0.92u
    I_MXI77_I32_XG_MP2 (VDD I77_G4_1n I77_G4_0 VDD) gpdk090_pmos1v w=0.24u l=0.1u ad=0.0936p as=0.0816p pd=0.92u ps=1.16u
    I_MXI77_I32_XG_MP0 (XI77_I32_XG_p1 I77_P4_1n VDD VDD) gpdk090_pmos1v w=0.48u l=0.1u ad=0.1056p as=0.0936p pd=0.92u ps=0.92u
    I_MXI77_I32_XG_MP1 (I77_G4_0 I77_G0_0n XI77_I32_XG_p1 VDD) gpdk090_pmos1v w=0.48u l=0.1u ad=0.1632p as=0.1056p pd=1.64u ps=0.92u
    I_MXI77_I20_XG_MP2 (VDD I77_gn2 I77_G2_1 VDD) gpdk090_pmos1v w=0.24u l=0.1u ad=0.0936p as=0.0816p pd=0.92u ps=1.16u
    I_MXI77_I20_XG_MP0 (XI77_I20_XG_p1 I77_pn2 VDD VDD) gpdk090_pmos1v w=0.48u l=0.1u ad=0.1056p as=0.0936p pd=0.92u ps=0.92u
    I_MXI77_I20_XG_MP1 (I77_G2_1 I77_gn1 XI77_I20_XG_p1 VDD) gpdk090_pmos1v w=0.48u l=0.1u ad=0.1632p as=0.1056p pd=1.64u ps=0.92u
    I_MXI77_I19_XG_MP2 (VDD I77_gn1 I77_G1_0 VDD) gpdk090_pmos1v w=0.24u l=0.1u ad=0.0936p as=0.0816p pd=0.92u ps=1.16u
    I_MXI77_I19_XG_MP0 (XI77_I19_XG_p1 I77_pn1 VDD VDD) gpdk090_pmos1v w=0.48u l=0.1u ad=0.1056p as=0.0936p pd=0.92u ps=0.92u
    I_MXI77_I19_XG_MP1 (I77_G1_0 I77_G0_0n XI77_I19_XG_p1 VDD) gpdk090_pmos1v w=0.48u l=0.1u ad=0.1632p as=0.1056p pd=1.64u ps=0.92u
    I_MXI77_I17_XG_MP2 (VDD I77_gn0 I77_G0_0 VDD) gpdk090_pmos1v w=0.24u l=0.1u ad=0.0936p as=0.0816p pd=0.92u ps=1.16u
    I_MXI77_I17_XG_MP0 (XI77_I17_XG_p1 I77_pn0 VDD VDD) gpdk090_pmos1v w=0.48u l=0.1u ad=0.1056p as=0.0936p pd=0.92u ps=0.92u
    I_MXI77_I17_XG_MP1 (I77_G0_0 I77_cinn XI77_I17_XG_p1 VDD) gpdk090_pmos1v w=0.48u l=0.1u ad=0.1632p as=0.1056p pd=1.64u ps=0.92u
    I_MXI77_I35_XG_MP2 (VDD I77_G6_3n kc7 VDD) gpdk090_pmos1v w=0.24u l=0.1u ad=0.0936p as=0.0816p pd=0.92u ps=1.16u
    I_MXI77_I35_XG_MP0 (XI77_I35_XG_p1 I77_P6_3n VDD VDD) gpdk090_pmos1v w=0.48u l=0.1u ad=0.1056p as=0.0936p pd=0.92u ps=0.92u
    I_MXI77_I35_XG_MP1 (kc7 I77_G2_0n XI77_I35_XG_p1 VDD) gpdk090_pmos1v w=0.48u l=0.1u ad=0.1632p as=0.1056p pd=1.64u ps=0.92u
    I_MXI77_I21_XG_MP2 (VDD I77_gn3 I77_G3_2 VDD) gpdk090_pmos1v w=0.24u l=0.1u ad=0.0936p as=0.0816p pd=0.92u ps=1.16u
    I_MXI77_I21_XG_MP0 (XI77_I21_XG_p1 I77_pn3 VDD VDD) gpdk090_pmos1v w=0.48u l=0.1u ad=0.1056p as=0.0936p pd=0.92u ps=0.92u
    I_MXI77_I21_XG_MP1 (I77_G3_2 I77_gn2 XI77_I21_XG_p1 VDD) gpdk090_pmos1v w=0.48u l=0.1u ad=0.1632p as=0.1056p pd=1.64u ps=0.92u
    I_MXI77_I22_XG_MP2 (VDD I77_gn4 I77_G4_3 VDD) gpdk090_pmos1v w=0.24u l=0.1u ad=0.0936p as=0.0816p pd=0.92u ps=1.16u
    I_MXI77_I22_XG_MP0 (XI77_I22_XG_p1 I77_pn4 VDD VDD) gpdk090_pmos1v w=0.48u l=0.1u ad=0.1056p as=0.0936p pd=0.92u ps=0.92u
    I_MXI77_I22_XG_MP1 (I77_G4_3 I77_gn3 XI77_I22_XG_p1 VDD) gpdk090_pmos1v w=0.48u l=0.1u ad=0.1632p as=0.1056p pd=1.64u ps=0.92u
    I_MXI77_I36_XG_MP2 (VDD I77_G7_4n kc8 VDD) gpdk090_pmos1v w=0.24u l=0.1u ad=0.0936p as=0.0816p pd=0.92u ps=1.16u
    I_MXI77_I36_XG_MP0 (XI77_I36_XG_p1 I77_P7_4n VDD VDD) gpdk090_pmos1v w=0.48u l=0.1u ad=0.1056p as=0.0936p pd=0.92u ps=0.92u
    I_MXI77_I36_XG_MP1 (kc8 I77_G3_0n XI77_I36_XG_p1 VDD) gpdk090_pmos1v w=0.48u l=0.1u ad=0.1632p as=0.1056p pd=1.64u ps=0.92u
    I_MXI77_I23_XG_MP2 (VDD I77_gn5 I77_G5_4 VDD) gpdk090_pmos1v w=0.24u l=0.1u ad=0.0936p as=0.0816p pd=0.92u ps=1.16u
    I_MXI77_I23_XG_MP0 (XI77_I23_XG_p1 I77_pn5 VDD VDD) gpdk090_pmos1v w=0.48u l=0.1u ad=0.1056p as=0.0936p pd=0.92u ps=0.92u
    I_MXI77_I23_XG_MP1 (I77_G5_4 I77_gn4 XI77_I23_XG_p1 VDD) gpdk090_pmos1v w=0.48u l=0.1u ad=0.1632p as=0.1056p pd=1.64u ps=0.92u
    I_MXI77_I25_XG_MP2 (VDD I77_gn7 I77_G7_6 VDD) gpdk090_pmos1v w=0.24u l=0.1u ad=0.0936p as=0.0816p pd=0.92u ps=1.16u
    I_MXI77_I25_XG_MP0 (XI77_I25_XG_p1 I77_pn7 VDD VDD) gpdk090_pmos1v w=0.48u l=0.1u ad=0.1056p as=0.0936p pd=0.92u ps=0.92u
    I_MXI77_I25_XG_MP1 (I77_G7_6 I77_gn6 XI77_I25_XG_p1 VDD) gpdk090_pmos1v w=0.48u l=0.1u ad=0.1632p as=0.1056p pd=1.64u ps=0.92u
    I_MXI77_I24_XG_MP2 (VDD I77_gn6 I77_G6_5 VDD) gpdk090_pmos1v w=0.24u l=0.1u ad=0.0936p as=0.0816p pd=0.92u ps=1.16u
    I_MXI77_I24_XG_MP0 (XI77_I24_XG_p1 I77_pn6 VDD VDD) gpdk090_pmos1v w=0.48u l=0.1u ad=0.1056p as=0.0936p pd=0.92u ps=0.92u
    I_MXI77_I24_XG_MP1 (I77_G6_5 I77_gn5 XI77_I24_XG_p1 VDD) gpdk090_pmos1v w=0.48u l=0.1u ad=0.1632p as=0.1056p pd=1.64u ps=0.92u
    I_MXI26_MP12 (VDD B_5 XI26_xbn VDD) gpdk090_pmos1v w=0.24u l=0.1u ad=0.0816p as=0.0816p pd=1.16u ps=1.16u
    I_MXI26_MP18 (XI26_xp1 XI26_xbn VDD VDD) gpdk090_pmos1v w=0.48u l=0.1u ad=0.1056p as=0.1632p pd=0.92u ps=1.64u
    I_MXI26_MP20 (pp2_3 B_5 XI26_xp1 VDD) gpdk090_pmos1v w=0.48u l=0.1u ad=0.1056p as=0.1056p pd=0.92u ps=0.92u
    I_MXI26_MP19 (XI26_xp1 XI26_xan pp2_3 VDD) gpdk090_pmos1v w=0.48u l=0.1u ad=0.1056p as=0.1056p pd=0.92u ps=0.92u
    I_MXI26_MP17 (VDD XI26_xn XI26_xp1 VDD) gpdk090_pmos1v w=0.48u l=0.1u ad=0.1632p as=0.1056p pd=1.64u ps=0.92u
    I_MXI26_MP6 (XI26_p1 A_3 VDD VDD) gpdk090_pmos1v w=0.48u l=0.1u ad=0.1056p as=0.1632p pd=0.92u ps=1.64u
    I_MXI26_MP8 (XI26_xn A_2 XI26_p1 VDD) gpdk090_pmos1v w=0.48u l=0.1u ad=0.1056p as=0.1056p pd=0.92u ps=0.92u
    I_MXI26_MP7 (XI26_p1 two2 XI26_xn VDD) gpdk090_pmos1v w=0.48u l=0.1u ad=0.1056p as=0.1056p pd=0.92u ps=0.92u
    I_MXI26_MP5 (VDD one2 XI26_p1 VDD) gpdk090_pmos1v w=0.48u l=0.1u ad=0.1632p as=0.1056p pd=1.64u ps=0.92u
    I_MXI26_MP10 (XI26_xan XI26_xn VDD VDD) gpdk090_pmos1v w=0.24u l=0.1u ad=0.0816p as=0.0816p pd=1.16u ps=1.16u
    I_MXI15_MP12 (VDD B_3 XI15_xbn VDD) gpdk090_pmos1v w=0.24u l=0.1u ad=0.0816p as=0.0816p pd=1.16u ps=1.16u
    I_MXI15_MP18 (XI15_xp1 XI15_xbn VDD VDD) gpdk090_pmos1v w=0.48u l=0.1u ad=0.1056p as=0.1632p pd=0.92u ps=1.64u
    I_MXI15_MP20 (pp1_3 B_3 XI15_xp1 VDD) gpdk090_pmos1v w=0.48u l=0.1u ad=0.1056p as=0.1056p pd=0.92u ps=0.92u
    I_MXI15_MP19 (XI15_xp1 XI15_xan pp1_3 VDD) gpdk090_pmos1v w=0.48u l=0.1u ad=0.1056p as=0.1056p pd=0.92u ps=0.92u
    I_MXI15_MP17 (VDD XI15_xn XI15_xp1 VDD) gpdk090_pmos1v w=0.48u l=0.1u ad=0.1632p as=0.1056p pd=1.64u ps=0.92u
    I_MXI15_MP6 (XI15_p1 A_3 VDD VDD) gpdk090_pmos1v w=0.48u l=0.1u ad=0.1056p as=0.1632p pd=0.92u ps=1.64u
    I_MXI15_MP8 (XI15_xn A_2 XI15_p1 VDD) gpdk090_pmos1v w=0.48u l=0.1u ad=0.1056p as=0.1056p pd=0.92u ps=0.92u
    I_MXI15_MP7 (XI15_p1 two1 XI15_xn VDD) gpdk090_pmos1v w=0.48u l=0.1u ad=0.1056p as=0.1056p pd=0.92u ps=0.92u
    I_MXI15_MP5 (VDD one1 XI15_p1 VDD) gpdk090_pmos1v w=0.48u l=0.1u ad=0.1632p as=0.1056p pd=1.64u ps=0.92u
    I_MXI15_MP10 (XI15_xan XI15_xn VDD VDD) gpdk090_pmos1v w=0.24u l=0.1u ad=0.0816p as=0.0816p pd=1.16u ps=1.16u
    I_MXI23_MP12 (VDD B_5 XI23_xbn VDD) gpdk090_pmos1v w=0.24u l=0.1u ad=0.0816p as=0.0816p pd=1.16u ps=1.16u
    I_MXI23_MP18 (XI23_xp1 XI23_xbn VDD VDD) gpdk090_pmos1v w=0.48u l=0.1u ad=0.1056p as=0.1632p pd=0.92u ps=1.64u
    I_MXI23_MP20 (pp2_0 B_5 XI23_xp1 VDD) gpdk090_pmos1v w=0.48u l=0.1u ad=0.1056p as=0.1056p pd=0.92u ps=0.92u
    I_MXI23_MP19 (XI23_xp1 XI23_xan pp2_0 VDD) gpdk090_pmos1v w=0.48u l=0.1u ad=0.1056p as=0.1056p pd=0.92u ps=0.92u
    I_MXI23_MP17 (VDD XI23_xn XI23_xp1 VDD) gpdk090_pmos1v w=0.48u l=0.1u ad=0.1632p as=0.1056p pd=1.64u ps=0.92u
    I_MXI23_MP6 (XI23_p1 A_0 VDD VDD) gpdk090_pmos1v w=0.48u l=0.1u ad=0.1056p as=0.1632p pd=0.92u ps=1.64u
    I_MXI23_MP8 (XI23_xn VSS XI23_p1 VDD) gpdk090_pmos1v w=0.48u l=0.1u ad=0.1056p as=0.1056p pd=0.92u ps=0.92u
    I_MXI23_MP7 (XI23_p1 two2 XI23_xn VDD) gpdk090_pmos1v w=0.48u l=0.1u ad=0.1056p as=0.1056p pd=0.92u ps=0.92u
    I_MXI23_MP5 (VDD one2 XI23_p1 VDD) gpdk090_pmos1v w=0.48u l=0.1u ad=0.1632p as=0.1056p pd=1.64u ps=0.92u
    I_MXI23_MP10 (XI23_xan XI23_xn VDD VDD) gpdk090_pmos1v w=0.24u l=0.1u ad=0.0816p as=0.0816p pd=1.16u ps=1.16u
    I_MXI14_MP12 (VDD B_3 XI14_xbn VDD) gpdk090_pmos1v w=0.24u l=0.1u ad=0.0816p as=0.0816p pd=1.16u ps=1.16u
    I_MXI14_MP18 (XI14_xp1 XI14_xbn VDD VDD) gpdk090_pmos1v w=0.48u l=0.1u ad=0.1056p as=0.1632p pd=0.92u ps=1.64u
    I_MXI14_MP20 (pp1_2 B_3 XI14_xp1 VDD) gpdk090_pmos1v w=0.48u l=0.1u ad=0.1056p as=0.1056p pd=0.92u ps=0.92u
    I_MXI14_MP19 (XI14_xp1 XI14_xan pp1_2 VDD) gpdk090_pmos1v w=0.48u l=0.1u ad=0.1056p as=0.1056p pd=0.92u ps=0.92u
    I_MXI14_MP17 (VDD XI14_xn XI14_xp1 VDD) gpdk090_pmos1v w=0.48u l=0.1u ad=0.1632p as=0.1056p pd=1.64u ps=0.92u
    I_MXI14_MP6 (XI14_p1 A_2 VDD VDD) gpdk090_pmos1v w=0.48u l=0.1u ad=0.1056p as=0.1632p pd=0.92u ps=1.64u
    I_MXI14_MP8 (XI14_xn A_1 XI14_p1 VDD) gpdk090_pmos1v w=0.48u l=0.1u ad=0.1056p as=0.1056p pd=0.92u ps=0.92u
    I_MXI14_MP7 (XI14_p1 two1 XI14_xn VDD) gpdk090_pmos1v w=0.48u l=0.1u ad=0.1056p as=0.1056p pd=0.92u ps=0.92u
    I_MXI14_MP5 (VDD one1 XI14_p1 VDD) gpdk090_pmos1v w=0.48u l=0.1u ad=0.1632p as=0.1056p pd=1.64u ps=0.92u
    I_MXI14_MP10 (XI14_xan XI14_xn VDD VDD) gpdk090_pmos1v w=0.24u l=0.1u ad=0.0816p as=0.0816p pd=1.16u ps=1.16u
    I_MXI28_MP12 (VDD B_5 XI28_xbn VDD) gpdk090_pmos1v w=0.24u l=0.1u ad=0.0816p as=0.0816p pd=1.16u ps=1.16u
    I_MXI28_MP18 (XI28_xp1 XI28_xbn VDD VDD) gpdk090_pmos1v w=0.48u l=0.1u ad=0.1056p as=0.1632p pd=0.92u ps=1.64u
    I_MXI28_MP20 (pp2_5 B_5 XI28_xp1 VDD) gpdk090_pmos1v w=0.48u l=0.1u ad=0.1056p as=0.1056p pd=0.92u ps=0.92u
    I_MXI28_MP19 (XI28_xp1 XI28_xan pp2_5 VDD) gpdk090_pmos1v w=0.48u l=0.1u ad=0.1056p as=0.1056p pd=0.92u ps=0.92u
    I_MXI28_MP17 (VDD XI28_xn XI28_xp1 VDD) gpdk090_pmos1v w=0.48u l=0.1u ad=0.1632p as=0.1056p pd=1.64u ps=0.92u
    I_MXI28_MP6 (XI28_p1 A_5 VDD VDD) gpdk090_pmos1v w=0.48u l=0.1u ad=0.1056p as=0.1632p pd=0.92u ps=1.64u
    I_MXI28_MP8 (XI28_xn A_4 XI28_p1 VDD) gpdk090_pmos1v w=0.48u l=0.1u ad=0.1056p as=0.1056p pd=0.92u ps=0.92u
    I_MXI28_MP7 (XI28_p1 two2 XI28_xn VDD) gpdk090_pmos1v w=0.48u l=0.1u ad=0.1056p as=0.1056p pd=0.92u ps=0.92u
    I_MXI28_MP5 (VDD one2 XI28_p1 VDD) gpdk090_pmos1v w=0.48u l=0.1u ad=0.1632p as=0.1056p pd=1.64u ps=0.92u
    I_MXI28_MP10 (XI28_xan XI28_xn VDD VDD) gpdk090_pmos1v w=0.24u l=0.1u ad=0.0816p as=0.0816p pd=1.16u ps=1.16u
    I_MXI27_MP12 (VDD B_5 XI27_xbn VDD) gpdk090_pmos1v w=0.24u l=0.1u ad=0.0816p as=0.0816p pd=1.16u ps=1.16u
    I_MXI27_MP18 (XI27_xp1 XI27_xbn VDD VDD) gpdk090_pmos1v w=0.48u l=0.1u ad=0.1056p as=0.1632p pd=0.92u ps=1.64u
    I_MXI27_MP20 (pp2_4 B_5 XI27_xp1 VDD) gpdk090_pmos1v w=0.48u l=0.1u ad=0.1056p as=0.1056p pd=0.92u ps=0.92u
    I_MXI27_MP19 (XI27_xp1 XI27_xan pp2_4 VDD) gpdk090_pmos1v w=0.48u l=0.1u ad=0.1056p as=0.1056p pd=0.92u ps=0.92u
    I_MXI27_MP17 (VDD XI27_xn XI27_xp1 VDD) gpdk090_pmos1v w=0.48u l=0.1u ad=0.1632p as=0.1056p pd=1.64u ps=0.92u
    I_MXI27_MP6 (XI27_p1 A_4 VDD VDD) gpdk090_pmos1v w=0.48u l=0.1u ad=0.1056p as=0.1632p pd=0.92u ps=1.64u
    I_MXI27_MP8 (XI27_xn A_3 XI27_p1 VDD) gpdk090_pmos1v w=0.48u l=0.1u ad=0.1056p as=0.1056p pd=0.92u ps=0.92u
    I_MXI27_MP7 (XI27_p1 two2 XI27_xn VDD) gpdk090_pmos1v w=0.48u l=0.1u ad=0.1056p as=0.1056p pd=0.92u ps=0.92u
    I_MXI27_MP5 (VDD one2 XI27_p1 VDD) gpdk090_pmos1v w=0.48u l=0.1u ad=0.1632p as=0.1056p pd=1.64u ps=0.92u
    I_MXI27_MP10 (XI27_xan XI27_xn VDD VDD) gpdk090_pmos1v w=0.24u l=0.1u ad=0.0816p as=0.0816p pd=1.16u ps=1.16u
    I_MXI19_MP12 (VDD B_3 XI19_xbn VDD) gpdk090_pmos1v w=0.24u l=0.1u ad=0.0816p as=0.0816p pd=1.16u ps=1.16u
    I_MXI19_MP18 (XI19_xp1 XI19_xbn VDD VDD) gpdk090_pmos1v w=0.48u l=0.1u ad=0.1056p as=0.1632p pd=0.92u ps=1.64u
    I_MXI19_MP20 (pp1_7 B_3 XI19_xp1 VDD) gpdk090_pmos1v w=0.48u l=0.1u ad=0.1056p as=0.1056p pd=0.92u ps=0.92u
    I_MXI19_MP19 (XI19_xp1 XI19_xan pp1_7 VDD) gpdk090_pmos1v w=0.48u l=0.1u ad=0.1056p as=0.1056p pd=0.92u ps=0.92u
    I_MXI19_MP17 (VDD XI19_xn XI19_xp1 VDD) gpdk090_pmos1v w=0.48u l=0.1u ad=0.1632p as=0.1056p pd=1.64u ps=0.92u
    I_MXI19_MP6 (XI19_p1 A_7 VDD VDD) gpdk090_pmos1v w=0.48u l=0.1u ad=0.1056p as=0.1632p pd=0.92u ps=1.64u
    I_MXI19_MP8 (XI19_xn A_6 XI19_p1 VDD) gpdk090_pmos1v w=0.48u l=0.1u ad=0.1056p as=0.1056p pd=0.92u ps=0.92u
    I_MXI19_MP7 (XI19_p1 two1 XI19_xn VDD) gpdk090_pmos1v w=0.48u l=0.1u ad=0.1056p as=0.1056p pd=0.92u ps=0.92u
    I_MXI19_MP5 (VDD one1 XI19_p1 VDD) gpdk090_pmos1v w=0.48u l=0.1u ad=0.1632p as=0.1056p pd=1.64u ps=0.92u
    I_MXI19_MP10 (XI19_xan XI19_xn VDD VDD) gpdk090_pmos1v w=0.24u l=0.1u ad=0.0816p as=0.0816p pd=1.16u ps=1.16u
    I_MXI18_MP12 (VDD B_3 XI18_xbn VDD) gpdk090_pmos1v w=0.24u l=0.1u ad=0.0816p as=0.0816p pd=1.16u ps=1.16u
    I_MXI18_MP18 (XI18_xp1 XI18_xbn VDD VDD) gpdk090_pmos1v w=0.48u l=0.1u ad=0.1056p as=0.1632p pd=0.92u ps=1.64u
    I_MXI18_MP20 (pp1_6 B_3 XI18_xp1 VDD) gpdk090_pmos1v w=0.48u l=0.1u ad=0.1056p as=0.1056p pd=0.92u ps=0.92u
    I_MXI18_MP19 (XI18_xp1 XI18_xan pp1_6 VDD) gpdk090_pmos1v w=0.48u l=0.1u ad=0.1056p as=0.1056p pd=0.92u ps=0.92u
    I_MXI18_MP17 (VDD XI18_xn XI18_xp1 VDD) gpdk090_pmos1v w=0.48u l=0.1u ad=0.1632p as=0.1056p pd=1.64u ps=0.92u
    I_MXI18_MP6 (XI18_p1 A_6 VDD VDD) gpdk090_pmos1v w=0.48u l=0.1u ad=0.1056p as=0.1632p pd=0.92u ps=1.64u
    I_MXI18_MP8 (XI18_xn A_5 XI18_p1 VDD) gpdk090_pmos1v w=0.48u l=0.1u ad=0.1056p as=0.1056p pd=0.92u ps=0.92u
    I_MXI18_MP7 (XI18_p1 two1 XI18_xn VDD) gpdk090_pmos1v w=0.48u l=0.1u ad=0.1056p as=0.1056p pd=0.92u ps=0.92u
    I_MXI18_MP5 (VDD one1 XI18_p1 VDD) gpdk090_pmos1v w=0.48u l=0.1u ad=0.1632p as=0.1056p pd=1.64u ps=0.92u
    I_MXI18_MP10 (XI18_xan XI18_xn VDD VDD) gpdk090_pmos1v w=0.24u l=0.1u ad=0.0816p as=0.0816p pd=1.16u ps=1.16u
    I_MXI17_MP12 (VDD B_3 XI17_xbn VDD) gpdk090_pmos1v w=0.24u l=0.1u ad=0.0816p as=0.0816p pd=1.16u ps=1.16u
    I_MXI17_MP18 (XI17_xp1 XI17_xbn VDD VDD) gpdk090_pmos1v w=0.48u l=0.1u ad=0.1056p as=0.1632p pd=0.92u ps=1.64u
    I_MXI17_MP20 (pp1_5 B_3 XI17_xp1 VDD) gpdk090_pmos1v w=0.48u l=0.1u ad=0.1056p as=0.1056p pd=0.92u ps=0.92u
    I_MXI17_MP19 (XI17_xp1 XI17_xan pp1_5 VDD) gpdk090_pmos1v w=0.48u l=0.1u ad=0.1056p as=0.1056p pd=0.92u ps=0.92u
    I_MXI17_MP17 (VDD XI17_xn XI17_xp1 VDD) gpdk090_pmos1v w=0.48u l=0.1u ad=0.1632p as=0.1056p pd=1.64u ps=0.92u
    I_MXI17_MP6 (XI17_p1 A_5 VDD VDD) gpdk090_pmos1v w=0.48u l=0.1u ad=0.1056p as=0.1632p pd=0.92u ps=1.64u
    I_MXI17_MP8 (XI17_xn A_4 XI17_p1 VDD) gpdk090_pmos1v w=0.48u l=0.1u ad=0.1056p as=0.1056p pd=0.92u ps=0.92u
    I_MXI17_MP7 (XI17_p1 two1 XI17_xn VDD) gpdk090_pmos1v w=0.48u l=0.1u ad=0.1056p as=0.1056p pd=0.92u ps=0.92u
    I_MXI17_MP5 (VDD one1 XI17_p1 VDD) gpdk090_pmos1v w=0.48u l=0.1u ad=0.1632p as=0.1056p pd=1.64u ps=0.92u
    I_MXI17_MP10 (XI17_xan XI17_xn VDD VDD) gpdk090_pmos1v w=0.24u l=0.1u ad=0.0816p as=0.0816p pd=1.16u ps=1.16u
    I_MXI24_MP12 (VDD B_5 XI24_xbn VDD) gpdk090_pmos1v w=0.24u l=0.1u ad=0.0816p as=0.0816p pd=1.16u ps=1.16u
    I_MXI24_MP18 (XI24_xp1 XI24_xbn VDD VDD) gpdk090_pmos1v w=0.48u l=0.1u ad=0.1056p as=0.1632p pd=0.92u ps=1.64u
    I_MXI24_MP20 (pp2_1 B_5 XI24_xp1 VDD) gpdk090_pmos1v w=0.48u l=0.1u ad=0.1056p as=0.1056p pd=0.92u ps=0.92u
    I_MXI24_MP19 (XI24_xp1 XI24_xan pp2_1 VDD) gpdk090_pmos1v w=0.48u l=0.1u ad=0.1056p as=0.1056p pd=0.92u ps=0.92u
    I_MXI24_MP17 (VDD XI24_xn XI24_xp1 VDD) gpdk090_pmos1v w=0.48u l=0.1u ad=0.1632p as=0.1056p pd=1.64u ps=0.92u
    I_MXI24_MP6 (XI24_p1 A_1 VDD VDD) gpdk090_pmos1v w=0.48u l=0.1u ad=0.1056p as=0.1632p pd=0.92u ps=1.64u
    I_MXI24_MP8 (XI24_xn A_0 XI24_p1 VDD) gpdk090_pmos1v w=0.48u l=0.1u ad=0.1056p as=0.1056p pd=0.92u ps=0.92u
    I_MXI24_MP7 (XI24_p1 two2 XI24_xn VDD) gpdk090_pmos1v w=0.48u l=0.1u ad=0.1056p as=0.1056p pd=0.92u ps=0.92u
    I_MXI24_MP5 (VDD one2 XI24_p1 VDD) gpdk090_pmos1v w=0.48u l=0.1u ad=0.1632p as=0.1056p pd=1.64u ps=0.92u
    I_MXI24_MP10 (XI24_xan XI24_xn VDD VDD) gpdk090_pmos1v w=0.24u l=0.1u ad=0.0816p as=0.0816p pd=1.16u ps=1.16u
    I_MXI30_MP12 (VDD B_5 XI30_xbn VDD) gpdk090_pmos1v w=0.24u l=0.1u ad=0.0816p as=0.0816p pd=1.16u ps=1.16u
    I_MXI30_MP18 (XI30_xp1 XI30_xbn VDD VDD) gpdk090_pmos1v w=0.48u l=0.1u ad=0.1056p as=0.1632p pd=0.92u ps=1.64u
    I_MXI30_MP20 (pp2_7 B_5 XI30_xp1 VDD) gpdk090_pmos1v w=0.48u l=0.1u ad=0.1056p as=0.1056p pd=0.92u ps=0.92u
    I_MXI30_MP19 (XI30_xp1 XI30_xan pp2_7 VDD) gpdk090_pmos1v w=0.48u l=0.1u ad=0.1056p as=0.1056p pd=0.92u ps=0.92u
    I_MXI30_MP17 (VDD XI30_xn XI30_xp1 VDD) gpdk090_pmos1v w=0.48u l=0.1u ad=0.1632p as=0.1056p pd=1.64u ps=0.92u
    I_MXI30_MP6 (XI30_p1 A_7 VDD VDD) gpdk090_pmos1v w=0.48u l=0.1u ad=0.1056p as=0.1632p pd=0.92u ps=1.64u
    I_MXI30_MP8 (XI30_xn A_6 XI30_p1 VDD) gpdk090_pmos1v w=0.48u l=0.1u ad=0.1056p as=0.1056p pd=0.92u ps=0.92u
    I_MXI30_MP7 (XI30_p1 two2 XI30_xn VDD) gpdk090_pmos1v w=0.48u l=0.1u ad=0.1056p as=0.1056p pd=0.92u ps=0.92u
    I_MXI30_MP5 (VDD one2 XI30_p1 VDD) gpdk090_pmos1v w=0.48u l=0.1u ad=0.1632p as=0.1056p pd=1.64u ps=0.92u
    I_MXI30_MP10 (XI30_xan XI30_xn VDD VDD) gpdk090_pmos1v w=0.24u l=0.1u ad=0.0816p as=0.0816p pd=1.16u ps=1.16u
    I_MXI29_MP12 (VDD B_5 XI29_xbn VDD) gpdk090_pmos1v w=0.24u l=0.1u ad=0.0816p as=0.0816p pd=1.16u ps=1.16u
    I_MXI29_MP18 (XI29_xp1 XI29_xbn VDD VDD) gpdk090_pmos1v w=0.48u l=0.1u ad=0.1056p as=0.1632p pd=0.92u ps=1.64u
    I_MXI29_MP20 (pp2_6 B_5 XI29_xp1 VDD) gpdk090_pmos1v w=0.48u l=0.1u ad=0.1056p as=0.1056p pd=0.92u ps=0.92u
    I_MXI29_MP19 (XI29_xp1 XI29_xan pp2_6 VDD) gpdk090_pmos1v w=0.48u l=0.1u ad=0.1056p as=0.1056p pd=0.92u ps=0.92u
    I_MXI29_MP17 (VDD XI29_xn XI29_xp1 VDD) gpdk090_pmos1v w=0.48u l=0.1u ad=0.1632p as=0.1056p pd=1.64u ps=0.92u
    I_MXI29_MP6 (XI29_p1 A_6 VDD VDD) gpdk090_pmos1v w=0.48u l=0.1u ad=0.1056p as=0.1632p pd=0.92u ps=1.64u
    I_MXI29_MP8 (XI29_xn A_5 XI29_p1 VDD) gpdk090_pmos1v w=0.48u l=0.1u ad=0.1056p as=0.1056p pd=0.92u ps=0.92u
    I_MXI29_MP7 (XI29_p1 two2 XI29_xn VDD) gpdk090_pmos1v w=0.48u l=0.1u ad=0.1056p as=0.1056p pd=0.92u ps=0.92u
    I_MXI29_MP5 (VDD one2 XI29_p1 VDD) gpdk090_pmos1v w=0.48u l=0.1u ad=0.1632p as=0.1056p pd=1.64u ps=0.92u
    I_MXI29_MP10 (XI29_xan XI29_xn VDD VDD) gpdk090_pmos1v w=0.24u l=0.1u ad=0.0816p as=0.0816p pd=1.16u ps=1.16u
    I_MXI20_MP12 (VDD B_3 XI20_xbn VDD) gpdk090_pmos1v w=0.24u l=0.1u ad=0.0816p as=0.0816p pd=1.16u ps=1.16u
    I_MXI20_MP18 (XI20_xp1 XI20_xbn VDD VDD) gpdk090_pmos1v w=0.48u l=0.1u ad=0.1056p as=0.1632p pd=0.92u ps=1.64u
    I_MXI20_MP20 (pp1_8 B_3 XI20_xp1 VDD) gpdk090_pmos1v w=0.48u l=0.1u ad=0.1056p as=0.1056p pd=0.92u ps=0.92u
    I_MXI20_MP19 (XI20_xp1 XI20_xan pp1_8 VDD) gpdk090_pmos1v w=0.48u l=0.1u ad=0.1056p as=0.1056p pd=0.92u ps=0.92u
    I_MXI20_MP17 (VDD XI20_xn XI20_xp1 VDD) gpdk090_pmos1v w=0.48u l=0.1u ad=0.1632p as=0.1056p pd=1.64u ps=0.92u
    I_MXI20_MP6 (XI20_p1 A_7 VDD VDD) gpdk090_pmos1v w=0.48u l=0.1u ad=0.1056p as=0.1632p pd=0.92u ps=1.64u
    I_MXI20_MP8 (XI20_xn A_7 XI20_p1 VDD) gpdk090_pmos1v w=0.48u l=0.1u ad=0.1056p as=0.1056p pd=0.92u ps=0.92u
    I_MXI20_MP7 (XI20_p1 two1 XI20_xn VDD) gpdk090_pmos1v w=0.48u l=0.1u ad=0.1056p as=0.1056p pd=0.92u ps=0.92u
    I_MXI20_MP5 (VDD one1 XI20_p1 VDD) gpdk090_pmos1v w=0.48u l=0.1u ad=0.1632p as=0.1056p pd=1.64u ps=0.92u
    I_MXI20_MP10 (XI20_xan XI20_xn VDD VDD) gpdk090_pmos1v w=0.24u l=0.1u ad=0.0816p as=0.0816p pd=1.16u ps=1.16u
    I_MXI8_MP12 (VDD B_1 XI8_xbn VDD) gpdk090_pmos1v w=0.24u l=0.1u ad=0.0816p as=0.0816p pd=1.16u ps=1.16u
    I_MXI8_MP18 (XI8_xp1 XI8_xbn VDD VDD) gpdk090_pmos1v w=0.48u l=0.1u ad=0.1056p as=0.1632p pd=0.92u ps=1.64u
    I_MXI8_MP20 (pp0_7 B_1 XI8_xp1 VDD) gpdk090_pmos1v w=0.48u l=0.1u ad=0.1056p as=0.1056p pd=0.92u ps=0.92u
    I_MXI8_MP19 (XI8_xp1 XI8_xan pp0_7 VDD) gpdk090_pmos1v w=0.48u l=0.1u ad=0.1056p as=0.1056p pd=0.92u ps=0.92u
    I_MXI8_MP17 (VDD XI8_xn XI8_xp1 VDD) gpdk090_pmos1v w=0.48u l=0.1u ad=0.1632p as=0.1056p pd=1.64u ps=0.92u
    I_MXI8_MP6 (XI8_p1 A_7 VDD VDD) gpdk090_pmos1v w=0.48u l=0.1u ad=0.1056p as=0.1632p pd=0.92u ps=1.64u
    I_MXI8_MP8 (XI8_xn A_6 XI8_p1 VDD) gpdk090_pmos1v w=0.48u l=0.1u ad=0.1056p as=0.1056p pd=0.92u ps=0.92u
    I_MXI8_MP7 (XI8_p1 two0 XI8_xn VDD) gpdk090_pmos1v w=0.48u l=0.1u ad=0.1056p as=0.1056p pd=0.92u ps=0.92u
    I_MXI8_MP5 (VDD one0 XI8_p1 VDD) gpdk090_pmos1v w=0.48u l=0.1u ad=0.1632p as=0.1056p pd=1.64u ps=0.92u
    I_MXI8_MP10 (XI8_xan XI8_xn VDD VDD) gpdk090_pmos1v w=0.24u l=0.1u ad=0.0816p as=0.0816p pd=1.16u ps=1.16u
    I_MXI5_MP12 (VDD B_1 XI5_xbn VDD) gpdk090_pmos1v w=0.24u l=0.1u ad=0.0816p as=0.0816p pd=1.16u ps=1.16u
    I_MXI5_MP18 (XI5_xp1 XI5_xbn VDD VDD) gpdk090_pmos1v w=0.48u l=0.1u ad=0.1056p as=0.1632p pd=0.92u ps=1.64u
    I_MXI5_MP20 (pp0_4 B_1 XI5_xp1 VDD) gpdk090_pmos1v w=0.48u l=0.1u ad=0.1056p as=0.1056p pd=0.92u ps=0.92u
    I_MXI5_MP19 (XI5_xp1 XI5_xan pp0_4 VDD) gpdk090_pmos1v w=0.48u l=0.1u ad=0.1056p as=0.1056p pd=0.92u ps=0.92u
    I_MXI5_MP17 (VDD XI5_xn XI5_xp1 VDD) gpdk090_pmos1v w=0.48u l=0.1u ad=0.1632p as=0.1056p pd=1.64u ps=0.92u
    I_MXI5_MP6 (XI5_p1 A_4 VDD VDD) gpdk090_pmos1v w=0.48u l=0.1u ad=0.1056p as=0.1632p pd=0.92u ps=1.64u
    I_MXI5_MP8 (XI5_xn A_3 XI5_p1 VDD) gpdk090_pmos1v w=0.48u l=0.1u ad=0.1056p as=0.1056p pd=0.92u ps=0.92u
    I_MXI5_MP7 (XI5_p1 two0 XI5_xn VDD) gpdk090_pmos1v w=0.48u l=0.1u ad=0.1056p as=0.1056p pd=0.92u ps=0.92u
    I_MXI5_MP5 (VDD one0 XI5_p1 VDD) gpdk090_pmos1v w=0.48u l=0.1u ad=0.1632p as=0.1056p pd=1.64u ps=0.92u
    I_MXI5_MP10 (XI5_xan XI5_xn VDD VDD) gpdk090_pmos1v w=0.24u l=0.1u ad=0.0816p as=0.0816p pd=1.16u ps=1.16u
    I_MXI13_MP12 (VDD B_3 XI13_xbn VDD) gpdk090_pmos1v w=0.24u l=0.1u ad=0.0816p as=0.0816p pd=1.16u ps=1.16u
    I_MXI13_MP18 (XI13_xp1 XI13_xbn VDD VDD) gpdk090_pmos1v w=0.48u l=0.1u ad=0.1056p as=0.1632p pd=0.92u ps=1.64u
    I_MXI13_MP20 (pp1_1 B_3 XI13_xp1 VDD) gpdk090_pmos1v w=0.48u l=0.1u ad=0.1056p as=0.1056p pd=0.92u ps=0.92u
    I_MXI13_MP19 (XI13_xp1 XI13_xan pp1_1 VDD) gpdk090_pmos1v w=0.48u l=0.1u ad=0.1056p as=0.1056p pd=0.92u ps=0.92u
    I_MXI13_MP17 (VDD XI13_xn XI13_xp1 VDD) gpdk090_pmos1v w=0.48u l=0.1u ad=0.1632p as=0.1056p pd=1.64u ps=0.92u
    I_MXI13_MP6 (XI13_p1 A_1 VDD VDD) gpdk090_pmos1v w=0.48u l=0.1u ad=0.1056p as=0.1632p pd=0.92u ps=1.64u
    I_MXI13_MP8 (XI13_xn A_0 XI13_p1 VDD) gpdk090_pmos1v w=0.48u l=0.1u ad=0.1056p as=0.1056p pd=0.92u ps=0.92u
    I_MXI13_MP7 (XI13_p1 two1 XI13_xn VDD) gpdk090_pmos1v w=0.48u l=0.1u ad=0.1056p as=0.1056p pd=0.92u ps=0.92u
    I_MXI13_MP5 (VDD one1 XI13_p1 VDD) gpdk090_pmos1v w=0.48u l=0.1u ad=0.1632p as=0.1056p pd=1.64u ps=0.92u
    I_MXI13_MP10 (XI13_xan XI13_xn VDD VDD) gpdk090_pmos1v w=0.24u l=0.1u ad=0.0816p as=0.0816p pd=1.16u ps=1.16u
    I_MXI38_MP12 (VDD B_7 XI38_xbn VDD) gpdk090_pmos1v w=0.24u l=0.1u ad=0.0816p as=0.0816p pd=1.16u ps=1.16u
    I_MXI38_MP18 (XI38_xp1 XI38_xbn VDD VDD) gpdk090_pmos1v w=0.48u l=0.1u ad=0.1056p as=0.1632p pd=0.92u ps=1.64u
    I_MXI38_MP20 (pp3_4 B_7 XI38_xp1 VDD) gpdk090_pmos1v w=0.48u l=0.1u ad=0.1056p as=0.1056p pd=0.92u ps=0.92u
    I_MXI38_MP19 (XI38_xp1 XI38_xan pp3_4 VDD) gpdk090_pmos1v w=0.48u l=0.1u ad=0.1056p as=0.1056p pd=0.92u ps=0.92u
    I_MXI38_MP17 (VDD XI38_xn XI38_xp1 VDD) gpdk090_pmos1v w=0.48u l=0.1u ad=0.1632p as=0.1056p pd=1.64u ps=0.92u
    I_MXI38_MP6 (XI38_p1 A_4 VDD VDD) gpdk090_pmos1v w=0.48u l=0.1u ad=0.1056p as=0.1632p pd=0.92u ps=1.64u
    I_MXI38_MP8 (XI38_xn A_3 XI38_p1 VDD) gpdk090_pmos1v w=0.48u l=0.1u ad=0.1056p as=0.1056p pd=0.92u ps=0.92u
    I_MXI38_MP7 (XI38_p1 two3 XI38_xn VDD) gpdk090_pmos1v w=0.48u l=0.1u ad=0.1056p as=0.1056p pd=0.92u ps=0.92u
    I_MXI38_MP5 (VDD one3 XI38_p1 VDD) gpdk090_pmos1v w=0.48u l=0.1u ad=0.1632p as=0.1056p pd=1.64u ps=0.92u
    I_MXI38_MP10 (XI38_xan XI38_xn VDD VDD) gpdk090_pmos1v w=0.24u l=0.1u ad=0.0816p as=0.0816p pd=1.16u ps=1.16u
    I_MXI37_MP12 (VDD B_7 XI37_xbn VDD) gpdk090_pmos1v w=0.24u l=0.1u ad=0.0816p as=0.0816p pd=1.16u ps=1.16u
    I_MXI37_MP18 (XI37_xp1 XI37_xbn VDD VDD) gpdk090_pmos1v w=0.48u l=0.1u ad=0.1056p as=0.1632p pd=0.92u ps=1.64u
    I_MXI37_MP20 (pp3_3 B_7 XI37_xp1 VDD) gpdk090_pmos1v w=0.48u l=0.1u ad=0.1056p as=0.1056p pd=0.92u ps=0.92u
    I_MXI37_MP19 (XI37_xp1 XI37_xan pp3_3 VDD) gpdk090_pmos1v w=0.48u l=0.1u ad=0.1056p as=0.1056p pd=0.92u ps=0.92u
    I_MXI37_MP17 (VDD XI37_xn XI37_xp1 VDD) gpdk090_pmos1v w=0.48u l=0.1u ad=0.1632p as=0.1056p pd=1.64u ps=0.92u
    I_MXI37_MP6 (XI37_p1 A_3 VDD VDD) gpdk090_pmos1v w=0.48u l=0.1u ad=0.1056p as=0.1632p pd=0.92u ps=1.64u
    I_MXI37_MP8 (XI37_xn A_2 XI37_p1 VDD) gpdk090_pmos1v w=0.48u l=0.1u ad=0.1056p as=0.1056p pd=0.92u ps=0.92u
    I_MXI37_MP7 (XI37_p1 two3 XI37_xn VDD) gpdk090_pmos1v w=0.48u l=0.1u ad=0.1056p as=0.1056p pd=0.92u ps=0.92u
    I_MXI37_MP5 (VDD one3 XI37_p1 VDD) gpdk090_pmos1v w=0.48u l=0.1u ad=0.1632p as=0.1056p pd=1.64u ps=0.92u
    I_MXI37_MP10 (XI37_xan XI37_xn VDD VDD) gpdk090_pmos1v w=0.24u l=0.1u ad=0.0816p as=0.0816p pd=1.16u ps=1.16u
    I_MXI25_MP12 (VDD B_5 XI25_xbn VDD) gpdk090_pmos1v w=0.24u l=0.1u ad=0.0816p as=0.0816p pd=1.16u ps=1.16u
    I_MXI25_MP18 (XI25_xp1 XI25_xbn VDD VDD) gpdk090_pmos1v w=0.48u l=0.1u ad=0.1056p as=0.1632p pd=0.92u ps=1.64u
    I_MXI25_MP20 (pp2_2 B_5 XI25_xp1 VDD) gpdk090_pmos1v w=0.48u l=0.1u ad=0.1056p as=0.1056p pd=0.92u ps=0.92u
    I_MXI25_MP19 (XI25_xp1 XI25_xan pp2_2 VDD) gpdk090_pmos1v w=0.48u l=0.1u ad=0.1056p as=0.1056p pd=0.92u ps=0.92u
    I_MXI25_MP17 (VDD XI25_xn XI25_xp1 VDD) gpdk090_pmos1v w=0.48u l=0.1u ad=0.1632p as=0.1056p pd=1.64u ps=0.92u
    I_MXI25_MP6 (XI25_p1 A_2 VDD VDD) gpdk090_pmos1v w=0.48u l=0.1u ad=0.1056p as=0.1632p pd=0.92u ps=1.64u
    I_MXI25_MP8 (XI25_xn A_1 XI25_p1 VDD) gpdk090_pmos1v w=0.48u l=0.1u ad=0.1056p as=0.1056p pd=0.92u ps=0.92u
    I_MXI25_MP7 (XI25_p1 two2 XI25_xn VDD) gpdk090_pmos1v w=0.48u l=0.1u ad=0.1056p as=0.1056p pd=0.92u ps=0.92u
    I_MXI25_MP5 (VDD one2 XI25_p1 VDD) gpdk090_pmos1v w=0.48u l=0.1u ad=0.1632p as=0.1056p pd=1.64u ps=0.92u
    I_MXI25_MP10 (XI25_xan XI25_xn VDD VDD) gpdk090_pmos1v w=0.24u l=0.1u ad=0.0816p as=0.0816p pd=1.16u ps=1.16u
    I_MXI16_MP12 (VDD B_3 XI16_xbn VDD) gpdk090_pmos1v w=0.24u l=0.1u ad=0.0816p as=0.0816p pd=1.16u ps=1.16u
    I_MXI16_MP18 (XI16_xp1 XI16_xbn VDD VDD) gpdk090_pmos1v w=0.48u l=0.1u ad=0.1056p as=0.1632p pd=0.92u ps=1.64u
    I_MXI16_MP20 (pp1_4 B_3 XI16_xp1 VDD) gpdk090_pmos1v w=0.48u l=0.1u ad=0.1056p as=0.1056p pd=0.92u ps=0.92u
    I_MXI16_MP19 (XI16_xp1 XI16_xan pp1_4 VDD) gpdk090_pmos1v w=0.48u l=0.1u ad=0.1056p as=0.1056p pd=0.92u ps=0.92u
    I_MXI16_MP17 (VDD XI16_xn XI16_xp1 VDD) gpdk090_pmos1v w=0.48u l=0.1u ad=0.1632p as=0.1056p pd=1.64u ps=0.92u
    I_MXI16_MP6 (XI16_p1 A_4 VDD VDD) gpdk090_pmos1v w=0.48u l=0.1u ad=0.1056p as=0.1632p pd=0.92u ps=1.64u
    I_MXI16_MP8 (XI16_xn A_3 XI16_p1 VDD) gpdk090_pmos1v w=0.48u l=0.1u ad=0.1056p as=0.1056p pd=0.92u ps=0.92u
    I_MXI16_MP7 (XI16_p1 two1 XI16_xn VDD) gpdk090_pmos1v w=0.48u l=0.1u ad=0.1056p as=0.1056p pd=0.92u ps=0.92u
    I_MXI16_MP5 (VDD one1 XI16_p1 VDD) gpdk090_pmos1v w=0.48u l=0.1u ad=0.1632p as=0.1056p pd=1.64u ps=0.92u
    I_MXI16_MP10 (XI16_xan XI16_xn VDD VDD) gpdk090_pmos1v w=0.24u l=0.1u ad=0.0816p as=0.0816p pd=1.16u ps=1.16u
    I_MXI6_MP12 (VDD B_1 XI6_xbn VDD) gpdk090_pmos1v w=0.24u l=0.1u ad=0.0816p as=0.0816p pd=1.16u ps=1.16u
    I_MXI6_MP18 (XI6_xp1 XI6_xbn VDD VDD) gpdk090_pmos1v w=0.48u l=0.1u ad=0.1056p as=0.1632p pd=0.92u ps=1.64u
    I_MXI6_MP20 (pp0_5 B_1 XI6_xp1 VDD) gpdk090_pmos1v w=0.48u l=0.1u ad=0.1056p as=0.1056p pd=0.92u ps=0.92u
    I_MXI6_MP19 (XI6_xp1 XI6_xan pp0_5 VDD) gpdk090_pmos1v w=0.48u l=0.1u ad=0.1056p as=0.1056p pd=0.92u ps=0.92u
    I_MXI6_MP17 (VDD XI6_xn XI6_xp1 VDD) gpdk090_pmos1v w=0.48u l=0.1u ad=0.1632p as=0.1056p pd=1.64u ps=0.92u
    I_MXI6_MP6 (XI6_p1 A_5 VDD VDD) gpdk090_pmos1v w=0.48u l=0.1u ad=0.1056p as=0.1632p pd=0.92u ps=1.64u
    I_MXI6_MP8 (XI6_xn A_4 XI6_p1 VDD) gpdk090_pmos1v w=0.48u l=0.1u ad=0.1056p as=0.1056p pd=0.92u ps=0.92u
    I_MXI6_MP7 (XI6_p1 two0 XI6_xn VDD) gpdk090_pmos1v w=0.48u l=0.1u ad=0.1056p as=0.1056p pd=0.92u ps=0.92u
    I_MXI6_MP5 (VDD one0 XI6_p1 VDD) gpdk090_pmos1v w=0.48u l=0.1u ad=0.1632p as=0.1056p pd=1.64u ps=0.92u
    I_MXI6_MP10 (XI6_xan XI6_xn VDD VDD) gpdk090_pmos1v w=0.24u l=0.1u ad=0.0816p as=0.0816p pd=1.16u ps=1.16u
    I_MXI4_MP12 (VDD B_1 XI4_xbn VDD) gpdk090_pmos1v w=0.24u l=0.1u ad=0.0816p as=0.0816p pd=1.16u ps=1.16u
    I_MXI4_MP18 (XI4_xp1 XI4_xbn VDD VDD) gpdk090_pmos1v w=0.48u l=0.1u ad=0.1056p as=0.1632p pd=0.92u ps=1.64u
    I_MXI4_MP20 (pp0_3 B_1 XI4_xp1 VDD) gpdk090_pmos1v w=0.48u l=0.1u ad=0.1056p as=0.1056p pd=0.92u ps=0.92u
    I_MXI4_MP19 (XI4_xp1 XI4_xan pp0_3 VDD) gpdk090_pmos1v w=0.48u l=0.1u ad=0.1056p as=0.1056p pd=0.92u ps=0.92u
    I_MXI4_MP17 (VDD XI4_xn XI4_xp1 VDD) gpdk090_pmos1v w=0.48u l=0.1u ad=0.1632p as=0.1056p pd=1.64u ps=0.92u
    I_MXI4_MP6 (XI4_p1 A_3 VDD VDD) gpdk090_pmos1v w=0.48u l=0.1u ad=0.1056p as=0.1632p pd=0.92u ps=1.64u
    I_MXI4_MP8 (XI4_xn A_2 XI4_p1 VDD) gpdk090_pmos1v w=0.48u l=0.1u ad=0.1056p as=0.1056p pd=0.92u ps=0.92u
    I_MXI4_MP7 (XI4_p1 two0 XI4_xn VDD) gpdk090_pmos1v w=0.48u l=0.1u ad=0.1056p as=0.1056p pd=0.92u ps=0.92u
    I_MXI4_MP5 (VDD one0 XI4_p1 VDD) gpdk090_pmos1v w=0.48u l=0.1u ad=0.1632p as=0.1056p pd=1.64u ps=0.92u
    I_MXI4_MP10 (XI4_xan XI4_xn VDD VDD) gpdk090_pmos1v w=0.24u l=0.1u ad=0.0816p as=0.0816p pd=1.16u ps=1.16u
    I_MXI12_MP12 (VDD B_3 XI12_xbn VDD) gpdk090_pmos1v w=0.24u l=0.1u ad=0.0816p as=0.0816p pd=1.16u ps=1.16u
    I_MXI12_MP18 (XI12_xp1 XI12_xbn VDD VDD) gpdk090_pmos1v w=0.48u l=0.1u ad=0.1056p as=0.1632p pd=0.92u ps=1.64u
    I_MXI12_MP20 (pp1_0 B_3 XI12_xp1 VDD) gpdk090_pmos1v w=0.48u l=0.1u ad=0.1056p as=0.1056p pd=0.92u ps=0.92u
    I_MXI12_MP19 (XI12_xp1 XI12_xan pp1_0 VDD) gpdk090_pmos1v w=0.48u l=0.1u ad=0.1056p as=0.1056p pd=0.92u ps=0.92u
    I_MXI12_MP17 (VDD XI12_xn XI12_xp1 VDD) gpdk090_pmos1v w=0.48u l=0.1u ad=0.1632p as=0.1056p pd=1.64u ps=0.92u
    I_MXI12_MP6 (XI12_p1 A_0 VDD VDD) gpdk090_pmos1v w=0.48u l=0.1u ad=0.1056p as=0.1632p pd=0.92u ps=1.64u
    I_MXI12_MP8 (XI12_xn VSS XI12_p1 VDD) gpdk090_pmos1v w=0.48u l=0.1u ad=0.1056p as=0.1056p pd=0.92u ps=0.92u
    I_MXI12_MP7 (XI12_p1 two1 XI12_xn VDD) gpdk090_pmos1v w=0.48u l=0.1u ad=0.1056p as=0.1056p pd=0.92u ps=0.92u
    I_MXI12_MP5 (VDD one1 XI12_p1 VDD) gpdk090_pmos1v w=0.48u l=0.1u ad=0.1632p as=0.1056p pd=1.64u ps=0.92u
    I_MXI12_MP10 (XI12_xan XI12_xn VDD VDD) gpdk090_pmos1v w=0.24u l=0.1u ad=0.0816p as=0.0816p pd=1.16u ps=1.16u
    I_MXI39_MP12 (VDD B_7 XI39_xbn VDD) gpdk090_pmos1v w=0.24u l=0.1u ad=0.0816p as=0.0816p pd=1.16u ps=1.16u
    I_MXI39_MP18 (XI39_xp1 XI39_xbn VDD VDD) gpdk090_pmos1v w=0.48u l=0.1u ad=0.1056p as=0.1632p pd=0.92u ps=1.64u
    I_MXI39_MP20 (pp3_5 B_7 XI39_xp1 VDD) gpdk090_pmos1v w=0.48u l=0.1u ad=0.1056p as=0.1056p pd=0.92u ps=0.92u
    I_MXI39_MP19 (XI39_xp1 XI39_xan pp3_5 VDD) gpdk090_pmos1v w=0.48u l=0.1u ad=0.1056p as=0.1056p pd=0.92u ps=0.92u
    I_MXI39_MP17 (VDD XI39_xn XI39_xp1 VDD) gpdk090_pmos1v w=0.48u l=0.1u ad=0.1632p as=0.1056p pd=1.64u ps=0.92u
    I_MXI39_MP6 (XI39_p1 A_5 VDD VDD) gpdk090_pmos1v w=0.48u l=0.1u ad=0.1056p as=0.1632p pd=0.92u ps=1.64u
    I_MXI39_MP8 (XI39_xn A_4 XI39_p1 VDD) gpdk090_pmos1v w=0.48u l=0.1u ad=0.1056p as=0.1056p pd=0.92u ps=0.92u
    I_MXI39_MP7 (XI39_p1 two3 XI39_xn VDD) gpdk090_pmos1v w=0.48u l=0.1u ad=0.1056p as=0.1056p pd=0.92u ps=0.92u
    I_MXI39_MP5 (VDD one3 XI39_p1 VDD) gpdk090_pmos1v w=0.48u l=0.1u ad=0.1632p as=0.1056p pd=1.64u ps=0.92u
    I_MXI39_MP10 (XI39_xan XI39_xn VDD VDD) gpdk090_pmos1v w=0.24u l=0.1u ad=0.0816p as=0.0816p pd=1.16u ps=1.16u
    I_MXI31_MP12 (VDD B_5 XI31_xbn VDD) gpdk090_pmos1v w=0.24u l=0.1u ad=0.0816p as=0.0816p pd=1.16u ps=1.16u
    I_MXI31_MP18 (XI31_xp1 XI31_xbn VDD VDD) gpdk090_pmos1v w=0.48u l=0.1u ad=0.1056p as=0.1632p pd=0.92u ps=1.64u
    I_MXI31_MP20 (pp2_8 B_5 XI31_xp1 VDD) gpdk090_pmos1v w=0.48u l=0.1u ad=0.1056p as=0.1056p pd=0.92u ps=0.92u
    I_MXI31_MP19 (XI31_xp1 XI31_xan pp2_8 VDD) gpdk090_pmos1v w=0.48u l=0.1u ad=0.1056p as=0.1056p pd=0.92u ps=0.92u
    I_MXI31_MP17 (VDD XI31_xn XI31_xp1 VDD) gpdk090_pmos1v w=0.48u l=0.1u ad=0.1632p as=0.1056p pd=1.64u ps=0.92u
    I_MXI31_MP6 (XI31_p1 A_7 VDD VDD) gpdk090_pmos1v w=0.48u l=0.1u ad=0.1056p as=0.1632p pd=0.92u ps=1.64u
    I_MXI31_MP8 (XI31_xn A_7 XI31_p1 VDD) gpdk090_pmos1v w=0.48u l=0.1u ad=0.1056p as=0.1056p pd=0.92u ps=0.92u
    I_MXI31_MP7 (XI31_p1 two2 XI31_xn VDD) gpdk090_pmos1v w=0.48u l=0.1u ad=0.1056p as=0.1056p pd=0.92u ps=0.92u
    I_MXI31_MP5 (VDD one2 XI31_p1 VDD) gpdk090_pmos1v w=0.48u l=0.1u ad=0.1632p as=0.1056p pd=1.64u ps=0.92u
    I_MXI31_MP10 (XI31_xan XI31_xn VDD VDD) gpdk090_pmos1v w=0.24u l=0.1u ad=0.0816p as=0.0816p pd=1.16u ps=1.16u
    I_MXI35_MP12 (VDD B_7 XI35_xbn VDD) gpdk090_pmos1v w=0.24u l=0.1u ad=0.0816p as=0.0816p pd=1.16u ps=1.16u
    I_MXI35_MP18 (XI35_xp1 XI35_xbn VDD VDD) gpdk090_pmos1v w=0.48u l=0.1u ad=0.1056p as=0.1632p pd=0.92u ps=1.64u
    I_MXI35_MP20 (pp3_1 B_7 XI35_xp1 VDD) gpdk090_pmos1v w=0.48u l=0.1u ad=0.1056p as=0.1056p pd=0.92u ps=0.92u
    I_MXI35_MP19 (XI35_xp1 XI35_xan pp3_1 VDD) gpdk090_pmos1v w=0.48u l=0.1u ad=0.1056p as=0.1056p pd=0.92u ps=0.92u
    I_MXI35_MP17 (VDD XI35_xn XI35_xp1 VDD) gpdk090_pmos1v w=0.48u l=0.1u ad=0.1632p as=0.1056p pd=1.64u ps=0.92u
    I_MXI35_MP6 (XI35_p1 A_1 VDD VDD) gpdk090_pmos1v w=0.48u l=0.1u ad=0.1056p as=0.1632p pd=0.92u ps=1.64u
    I_MXI35_MP8 (XI35_xn A_0 XI35_p1 VDD) gpdk090_pmos1v w=0.48u l=0.1u ad=0.1056p as=0.1056p pd=0.92u ps=0.92u
    I_MXI35_MP7 (XI35_p1 two3 XI35_xn VDD) gpdk090_pmos1v w=0.48u l=0.1u ad=0.1056p as=0.1056p pd=0.92u ps=0.92u
    I_MXI35_MP5 (VDD one3 XI35_p1 VDD) gpdk090_pmos1v w=0.48u l=0.1u ad=0.1632p as=0.1056p pd=1.64u ps=0.92u
    I_MXI35_MP10 (XI35_xan XI35_xn VDD VDD) gpdk090_pmos1v w=0.24u l=0.1u ad=0.0816p as=0.0816p pd=1.16u ps=1.16u
    I_MXI36_MP12 (VDD B_7 XI36_xbn VDD) gpdk090_pmos1v w=0.24u l=0.1u ad=0.0816p as=0.0816p pd=1.16u ps=1.16u
    I_MXI36_MP18 (XI36_xp1 XI36_xbn VDD VDD) gpdk090_pmos1v w=0.48u l=0.1u ad=0.1056p as=0.1632p pd=0.92u ps=1.64u
    I_MXI36_MP20 (pp3_2 B_7 XI36_xp1 VDD) gpdk090_pmos1v w=0.48u l=0.1u ad=0.1056p as=0.1056p pd=0.92u ps=0.92u
    I_MXI36_MP19 (XI36_xp1 XI36_xan pp3_2 VDD) gpdk090_pmos1v w=0.48u l=0.1u ad=0.1056p as=0.1056p pd=0.92u ps=0.92u
    I_MXI36_MP17 (VDD XI36_xn XI36_xp1 VDD) gpdk090_pmos1v w=0.48u l=0.1u ad=0.1632p as=0.1056p pd=1.64u ps=0.92u
    I_MXI36_MP6 (XI36_p1 A_2 VDD VDD) gpdk090_pmos1v w=0.48u l=0.1u ad=0.1056p as=0.1632p pd=0.92u ps=1.64u
    I_MXI36_MP8 (XI36_xn A_1 XI36_p1 VDD) gpdk090_pmos1v w=0.48u l=0.1u ad=0.1056p as=0.1056p pd=0.92u ps=0.92u
    I_MXI36_MP7 (XI36_p1 two3 XI36_xn VDD) gpdk090_pmos1v w=0.48u l=0.1u ad=0.1056p as=0.1056p pd=0.92u ps=0.92u
    I_MXI36_MP5 (VDD one3 XI36_p1 VDD) gpdk090_pmos1v w=0.48u l=0.1u ad=0.1632p as=0.1056p pd=1.64u ps=0.92u
    I_MXI36_MP10 (XI36_xan XI36_xn VDD VDD) gpdk090_pmos1v w=0.24u l=0.1u ad=0.0816p as=0.0816p pd=1.16u ps=1.16u
    I_MXI9_MP12 (VDD B_1 XI9_xbn VDD) gpdk090_pmos1v w=0.24u l=0.1u ad=0.0816p as=0.0816p pd=1.16u ps=1.16u
    I_MXI9_MP18 (XI9_xp1 XI9_xbn VDD VDD) gpdk090_pmos1v w=0.48u l=0.1u ad=0.1056p as=0.1632p pd=0.92u ps=1.64u
    I_MXI9_MP20 (pp0_8 B_1 XI9_xp1 VDD) gpdk090_pmos1v w=0.48u l=0.1u ad=0.1056p as=0.1056p pd=0.92u ps=0.92u
    I_MXI9_MP19 (XI9_xp1 XI9_xan pp0_8 VDD) gpdk090_pmos1v w=0.48u l=0.1u ad=0.1056p as=0.1056p pd=0.92u ps=0.92u
    I_MXI9_MP17 (VDD XI9_xn XI9_xp1 VDD) gpdk090_pmos1v w=0.48u l=0.1u ad=0.1632p as=0.1056p pd=1.64u ps=0.92u
    I_MXI9_MP6 (XI9_p1 A_7 VDD VDD) gpdk090_pmos1v w=0.48u l=0.1u ad=0.1056p as=0.1632p pd=0.92u ps=1.64u
    I_MXI9_MP8 (XI9_xn A_7 XI9_p1 VDD) gpdk090_pmos1v w=0.48u l=0.1u ad=0.1056p as=0.1056p pd=0.92u ps=0.92u
    I_MXI9_MP7 (XI9_p1 two0 XI9_xn VDD) gpdk090_pmos1v w=0.48u l=0.1u ad=0.1056p as=0.1056p pd=0.92u ps=0.92u
    I_MXI9_MP5 (VDD one0 XI9_p1 VDD) gpdk090_pmos1v w=0.48u l=0.1u ad=0.1632p as=0.1056p pd=1.64u ps=0.92u
    I_MXI9_MP10 (XI9_xan XI9_xn VDD VDD) gpdk090_pmos1v w=0.24u l=0.1u ad=0.0816p as=0.0816p pd=1.16u ps=1.16u
    I_MXI7_MP12 (VDD B_1 XI7_xbn VDD) gpdk090_pmos1v w=0.24u l=0.1u ad=0.0816p as=0.0816p pd=1.16u ps=1.16u
    I_MXI7_MP18 (XI7_xp1 XI7_xbn VDD VDD) gpdk090_pmos1v w=0.48u l=0.1u ad=0.1056p as=0.1632p pd=0.92u ps=1.64u
    I_MXI7_MP20 (pp0_6 B_1 XI7_xp1 VDD) gpdk090_pmos1v w=0.48u l=0.1u ad=0.1056p as=0.1056p pd=0.92u ps=0.92u
    I_MXI7_MP19 (XI7_xp1 XI7_xan pp0_6 VDD) gpdk090_pmos1v w=0.48u l=0.1u ad=0.1056p as=0.1056p pd=0.92u ps=0.92u
    I_MXI7_MP17 (VDD XI7_xn XI7_xp1 VDD) gpdk090_pmos1v w=0.48u l=0.1u ad=0.1632p as=0.1056p pd=1.64u ps=0.92u
    I_MXI7_MP6 (XI7_p1 A_6 VDD VDD) gpdk090_pmos1v w=0.48u l=0.1u ad=0.1056p as=0.1632p pd=0.92u ps=1.64u
    I_MXI7_MP8 (XI7_xn A_5 XI7_p1 VDD) gpdk090_pmos1v w=0.48u l=0.1u ad=0.1056p as=0.1056p pd=0.92u ps=0.92u
    I_MXI7_MP7 (XI7_p1 two0 XI7_xn VDD) gpdk090_pmos1v w=0.48u l=0.1u ad=0.1056p as=0.1056p pd=0.92u ps=0.92u
    I_MXI7_MP5 (VDD one0 XI7_p1 VDD) gpdk090_pmos1v w=0.48u l=0.1u ad=0.1632p as=0.1056p pd=1.64u ps=0.92u
    I_MXI7_MP10 (XI7_xan XI7_xn VDD VDD) gpdk090_pmos1v w=0.24u l=0.1u ad=0.0816p as=0.0816p pd=1.16u ps=1.16u
    I_MXI3_MP12 (VDD B_1 XI3_xbn VDD) gpdk090_pmos1v w=0.24u l=0.1u ad=0.0816p as=0.0816p pd=1.16u ps=1.16u
    I_MXI3_MP18 (XI3_xp1 XI3_xbn VDD VDD) gpdk090_pmos1v w=0.48u l=0.1u ad=0.1056p as=0.1632p pd=0.92u ps=1.64u
    I_MXI3_MP20 (pp0_2 B_1 XI3_xp1 VDD) gpdk090_pmos1v w=0.48u l=0.1u ad=0.1056p as=0.1056p pd=0.92u ps=0.92u
    I_MXI3_MP19 (XI3_xp1 XI3_xan pp0_2 VDD) gpdk090_pmos1v w=0.48u l=0.1u ad=0.1056p as=0.1056p pd=0.92u ps=0.92u
    I_MXI3_MP17 (VDD XI3_xn XI3_xp1 VDD) gpdk090_pmos1v w=0.48u l=0.1u ad=0.1632p as=0.1056p pd=1.64u ps=0.92u
    I_MXI3_MP6 (XI3_p1 A_2 VDD VDD) gpdk090_pmos1v w=0.48u l=0.1u ad=0.1056p as=0.1632p pd=0.92u ps=1.64u
    I_MXI3_MP8 (XI3_xn A_1 XI3_p1 VDD) gpdk090_pmos1v w=0.48u l=0.1u ad=0.1056p as=0.1056p pd=0.92u ps=0.92u
    I_MXI3_MP7 (XI3_p1 two0 XI3_xn VDD) gpdk090_pmos1v w=0.48u l=0.1u ad=0.1056p as=0.1056p pd=0.92u ps=0.92u
    I_MXI3_MP5 (VDD one0 XI3_p1 VDD) gpdk090_pmos1v w=0.48u l=0.1u ad=0.1632p as=0.1056p pd=1.64u ps=0.92u
    I_MXI3_MP10 (XI3_xan XI3_xn VDD VDD) gpdk090_pmos1v w=0.24u l=0.1u ad=0.0816p as=0.0816p pd=1.16u ps=1.16u
    I_MXI41_MP12 (VDD B_7 XI41_xbn VDD) gpdk090_pmos1v w=0.24u l=0.1u ad=0.0816p as=0.0816p pd=1.16u ps=1.16u
    I_MXI41_MP18 (XI41_xp1 XI41_xbn VDD VDD) gpdk090_pmos1v w=0.48u l=0.1u ad=0.1056p as=0.1632p pd=0.92u ps=1.64u
    I_MXI41_MP20 (pp3_7 B_7 XI41_xp1 VDD) gpdk090_pmos1v w=0.48u l=0.1u ad=0.1056p as=0.1056p pd=0.92u ps=0.92u
    I_MXI41_MP19 (XI41_xp1 XI41_xan pp3_7 VDD) gpdk090_pmos1v w=0.48u l=0.1u ad=0.1056p as=0.1056p pd=0.92u ps=0.92u
    I_MXI41_MP17 (VDD XI41_xn XI41_xp1 VDD) gpdk090_pmos1v w=0.48u l=0.1u ad=0.1632p as=0.1056p pd=1.64u ps=0.92u
    I_MXI41_MP6 (XI41_p1 A_7 VDD VDD) gpdk090_pmos1v w=0.48u l=0.1u ad=0.1056p as=0.1632p pd=0.92u ps=1.64u
    I_MXI41_MP8 (XI41_xn A_6 XI41_p1 VDD) gpdk090_pmos1v w=0.48u l=0.1u ad=0.1056p as=0.1056p pd=0.92u ps=0.92u
    I_MXI41_MP7 (XI41_p1 two3 XI41_xn VDD) gpdk090_pmos1v w=0.48u l=0.1u ad=0.1056p as=0.1056p pd=0.92u ps=0.92u
    I_MXI41_MP5 (VDD one3 XI41_p1 VDD) gpdk090_pmos1v w=0.48u l=0.1u ad=0.1632p as=0.1056p pd=1.64u ps=0.92u
    I_MXI41_MP10 (XI41_xan XI41_xn VDD VDD) gpdk090_pmos1v w=0.24u l=0.1u ad=0.0816p as=0.0816p pd=1.16u ps=1.16u
    I_MXI40_MP12 (VDD B_7 XI40_xbn VDD) gpdk090_pmos1v w=0.24u l=0.1u ad=0.0816p as=0.0816p pd=1.16u ps=1.16u
    I_MXI40_MP18 (XI40_xp1 XI40_xbn VDD VDD) gpdk090_pmos1v w=0.48u l=0.1u ad=0.1056p as=0.1632p pd=0.92u ps=1.64u
    I_MXI40_MP20 (pp3_6 B_7 XI40_xp1 VDD) gpdk090_pmos1v w=0.48u l=0.1u ad=0.1056p as=0.1056p pd=0.92u ps=0.92u
    I_MXI40_MP19 (XI40_xp1 XI40_xan pp3_6 VDD) gpdk090_pmos1v w=0.48u l=0.1u ad=0.1056p as=0.1056p pd=0.92u ps=0.92u
    I_MXI40_MP17 (VDD XI40_xn XI40_xp1 VDD) gpdk090_pmos1v w=0.48u l=0.1u ad=0.1632p as=0.1056p pd=1.64u ps=0.92u
    I_MXI40_MP6 (XI40_p1 A_6 VDD VDD) gpdk090_pmos1v w=0.48u l=0.1u ad=0.1056p as=0.1632p pd=0.92u ps=1.64u
    I_MXI40_MP8 (XI40_xn A_5 XI40_p1 VDD) gpdk090_pmos1v w=0.48u l=0.1u ad=0.1056p as=0.1056p pd=0.92u ps=0.92u
    I_MXI40_MP7 (XI40_p1 two3 XI40_xn VDD) gpdk090_pmos1v w=0.48u l=0.1u ad=0.1056p as=0.1056p pd=0.92u ps=0.92u
    I_MXI40_MP5 (VDD one3 XI40_p1 VDD) gpdk090_pmos1v w=0.48u l=0.1u ad=0.1632p as=0.1056p pd=1.64u ps=0.92u
    I_MXI40_MP10 (XI40_xan XI40_xn VDD VDD) gpdk090_pmos1v w=0.24u l=0.1u ad=0.0816p as=0.0816p pd=1.16u ps=1.16u
    I_MXI34_MP12 (VDD B_7 XI34_xbn VDD) gpdk090_pmos1v w=0.24u l=0.1u ad=0.0816p as=0.0816p pd=1.16u ps=1.16u
    I_MXI34_MP18 (XI34_xp1 XI34_xbn VDD VDD) gpdk090_pmos1v w=0.48u l=0.1u ad=0.1056p as=0.1632p pd=0.92u ps=1.64u
    I_MXI34_MP20 (pp3_0 B_7 XI34_xp1 VDD) gpdk090_pmos1v w=0.48u l=0.1u ad=0.1056p as=0.1056p pd=0.92u ps=0.92u
    I_MXI34_MP19 (XI34_xp1 XI34_xan pp3_0 VDD) gpdk090_pmos1v w=0.48u l=0.1u ad=0.1056p as=0.1056p pd=0.92u ps=0.92u
    I_MXI34_MP17 (VDD XI34_xn XI34_xp1 VDD) gpdk090_pmos1v w=0.48u l=0.1u ad=0.1632p as=0.1056p pd=1.64u ps=0.92u
    I_MXI34_MP6 (XI34_p1 A_0 VDD VDD) gpdk090_pmos1v w=0.48u l=0.1u ad=0.1056p as=0.1632p pd=0.92u ps=1.64u
    I_MXI34_MP8 (XI34_xn VSS XI34_p1 VDD) gpdk090_pmos1v w=0.48u l=0.1u ad=0.1056p as=0.1056p pd=0.92u ps=0.92u
    I_MXI34_MP7 (XI34_p1 two3 XI34_xn VDD) gpdk090_pmos1v w=0.48u l=0.1u ad=0.1056p as=0.1056p pd=0.92u ps=0.92u
    I_MXI34_MP5 (VDD one3 XI34_p1 VDD) gpdk090_pmos1v w=0.48u l=0.1u ad=0.1632p as=0.1056p pd=1.64u ps=0.92u
    I_MXI34_MP10 (XI34_xan XI34_xn VDD VDD) gpdk090_pmos1v w=0.24u l=0.1u ad=0.0816p as=0.0816p pd=1.16u ps=1.16u
    I_MXI2_MP12 (VDD B_1 XI2_xbn VDD) gpdk090_pmos1v w=0.24u l=0.1u ad=0.0816p as=0.0816p pd=1.16u ps=1.16u
    I_MXI2_MP18 (XI2_xp1 XI2_xbn VDD VDD) gpdk090_pmos1v w=0.48u l=0.1u ad=0.1056p as=0.1632p pd=0.92u ps=1.64u
    I_MXI2_MP20 (pp0_1 B_1 XI2_xp1 VDD) gpdk090_pmos1v w=0.48u l=0.1u ad=0.1056p as=0.1056p pd=0.92u ps=0.92u
    I_MXI2_MP19 (XI2_xp1 XI2_xan pp0_1 VDD) gpdk090_pmos1v w=0.48u l=0.1u ad=0.1056p as=0.1056p pd=0.92u ps=0.92u
    I_MXI2_MP17 (VDD XI2_xn XI2_xp1 VDD) gpdk090_pmos1v w=0.48u l=0.1u ad=0.1632p as=0.1056p pd=1.64u ps=0.92u
    I_MXI2_MP6 (XI2_p1 A_1 VDD VDD) gpdk090_pmos1v w=0.48u l=0.1u ad=0.1056p as=0.1632p pd=0.92u ps=1.64u
    I_MXI2_MP8 (XI2_xn A_0 XI2_p1 VDD) gpdk090_pmos1v w=0.48u l=0.1u ad=0.1056p as=0.1056p pd=0.92u ps=0.92u
    I_MXI2_MP7 (XI2_p1 two0 XI2_xn VDD) gpdk090_pmos1v w=0.48u l=0.1u ad=0.1056p as=0.1056p pd=0.92u ps=0.92u
    I_MXI2_MP5 (VDD one0 XI2_p1 VDD) gpdk090_pmos1v w=0.48u l=0.1u ad=0.1632p as=0.1056p pd=1.64u ps=0.92u
    I_MXI2_MP10 (XI2_xan XI2_xn VDD VDD) gpdk090_pmos1v w=0.24u l=0.1u ad=0.0816p as=0.0816p pd=1.16u ps=1.16u
    I_MXI1_MP12 (VDD B_1 XI1_xbn VDD) gpdk090_pmos1v w=0.24u l=0.1u ad=0.0816p as=0.0816p pd=1.16u ps=1.16u
    I_MXI1_MP18 (XI1_xp1 XI1_xbn VDD VDD) gpdk090_pmos1v w=0.48u l=0.1u ad=0.1056p as=0.1632p pd=0.92u ps=1.64u
    I_MXI1_MP20 (pp0_0 B_1 XI1_xp1 VDD) gpdk090_pmos1v w=0.48u l=0.1u ad=0.1056p as=0.1056p pd=0.92u ps=0.92u
    I_MXI1_MP19 (XI1_xp1 XI1_xan pp0_0 VDD) gpdk090_pmos1v w=0.48u l=0.1u ad=0.1056p as=0.1056p pd=0.92u ps=0.92u
    I_MXI1_MP17 (VDD XI1_xn XI1_xp1 VDD) gpdk090_pmos1v w=0.48u l=0.1u ad=0.1632p as=0.1056p pd=1.64u ps=0.92u
    I_MXI1_MP6 (XI1_p1 A_0 VDD VDD) gpdk090_pmos1v w=0.48u l=0.1u ad=0.1056p as=0.1632p pd=0.92u ps=1.64u
    I_MXI1_MP8 (XI1_xn VSS XI1_p1 VDD) gpdk090_pmos1v w=0.48u l=0.1u ad=0.1056p as=0.1056p pd=0.92u ps=0.92u
    I_MXI1_MP7 (XI1_p1 two0 XI1_xn VDD) gpdk090_pmos1v w=0.48u l=0.1u ad=0.1056p as=0.1056p pd=0.92u ps=0.92u
    I_MXI1_MP5 (VDD one0 XI1_p1 VDD) gpdk090_pmos1v w=0.48u l=0.1u ad=0.1632p as=0.1056p pd=1.64u ps=0.92u
    I_MXI1_MP10 (XI1_xan XI1_xn VDD VDD) gpdk090_pmos1v w=0.24u l=0.1u ad=0.0816p as=0.0816p pd=1.16u ps=1.16u
    I_MXI42_MP12 (VDD B_7 XI42_xbn VDD) gpdk090_pmos1v w=0.24u l=0.1u ad=0.0816p as=0.0816p pd=1.16u ps=1.16u
    I_MXI42_MP18 (XI42_xp1 XI42_xbn VDD VDD) gpdk090_pmos1v w=0.48u l=0.1u ad=0.1056p as=0.1632p pd=0.92u ps=1.64u
    I_MXI42_MP20 (pp3_8 B_7 XI42_xp1 VDD) gpdk090_pmos1v w=0.48u l=0.1u ad=0.1056p as=0.1056p pd=0.92u ps=0.92u
    I_MXI42_MP19 (XI42_xp1 XI42_xan pp3_8 VDD) gpdk090_pmos1v w=0.48u l=0.1u ad=0.1056p as=0.1056p pd=0.92u ps=0.92u
    I_MXI42_MP17 (VDD XI42_xn XI42_xp1 VDD) gpdk090_pmos1v w=0.48u l=0.1u ad=0.1632p as=0.1056p pd=1.64u ps=0.92u
    I_MXI42_MP6 (XI42_p1 A_7 VDD VDD) gpdk090_pmos1v w=0.48u l=0.1u ad=0.1056p as=0.1632p pd=0.92u ps=1.64u
    I_MXI42_MP8 (XI42_xn A_7 XI42_p1 VDD) gpdk090_pmos1v w=0.48u l=0.1u ad=0.1056p as=0.1056p pd=0.92u ps=0.92u
    I_MXI42_MP7 (XI42_p1 two3 XI42_xn VDD) gpdk090_pmos1v w=0.48u l=0.1u ad=0.1056p as=0.1056p pd=0.92u ps=0.92u
    I_MXI42_MP5 (VDD one3 XI42_p1 VDD) gpdk090_pmos1v w=0.48u l=0.1u ad=0.1632p as=0.1056p pd=1.64u ps=0.92u
    I_MXI42_MP10 (XI42_xan XI42_xn VDD VDD) gpdk090_pmos1v w=0.24u l=0.1u ad=0.0816p as=0.0816p pd=1.16u ps=1.16u
    I_MXI77_I29_XP_MP1 (I77_P5_2n I77_P3_2 VDD VDD) gpdk090_pmos1v w=0.24u l=0.1u ad=0.0528p as=0.0816p pd=0.68u ps=1.16u
    I_MXI77_I29_XP_MP0 (VDD I77_P5_4 I77_P5_2n VDD) gpdk090_pmos1v w=0.24u l=0.1u ad=0.0816p as=0.0528p pd=1.16u ps=0.68u
    I_MXI77_I28_XP_MP1 (I77_P4_1n I77_P2_1 VDD VDD) gpdk090_pmos1v w=0.24u l=0.1u ad=0.0528p as=0.0816p pd=0.68u ps=1.16u
    I_MXI77_I28_XP_MP0 (VDD I77_P4_3 I77_P4_1n VDD) gpdk090_pmos1v w=0.24u l=0.1u ad=0.0816p as=0.0528p pd=1.16u ps=0.68u
    I_MXI77_I1_MP1 (I77_gn1 ha19_0 VDD VDD) gpdk090_pmos1v w=0.24u l=0.1u ad=0.0528p as=0.0816p pd=0.68u ps=1.16u
    I_MXI77_I1_MP0 (VDD ha18_1 I77_gn1 VDD) gpdk090_pmos1v w=0.24u l=0.1u ad=0.0816p as=0.0528p pd=1.16u ps=0.68u
    I_MXI77_I0_MP1 (I77_gn0 ha18_0 VDD VDD) gpdk090_pmos1v w=0.24u l=0.1u ad=0.0528p as=0.0816p pd=0.68u ps=1.16u
    I_MXI77_I0_MP0 (VDD ha17_1 I77_gn0 VDD) gpdk090_pmos1v w=0.24u l=0.1u ad=0.0816p as=0.0528p pd=1.16u ps=0.68u
    I_MXI77_I30_XP_MP1 (I77_P6_3n I77_P4_3 VDD VDD) gpdk090_pmos1v w=0.24u l=0.1u ad=0.0528p as=0.0816p pd=0.68u ps=1.16u
    I_MXI77_I30_XP_MP0 (VDD I77_P6_5 I77_P6_3n VDD) gpdk090_pmos1v w=0.24u l=0.1u ad=0.0816p as=0.0528p pd=1.16u ps=0.68u
    I_MXI77_I2_MP1 (I77_gn2 ha20_0 VDD VDD) gpdk090_pmos1v w=0.24u l=0.1u ad=0.0528p as=0.0816p pd=0.68u ps=1.16u
    I_MXI77_I2_MP0 (VDD ha19_1 I77_gn2 VDD) gpdk090_pmos1v w=0.24u l=0.1u ad=0.0816p as=0.0528p pd=1.16u ps=0.68u
    I_MXI77_I31_XP_MP1 (I77_P7_4n I77_P5_4 VDD VDD) gpdk090_pmos1v w=0.24u l=0.1u ad=0.0528p as=0.0816p pd=0.68u ps=1.16u
    I_MXI77_I31_XP_MP0 (VDD I77_P7_6 I77_P7_4n VDD) gpdk090_pmos1v w=0.24u l=0.1u ad=0.0816p as=0.0528p pd=1.16u ps=0.68u
    I_MXI77_I3_MP1 (I77_gn3 ha21_0 VDD VDD) gpdk090_pmos1v w=0.24u l=0.1u ad=0.0528p as=0.0816p pd=0.68u ps=1.16u
    I_MXI77_I3_MP0 (VDD ha20_1 I77_gn3 VDD) gpdk090_pmos1v w=0.24u l=0.1u ad=0.0816p as=0.0528p pd=1.16u ps=0.68u
    I_MXI77_I4_MP1 (I77_gn4 ha22_0 VDD VDD) gpdk090_pmos1v w=0.24u l=0.1u ad=0.0528p as=0.0816p pd=0.68u ps=1.16u
    I_MXI77_I4_MP0 (VDD ha21_1 I77_gn4 VDD) gpdk090_pmos1v w=0.24u l=0.1u ad=0.0816p as=0.0528p pd=1.16u ps=0.68u
    I_MXI77_I5_MP1 (I77_gn5 ha23_0 VDD VDD) gpdk090_pmos1v w=0.24u l=0.1u ad=0.0528p as=0.0816p pd=0.68u ps=1.16u
    I_MXI77_I5_MP0 (VDD ha22_1 I77_gn5 VDD) gpdk090_pmos1v w=0.24u l=0.1u ad=0.0816p as=0.0528p pd=1.16u ps=0.68u
    I_MXI77_I7_MP1 (I77_gn7 ha25_0 VDD VDD) gpdk090_pmos1v w=0.24u l=0.1u ad=0.0528p as=0.0816p pd=0.68u ps=1.16u
    I_MXI77_I7_MP0 (VDD ha24_1 I77_gn7 VDD) gpdk090_pmos1v w=0.24u l=0.1u ad=0.0816p as=0.0528p pd=1.16u ps=0.68u
    I_MXI77_I6_MP1 (I77_gn6 ha24_0 VDD VDD) gpdk090_pmos1v w=0.24u l=0.1u ad=0.0528p as=0.0816p pd=0.68u ps=1.16u
    I_MXI77_I6_MP0 (VDD ha23_1 I77_gn6 VDD) gpdk090_pmos1v w=0.24u l=0.1u ad=0.0816p as=0.0528p pd=1.16u ps=0.68u
    I_MXI77_I21_XP_MP0 (XI77_I21_XP_p1 I77_pn3 VDD VDD) gpdk090_pmos1v w=0.48u l=0.1u ad=0.1056p as=0.1632p pd=0.92u ps=1.64u
    I_MXI77_I21_XP_MP1 (I77_P3_2 I77_pn2 XI77_I21_XP_p1 VDD) gpdk090_pmos1v w=0.48u l=0.1u ad=0.1632p as=0.1056p pd=1.64u ps=0.92u
    I_MXI77_I20_XP_MP0 (XI77_I20_XP_p1 I77_pn2 VDD VDD) gpdk090_pmos1v w=0.48u l=0.1u ad=0.1056p as=0.1632p pd=0.92u ps=1.64u
    I_MXI77_I20_XP_MP1 (I77_P2_1 I77_pn1 XI77_I20_XP_p1 VDD) gpdk090_pmos1v w=0.48u l=0.1u ad=0.1632p as=0.1056p pd=1.64u ps=0.92u
    I_MXI77_I24_XP_MP0 (XI77_I24_XP_p1 I77_pn6 VDD VDD) gpdk090_pmos1v w=0.48u l=0.1u ad=0.1056p as=0.1632p pd=0.92u ps=1.64u
    I_MXI77_I24_XP_MP1 (I77_P6_5 I77_pn5 XI77_I24_XP_p1 VDD) gpdk090_pmos1v w=0.48u l=0.1u ad=0.1632p as=0.1056p pd=1.64u ps=0.92u
    I_MXI77_I22_XP_MP0 (XI77_I22_XP_p1 I77_pn4 VDD VDD) gpdk090_pmos1v w=0.48u l=0.1u ad=0.1056p as=0.1632p pd=0.92u ps=1.64u
    I_MXI77_I22_XP_MP1 (I77_P4_3 I77_pn3 XI77_I22_XP_p1 VDD) gpdk090_pmos1v w=0.48u l=0.1u ad=0.1632p as=0.1056p pd=1.64u ps=0.92u
    I_MXI77_I23_XP_MP0 (XI77_I23_XP_p1 I77_pn5 VDD VDD) gpdk090_pmos1v w=0.48u l=0.1u ad=0.1056p as=0.1632p pd=0.92u ps=1.64u
    I_MXI77_I23_XP_MP1 (I77_P5_4 I77_pn4 XI77_I23_XP_p1 VDD) gpdk090_pmos1v w=0.48u l=0.1u ad=0.1632p as=0.1056p pd=1.64u ps=0.92u
    I_MXI77_I25_XP_MP0 (XI77_I25_XP_p1 I77_pn7 VDD VDD) gpdk090_pmos1v w=0.48u l=0.1u ad=0.1056p as=0.1632p pd=0.92u ps=1.64u
    I_MXI77_I25_XP_MP1 (I77_P7_6 I77_pn6 XI77_I25_XP_p1 VDD) gpdk090_pmos1v w=0.48u l=0.1u ad=0.1632p as=0.1056p pd=1.64u ps=0.92u
    I_MXI50_MP50 (VDD XI50_s1 XI50_bp4 VDD) gpdk090_pmos1v w=0.36u l=0.1u ad=0.0996p as=0.0792p pd=0.92u ps=0.8u
    I_MXI50_MP47 (XI50_bp3 pp3_2 VDD VDD) gpdk090_pmos1v w=0.48u l=0.1u ad=0.2352p as=0.0996p pd=1.46u ps=0.92u
    I_MXI50_MP49 (XI50_bsn XI50_bcon XI50_bp3 VDD) gpdk090_pmos1v w=0.48u l=0.1u ad=0.0996p as=0.2352p pd=0.92u ps=1.46u
    I_MXI50_MP52 (XI50_bp5 cm6_2 XI50_bsn VDD) gpdk090_pmos1v w=0.36u l=0.1u ad=0.0792p as=0.0996p pd=0.8u ps=0.92u
    I_MXI50_MP51 (XI50_bp4 pp3_2 XI50_bp5 VDD) gpdk090_pmos1v w=0.36u l=0.1u ad=0.0792p as=0.0792p pd=0.8u ps=0.8u
    I_MXI50_MP51_1 (XI50_bp5 pp3_2 XI50_bp4 VDD) gpdk090_pmos1v w=0.36u l=0.1u ad=0.0792p as=0.0792p pd=0.8u ps=0.8u
    I_MXI50_MP52_1 (XI50_bsn cm6_2 XI50_bp5 VDD) gpdk090_pmos1v w=0.36u l=0.1u ad=0.1224p as=0.0792p pd=1.4u ps=0.8u
    I_MXI50_MP54 (VDD XI50_bsn cm7_0 VDD) gpdk090_pmos1v w=0.24u l=0.1u ad=0.0816p as=0.0816p pd=1.16u ps=1.16u
    I_MXI50_MP41 (XI50_bp1 XI50_s1 VDD VDD) gpdk090_pmos1v w=0.48u l=0.1u ad=0.1056p as=0.0936p pd=0.92u ps=0.92u
    I_MXI50_MP42 (XI50_bcon pp3_2 XI50_bp1 VDD) gpdk090_pmos1v w=0.48u l=0.1u ad=0.1056p as=0.1056p pd=0.92u ps=0.92u
    I_MXI50_MP45 (XI50_bp2 cm6_2 XI50_bcon VDD) gpdk090_pmos1v w=0.48u l=0.1u ad=0.1056p as=0.1056p pd=0.92u ps=0.92u
    I_MXI50_MP43 (VDD XI50_s1 XI50_bp2 VDD) gpdk090_pmos1v w=0.48u l=0.1u ad=0.1056p as=0.1056p pd=0.92u ps=0.92u
    I_MXI50_MP44 (XI50_bp2 pp3_2 VDD VDD) gpdk090_pmos1v w=0.48u l=0.1u ad=0.1632p as=0.1056p pd=1.64u ps=0.92u
    I_MXI50_MP56 (VDD XI50_bcon cm7_1 VDD) gpdk090_pmos1v w=0.24u l=0.1u ad=0.0936p as=0.0816p pd=0.92u ps=1.16u
    I_MXI50_MP46 (XI50_bp3 XI50_s1 VDD VDD) gpdk090_pmos1v w=0.48u l=0.1u ad=0.1056p as=0.0936p pd=0.92u ps=0.92u
    I_MXI50_MP48 (VDD cm6_2 XI50_bp3 VDD) gpdk090_pmos1v w=0.48u l=0.1u ad=0.0996p as=0.1056p pd=0.92u ps=0.92u
    I_MXI50_MP50_1 (XI50_bp4 XI50_s1 VDD VDD) gpdk090_pmos1v w=0.36u l=0.1u ad=0.0792p as=0.0996p pd=0.8u ps=0.92u
    I_MXI50_MP26 (VDD XI50_asn XI50_s1 VDD) gpdk090_pmos1v w=0.24u l=0.1u ad=0.0936p as=0.0816p pd=0.92u ps=1.16u
    I_MXI50_MP18 (XI50_ap3 pp0_8 VDD VDD) gpdk090_pmos1v w=0.48u l=0.1u ad=0.1056p as=0.264p pd=0.92u ps=2.24u
    I_MXI50_MP21 (XI50_asn XI50_acon XI50_ap3 VDD) gpdk090_pmos1v w=0.48u l=0.1u ad=0.0996p as=0.1056p pd=0.92u ps=0.92u
    I_MXI50_MP24 (XI50_ap5 pp2_4 XI50_asn VDD) gpdk090_pmos1v w=0.36u l=0.1u ad=0.0792p as=0.0996p pd=0.8u ps=0.92u
    I_MXI50_MP23 (XI50_ap4 pp1_6 XI50_ap5 VDD) gpdk090_pmos1v w=0.36u l=0.1u ad=0.0792p as=0.0792p pd=0.8u ps=0.8u
    I_MXI50_MP22 (VDD pp0_8 XI50_ap4 VDD) gpdk090_pmos1v w=0.36u l=0.1u ad=0.0792p as=0.0792p pd=0.8u ps=0.8u
    I_MXI50_MP22_1 (XI50_ap4 pp0_8 VDD VDD) gpdk090_pmos1v w=0.36u l=0.1u ad=0.0792p as=0.0792p pd=0.8u ps=0.8u
    I_MXI50_MP23_1 (XI50_ap5 pp1_6 XI50_ap4 VDD) gpdk090_pmos1v w=0.36u l=0.1u ad=0.0792p as=0.0792p pd=0.8u ps=0.8u
    I_MXI50_MP24_1 (XI50_asn pp2_4 XI50_ap5 VDD) gpdk090_pmos1v w=0.36u l=0.1u ad=0.1224p as=0.0792p pd=1.4u ps=0.8u
    I_MXI50_MP17 (XI50_acon pp2_4 XI50_ap2 VDD) gpdk090_pmos1v w=0.48u l=0.1u ad=0.1056p as=0.1632p pd=0.92u ps=1.64u
    I_MXI50_MP14 (XI50_ap1 pp1_6 XI50_acon VDD) gpdk090_pmos1v w=0.48u l=0.1u ad=0.1056p as=0.1056p pd=0.92u ps=0.92u
    I_MXI50_MP13 (VDD pp0_8 XI50_ap1 VDD) gpdk090_pmos1v w=0.48u l=0.1u ad=0.1056p as=0.1056p pd=0.92u ps=0.92u
    I_MXI50_MP15 (XI50_ap2 pp0_8 VDD VDD) gpdk090_pmos1v w=0.48u l=0.1u ad=0.1056p as=0.1056p pd=0.92u ps=0.92u
    I_MXI50_MP16 (VDD pp1_6 XI50_ap2 VDD) gpdk090_pmos1v w=0.48u l=0.1u ad=0.0936p as=0.1056p pd=0.92u ps=0.92u
    I_MXI50_MP28 (cm7_2 XI50_acon VDD VDD) gpdk090_pmos1v w=0.24u l=0.1u ad=0.0816p as=0.0936p pd=1.16u ps=0.92u
    I_MXI50_MP19 (XI50_ap3 pp1_6 VDD VDD) gpdk090_pmos1v w=0.48u l=0.1u ad=0.1056p as=0.1632p pd=0.92u ps=1.64u
    I_MXI50_MP20 (VDD pp2_4 XI50_ap3 VDD) gpdk090_pmos1v w=0.48u l=0.1u ad=0.264p as=0.1056p pd=2.24u ps=0.92u
    I_MXI51_MP50 (VDD XI51_s1 XI51_bp4 VDD) gpdk090_pmos1v w=0.36u l=0.1u ad=0.0996p as=0.0792p pd=0.92u ps=0.8u
    I_MXI51_MP47 (XI51_bp3 pp3_3 VDD VDD) gpdk090_pmos1v w=0.48u l=0.1u ad=0.2352p as=0.0996p pd=1.46u ps=0.92u
    I_MXI51_MP49 (XI51_bsn XI51_bcon XI51_bp3 VDD) gpdk090_pmos1v w=0.48u l=0.1u ad=0.0996p as=0.2352p pd=0.92u ps=1.46u
    I_MXI51_MP52 (XI51_bp5 cm7_2 XI51_bsn VDD) gpdk090_pmos1v w=0.36u l=0.1u ad=0.0792p as=0.0996p pd=0.8u ps=0.92u
    I_MXI51_MP51 (XI51_bp4 pp3_3 XI51_bp5 VDD) gpdk090_pmos1v w=0.36u l=0.1u ad=0.0792p as=0.0792p pd=0.8u ps=0.8u
    I_MXI51_MP51_1 (XI51_bp5 pp3_3 XI51_bp4 VDD) gpdk090_pmos1v w=0.36u l=0.1u ad=0.0792p as=0.0792p pd=0.8u ps=0.8u
    I_MXI51_MP52_1 (XI51_bsn cm7_2 XI51_bp5 VDD) gpdk090_pmos1v w=0.36u l=0.1u ad=0.1224p as=0.0792p pd=1.4u ps=0.8u
    I_MXI51_MP54 (VDD XI51_bsn cm8_0 VDD) gpdk090_pmos1v w=0.24u l=0.1u ad=0.0816p as=0.0816p pd=1.16u ps=1.16u
    I_MXI51_MP41 (XI51_bp1 XI51_s1 VDD VDD) gpdk090_pmos1v w=0.48u l=0.1u ad=0.1056p as=0.0936p pd=0.92u ps=0.92u
    I_MXI51_MP42 (XI51_bcon pp3_3 XI51_bp1 VDD) gpdk090_pmos1v w=0.48u l=0.1u ad=0.1056p as=0.1056p pd=0.92u ps=0.92u
    I_MXI51_MP45 (XI51_bp2 cm7_2 XI51_bcon VDD) gpdk090_pmos1v w=0.48u l=0.1u ad=0.1056p as=0.1056p pd=0.92u ps=0.92u
    I_MXI51_MP43 (VDD XI51_s1 XI51_bp2 VDD) gpdk090_pmos1v w=0.48u l=0.1u ad=0.1056p as=0.1056p pd=0.92u ps=0.92u
    I_MXI51_MP44 (XI51_bp2 pp3_3 VDD VDD) gpdk090_pmos1v w=0.48u l=0.1u ad=0.1632p as=0.1056p pd=1.64u ps=0.92u
    I_MXI51_MP56 (VDD XI51_bcon cm8_1 VDD) gpdk090_pmos1v w=0.24u l=0.1u ad=0.0936p as=0.0816p pd=0.92u ps=1.16u
    I_MXI51_MP46 (XI51_bp3 XI51_s1 VDD VDD) gpdk090_pmos1v w=0.48u l=0.1u ad=0.1056p as=0.0936p pd=0.92u ps=0.92u
    I_MXI51_MP48 (VDD cm7_2 XI51_bp3 VDD) gpdk090_pmos1v w=0.48u l=0.1u ad=0.0996p as=0.1056p pd=0.92u ps=0.92u
    I_MXI51_MP50_1 (XI51_bp4 XI51_s1 VDD VDD) gpdk090_pmos1v w=0.36u l=0.1u ad=0.0792p as=0.0996p pd=0.8u ps=0.92u
    I_MXI51_MP26 (VDD XI51_asn XI51_s1 VDD) gpdk090_pmos1v w=0.24u l=0.1u ad=0.0936p as=0.0816p pd=0.92u ps=1.16u
    I_MXI51_MP18 (XI51_ap3 pp0_8 VDD VDD) gpdk090_pmos1v w=0.48u l=0.1u ad=0.1056p as=0.264p pd=0.92u ps=2.24u
    I_MXI51_MP21 (XI51_asn XI51_acon XI51_ap3 VDD) gpdk090_pmos1v w=0.48u l=0.1u ad=0.0996p as=0.1056p pd=0.92u ps=0.92u
    I_MXI51_MP24 (XI51_ap5 pp2_5 XI51_asn VDD) gpdk090_pmos1v w=0.36u l=0.1u ad=0.0792p as=0.0996p pd=0.8u ps=0.92u
    I_MXI51_MP23 (XI51_ap4 pp1_7 XI51_ap5 VDD) gpdk090_pmos1v w=0.36u l=0.1u ad=0.0792p as=0.0792p pd=0.8u ps=0.8u
    I_MXI51_MP22 (VDD pp0_8 XI51_ap4 VDD) gpdk090_pmos1v w=0.36u l=0.1u ad=0.0792p as=0.0792p pd=0.8u ps=0.8u
    I_MXI51_MP22_1 (XI51_ap4 pp0_8 VDD VDD) gpdk090_pmos1v w=0.36u l=0.1u ad=0.0792p as=0.0792p pd=0.8u ps=0.8u
    I_MXI51_MP23_1 (XI51_ap5 pp1_7 XI51_ap4 VDD) gpdk090_pmos1v w=0.36u l=0.1u ad=0.0792p as=0.0792p pd=0.8u ps=0.8u
    I_MXI51_MP24_1 (XI51_asn pp2_5 XI51_ap5 VDD) gpdk090_pmos1v w=0.36u l=0.1u ad=0.1224p as=0.0792p pd=1.4u ps=0.8u
    I_MXI51_MP17 (XI51_acon pp2_5 XI51_ap2 VDD) gpdk090_pmos1v w=0.48u l=0.1u ad=0.1056p as=0.1632p pd=0.92u ps=1.64u
    I_MXI51_MP14 (XI51_ap1 pp1_7 XI51_acon VDD) gpdk090_pmos1v w=0.48u l=0.1u ad=0.1056p as=0.1056p pd=0.92u ps=0.92u
    I_MXI51_MP13 (VDD pp0_8 XI51_ap1 VDD) gpdk090_pmos1v w=0.48u l=0.1u ad=0.1056p as=0.1056p pd=0.92u ps=0.92u
    I_MXI51_MP15 (XI51_ap2 pp0_8 VDD VDD) gpdk090_pmos1v w=0.48u l=0.1u ad=0.1056p as=0.1056p pd=0.92u ps=0.92u
    I_MXI51_MP16 (VDD pp1_7 XI51_ap2 VDD) gpdk090_pmos1v w=0.48u l=0.1u ad=0.0936p as=0.1056p pd=0.92u ps=0.92u
    I_MXI51_MP28 (cm8_2 XI51_acon VDD VDD) gpdk090_pmos1v w=0.24u l=0.1u ad=0.0816p as=0.0936p pd=1.16u ps=0.92u
    I_MXI51_MP19 (XI51_ap3 pp1_7 VDD VDD) gpdk090_pmos1v w=0.48u l=0.1u ad=0.1056p as=0.1632p pd=0.92u ps=1.64u
    I_MXI51_MP20 (VDD pp2_5 XI51_ap3 VDD) gpdk090_pmos1v w=0.48u l=0.1u ad=0.264p as=0.1056p pd=2.24u ps=0.92u
    I_MXI49_MP50 (VDD XI49_s1 XI49_bp4 VDD) gpdk090_pmos1v w=0.36u l=0.1u ad=0.0996p as=0.0792p pd=0.92u ps=0.8u
    I_MXI49_MP47 (XI49_bp3 pp3_1 VDD VDD) gpdk090_pmos1v w=0.48u l=0.1u ad=0.2352p as=0.0996p pd=1.46u ps=0.92u
    I_MXI49_MP49 (XI49_bsn XI49_bcon XI49_bp3 VDD) gpdk090_pmos1v w=0.48u l=0.1u ad=0.0996p as=0.2352p pd=0.92u ps=1.46u
    I_MXI49_MP52 (XI49_bp5 cm5_2 XI49_bsn VDD) gpdk090_pmos1v w=0.36u l=0.1u ad=0.0792p as=0.0996p pd=0.8u ps=0.92u
    I_MXI49_MP51 (XI49_bp4 pp3_1 XI49_bp5 VDD) gpdk090_pmos1v w=0.36u l=0.1u ad=0.0792p as=0.0792p pd=0.8u ps=0.8u
    I_MXI49_MP51_1 (XI49_bp5 pp3_1 XI49_bp4 VDD) gpdk090_pmos1v w=0.36u l=0.1u ad=0.0792p as=0.0792p pd=0.8u ps=0.8u
    I_MXI49_MP52_1 (XI49_bsn cm5_2 XI49_bp5 VDD) gpdk090_pmos1v w=0.36u l=0.1u ad=0.1224p as=0.0792p pd=1.4u ps=0.8u
    I_MXI49_MP54 (VDD XI49_bsn cm6_0 VDD) gpdk090_pmos1v w=0.24u l=0.1u ad=0.0816p as=0.0816p pd=1.16u ps=1.16u
    I_MXI49_MP41 (XI49_bp1 XI49_s1 VDD VDD) gpdk090_pmos1v w=0.48u l=0.1u ad=0.1056p as=0.0936p pd=0.92u ps=0.92u
    I_MXI49_MP42 (XI49_bcon pp3_1 XI49_bp1 VDD) gpdk090_pmos1v w=0.48u l=0.1u ad=0.1056p as=0.1056p pd=0.92u ps=0.92u
    I_MXI49_MP45 (XI49_bp2 cm5_2 XI49_bcon VDD) gpdk090_pmos1v w=0.48u l=0.1u ad=0.1056p as=0.1056p pd=0.92u ps=0.92u
    I_MXI49_MP43 (VDD XI49_s1 XI49_bp2 VDD) gpdk090_pmos1v w=0.48u l=0.1u ad=0.1056p as=0.1056p pd=0.92u ps=0.92u
    I_MXI49_MP44 (XI49_bp2 pp3_1 VDD VDD) gpdk090_pmos1v w=0.48u l=0.1u ad=0.1632p as=0.1056p pd=1.64u ps=0.92u
    I_MXI49_MP56 (VDD XI49_bcon cm6_1 VDD) gpdk090_pmos1v w=0.24u l=0.1u ad=0.0936p as=0.0816p pd=0.92u ps=1.16u
    I_MXI49_MP46 (XI49_bp3 XI49_s1 VDD VDD) gpdk090_pmos1v w=0.48u l=0.1u ad=0.1056p as=0.0936p pd=0.92u ps=0.92u
    I_MXI49_MP48 (VDD cm5_2 XI49_bp3 VDD) gpdk090_pmos1v w=0.48u l=0.1u ad=0.0996p as=0.1056p pd=0.92u ps=0.92u
    I_MXI49_MP50_1 (XI49_bp4 XI49_s1 VDD VDD) gpdk090_pmos1v w=0.36u l=0.1u ad=0.0792p as=0.0996p pd=0.8u ps=0.92u
    I_MXI49_MP26 (VDD XI49_asn XI49_s1 VDD) gpdk090_pmos1v w=0.24u l=0.1u ad=0.0936p as=0.0816p pd=0.92u ps=1.16u
    I_MXI49_MP18 (XI49_ap3 pp0_7 VDD VDD) gpdk090_pmos1v w=0.48u l=0.1u ad=0.1056p as=0.264p pd=0.92u ps=2.24u
    I_MXI49_MP21 (XI49_asn XI49_acon XI49_ap3 VDD) gpdk090_pmos1v w=0.48u l=0.1u ad=0.0996p as=0.1056p pd=0.92u ps=0.92u
    I_MXI49_MP24 (XI49_ap5 pp2_3 XI49_asn VDD) gpdk090_pmos1v w=0.36u l=0.1u ad=0.0792p as=0.0996p pd=0.8u ps=0.92u
    I_MXI49_MP23 (XI49_ap4 pp1_5 XI49_ap5 VDD) gpdk090_pmos1v w=0.36u l=0.1u ad=0.0792p as=0.0792p pd=0.8u ps=0.8u
    I_MXI49_MP22 (VDD pp0_7 XI49_ap4 VDD) gpdk090_pmos1v w=0.36u l=0.1u ad=0.0792p as=0.0792p pd=0.8u ps=0.8u
    I_MXI49_MP22_1 (XI49_ap4 pp0_7 VDD VDD) gpdk090_pmos1v w=0.36u l=0.1u ad=0.0792p as=0.0792p pd=0.8u ps=0.8u
    I_MXI49_MP23_1 (XI49_ap5 pp1_5 XI49_ap4 VDD) gpdk090_pmos1v w=0.36u l=0.1u ad=0.0792p as=0.0792p pd=0.8u ps=0.8u
    I_MXI49_MP24_1 (XI49_asn pp2_3 XI49_ap5 VDD) gpdk090_pmos1v w=0.36u l=0.1u ad=0.1224p as=0.0792p pd=1.4u ps=0.8u
    I_MXI49_MP17 (XI49_acon pp2_3 XI49_ap2 VDD) gpdk090_pmos1v w=0.48u l=0.1u ad=0.1056p as=0.1632p pd=0.92u ps=1.64u
    I_MXI49_MP14 (XI49_ap1 pp1_5 XI49_acon VDD) gpdk090_pmos1v w=0.48u l=0.1u ad=0.1056p as=0.1056p pd=0.92u ps=0.92u
    I_MXI49_MP13 (VDD pp0_7 XI49_ap1 VDD) gpdk090_pmos1v w=0.48u l=0.1u ad=0.1056p as=0.1056p pd=0.92u ps=0.92u
    I_MXI49_MP15 (XI49_ap2 pp0_7 VDD VDD) gpdk090_pmos1v w=0.48u l=0.1u ad=0.1056p as=0.1056p pd=0.92u ps=0.92u
    I_MXI49_MP16 (VDD pp1_5 XI49_ap2 VDD) gpdk090_pmos1v w=0.48u l=0.1u ad=0.0936p as=0.1056p pd=0.92u ps=0.92u
    I_MXI49_MP28 (cm6_2 XI49_acon VDD VDD) gpdk090_pmos1v w=0.24u l=0.1u ad=0.0816p as=0.0936p pd=1.16u ps=0.92u
    I_MXI49_MP19 (XI49_ap3 pp1_5 VDD VDD) gpdk090_pmos1v w=0.48u l=0.1u ad=0.1056p as=0.1632p pd=0.92u ps=1.64u
    I_MXI49_MP20 (VDD pp2_3 XI49_ap3 VDD) gpdk090_pmos1v w=0.48u l=0.1u ad=0.264p as=0.1056p pd=2.24u ps=0.92u
    I_MXI52_MP50 (VDD XI52_s1 XI52_bp4 VDD) gpdk090_pmos1v w=0.36u l=0.1u ad=0.0996p as=0.0792p pd=0.92u ps=0.8u
    I_MXI52_MP47 (XI52_bp3 pp3_4 VDD VDD) gpdk090_pmos1v w=0.48u l=0.1u ad=0.2352p as=0.0996p pd=1.46u ps=0.92u
    I_MXI52_MP49 (XI52_bsn XI52_bcon XI52_bp3 VDD) gpdk090_pmos1v w=0.48u l=0.1u ad=0.0996p as=0.2352p pd=0.92u ps=1.46u
    I_MXI52_MP52 (XI52_bp5 cm8_2 XI52_bsn VDD) gpdk090_pmos1v w=0.36u l=0.1u ad=0.0792p as=0.0996p pd=0.8u ps=0.92u
    I_MXI52_MP51 (XI52_bp4 pp3_4 XI52_bp5 VDD) gpdk090_pmos1v w=0.36u l=0.1u ad=0.0792p as=0.0792p pd=0.8u ps=0.8u
    I_MXI52_MP51_1 (XI52_bp5 pp3_4 XI52_bp4 VDD) gpdk090_pmos1v w=0.36u l=0.1u ad=0.0792p as=0.0792p pd=0.8u ps=0.8u
    I_MXI52_MP52_1 (XI52_bsn cm8_2 XI52_bp5 VDD) gpdk090_pmos1v w=0.36u l=0.1u ad=0.1224p as=0.0792p pd=1.4u ps=0.8u
    I_MXI52_MP54 (VDD XI52_bsn cm9_0 VDD) gpdk090_pmos1v w=0.24u l=0.1u ad=0.0816p as=0.0816p pd=1.16u ps=1.16u
    I_MXI52_MP41 (XI52_bp1 XI52_s1 VDD VDD) gpdk090_pmos1v w=0.48u l=0.1u ad=0.1056p as=0.0936p pd=0.92u ps=0.92u
    I_MXI52_MP42 (XI52_bcon pp3_4 XI52_bp1 VDD) gpdk090_pmos1v w=0.48u l=0.1u ad=0.1056p as=0.1056p pd=0.92u ps=0.92u
    I_MXI52_MP45 (XI52_bp2 cm8_2 XI52_bcon VDD) gpdk090_pmos1v w=0.48u l=0.1u ad=0.1056p as=0.1056p pd=0.92u ps=0.92u
    I_MXI52_MP43 (VDD XI52_s1 XI52_bp2 VDD) gpdk090_pmos1v w=0.48u l=0.1u ad=0.1056p as=0.1056p pd=0.92u ps=0.92u
    I_MXI52_MP44 (XI52_bp2 pp3_4 VDD VDD) gpdk090_pmos1v w=0.48u l=0.1u ad=0.1632p as=0.1056p pd=1.64u ps=0.92u
    I_MXI52_MP56 (VDD XI52_bcon cm9_1 VDD) gpdk090_pmos1v w=0.24u l=0.1u ad=0.0936p as=0.0816p pd=0.92u ps=1.16u
    I_MXI52_MP46 (XI52_bp3 XI52_s1 VDD VDD) gpdk090_pmos1v w=0.48u l=0.1u ad=0.1056p as=0.0936p pd=0.92u ps=0.92u
    I_MXI52_MP48 (VDD cm8_2 XI52_bp3 VDD) gpdk090_pmos1v w=0.48u l=0.1u ad=0.0996p as=0.1056p pd=0.92u ps=0.92u
    I_MXI52_MP50_1 (XI52_bp4 XI52_s1 VDD VDD) gpdk090_pmos1v w=0.36u l=0.1u ad=0.0792p as=0.0996p pd=0.8u ps=0.92u
    I_MXI52_MP26 (VDD XI52_asn XI52_s1 VDD) gpdk090_pmos1v w=0.24u l=0.1u ad=0.0936p as=0.0816p pd=0.92u ps=1.16u
    I_MXI52_MP18 (XI52_ap3 pp0_8 VDD VDD) gpdk090_pmos1v w=0.48u l=0.1u ad=0.1056p as=0.264p pd=0.92u ps=2.24u
    I_MXI52_MP21 (XI52_asn XI52_acon XI52_ap3 VDD) gpdk090_pmos1v w=0.48u l=0.1u ad=0.0996p as=0.1056p pd=0.92u ps=0.92u
    I_MXI52_MP24 (XI52_ap5 pp2_6 XI52_asn VDD) gpdk090_pmos1v w=0.36u l=0.1u ad=0.0792p as=0.0996p pd=0.8u ps=0.92u
    I_MXI52_MP23 (XI52_ap4 pp1_8 XI52_ap5 VDD) gpdk090_pmos1v w=0.36u l=0.1u ad=0.0792p as=0.0792p pd=0.8u ps=0.8u
    I_MXI52_MP22 (VDD pp0_8 XI52_ap4 VDD) gpdk090_pmos1v w=0.36u l=0.1u ad=0.0792p as=0.0792p pd=0.8u ps=0.8u
    I_MXI52_MP22_1 (XI52_ap4 pp0_8 VDD VDD) gpdk090_pmos1v w=0.36u l=0.1u ad=0.0792p as=0.0792p pd=0.8u ps=0.8u
    I_MXI52_MP23_1 (XI52_ap5 pp1_8 XI52_ap4 VDD) gpdk090_pmos1v w=0.36u l=0.1u ad=0.0792p as=0.0792p pd=0.8u ps=0.8u
    I_MXI52_MP24_1 (XI52_asn pp2_6 XI52_ap5 VDD) gpdk090_pmos1v w=0.36u l=0.1u ad=0.1224p as=0.0792p pd=1.4u ps=0.8u
    I_MXI52_MP17 (XI52_acon pp2_6 XI52_ap2 VDD) gpdk090_pmos1v w=0.48u l=0.1u ad=0.1056p as=0.1632p pd=0.92u ps=1.64u
    I_MXI52_MP14 (XI52_ap1 pp1_8 XI52_acon VDD) gpdk090_pmos1v w=0.48u l=0.1u ad=0.1056p as=0.1056p pd=0.92u ps=0.92u
    I_MXI52_MP13 (VDD pp0_8 XI52_ap1 VDD) gpdk090_pmos1v w=0.48u l=0.1u ad=0.1056p as=0.1056p pd=0.92u ps=0.92u
    I_MXI52_MP15 (XI52_ap2 pp0_8 VDD VDD) gpdk090_pmos1v w=0.48u l=0.1u ad=0.1056p as=0.1056p pd=0.92u ps=0.92u
    I_MXI52_MP16 (VDD pp1_8 XI52_ap2 VDD) gpdk090_pmos1v w=0.48u l=0.1u ad=0.0936p as=0.1056p pd=0.92u ps=0.92u
    I_MXI52_MP28 (cm9_2 XI52_acon VDD VDD) gpdk090_pmos1v w=0.24u l=0.1u ad=0.0816p as=0.0936p pd=1.16u ps=0.92u
    I_MXI52_MP19 (XI52_ap3 pp1_8 VDD VDD) gpdk090_pmos1v w=0.48u l=0.1u ad=0.1056p as=0.1632p pd=0.92u ps=1.64u
    I_MXI52_MP20 (VDD pp2_6 XI52_ap3 VDD) gpdk090_pmos1v w=0.48u l=0.1u ad=0.264p as=0.1056p pd=2.24u ps=0.92u
    I_MXI48_MP50 (VDD XI48_s1 XI48_bp4 VDD) gpdk090_pmos1v w=0.36u l=0.1u ad=0.0996p as=0.0792p pd=0.92u ps=0.8u
    I_MXI48_MP47 (XI48_bp3 pp3_0 VDD VDD) gpdk090_pmos1v w=0.48u l=0.1u ad=0.2352p as=0.0996p pd=1.46u ps=0.92u
    I_MXI48_MP49 (XI48_bsn XI48_bcon XI48_bp3 VDD) gpdk090_pmos1v w=0.48u l=0.1u ad=0.0996p as=0.2352p pd=0.92u ps=1.46u
    I_MXI48_MP52 (XI48_bp5 B_7 XI48_bsn VDD) gpdk090_pmos1v w=0.36u l=0.1u ad=0.0792p as=0.0996p pd=0.8u ps=0.92u
    I_MXI48_MP51 (XI48_bp4 pp3_0 XI48_bp5 VDD) gpdk090_pmos1v w=0.36u l=0.1u ad=0.0792p as=0.0792p pd=0.8u ps=0.8u
    I_MXI48_MP51_1 (XI48_bp5 pp3_0 XI48_bp4 VDD) gpdk090_pmos1v w=0.36u l=0.1u ad=0.0792p as=0.0792p pd=0.8u ps=0.8u
    I_MXI48_MP52_1 (XI48_bsn B_7 XI48_bp5 VDD) gpdk090_pmos1v w=0.36u l=0.1u ad=0.1224p as=0.0792p pd=1.4u ps=0.8u
    I_MXI48_MP54 (VDD XI48_bsn cm5_0 VDD) gpdk090_pmos1v w=0.24u l=0.1u ad=0.0816p as=0.0816p pd=1.16u ps=1.16u
    I_MXI48_MP41 (XI48_bp1 XI48_s1 VDD VDD) gpdk090_pmos1v w=0.48u l=0.1u ad=0.1056p as=0.0936p pd=0.92u ps=0.92u
    I_MXI48_MP42 (XI48_bcon pp3_0 XI48_bp1 VDD) gpdk090_pmos1v w=0.48u l=0.1u ad=0.1056p as=0.1056p pd=0.92u ps=0.92u
    I_MXI48_MP45 (XI48_bp2 B_7 XI48_bcon VDD) gpdk090_pmos1v w=0.48u l=0.1u ad=0.1056p as=0.1056p pd=0.92u ps=0.92u
    I_MXI48_MP43 (VDD XI48_s1 XI48_bp2 VDD) gpdk090_pmos1v w=0.48u l=0.1u ad=0.1056p as=0.1056p pd=0.92u ps=0.92u
    I_MXI48_MP44 (XI48_bp2 pp3_0 VDD VDD) gpdk090_pmos1v w=0.48u l=0.1u ad=0.1632p as=0.1056p pd=1.64u ps=0.92u
    I_MXI48_MP56 (VDD XI48_bcon cm5_1 VDD) gpdk090_pmos1v w=0.24u l=0.1u ad=0.0936p as=0.0816p pd=0.92u ps=1.16u
    I_MXI48_MP46 (XI48_bp3 XI48_s1 VDD VDD) gpdk090_pmos1v w=0.48u l=0.1u ad=0.1056p as=0.0936p pd=0.92u ps=0.92u
    I_MXI48_MP48 (VDD B_7 XI48_bp3 VDD) gpdk090_pmos1v w=0.48u l=0.1u ad=0.0996p as=0.1056p pd=0.92u ps=0.92u
    I_MXI48_MP50_1 (XI48_bp4 XI48_s1 VDD VDD) gpdk090_pmos1v w=0.36u l=0.1u ad=0.0792p as=0.0996p pd=0.8u ps=0.92u
    I_MXI48_MP26 (VDD XI48_asn XI48_s1 VDD) gpdk090_pmos1v w=0.24u l=0.1u ad=0.0936p as=0.0816p pd=0.92u ps=1.16u
    I_MXI48_MP18 (XI48_ap3 pp0_6 VDD VDD) gpdk090_pmos1v w=0.48u l=0.1u ad=0.1056p as=0.264p pd=0.92u ps=2.24u
    I_MXI48_MP21 (XI48_asn XI48_acon XI48_ap3 VDD) gpdk090_pmos1v w=0.48u l=0.1u ad=0.0996p as=0.1056p pd=0.92u ps=0.92u
    I_MXI48_MP24 (XI48_ap5 pp2_2 XI48_asn VDD) gpdk090_pmos1v w=0.36u l=0.1u ad=0.0792p as=0.0996p pd=0.8u ps=0.92u
    I_MXI48_MP23 (XI48_ap4 pp1_4 XI48_ap5 VDD) gpdk090_pmos1v w=0.36u l=0.1u ad=0.0792p as=0.0792p pd=0.8u ps=0.8u
    I_MXI48_MP22 (VDD pp0_6 XI48_ap4 VDD) gpdk090_pmos1v w=0.36u l=0.1u ad=0.0792p as=0.0792p pd=0.8u ps=0.8u
    I_MXI48_MP22_1 (XI48_ap4 pp0_6 VDD VDD) gpdk090_pmos1v w=0.36u l=0.1u ad=0.0792p as=0.0792p pd=0.8u ps=0.8u
    I_MXI48_MP23_1 (XI48_ap5 pp1_4 XI48_ap4 VDD) gpdk090_pmos1v w=0.36u l=0.1u ad=0.0792p as=0.0792p pd=0.8u ps=0.8u
    I_MXI48_MP24_1 (XI48_asn pp2_2 XI48_ap5 VDD) gpdk090_pmos1v w=0.36u l=0.1u ad=0.1224p as=0.0792p pd=1.4u ps=0.8u
    I_MXI48_MP17 (XI48_acon pp2_2 XI48_ap2 VDD) gpdk090_pmos1v w=0.48u l=0.1u ad=0.1056p as=0.1632p pd=0.92u ps=1.64u
    I_MXI48_MP14 (XI48_ap1 pp1_4 XI48_acon VDD) gpdk090_pmos1v w=0.48u l=0.1u ad=0.1056p as=0.1056p pd=0.92u ps=0.92u
    I_MXI48_MP13 (VDD pp0_6 XI48_ap1 VDD) gpdk090_pmos1v w=0.48u l=0.1u ad=0.1056p as=0.1056p pd=0.92u ps=0.92u
    I_MXI48_MP15 (XI48_ap2 pp0_6 VDD VDD) gpdk090_pmos1v w=0.48u l=0.1u ad=0.1056p as=0.1056p pd=0.92u ps=0.92u
    I_MXI48_MP16 (VDD pp1_4 XI48_ap2 VDD) gpdk090_pmos1v w=0.48u l=0.1u ad=0.0936p as=0.1056p pd=0.92u ps=0.92u
    I_MXI48_MP28 (cm5_2 XI48_acon VDD VDD) gpdk090_pmos1v w=0.24u l=0.1u ad=0.0816p as=0.0936p pd=1.16u ps=0.92u
    I_MXI48_MP19 (XI48_ap3 pp1_4 VDD VDD) gpdk090_pmos1v w=0.48u l=0.1u ad=0.1056p as=0.1632p pd=0.92u ps=1.64u
    I_MXI48_MP20 (VDD pp2_2 XI48_ap3 VDD) gpdk090_pmos1v w=0.48u l=0.1u ad=0.264p as=0.1056p pd=2.24u ps=0.92u
    I_MXI53_MP50 (VDD XI53_s1 XI53_bp4 VDD) gpdk090_pmos1v w=0.36u l=0.1u ad=0.0996p as=0.0792p pd=0.92u ps=0.8u
    I_MXI53_MP47 (XI53_bp3 pp3_5 VDD VDD) gpdk090_pmos1v w=0.48u l=0.1u ad=0.2352p as=0.0996p pd=1.46u ps=0.92u
    I_MXI53_MP49 (XI53_bsn XI53_bcon XI53_bp3 VDD) gpdk090_pmos1v w=0.48u l=0.1u ad=0.0996p as=0.2352p pd=0.92u ps=1.46u
    I_MXI53_MP52 (XI53_bp5 cm9_2 XI53_bsn VDD) gpdk090_pmos1v w=0.36u l=0.1u ad=0.0792p as=0.0996p pd=0.8u ps=0.92u
    I_MXI53_MP51 (XI53_bp4 pp3_5 XI53_bp5 VDD) gpdk090_pmos1v w=0.36u l=0.1u ad=0.0792p as=0.0792p pd=0.8u ps=0.8u
    I_MXI53_MP51_1 (XI53_bp5 pp3_5 XI53_bp4 VDD) gpdk090_pmos1v w=0.36u l=0.1u ad=0.0792p as=0.0792p pd=0.8u ps=0.8u
    I_MXI53_MP52_1 (XI53_bsn cm9_2 XI53_bp5 VDD) gpdk090_pmos1v w=0.36u l=0.1u ad=0.1224p as=0.0792p pd=1.4u ps=0.8u
    I_MXI53_MP54 (VDD XI53_bsn cm10_0 VDD) gpdk090_pmos1v w=0.24u l=0.1u ad=0.0816p as=0.0816p pd=1.16u ps=1.16u
    I_MXI53_MP41 (XI53_bp1 XI53_s1 VDD VDD) gpdk090_pmos1v w=0.48u l=0.1u ad=0.1056p as=0.0936p pd=0.92u ps=0.92u
    I_MXI53_MP42 (XI53_bcon pp3_5 XI53_bp1 VDD) gpdk090_pmos1v w=0.48u l=0.1u ad=0.1056p as=0.1056p pd=0.92u ps=0.92u
    I_MXI53_MP45 (XI53_bp2 cm9_2 XI53_bcon VDD) gpdk090_pmos1v w=0.48u l=0.1u ad=0.1056p as=0.1056p pd=0.92u ps=0.92u
    I_MXI53_MP43 (VDD XI53_s1 XI53_bp2 VDD) gpdk090_pmos1v w=0.48u l=0.1u ad=0.1056p as=0.1056p pd=0.92u ps=0.92u
    I_MXI53_MP44 (XI53_bp2 pp3_5 VDD VDD) gpdk090_pmos1v w=0.48u l=0.1u ad=0.1632p as=0.1056p pd=1.64u ps=0.92u
    I_MXI53_MP56 (VDD XI53_bcon cm10_1 VDD) gpdk090_pmos1v w=0.24u l=0.1u ad=0.0936p as=0.0816p pd=0.92u ps=1.16u
    I_MXI53_MP46 (XI53_bp3 XI53_s1 VDD VDD) gpdk090_pmos1v w=0.48u l=0.1u ad=0.1056p as=0.0936p pd=0.92u ps=0.92u
    I_MXI53_MP48 (VDD cm9_2 XI53_bp3 VDD) gpdk090_pmos1v w=0.48u l=0.1u ad=0.0996p as=0.1056p pd=0.92u ps=0.92u
    I_MXI53_MP50_1 (XI53_bp4 XI53_s1 VDD VDD) gpdk090_pmos1v w=0.36u l=0.1u ad=0.0792p as=0.0996p pd=0.8u ps=0.92u
    I_MXI53_MP26 (VDD XI53_asn XI53_s1 VDD) gpdk090_pmos1v w=0.24u l=0.1u ad=0.0936p as=0.0816p pd=0.92u ps=1.16u
    I_MXI53_MP18 (XI53_ap3 sn0 VDD VDD) gpdk090_pmos1v w=0.48u l=0.1u ad=0.1056p as=0.264p pd=0.92u ps=2.24u
    I_MXI53_MP21 (XI53_asn XI53_acon XI53_ap3 VDD) gpdk090_pmos1v w=0.48u l=0.1u ad=0.0996p as=0.1056p pd=0.92u ps=0.92u
    I_MXI53_MP24 (XI53_ap5 pp2_7 XI53_asn VDD) gpdk090_pmos1v w=0.36u l=0.1u ad=0.0792p as=0.0996p pd=0.8u ps=0.92u
    I_MXI53_MP23 (XI53_ap4 sn1 XI53_ap5 VDD) gpdk090_pmos1v w=0.36u l=0.1u ad=0.0792p as=0.0792p pd=0.8u ps=0.8u
    I_MXI53_MP22 (VDD sn0 XI53_ap4 VDD) gpdk090_pmos1v w=0.36u l=0.1u ad=0.0792p as=0.0792p pd=0.8u ps=0.8u
    I_MXI53_MP22_1 (XI53_ap4 sn0 VDD VDD) gpdk090_pmos1v w=0.36u l=0.1u ad=0.0792p as=0.0792p pd=0.8u ps=0.8u
    I_MXI53_MP23_1 (XI53_ap5 sn1 XI53_ap4 VDD) gpdk090_pmos1v w=0.36u l=0.1u ad=0.0792p as=0.0792p pd=0.8u ps=0.8u
    I_MXI53_MP24_1 (XI53_asn pp2_7 XI53_ap5 VDD) gpdk090_pmos1v w=0.36u l=0.1u ad=0.1224p as=0.0792p pd=1.4u ps=0.8u
    I_MXI53_MP17 (XI53_acon pp2_7 XI53_ap2 VDD) gpdk090_pmos1v w=0.48u l=0.1u ad=0.1056p as=0.1632p pd=0.92u ps=1.64u
    I_MXI53_MP14 (XI53_ap1 sn1 XI53_acon VDD) gpdk090_pmos1v w=0.48u l=0.1u ad=0.1056p as=0.1056p pd=0.92u ps=0.92u
    I_MXI53_MP13 (VDD sn0 XI53_ap1 VDD) gpdk090_pmos1v w=0.48u l=0.1u ad=0.1056p as=0.1056p pd=0.92u ps=0.92u
    I_MXI53_MP15 (XI53_ap2 sn0 VDD VDD) gpdk090_pmos1v w=0.48u l=0.1u ad=0.1056p as=0.1056p pd=0.92u ps=0.92u
    I_MXI53_MP16 (VDD sn1 XI53_ap2 VDD) gpdk090_pmos1v w=0.48u l=0.1u ad=0.0936p as=0.1056p pd=0.92u ps=0.92u
    I_MXI53_MP28 (cm10_2 XI53_acon VDD VDD) gpdk090_pmos1v w=0.24u l=0.1u ad=0.0816p as=0.0936p pd=1.16u ps=0.92u
    I_MXI53_MP19 (XI53_ap3 sn1 VDD VDD) gpdk090_pmos1v w=0.48u l=0.1u ad=0.1056p as=0.1632p pd=0.92u ps=1.64u
    I_MXI53_MP20 (VDD pp2_7 XI53_ap3 VDD) gpdk090_pmos1v w=0.48u l=0.1u ad=0.264p as=0.1056p pd=2.24u ps=0.92u
    I_MXI54_MP50 (VDD XI54_s1 XI54_bp4 VDD) gpdk090_pmos1v w=0.36u l=0.1u ad=0.0996p as=0.0792p pd=0.92u ps=0.8u
    I_MXI54_MP47 (XI54_bp3 VSS VDD VDD) gpdk090_pmos1v w=0.48u l=0.1u ad=0.2352p as=0.0996p pd=1.46u ps=0.92u
    I_MXI54_MP49 (XI54_bsn XI54_bcon XI54_bp3 VDD) gpdk090_pmos1v w=0.48u l=0.1u ad=0.0996p as=0.2352p pd=0.92u ps=1.46u
    I_MXI54_MP52 (XI54_bp5 cm10_2 XI54_bsn VDD) gpdk090_pmos1v w=0.36u l=0.1u ad=0.0792p as=0.0996p pd=0.8u ps=0.92u
    I_MXI54_MP51 (XI54_bp4 VSS XI54_bp5 VDD) gpdk090_pmos1v w=0.36u l=0.1u ad=0.0792p as=0.0792p pd=0.8u ps=0.8u
    I_MXI54_MP51_1 (XI54_bp5 VSS XI54_bp4 VDD) gpdk090_pmos1v w=0.36u l=0.1u ad=0.0792p as=0.0792p pd=0.8u ps=0.8u
    I_MXI54_MP52_1 (XI54_bsn cm10_2 XI54_bp5 VDD) gpdk090_pmos1v w=0.36u l=0.1u ad=0.1224p as=0.0792p pd=1.4u ps=0.8u
    I_MXI54_MP54 (VDD XI54_bsn cm11_0 VDD) gpdk090_pmos1v w=0.24u l=0.1u ad=0.0816p as=0.0816p pd=1.16u ps=1.16u
    I_MXI54_MP41 (XI54_bp1 XI54_s1 VDD VDD) gpdk090_pmos1v w=0.48u l=0.1u ad=0.1056p as=0.0936p pd=0.92u ps=0.92u
    I_MXI54_MP42 (XI54_bcon VSS XI54_bp1 VDD) gpdk090_pmos1v w=0.48u l=0.1u ad=0.1056p as=0.1056p pd=0.92u ps=0.92u
    I_MXI54_MP45 (XI54_bp2 cm10_2 XI54_bcon VDD) gpdk090_pmos1v w=0.48u l=0.1u ad=0.1056p as=0.1056p pd=0.92u ps=0.92u
    I_MXI54_MP43 (VDD XI54_s1 XI54_bp2 VDD) gpdk090_pmos1v w=0.48u l=0.1u ad=0.1056p as=0.1056p pd=0.92u ps=0.92u
    I_MXI54_MP44 (XI54_bp2 VSS VDD VDD) gpdk090_pmos1v w=0.48u l=0.1u ad=0.1632p as=0.1056p pd=1.64u ps=0.92u
    I_MXI54_MP56 (VDD XI54_bcon cm11_1 VDD) gpdk090_pmos1v w=0.24u l=0.1u ad=0.0936p as=0.0816p pd=0.92u ps=1.16u
    I_MXI54_MP46 (XI54_bp3 XI54_s1 VDD VDD) gpdk090_pmos1v w=0.48u l=0.1u ad=0.1056p as=0.0936p pd=0.92u ps=0.92u
    I_MXI54_MP48 (VDD cm10_2 XI54_bp3 VDD) gpdk090_pmos1v w=0.48u l=0.1u ad=0.0996p as=0.1056p pd=0.92u ps=0.92u
    I_MXI54_MP50_1 (XI54_bp4 XI54_s1 VDD VDD) gpdk090_pmos1v w=0.36u l=0.1u ad=0.0792p as=0.0996p pd=0.8u ps=0.92u
    I_MXI54_MP26 (VDD XI54_asn XI54_s1 VDD) gpdk090_pmos1v w=0.24u l=0.1u ad=0.0936p as=0.0816p pd=0.92u ps=1.16u
    I_MXI54_MP18 (XI54_ap3 VDD VDD VDD) gpdk090_pmos1v w=0.48u l=0.1u ad=0.1056p as=0.264p pd=0.92u ps=2.24u
    I_MXI54_MP21 (XI54_asn XI54_acon XI54_ap3 VDD) gpdk090_pmos1v w=0.48u l=0.1u ad=0.0996p as=0.1056p pd=0.92u ps=0.92u
    I_MXI54_MP24 (XI54_ap5 pp3_6 XI54_asn VDD) gpdk090_pmos1v w=0.36u l=0.1u ad=0.0792p as=0.0996p pd=0.8u ps=0.92u
    I_MXI54_MP23 (XI54_ap4 pp2_8 XI54_ap5 VDD) gpdk090_pmos1v w=0.36u l=0.1u ad=0.0792p as=0.0792p pd=0.8u ps=0.8u
    I_MXI54_MP22 (VDD VDD XI54_ap4 VDD) gpdk090_pmos1v w=0.36u l=0.1u ad=0.0792p as=0.0792p pd=0.8u ps=0.8u
    I_MXI54_MP22_1 (XI54_ap4 VDD VDD VDD) gpdk090_pmos1v w=0.36u l=0.1u ad=0.0792p as=0.0792p pd=0.8u ps=0.8u
    I_MXI54_MP23_1 (XI54_ap5 pp2_8 XI54_ap4 VDD) gpdk090_pmos1v w=0.36u l=0.1u ad=0.0792p as=0.0792p pd=0.8u ps=0.8u
    I_MXI54_MP24_1 (XI54_asn pp3_6 XI54_ap5 VDD) gpdk090_pmos1v w=0.36u l=0.1u ad=0.1224p as=0.0792p pd=1.4u ps=0.8u
    I_MXI54_MP17 (XI54_acon pp3_6 XI54_ap2 VDD) gpdk090_pmos1v w=0.48u l=0.1u ad=0.1056p as=0.1632p pd=0.92u ps=1.64u
    I_MXI54_MP14 (XI54_ap1 pp2_8 XI54_acon VDD) gpdk090_pmos1v w=0.48u l=0.1u ad=0.1056p as=0.1056p pd=0.92u ps=0.92u
    I_MXI54_MP13 (VDD VDD XI54_ap1 VDD) gpdk090_pmos1v w=0.48u l=0.1u ad=0.1056p as=0.1056p pd=0.92u ps=0.92u
    I_MXI54_MP15 (XI54_ap2 VDD VDD VDD) gpdk090_pmos1v w=0.48u l=0.1u ad=0.1056p as=0.1056p pd=0.92u ps=0.92u
    I_MXI54_MP16 (VDD pp2_8 XI54_ap2 VDD) gpdk090_pmos1v w=0.48u l=0.1u ad=0.0936p as=0.1056p pd=0.92u ps=0.92u
    I_MXI54_MP28 (cm11_2 XI54_acon VDD VDD) gpdk090_pmos1v w=0.24u l=0.1u ad=0.0816p as=0.0936p pd=1.16u ps=0.92u
    I_MXI54_MP19 (XI54_ap3 pp2_8 VDD VDD) gpdk090_pmos1v w=0.48u l=0.1u ad=0.1056p as=0.1632p pd=0.92u ps=1.64u
    I_MXI54_MP20 (VDD pp3_6 XI54_ap3 VDD) gpdk090_pmos1v w=0.48u l=0.1u ad=0.264p as=0.1056p pd=2.24u ps=0.92u
    I_MXI22_MP9 (XI22_ap1 B_4 VDD VDD) gpdk090_pmos1v w=0.48u l=0.1u ad=0.1056p as=0.1632p pd=0.92u ps=1.64u
    I_MXI22_MP11 (one2 XI22_aan XI22_ap1 VDD) gpdk090_pmos1v w=0.48u l=0.1u ad=0.1056p as=0.1056p pd=0.92u ps=0.92u
    I_MXI22_MP12 (XI22_ap1 XI22_abn one2 VDD) gpdk090_pmos1v w=0.48u l=0.1u ad=0.1056p as=0.1056p pd=0.92u ps=0.92u
    I_MXI22_MP10 (VDD B_3 XI22_ap1 VDD) gpdk090_pmos1v w=0.48u l=0.1u ad=0.1632p as=0.1056p pd=1.64u ps=0.92u
    I_MXI22_MP2 (VDD B_4 XI22_aan VDD) gpdk090_pmos1v w=0.24u l=0.1u ad=0.0816p as=0.0816p pd=1.16u ps=1.16u
    I_MXI22_MP4 (XI22_abn B_3 VDD VDD) gpdk090_pmos1v w=0.24u l=0.1u ad=0.0816p as=0.0816p pd=1.16u ps=1.16u
    I_MXI22_MP16 (XI22_bbn B_4 VDD VDD) gpdk090_pmos1v w=0.24u l=0.1u ad=0.0816p as=0.0936p pd=1.16u ps=0.92u
    I_MXI22_MP14 (XI22_ban B_5 VDD VDD) gpdk090_pmos1v w=0.24u l=0.1u ad=0.0816p as=0.0816p pd=1.16u ps=1.16u
    I_MXI22_MP23 (XI22_e XI22_ban XI22_bp1 VDD) gpdk090_pmos1v w=0.48u l=0.1u ad=0.1056p as=0.1632p pd=0.92u ps=1.64u
    I_MXI22_MP24 (XI22_bp1 B_4 XI22_e VDD) gpdk090_pmos1v w=0.48u l=0.1u ad=0.1056p as=0.1056p pd=0.92u ps=0.92u
    I_MXI22_MP22 (VDD XI22_bbn XI22_bp1 VDD) gpdk090_pmos1v w=0.48u l=0.1u ad=0.1056p as=0.1056p pd=0.92u ps=0.92u
    I_MXI22_MP21 (XI22_bp1 B_5 VDD VDD) gpdk090_pmos1v w=0.48u l=0.1u ad=0.1632p as=0.1056p pd=1.64u ps=0.92u
    I_MXI22_MP28 (XI22_cp one2 two2 VDD) gpdk090_pmos1v w=0.48u l=0.1u ad=0.1056p as=0.1632p pd=0.92u ps=1.64u
    I_MXI22_MP27 (VDD XI22_e XI22_cp VDD) gpdk090_pmos1v w=0.48u l=0.1u ad=0.0936p as=0.1056p pd=0.92u ps=0.92u
    I_MXI11_MP9 (XI11_ap1 B_2 VDD VDD) gpdk090_pmos1v w=0.48u l=0.1u ad=0.1056p as=0.1632p pd=0.92u ps=1.64u
    I_MXI11_MP11 (one1 XI11_aan XI11_ap1 VDD) gpdk090_pmos1v w=0.48u l=0.1u ad=0.1056p as=0.1056p pd=0.92u ps=0.92u
    I_MXI11_MP12 (XI11_ap1 XI11_abn one1 VDD) gpdk090_pmos1v w=0.48u l=0.1u ad=0.1056p as=0.1056p pd=0.92u ps=0.92u
    I_MXI11_MP10 (VDD B_1 XI11_ap1 VDD) gpdk090_pmos1v w=0.48u l=0.1u ad=0.1632p as=0.1056p pd=1.64u ps=0.92u
    I_MXI11_MP2 (VDD B_2 XI11_aan VDD) gpdk090_pmos1v w=0.24u l=0.1u ad=0.0816p as=0.0816p pd=1.16u ps=1.16u
    I_MXI11_MP4 (XI11_abn B_1 VDD VDD) gpdk090_pmos1v w=0.24u l=0.1u ad=0.0816p as=0.0816p pd=1.16u ps=1.16u
    I_MXI11_MP16 (XI11_bbn B_2 VDD VDD) gpdk090_pmos1v w=0.24u l=0.1u ad=0.0816p as=0.0936p pd=1.16u ps=0.92u
    I_MXI11_MP14 (XI11_ban B_3 VDD VDD) gpdk090_pmos1v w=0.24u l=0.1u ad=0.0816p as=0.0816p pd=1.16u ps=1.16u
    I_MXI11_MP23 (XI11_e XI11_ban XI11_bp1 VDD) gpdk090_pmos1v w=0.48u l=0.1u ad=0.1056p as=0.1632p pd=0.92u ps=1.64u
    I_MXI11_MP24 (XI11_bp1 B_2 XI11_e VDD) gpdk090_pmos1v w=0.48u l=0.1u ad=0.1056p as=0.1056p pd=0.92u ps=0.92u
    I_MXI11_MP22 (VDD XI11_bbn XI11_bp1 VDD) gpdk090_pmos1v w=0.48u l=0.1u ad=0.1056p as=0.1056p pd=0.92u ps=0.92u
    I_MXI11_MP21 (XI11_bp1 B_3 VDD VDD) gpdk090_pmos1v w=0.48u l=0.1u ad=0.1632p as=0.1056p pd=1.64u ps=0.92u
    I_MXI11_MP28 (XI11_cp one1 two1 VDD) gpdk090_pmos1v w=0.48u l=0.1u ad=0.1056p as=0.1632p pd=0.92u ps=1.64u
    I_MXI11_MP27 (VDD XI11_e XI11_cp VDD) gpdk090_pmos1v w=0.48u l=0.1u ad=0.0936p as=0.1056p pd=0.92u ps=0.92u
    I_MXI33_MP9 (XI33_ap1 B_6 VDD VDD) gpdk090_pmos1v w=0.48u l=0.1u ad=0.1056p as=0.1632p pd=0.92u ps=1.64u
    I_MXI33_MP11 (one3 XI33_aan XI33_ap1 VDD) gpdk090_pmos1v w=0.48u l=0.1u ad=0.1056p as=0.1056p pd=0.92u ps=0.92u
    I_MXI33_MP12 (XI33_ap1 XI33_abn one3 VDD) gpdk090_pmos1v w=0.48u l=0.1u ad=0.1056p as=0.1056p pd=0.92u ps=0.92u
    I_MXI33_MP10 (VDD B_5 XI33_ap1 VDD) gpdk090_pmos1v w=0.48u l=0.1u ad=0.1632p as=0.1056p pd=1.64u ps=0.92u
    I_MXI33_MP2 (VDD B_6 XI33_aan VDD) gpdk090_pmos1v w=0.24u l=0.1u ad=0.0816p as=0.0816p pd=1.16u ps=1.16u
    I_MXI33_MP4 (XI33_abn B_5 VDD VDD) gpdk090_pmos1v w=0.24u l=0.1u ad=0.0816p as=0.0816p pd=1.16u ps=1.16u
    I_MXI33_MP16 (XI33_bbn B_6 VDD VDD) gpdk090_pmos1v w=0.24u l=0.1u ad=0.0816p as=0.0936p pd=1.16u ps=0.92u
    I_MXI33_MP14 (XI33_ban B_7 VDD VDD) gpdk090_pmos1v w=0.24u l=0.1u ad=0.0816p as=0.0816p pd=1.16u ps=1.16u
    I_MXI33_MP23 (XI33_e XI33_ban XI33_bp1 VDD) gpdk090_pmos1v w=0.48u l=0.1u ad=0.1056p as=0.1632p pd=0.92u ps=1.64u
    I_MXI33_MP24 (XI33_bp1 B_6 XI33_e VDD) gpdk090_pmos1v w=0.48u l=0.1u ad=0.1056p as=0.1056p pd=0.92u ps=0.92u
    I_MXI33_MP22 (VDD XI33_bbn XI33_bp1 VDD) gpdk090_pmos1v w=0.48u l=0.1u ad=0.1056p as=0.1056p pd=0.92u ps=0.92u
    I_MXI33_MP21 (XI33_bp1 B_7 VDD VDD) gpdk090_pmos1v w=0.48u l=0.1u ad=0.1632p as=0.1056p pd=1.64u ps=0.92u
    I_MXI33_MP28 (XI33_cp one3 two3 VDD) gpdk090_pmos1v w=0.48u l=0.1u ad=0.1056p as=0.1632p pd=0.92u ps=1.64u
    I_MXI33_MP27 (VDD XI33_e XI33_cp VDD) gpdk090_pmos1v w=0.48u l=0.1u ad=0.0936p as=0.1056p pd=0.92u ps=0.92u
    I_MXI0_MP9 (XI0_ap1 B_0 VDD VDD) gpdk090_pmos1v w=0.48u l=0.1u ad=0.1056p as=0.1632p pd=0.92u ps=1.64u
    I_MXI0_MP11 (one0 XI0_aan XI0_ap1 VDD) gpdk090_pmos1v w=0.48u l=0.1u ad=0.1056p as=0.1056p pd=0.92u ps=0.92u
    I_MXI0_MP12 (XI0_ap1 XI0_abn one0 VDD) gpdk090_pmos1v w=0.48u l=0.1u ad=0.1056p as=0.1056p pd=0.92u ps=0.92u
    I_MXI0_MP10 (VDD VSS XI0_ap1 VDD) gpdk090_pmos1v w=0.48u l=0.1u ad=0.1632p as=0.1056p pd=1.64u ps=0.92u
    I_MXI0_MP2 (VDD B_0 XI0_aan VDD) gpdk090_pmos1v w=0.24u l=0.1u ad=0.0816p as=0.0816p pd=1.16u ps=1.16u
    I_MXI0_MP4 (XI0_abn VSS VDD VDD) gpdk090_pmos1v w=0.24u l=0.1u ad=0.0816p as=0.0816p pd=1.16u ps=1.16u
    I_MXI0_MP16 (XI0_bbn B_0 VDD VDD) gpdk090_pmos1v w=0.24u l=0.1u ad=0.0816p as=0.0936p pd=1.16u ps=0.92u
    I_MXI0_MP14 (XI0_ban B_1 VDD VDD) gpdk090_pmos1v w=0.24u l=0.1u ad=0.0816p as=0.0816p pd=1.16u ps=1.16u
    I_MXI0_MP23 (XI0_e XI0_ban XI0_bp1 VDD) gpdk090_pmos1v w=0.48u l=0.1u ad=0.1056p as=0.1632p pd=0.92u ps=1.64u
    I_MXI0_MP24 (XI0_bp1 B_0 XI0_e VDD) gpdk090_pmos1v w=0.48u l=0.1u ad=0.1056p as=0.1056p pd=0.92u ps=0.92u
    I_MXI0_MP22 (VDD XI0_bbn XI0_bp1 VDD) gpdk090_pmos1v w=0.48u l=0.1u ad=0.1056p as=0.1056p pd=0.92u ps=0.92u
    I_MXI0_MP21 (XI0_bp1 B_1 VDD VDD) gpdk090_pmos1v w=0.48u l=0.1u ad=0.1632p as=0.1056p pd=1.64u ps=0.92u
    I_MXI0_MP28 (XI0_cp one0 two0 VDD) gpdk090_pmos1v w=0.48u l=0.1u ad=0.1056p as=0.1632p pd=0.92u ps=1.64u
    I_MXI0_MP27 (VDD XI0_e XI0_cp VDD) gpdk090_pmos1v w=0.48u l=0.1u ad=0.0936p as=0.1056p pd=0.92u ps=0.92u
    I_MXI77_I40_MP1 (VDD I77_G2_0n XI77_I40_Bn VDD) gpdk090_pmos1v w=0.24u l=0.1u ad=0.0816p as=0.0816p pd=1.16u ps=1.16u
    I_MXI77_I40_MP5 (P_11 XI77_I40_Bn XI77_I40_p1 VDD) gpdk090_pmos1v w=0.48u l=0.1u ad=0.1056p as=0.1632p pd=0.92u ps=1.64u
    I_MXI77_I40_MP4 (XI77_I40_p1 XI77_I40_An P_11 VDD) gpdk090_pmos1v w=0.48u l=0.1u ad=0.1056p as=0.1056p pd=0.92u ps=0.92u
    I_MXI77_I40_MP2 (VDD I77_pn3 XI77_I40_p1 VDD) gpdk090_pmos1v w=0.48u l=0.1u ad=0.1056p as=0.1056p pd=0.92u ps=0.92u
    I_MXI77_I40_MP3 (XI77_I40_p1 I77_G2_0n VDD VDD) gpdk090_pmos1v w=0.48u l=0.1u ad=0.1632p as=0.1056p pd=1.64u ps=0.92u
    I_MXI77_I40_MP0 (VDD I77_pn3 XI77_I40_An VDD) gpdk090_pmos1v w=0.24u l=0.1u ad=0.0816p as=0.0816p pd=1.16u ps=1.16u
    I_MXI77_I41_MP1 (VDD I77_G3_0n XI77_I41_Bn VDD) gpdk090_pmos1v w=0.24u l=0.1u ad=0.0816p as=0.0816p pd=1.16u ps=1.16u
    I_MXI77_I41_MP5 (P_12 XI77_I41_Bn XI77_I41_p1 VDD) gpdk090_pmos1v w=0.48u l=0.1u ad=0.1056p as=0.1632p pd=0.92u ps=1.64u
    I_MXI77_I41_MP4 (XI77_I41_p1 XI77_I41_An P_12 VDD) gpdk090_pmos1v w=0.48u l=0.1u ad=0.1056p as=0.1056p pd=0.92u ps=0.92u
    I_MXI77_I41_MP2 (VDD I77_pn4 XI77_I41_p1 VDD) gpdk090_pmos1v w=0.48u l=0.1u ad=0.1056p as=0.1056p pd=0.92u ps=0.92u
    I_MXI77_I41_MP3 (XI77_I41_p1 I77_G3_0n VDD VDD) gpdk090_pmos1v w=0.48u l=0.1u ad=0.1632p as=0.1056p pd=1.64u ps=0.92u
    I_MXI77_I41_MP0 (VDD I77_pn4 XI77_I41_An VDD) gpdk090_pmos1v w=0.24u l=0.1u ad=0.0816p as=0.0816p pd=1.16u ps=1.16u
    I_C1 (VDD VSS) capacitor c=1.642E-13
    I_C2 (A_0 VSS) capacitor c=1.331E-14
    I_C3 (A_1 VSS) capacitor c=1.343E-14
    I_C4 (A_2 VSS) capacitor c=1.438E-14
    I_C5 (A_3 VSS) capacitor c=1.381E-14
    I_C6 (A_4 VSS) capacitor c=1.409E-14
    I_C7 (A_5 VSS) capacitor c=1.334E-14
    I_C8 (A_6 VSS) capacitor c=1.439E-14
    I_C9 (A_7 VSS) capacitor c=1.113E-14
    I_C10 (B_0 VSS) capacitor c=3.119E-15
    I_C11 (B_1 VSS) capacitor c=1.622E-14
    I_C12 (B_2 VSS) capacitor c=3.323E-15
    I_C13 (B_3 VSS) capacitor c=1.941E-14
    I_C14 (B_4 VSS) capacitor c=3.306E-15
    I_C15 (B_5 VSS) capacitor c=2.114E-14
    I_C16 (B_6 VSS) capacitor c=3.096E-15
    I_C17 (B_7 VSS) capacitor c=1.837E-14
    I_C18 (P_0 VSS) capacitor c=1.187E-15
    I_C19 (P_1 VSS) capacitor c=1.322E-15
    I_C20 (P_10 VSS) capacitor c=7.504E-16
    I_C21 (P_11 VSS) capacitor c=1.195E-15
    I_C22 (P_12 VSS) capacitor c=1.567E-15
    I_C23 (P_13 VSS) capacitor c=1.118E-15
    I_C24 (P_14 VSS) capacitor c=9.562E-16
    I_C25 (P_15 VSS) capacitor c=1.263E-15
    I_C26 (P_2 VSS) capacitor c=1.060E-15
    I_C27 (P_3 VSS) capacitor c=1.146E-15
    I_C28 (P_4 VSS) capacitor c=1.115E-15
    I_C29 (P_5 VSS) capacitor c=1.269E-15
    I_C30 (P_6 VSS) capacitor c=7.744E-16
    I_C31 (P_7 VSS) capacitor c=1.172E-15
    I_C32 (P_8 VSS) capacitor c=7.837E-16
    I_C33 (P_9 VSS) capacitor c=7.497E-16
    I_C34 (I77_pn4 VSS) capacitor c=3.635E-15
    I_C35 (I77_G3_0n VSS) capacitor c=3.237E-15
    I_C36 (I77_pn3 VSS) capacitor c=4.393E-15
    I_C37 (I77_G2_0n VSS) capacitor c=3.553E-15
    I_C38 (one0 VSS) capacitor c=1.074E-14
    I_C39 (two0 VSS) capacitor c=1.248E-14
    I_C40 (one3 VSS) capacitor c=9.701E-15
    I_C41 (two3 VSS) capacitor c=9.559E-15
    I_C42 (one1 VSS) capacitor c=1.426E-14
    I_C43 (two1 VSS) capacitor c=1.257E-14
    I_C44 (one2 VSS) capacitor c=1.217E-14
    I_C45 (two2 VSS) capacitor c=1.248E-14
    I_C46 (cm11_1 VSS) capacitor c=2.870E-15
    I_C47 (cm10_2 VSS) capacitor c=3.916E-15
    I_C48 (cm11_2 VSS) capacitor c=3.499E-15
    I_C49 (cm11_0 VSS) capacitor c=3.715E-15
    I_C50 (pp2_8 VSS) capacitor c=4.412E-15
    I_C51 (pp3_6 VSS) capacitor c=3.959E-15
    I_C52 (cm10_1 VSS) capacitor c=3.165E-15
    I_C53 (cm9_2 VSS) capacitor c=3.663E-15
    I_C54 (cm10_0 VSS) capacitor c=4.266E-15
    I_C55 (sn0 VSS) capacitor c=3.418E-15
    I_C56 (sn1 VSS) capacitor c=3.454E-15
    I_C57 (pp2_7 VSS) capacitor c=4.281E-15
    I_C58 (pp3_5 VSS) capacitor c=3.769E-15
    I_C59 (cm5_1 VSS) capacitor c=4.995E-15
    I_C60 (cm5_2 VSS) capacitor c=4.701E-15
    I_C61 (cm5_0 VSS) capacitor c=5.141E-15
    I_C62 (pp0_6 VSS) capacitor c=5.034E-15
    I_C63 (pp1_4 VSS) capacitor c=4.250E-15
    I_C64 (pp2_2 VSS) capacitor c=4.562E-15
    I_C65 (pp3_0 VSS) capacitor c=5.605E-15
    I_C66 (cm9_1 VSS) capacitor c=2.647E-15
    I_C67 (cm8_2 VSS) capacitor c=3.311E-15
    I_C68 (cm9_0 VSS) capacitor c=3.647E-15
    I_C69 (pp0_8 VSS) capacitor c=1.466E-14
    I_C70 (pp1_8 VSS) capacitor c=5.525E-15
    I_C71 (pp2_6 VSS) capacitor c=4.733E-15
    I_C72 (pp3_4 VSS) capacitor c=4.824E-15
    I_C73 (cm6_1 VSS) capacitor c=3.473E-15
    I_C74 (cm6_2 VSS) capacitor c=3.093E-15
    I_C75 (cm6_0 VSS) capacitor c=4.065E-15
    I_C76 (pp0_7 VSS) capacitor c=4.515E-15
    I_C77 (pp1_5 VSS) capacitor c=4.381E-15
    I_C78 (pp2_3 VSS) capacitor c=4.052E-15
    I_C79 (pp3_1 VSS) capacitor c=6.587E-15
    I_C80 (cm8_1 VSS) capacitor c=2.898E-15
    I_C81 (cm7_2 VSS) capacitor c=3.406E-15
    I_C82 (cm8_0 VSS) capacitor c=3.445E-15
    I_C83 (pp1_7 VSS) capacitor c=5.592E-15
    I_C84 (pp2_5 VSS) capacitor c=3.975E-15
    I_C85 (pp3_3 VSS) capacitor c=5.244E-15
    I_C86 (cm7_1 VSS) capacitor c=3.153E-15
    I_C87 (cm7_0 VSS) capacitor c=3.371E-15
    I_C88 (pp1_6 VSS) capacitor c=5.573E-15
    I_C89 (pp2_4 VSS) capacitor c=4.484E-15
    I_C90 (pp3_2 VSS) capacitor c=6.122E-15
    I_C91 (I77_pn7 VSS) capacitor c=4.085E-15
    I_C92 (I77_pn6 VSS) capacitor c=6.664E-15
    I_C93 (I77_P7_6 VSS) capacitor c=1.862E-15
    I_C94 (I77_pn5 VSS) capacitor c=5.780E-15
    I_C95 (I77_P5_4 VSS) capacitor c=2.898E-15
    I_C96 (I77_P4_3 VSS) capacitor c=2.701E-15
    I_C97 (I77_P6_5 VSS) capacitor c=1.908E-15
    I_C98 (I77_pn2 VSS) capacitor c=4.447E-15
    I_C99 (I77_pn1 VSS) capacitor c=3.488E-15
    I_C100 (I77_P2_1 VSS) capacitor c=1.235E-15
    I_C101 (I77_P3_2 VSS) capacitor c=1.719E-15
    I_C102 (ha23_1 VSS) capacitor c=2.829E-15
    I_C103 (ha24_0 VSS) capacitor c=2.680E-15
    I_C104 (I77_gn6 VSS) capacitor c=1.614E-15
    I_C105 (ha24_1 VSS) capacitor c=2.361E-15
    I_C106 (ha25_0 VSS) capacitor c=3.235E-15
    I_C107 (I77_gn7 VSS) capacitor c=9.185E-16
    I_C108 (ha22_1 VSS) capacitor c=2.298E-15
    I_C109 (ha23_0 VSS) capacitor c=2.605E-15
    I_C110 (I77_gn5 VSS) capacitor c=2.026E-15
    I_C111 (ha21_1 VSS) capacitor c=2.346E-15
    I_C112 (ha22_0 VSS) capacitor c=3.222E-15
    I_C113 (I77_gn4 VSS) capacitor c=2.144E-15
    I_C114 (ha20_1 VSS) capacitor c=2.108E-15
    I_C115 (ha21_0 VSS) capacitor c=2.488E-15
    I_C116 (I77_gn3 VSS) capacitor c=2.053E-15
    I_C117 (I77_P7_4n VSS) capacitor c=8.964E-16
    I_C118 (ha19_1 VSS) capacitor c=2.333E-15
    I_C119 (ha20_0 VSS) capacitor c=2.497E-15
    I_C120 (I77_gn2 VSS) capacitor c=2.278E-15
    I_C121 (I77_P6_3n VSS) capacitor c=9.076E-16
    I_C122 (ha17_1 VSS) capacitor c=2.643E-15
    I_C123 (ha18_0 VSS) capacitor c=2.106E-15
    I_C124 (I77_gn0 VSS) capacitor c=8.237E-16
    I_C125 (ha18_1 VSS) capacitor c=2.458E-15
    I_C126 (ha19_0 VSS) capacitor c=2.843E-15
    I_C127 (I77_gn1 VSS) capacitor c=1.945E-15
    I_C128 (I77_P4_1n VSS) capacitor c=1.342E-15
    I_C129 (I77_P5_2n VSS) capacitor c=9.398E-16
    I_C130 (pp3_8 VSS) capacitor c=3.587E-15
    I_C131 (pp0_0 VSS) capacitor c=2.426E-15
    I_C132 (pp0_1 VSS) capacitor c=3.038E-15
    I_C133 (pp3_7 VSS) capacitor c=4.086E-15
    I_C134 (pp0_2 VSS) capacitor c=3.956E-15
    I_C135 (pp1_0 VSS) capacitor c=4.158E-15
    I_C136 (pp0_3 VSS) capacitor c=2.921E-15
    I_C137 (pp0_5 VSS) capacitor c=8.109E-15
    I_C138 (pp1_1 VSS) capacitor c=3.523E-15
    I_C139 (pp0_4 VSS) capacitor c=5.528E-15
    I_C140 (pp2_1 VSS) capacitor c=4.756E-15
    I_C141 (pp1_2 VSS) capacitor c=3.929E-15
    I_C142 (pp2_0 VSS) capacitor c=3.496E-15
    I_C143 (pp1_3 VSS) capacitor c=4.192E-15
    I_C144 (I77_G6_5 VSS) capacitor c=2.816E-15
    I_C145 (I77_G7_6 VSS) capacitor c=2.688E-15
    I_C146 (I77_G5_4 VSS) capacitor c=2.325E-15
    I_C147 (I77_G7_4n VSS) capacitor c=1.295E-15
    I_C148 (kc8 VSS) capacitor c=5.267E-16
    I_C149 (I77_G4_3 VSS) capacitor c=2.730E-15
    I_C150 (I77_G3_2 VSS) capacitor c=3.186E-15
    I_C151 (I77_G6_3n VSS) capacitor c=9.205E-16
    I_C152 (kc7 VSS) capacitor c=3.740E-15
    I_C153 (I77_pn0 VSS) capacitor c=2.829E-15
    I_C154 (I77_cinn VSS) capacitor c=9.438E-16
    I_C155 (I77_G0_0 VSS) capacitor c=3.208E-15
    I_C156 (I77_G0_0n VSS) capacitor c=1.708E-15
    I_C157 (I77_G1_0 VSS) capacitor c=4.289E-15
    I_C158 (I77_G2_1 VSS) capacitor c=1.884E-15
    I_C159 (I77_G4_1n VSS) capacitor c=1.344E-15
    I_C160 (I77_G4_0 VSS) capacitor c=2.182E-15
    I_C161 (I77_G1_0n VSS) capacitor c=6.201E-16
    I_C162 (I77_G5_2n VSS) capacitor c=1.210E-15
    I_C163 (I77_G5_0 VSS) capacitor c=1.848E-15
    I_C164 (fa1_1 VSS) capacitor c=3.945E-15
    I_C165 (ha2_0 VSS) capacitor c=4.584E-15
    I_C166 (rc3 VSS) capacitor c=2.698E-15
    I_C167 (rc4 VSS) capacitor c=5.164E-15
    I_C168 (fa1_0 VSS) capacitor c=3.282E-15
    I_C169 (sn2 VSS) capacitor c=3.017E-15
    I_C170 (fa12_1 VSS) capacitor c=2.556E-15
    I_C171 (fa12_0 VSS) capacitor c=2.432E-15
    I_C172 (ha2_1 VSS) capacitor c=6.213E-15
    I_C173 (fa3_0 VSS) capacitor c=3.471E-15
    I_C174 (fa14_1 VSS) capacitor c=3.923E-15
    I_C175 (fa14_0 VSS) capacitor c=3.259E-15
    I_C176 (fa3_1 VSS) capacitor c=3.424E-15
    I_C177 (fa4_1 VSS) capacitor c=2.716E-15
    I_C178 (fa4_0 VSS) capacitor c=2.466E-15
    I_C179 (ha16_1 VSS) capacitor c=3.518E-15
    I_C180 (ha17_0 VSS) capacitor c=3.869E-15
    I_C181 (rc7 VSS) capacitor c=2.624E-15
    I_C182 (rc8 VSS) capacitor c=1.640E-15
    I_C183 (ha15_0 VSS) capacitor c=3.718E-15
    I_C184 (rc5 VSS) capacitor c=2.490E-15
    I_C185 (rc6 VSS) capacitor c=3.044E-15
    I_C186 (ha15_1 VSS) capacitor c=4.378E-15
    I_C187 (ha16_0 VSS) capacitor c=3.598E-15
    I_C188 (rc1 VSS) capacitor c=2.437E-15
    I_C189 (ha13_1 VSS) capacitor c=2.546E-15
    I_C190 (ha13_0 VSS) capacitor c=3.240E-15
    I_C191 (rc2 VSS) capacitor c=2.592E-15
    I_C192 (sn3 VSS) capacitor c=2.190E-15
    I_C193 (ha25_1 VSS) capacitor c=4.284E-16
    I_C194 (XI77_I39_p1 VSS) capacitor c=5.189E-16
    I_C195 (XI77_I39_n1 VSS) capacitor c=5.786E-19
    I_C196 (XI77_I39_n2 VSS) capacitor c=9.213E-18
    I_C197 (XI77_I39_Bn VSS) capacitor c=1.050E-15
    I_C198 (XI77_I39_An VSS) capacitor c=9.117E-16
    I_C199 (XI77_I38_p1 VSS) capacitor c=5.181E-16
    I_C200 (XI77_I38_n1 VSS) capacitor c=5.786E-19
    I_C201 (XI77_I38_n2 VSS) capacitor c=9.278E-18
    I_C202 (XI77_I38_Bn VSS) capacitor c=1.059E-15
    I_C203 (XI77_I38_An VSS) capacitor c=9.122E-16
    I_C204 (XI77_I37_p1 VSS) capacitor c=5.126E-16
    I_C205 (XI77_I37_n1 VSS) capacitor c=5.786E-19
    I_C206 (XI77_I37_n2 VSS) capacitor c=9.267E-18
    I_C207 (XI77_I37_Bn VSS) capacitor c=1.057E-15
    I_C208 (XI77_I37_An VSS) capacitor c=9.084E-16
    I_C209 (XI77_I43_p1 VSS) capacitor c=5.664E-16
    I_C210 (XI77_I43_n1 VSS) capacitor c=6.078E-19
    I_C211 (XI77_I43_n2 VSS) capacitor c=9.849E-18
    I_C212 (XI77_I43_Bn VSS) capacitor c=1.105E-15
    I_C213 (XI77_I43_An VSS) capacitor c=9.362E-16
    I_C214 (XI77_I42_p1 VSS) capacitor c=5.339E-16
    I_C215 (XI77_I42_n2 VSS) capacitor c=7.258E-18
    I_C216 (XI77_I42_Bn VSS) capacitor c=1.070E-15
    I_C217 (XI77_I42_An VSS) capacitor c=9.283E-16
    I_C218 (XI77_I9_p1 VSS) capacitor c=5.347E-16
    I_C219 (XI77_I9_n1 VSS) capacitor c=4.706E-20
    I_C220 (XI77_I9_n2 VSS) capacitor c=8.620E-18
    I_C221 (XI77_I9_Bn VSS) capacitor c=1.080E-15
    I_C222 (XI77_I9_An VSS) capacitor c=9.184E-16
    I_C223 (XI77_I8_p1 VSS) capacitor c=5.425E-16
    I_C224 (XI77_I8_n2 VSS) capacitor c=8.048E-18
    I_C225 (XI77_I8_Bn VSS) capacitor c=1.090E-15
    I_C226 (XI77_I8_An VSS) capacitor c=9.081E-16
    I_C227 (XI77_I10_p1 VSS) capacitor c=5.261E-16
    I_C228 (XI77_I10_n1 VSS) capacitor c=2.583E-18
    I_C229 (XI77_I10_n2 VSS) capacitor c=7.934E-18
    I_C230 (XI77_I10_Bn VSS) capacitor c=1.022E-15
    I_C231 (XI77_I10_An VSS) capacitor c=8.979E-16
    I_C232 (XI77_I11_p1 VSS) capacitor c=5.306E-16
    I_C233 (XI77_I11_n1 VSS) capacitor c=1.105E-18
    I_C234 (XI77_I11_n2 VSS) capacitor c=1.084E-17
    I_C235 (XI77_I11_Bn VSS) capacitor c=1.059E-15
    I_C236 (XI77_I11_An VSS) capacitor c=9.100E-16
    I_C237 (XI77_I44_p1 VSS) capacitor c=5.556E-16
    I_C238 (XI77_I44_n2 VSS) capacitor c=8.320E-18
    I_C239 (XI77_I44_Bn VSS) capacitor c=1.050E-15
    I_C240 (XI77_I44_An VSS) capacitor c=9.605E-16
    I_C241 (XI77_I12_p1 VSS) capacitor c=5.727E-16
    I_C242 (XI77_I12_n1 VSS) capacitor c=4.723E-19
    I_C243 (XI77_I12_n2 VSS) capacitor c=1.064E-17
    I_C244 (XI77_I12_Bn VSS) capacitor c=1.065E-15
    I_C245 (XI77_I12_An VSS) capacitor c=9.167E-16
    I_C246 (XI77_I13_p1 VSS) capacitor c=5.394E-16
    I_C247 (XI77_I13_n1 VSS) capacitor c=4.457E-19
    I_C248 (XI77_I13_n2 VSS) capacitor c=9.311E-18
    I_C249 (XI77_I13_Bn VSS) capacitor c=1.043E-15
    I_C250 (XI77_I13_An VSS) capacitor c=8.970E-16
    I_C251 (XI77_I15_p1 VSS) capacitor c=5.600E-16
    I_C252 (XI77_I15_n1 VSS) capacitor c=3.273E-19
    I_C253 (XI77_I15_n2 VSS) capacitor c=7.649E-18
    I_C254 (XI77_I15_Bn VSS) capacitor c=1.053E-15
    I_C255 (XI77_I15_An VSS) capacitor c=9.162E-16
    I_C256 (XI77_I14_p1 VSS) capacitor c=5.516E-16
    I_C257 (XI77_I14_n1 VSS) capacitor c=9.159E-19
    I_C258 (XI77_I14_n2 VSS) capacitor c=7.889E-18
    I_C259 (XI77_I14_Bn VSS) capacitor c=1.062E-15
    I_C260 (XI77_I14_An VSS) capacitor c=9.244E-16
    I_C261 (XI59_xp1 VSS) capacitor c=5.207E-16
    I_C262 (XI59_xn2 VSS) capacitor c=8.134E-18
    I_C263 (XI59_xn1 VSS) capacitor c=4.423E-16
    I_C264 (XI59_con VSS) capacitor c=8.191E-16
    I_C265 (XI59_xbn VSS) capacitor c=1.474E-15
    I_C266 (XI59_xan VSS) capacitor c=9.920E-16
    I_C267 (XI62_xp1 VSS) capacitor c=5.235E-16
    I_C268 (XI62_an VSS) capacitor c=1.246E-19
    I_C269 (XI62_xn2 VSS) capacitor c=3.531E-18
    I_C270 (XI62_xn1 VSS) capacitor c=4.408E-16
    I_C271 (XI62_con VSS) capacitor c=8.402E-16
    I_C272 (XI62_xbn VSS) capacitor c=1.507E-15
    I_C273 (XI62_xan VSS) capacitor c=9.967E-16
    I_C274 (XI61_xp1 VSS) capacitor c=5.154E-16
    I_C275 (XI61_an VSS) capacitor c=8.953E-20
    I_C276 (XI61_xn2 VSS) capacitor c=3.336E-18
    I_C277 (XI61_xn1 VSS) capacitor c=4.271E-16
    I_C278 (XI61_con VSS) capacitor c=8.146E-16
    I_C279 (XI61_xbn VSS) capacitor c=1.490E-15
    I_C280 (XI61_xan VSS) capacitor c=1.005E-15
    I_C281 (XI60_xp1 VSS) capacitor c=5.236E-16
    I_C282 (XI60_xn2 VSS) capacitor c=3.880E-18
    I_C283 (XI60_xn1 VSS) capacitor c=4.232E-16
    I_C284 (XI60_con VSS) capacitor c=8.596E-16
    I_C285 (XI60_xbn VSS) capacitor c=1.536E-15
    I_C286 (XI60_xan VSS) capacitor c=9.912E-16
    I_C287 (XI58_xp1 VSS) capacitor c=5.212E-16
    I_C288 (XI58_xn2 VSS) capacitor c=3.167E-18
    I_C289 (XI58_xn1 VSS) capacitor c=4.523E-16
    I_C290 (XI58_con VSS) capacitor c=8.456E-16
    I_C291 (XI58_xbn VSS) capacitor c=1.484E-15
    I_C292 (XI58_xan VSS) capacitor c=1.031E-15
    I_C293 (XI73_xp1 VSS) capacitor c=5.209E-16
    I_C294 (XI73_an VSS) capacitor c=1.246E-19
    I_C295 (XI73_xn2 VSS) capacitor c=3.318E-18
    I_C296 (XI73_xn1 VSS) capacitor c=4.031E-16
    I_C297 (XI73_con VSS) capacitor c=8.253E-16
    I_C298 (XI73_xbn VSS) capacitor c=1.490E-15
    I_C299 (XI73_xan VSS) capacitor c=9.898E-16
    I_C300 (XI63_xp1 VSS) capacitor c=5.190E-16
    I_C301 (XI63_xn2 VSS) capacitor c=3.235E-18
    I_C302 (XI63_xn1 VSS) capacitor c=4.075E-16
    I_C303 (XI63_con VSS) capacitor c=8.262E-16
    I_C304 (XI63_xbn VSS) capacitor c=1.515E-15
    I_C305 (XI63_xan VSS) capacitor c=9.878E-16
    I_C306 (XI64_xp1 VSS) capacitor c=5.236E-16
    I_C307 (XI64_xn2 VSS) capacitor c=3.039E-18
    I_C308 (XI64_xn1 VSS) capacitor c=4.349E-16
    I_C309 (XI64_con VSS) capacitor c=8.389E-16
    I_C310 (XI64_xbn VSS) capacitor c=1.552E-15
    I_C311 (XI64_xan VSS) capacitor c=1.003E-15
    I_C312 (XI65_xp1 VSS) capacitor c=5.089E-16
    I_C313 (XI65_an VSS) capacitor c=1.928E-19
    I_C314 (XI65_xn2 VSS) capacitor c=3.653E-18
    I_C315 (XI65_xn1 VSS) capacitor c=4.343E-16
    I_C316 (XI65_con VSS) capacitor c=8.198E-16
    I_C317 (XI65_xbn VSS) capacitor c=1.527E-15
    I_C318 (XI65_xan VSS) capacitor c=9.978E-16
    I_C319 (XI45_xp1 VSS) capacitor c=5.164E-16
    I_C320 (XI45_an VSS) capacitor c=8.591E-20
    I_C321 (XI45_xn2 VSS) capacitor c=2.337E-18
    I_C322 (XI45_xn1 VSS) capacitor c=4.633E-16
    I_C323 (XI45_con VSS) capacitor c=8.121E-16
    I_C324 (XI45_xbn VSS) capacitor c=1.503E-15
    I_C325 (XI45_xan VSS) capacitor c=9.877E-16
    I_C326 (XI66_xp1 VSS) capacitor c=5.254E-16
    I_C327 (XI66_an VSS) capacitor c=9.188E-20
    I_C328 (XI66_xn2 VSS) capacitor c=3.664E-18
    I_C329 (XI66_xn1 VSS) capacitor c=4.335E-16
    I_C330 (XI66_con VSS) capacitor c=8.509E-16
    I_C331 (XI66_xbn VSS) capacitor c=1.463E-15
    I_C332 (XI66_xan VSS) capacitor c=9.926E-16
    I_C333 (XI67_xp1 VSS) capacitor c=5.299E-16
    I_C334 (XI67_xn2 VSS) capacitor c=6.939E-18
    I_C335 (XI67_xn1 VSS) capacitor c=4.285E-16
    I_C336 (XI67_con VSS) capacitor c=8.165E-16
    I_C337 (XI67_xbn VSS) capacitor c=1.539E-15
    I_C338 (XI67_xan VSS) capacitor c=1.004E-15
    I_C339 (XI71_xp1 VSS) capacitor c=5.066E-16
    I_C340 (XI71_an VSS) capacitor c=1.246E-19
    I_C341 (XI71_xn2 VSS) capacitor c=3.187E-18
    I_C342 (XI71_xn1 VSS) capacitor c=4.580E-16
    I_C343 (XI71_con VSS) capacitor c=8.615E-16
    I_C344 (XI71_xbn VSS) capacitor c=1.494E-15
    I_C345 (XI71_xan VSS) capacitor c=1.006E-15
    I_C346 (XI68_xp1 VSS) capacitor c=5.143E-16
    I_C347 (XI68_an VSS) capacitor c=1.246E-19
    I_C348 (XI68_xn2 VSS) capacitor c=3.217E-18
    I_C349 (XI68_xn1 VSS) capacitor c=4.361E-16
    I_C350 (XI68_con VSS) capacitor c=8.219E-16
    I_C351 (XI68_xbn VSS) capacitor c=1.413E-15
    I_C352 (XI68_xan VSS) capacitor c=9.835E-16
    I_C353 (XI70_xp1 VSS) capacitor c=5.159E-16
    I_C354 (XI70_an VSS) capacitor c=1.246E-19
    I_C355 (XI70_xn2 VSS) capacitor c=3.313E-18
    I_C356 (XI70_xn1 VSS) capacitor c=4.663E-16
    I_C357 (XI70_con VSS) capacitor c=8.326E-16
    I_C358 (XI70_xbn VSS) capacitor c=1.476E-15
    I_C359 (XI70_xan VSS) capacitor c=9.776E-16
    I_C360 (XI56_xp1 VSS) capacitor c=5.133E-16
    I_C361 (XI56_an VSS) capacitor c=8.849E-20
    I_C362 (XI56_xn2 VSS) capacitor c=2.338E-18
    I_C363 (XI56_xn1 VSS) capacitor c=4.522E-16
    I_C364 (XI56_con VSS) capacitor c=8.279E-16
    I_C365 (XI56_xbn VSS) capacitor c=1.478E-15
    I_C366 (XI56_xan VSS) capacitor c=1.006E-15
    I_C367 (XI69_xp1 VSS) capacitor c=5.101E-16
    I_C368 (XI69_xn2 VSS) capacitor c=7.443E-18
    I_C369 (XI69_xn1 VSS) capacitor c=4.055E-16
    I_C370 (XI69_con VSS) capacitor c=8.284E-16
    I_C371 (XI69_xbn VSS) capacitor c=1.458E-15
    I_C372 (XI69_xan VSS) capacitor c=9.896E-16
    I_C373 (XI77_I27_XG_p1 VSS) capacitor c=2.504E-16
    I_C374 (XI77_I27_XG_n1 VSS) capacitor c=1.482E-18
    I_C375 (XI77_I28_XG_p1 VSS) capacitor c=2.786E-16
    I_C376 (XI77_I28_XG_n1 VSS) capacitor c=2.627E-19
    I_C377 (XI77_I26_XG_p1 VSS) capacitor c=2.765E-16
    I_C378 (XI77_I26_XG_n1 VSS) capacitor c=2.860E-19
    I_C379 (XI77_I29_XG_p1 VSS) capacitor c=2.568E-16
    I_C380 (XI77_I29_XG_n1 VSS) capacitor c=5.808E-18
    I_C381 (XI77_I30_XG_p1 VSS) capacitor c=2.670E-16
    I_C382 (XI77_I30_XG_n1 VSS) capacitor c=1.085E-17
    I_C383 (XI77_I31_XG_p1 VSS) capacitor c=2.866E-16
    I_C384 (XI75_p1 VSS) capacitor c=6.610E-18
    I_C385 (XI75_p2 VSS) capacitor c=5.076E-16
    I_C386 (XI75_p3 VSS) capacitor c=3.905E-16
    I_C387 (XI75_p5 VSS) capacitor c=9.412E-16
    I_C388 (XI75_p4 VSS) capacitor c=3.171E-16
    I_C389 (XI75_n1 VSS) capacitor c=2.417E-18
    I_C390 (XI75_n2 VSS) capacitor c=4.213E-16
    I_C391 (XI75_n3 VSS) capacitor c=4.832E-16
    I_C392 (XI75_n5 VSS) capacitor c=9.972E-16
    I_C393 (XI75_n4 VSS) capacitor c=3.722E-16
    I_C394 (XI75_sn VSS) capacitor c=1.285E-15
    I_C395 (XI75_con VSS) capacitor c=1.977E-15
    I_C396 (XI74_p1 VSS) capacitor c=4.585E-18
    I_C397 (XI74_p2 VSS) capacitor c=4.980E-16
    I_C398 (XI74_p3 VSS) capacitor c=3.936E-16
    I_C399 (XI74_p5 VSS) capacitor c=8.759E-16
    I_C400 (XI74_p4 VSS) capacitor c=3.318E-16
    I_C401 (XI74_n1 VSS) capacitor c=2.459E-18
    I_C402 (XI74_n2 VSS) capacitor c=4.329E-16
    I_C403 (XI74_n3 VSS) capacitor c=5.024E-16
    I_C404 (XI74_n5 VSS) capacitor c=1.011E-15
    I_C405 (XI74_n4 VSS) capacitor c=3.827E-16
    I_C406 (XI74_sn VSS) capacitor c=1.287E-15
    I_C407 (XI74_con VSS) capacitor c=1.978E-15
    I_C408 (XI76_p1 VSS) capacitor c=4.052E-18
    I_C409 (XI76_p2 VSS) capacitor c=5.052E-16
    I_C410 (XI76_p3 VSS) capacitor c=3.965E-16
    I_C411 (XI76_p5 VSS) capacitor c=7.929E-16
    I_C412 (XI76_p4 VSS) capacitor c=3.470E-16
    I_C413 (XI76_n1 VSS) capacitor c=2.474E-18
    I_C414 (XI76_n2 VSS) capacitor c=4.622E-16
    I_C415 (XI76_n3 VSS) capacitor c=4.842E-16
    I_C416 (XI76_n5 VSS) capacitor c=9.703E-16
    I_C417 (XI76_n4 VSS) capacitor c=3.853E-16
    I_C418 (XI76_sn VSS) capacitor c=1.279E-15
    I_C419 (XI76_con VSS) capacitor c=1.977E-15
    I_C420 (XI47_p1 VSS) capacitor c=1.080E-17
    I_C421 (XI47_p2 VSS) capacitor c=4.938E-16
    I_C422 (XI47_p3 VSS) capacitor c=4.015E-16
    I_C423 (XI47_p5 VSS) capacitor c=8.627E-16
    I_C424 (XI47_p4 VSS) capacitor c=3.543E-16
    I_C425 (XI47_n1 VSS) capacitor c=2.438E-18
    I_C426 (XI47_n2 VSS) capacitor c=4.579E-16
    I_C427 (XI47_n3 VSS) capacitor c=4.983E-16
    I_C428 (XI47_n5 VSS) capacitor c=9.775E-16
    I_C429 (XI47_n4 VSS) capacitor c=3.788E-16
    I_C430 (XI47_sn VSS) capacitor c=1.263E-15
    I_C431 (XI47_con VSS) capacitor c=1.998E-15
    I_C432 (XI46_p1 VSS) capacitor c=1.138E-17
    I_C433 (XI46_p2 VSS) capacitor c=4.888E-16
    I_C434 (XI46_p3 VSS) capacitor c=3.830E-16
    I_C435 (XI46_p5 VSS) capacitor c=9.208E-16
    I_C436 (XI46_p4 VSS) capacitor c=3.266E-16
    I_C437 (XI46_n1 VSS) capacitor c=5.913E-18
    I_C438 (XI46_n2 VSS) capacitor c=4.629E-16
    I_C439 (XI46_n3 VSS) capacitor c=5.146E-16
    I_C440 (XI46_n5 VSS) capacitor c=9.947E-16
    I_C441 (XI46_n4 VSS) capacitor c=3.978E-16
    I_C442 (XI46_sn VSS) capacitor c=1.260E-15
    I_C443 (XI46_con VSS) capacitor c=1.972E-15
    I_C444 (XI57_p1 VSS) capacitor c=4.065E-18
    I_C445 (XI57_p2 VSS) capacitor c=4.882E-16
    I_C446 (XI57_p3 VSS) capacitor c=3.723E-16
    I_C447 (XI57_p5 VSS) capacitor c=7.923E-16
    I_C448 (XI57_p4 VSS) capacitor c=3.289E-16
    I_C449 (XI57_n1 VSS) capacitor c=2.401E-18
    I_C450 (XI57_n2 VSS) capacitor c=4.516E-16
    I_C451 (XI57_n3 VSS) capacitor c=5.174E-16
    I_C452 (XI57_n5 VSS) capacitor c=1.004E-15
    I_C453 (XI57_n4 VSS) capacitor c=3.948E-16
    I_C454 (XI57_sn VSS) capacitor c=1.287E-15
    I_C455 (XI57_con VSS) capacitor c=1.981E-15
    I_C456 (XI55_p1 VSS) capacitor c=4.396E-18
    I_C457 (XI55_p2 VSS) capacitor c=5.339E-16
    I_C458 (XI55_p3 VSS) capacitor c=3.981E-16
    I_C459 (XI55_p5 VSS) capacitor c=8.091E-16
    I_C460 (XI55_p4 VSS) capacitor c=3.394E-16
    I_C461 (XI55_n1 VSS) capacitor c=2.639E-18
    I_C462 (XI55_n2 VSS) capacitor c=4.451E-16
    I_C463 (XI55_n3 VSS) capacitor c=4.934E-16
    I_C464 (XI55_n5 VSS) capacitor c=9.811E-16
    I_C465 (XI55_n4 VSS) capacitor c=3.796E-16
    I_C466 (XI55_sn VSS) capacitor c=1.274E-15
    I_C467 (XI55_con VSS) capacitor c=1.956E-15
    I_C468 (XI44_p1 VSS) capacitor c=4.884E-18
    I_C469 (XI44_p2 VSS) capacitor c=5.087E-16
    I_C470 (XI44_p3 VSS) capacitor c=4.127E-16
    I_C471 (XI44_p5 VSS) capacitor c=1.060E-15
    I_C472 (XI44_p4 VSS) capacitor c=3.369E-16
    I_C473 (XI44_n1 VSS) capacitor c=1.746E-18
    I_C474 (XI44_n2 VSS) capacitor c=4.638E-16
    I_C475 (XI44_n3 VSS) capacitor c=5.172E-16
    I_C476 (XI44_n5 VSS) capacitor c=9.759E-16
    I_C477 (XI44_n4 VSS) capacitor c=4.095E-16
    I_C478 (XI44_sn VSS) capacitor c=1.307E-15
    I_C479 (XI44_con VSS) capacitor c=1.991E-15
    I_C480 (XI72_p1 VSS) capacitor c=1.033E-17
    I_C481 (XI72_p2 VSS) capacitor c=4.859E-16
    I_C482 (XI72_p3 VSS) capacitor c=3.899E-16
    I_C483 (XI72_p5 VSS) capacitor c=8.124E-16
    I_C484 (XI72_p4 VSS) capacitor c=3.393E-16
    I_C485 (XI72_n1 VSS) capacitor c=5.088E-18
    I_C486 (XI72_n2 VSS) capacitor c=4.904E-16
    I_C487 (XI72_n3 VSS) capacitor c=5.056E-16
    I_C488 (XI72_n5 VSS) capacitor c=9.819E-16
    I_C489 (XI72_n4 VSS) capacitor c=4.131E-16
    I_C490 (XI72_sn VSS) capacitor c=1.253E-15
    I_C491 (XI72_con VSS) capacitor c=1.971E-15
    I_C492 (XI77_I34_XG_p1 VSS) capacitor c=4.729E-19
    I_C493 (XI77_I34_XG_n1 VSS) capacitor c=3.274E-16
    I_C494 (XI77_I32_XG_p1 VSS) capacitor c=8.184E-18
    I_C495 (XI77_I32_XG_n1 VSS) capacitor c=3.038E-16
    I_C496 (XI77_I20_XG_p1 VSS) capacitor c=8.222E-18
    I_C497 (XI77_I20_XG_n1 VSS) capacitor c=3.178E-16
    I_C498 (XI77_I19_XG_p1 VSS) capacitor c=4.045E-18
    I_C499 (XI77_I19_XG_n1 VSS) capacitor c=2.910E-16
    I_C500 (XI77_I17_XG_n1 VSS) capacitor c=2.749E-16
    I_C501 (XI77_I35_XG_p1 VSS) capacitor c=8.462E-18
    I_C502 (XI77_I35_XG_n1 VSS) capacitor c=3.096E-16
    I_C503 (XI77_I21_XG_p1 VSS) capacitor c=1.890E-18
    I_C504 (XI77_I21_XG_n1 VSS) capacitor c=2.742E-16
    I_C505 (XI77_I22_XG_p1 VSS) capacitor c=3.570E-18
    I_C506 (XI77_I22_XG_n1 VSS) capacitor c=2.651E-16
    I_C507 (XI77_I36_XG_p1 VSS) capacitor c=2.190E-18
    I_C508 (XI77_I36_XG_n1 VSS) capacitor c=3.049E-16
    I_C509 (XI77_I23_XG_p1 VSS) capacitor c=1.974E-18
    I_C510 (XI77_I23_XG_n1 VSS) capacitor c=3.041E-16
    I_C511 (XI77_I25_XG_n1 VSS) capacitor c=3.147E-16
    I_C512 (XI77_I24_XG_p1 VSS) capacitor c=1.490E-17
    I_C513 (XI77_I24_XG_n1 VSS) capacitor c=3.134E-16
    I_C514 (XI26_p1 VSS) capacitor c=3.275E-16
    I_C515 (XI26_xp1 VSS) capacitor c=3.356E-16
    I_C516 (XI26_n2 VSS) capacitor c=5.945E-18
    I_C517 (XI26_n1 VSS) capacitor c=5.834E-16
    I_C518 (XI26_xn2 VSS) capacitor c=2.990E-18
    I_C519 (XI26_xn1 VSS) capacitor c=5.026E-16
    I_C520 (XI26_xn VSS) capacitor c=1.745E-15
    I_C521 (XI26_xan VSS) capacitor c=1.414E-15
    I_C522 (XI26_xbn VSS) capacitor c=6.700E-16
    I_C523 (XI15_p1 VSS) capacitor c=3.472E-16
    I_C524 (XI15_xp1 VSS) capacitor c=3.375E-16
    I_C525 (XI15_n2 VSS) capacitor c=4.909E-18
    I_C526 (XI15_n1 VSS) capacitor c=5.964E-16
    I_C527 (XI15_xn2 VSS) capacitor c=3.325E-18
    I_C528 (XI15_xn1 VSS) capacitor c=5.011E-16
    I_C529 (XI15_xn VSS) capacitor c=1.719E-15
    I_C530 (XI15_xan VSS) capacitor c=1.424E-15
    I_C531 (XI15_xbn VSS) capacitor c=6.748E-16
    I_C532 (XI23_p1 VSS) capacitor c=3.442E-16
    I_C533 (XI23_xp1 VSS) capacitor c=3.150E-16
    I_C534 (XI23_n2 VSS) capacitor c=5.298E-18
    I_C535 (XI23_n1 VSS) capacitor c=5.880E-16
    I_C536 (XI23_xn2 VSS) capacitor c=3.398E-18
    I_C537 (XI23_xn1 VSS) capacitor c=5.052E-16
    I_C538 (XI23_xn VSS) capacitor c=1.744E-15
    I_C539 (XI23_xan VSS) capacitor c=1.441E-15
    I_C540 (XI23_xbn VSS) capacitor c=6.126E-16
    I_C541 (XI14_p1 VSS) capacitor c=3.365E-16
    I_C542 (XI14_xp1 VSS) capacitor c=3.428E-16
    I_C543 (XI14_n2 VSS) capacitor c=6.173E-18
    I_C544 (XI14_n1 VSS) capacitor c=5.910E-16
    I_C545 (XI14_xn2 VSS) capacitor c=3.616E-18
    I_C546 (XI14_xn1 VSS) capacitor c=4.958E-16
    I_C547 (XI14_xn VSS) capacitor c=1.758E-15
    I_C548 (XI14_xan VSS) capacitor c=1.417E-15
    I_C549 (XI14_xbn VSS) capacitor c=5.843E-16
    I_C550 (XI28_p1 VSS) capacitor c=3.119E-16
    I_C551 (XI28_xp1 VSS) capacitor c=3.199E-16
    I_C552 (XI28_n2 VSS) capacitor c=5.268E-18
    I_C553 (XI28_n1 VSS) capacitor c=5.908E-16
    I_C554 (XI28_xn2 VSS) capacitor c=3.493E-18
    I_C555 (XI28_xn1 VSS) capacitor c=5.156E-16
    I_C556 (XI28_xn VSS) capacitor c=1.687E-15
    I_C557 (XI28_xan VSS) capacitor c=1.369E-15
    I_C558 (XI28_xbn VSS) capacitor c=6.397E-16
    I_C559 (XI27_p1 VSS) capacitor c=3.040E-16
    I_C560 (XI27_xp1 VSS) capacitor c=3.252E-16
    I_C561 (XI27_n2 VSS) capacitor c=5.995E-18
    I_C562 (XI27_n1 VSS) capacitor c=6.143E-16
    I_C563 (XI27_xn2 VSS) capacitor c=2.337E-18
    I_C564 (XI27_xn1 VSS) capacitor c=5.422E-16
    I_C565 (XI27_xn VSS) capacitor c=1.724E-15
    I_C566 (XI27_xan VSS) capacitor c=1.538E-15
    I_C567 (XI27_xbn VSS) capacitor c=6.449E-16
    I_C568 (XI19_p1 VSS) capacitor c=3.338E-16
    I_C569 (XI19_xp1 VSS) capacitor c=3.159E-16
    I_C570 (XI19_n2 VSS) capacitor c=5.737E-18
    I_C571 (XI19_n1 VSS) capacitor c=6.105E-16
    I_C572 (XI19_xn2 VSS) capacitor c=2.313E-18
    I_C573 (XI19_xn1 VSS) capacitor c=5.522E-16
    I_C574 (XI19_xn VSS) capacitor c=1.783E-15
    I_C575 (XI19_xan VSS) capacitor c=1.498E-15
    I_C576 (XI19_xbn VSS) capacitor c=6.771E-16
    I_C577 (XI18_p1 VSS) capacitor c=3.109E-16
    I_C578 (XI18_xp1 VSS) capacitor c=3.378E-16
    I_C579 (XI18_n2 VSS) capacitor c=5.502E-18
    I_C580 (XI18_n1 VSS) capacitor c=6.021E-16
    I_C581 (XI18_xn2 VSS) capacitor c=2.523E-18
    I_C582 (XI18_xn1 VSS) capacitor c=5.388E-16
    I_C583 (XI18_xn VSS) capacitor c=1.764E-15
    I_C584 (XI18_xan VSS) capacitor c=1.432E-15
    I_C585 (XI18_xbn VSS) capacitor c=6.912E-16
    I_C586 (XI17_p1 VSS) capacitor c=3.316E-16
    I_C587 (XI17_xp1 VSS) capacitor c=3.273E-16
    I_C588 (XI17_n2 VSS) capacitor c=6.093E-18
    I_C589 (XI17_n1 VSS) capacitor c=6.156E-16
    I_C590 (XI17_xn2 VSS) capacitor c=5.346E-18
    I_C591 (XI17_xn1 VSS) capacitor c=5.344E-16
    I_C592 (XI17_xn VSS) capacitor c=1.706E-15
    I_C593 (XI17_xan VSS) capacitor c=1.643E-15
    I_C594 (XI17_xbn VSS) capacitor c=6.419E-16
    I_C595 (XI24_p1 VSS) capacitor c=3.349E-16
    I_C596 (XI24_xp1 VSS) capacitor c=3.520E-16
    I_C597 (XI24_n2 VSS) capacitor c=5.489E-18
    I_C598 (XI24_n1 VSS) capacitor c=5.994E-16
    I_C599 (XI24_xn2 VSS) capacitor c=3.508E-18
    I_C600 (XI24_xn1 VSS) capacitor c=5.203E-16
    I_C601 (XI24_xn VSS) capacitor c=1.724E-15
    I_C602 (XI24_xan VSS) capacitor c=1.391E-15
    I_C603 (XI24_xbn VSS) capacitor c=6.530E-16
    I_C604 (XI30_p1 VSS) capacitor c=3.040E-16
    I_C605 (XI30_xp1 VSS) capacitor c=3.317E-16
    I_C606 (XI30_n2 VSS) capacitor c=4.911E-18
    I_C607 (XI30_n1 VSS) capacitor c=6.023E-16
    I_C608 (XI30_xn2 VSS) capacitor c=3.187E-18
    I_C609 (XI30_xn1 VSS) capacitor c=5.525E-16
    I_C610 (XI30_xn VSS) capacitor c=1.732E-15
    I_C611 (XI30_xan VSS) capacitor c=1.431E-15
    I_C612 (XI30_xbn VSS) capacitor c=6.923E-16
    I_C613 (XI29_p1 VSS) capacitor c=3.091E-16
    I_C614 (XI29_xp1 VSS) capacitor c=3.172E-16
    I_C615 (XI29_n2 VSS) capacitor c=5.429E-18
    I_C616 (XI29_n1 VSS) capacitor c=5.805E-16
    I_C617 (XI29_xn2 VSS) capacitor c=3.428E-18
    I_C618 (XI29_xn1 VSS) capacitor c=5.037E-16
    I_C619 (XI29_xn VSS) capacitor c=1.681E-15
    I_C620 (XI29_xan VSS) capacitor c=1.471E-15
    I_C621 (XI29_xbn VSS) capacitor c=6.126E-16
    I_C622 (XI20_p1 VSS) capacitor c=3.316E-16
    I_C623 (XI20_xp1 VSS) capacitor c=3.124E-16
    I_C624 (XI20_n2 VSS) capacitor c=5.485E-18
    I_C625 (XI20_n1 VSS) capacitor c=5.702E-16
    I_C626 (XI20_xn2 VSS) capacitor c=2.432E-18
    I_C627 (XI20_xn1 VSS) capacitor c=5.364E-16
    I_C628 (XI20_xn VSS) capacitor c=1.661E-15
    I_C629 (XI20_xan VSS) capacitor c=1.415E-15
    I_C630 (XI20_xbn VSS) capacitor c=6.528E-16
    I_C631 (XI8_p1 VSS) capacitor c=3.558E-16
    I_C632 (XI8_xp1 VSS) capacitor c=3.221E-16
    I_C633 (XI8_n2 VSS) capacitor c=7.242E-18
    I_C634 (XI8_n1 VSS) capacitor c=6.076E-16
    I_C635 (XI8_xn2 VSS) capacitor c=2.889E-18
    I_C636 (XI8_xn1 VSS) capacitor c=5.180E-16
    I_C637 (XI8_xn VSS) capacitor c=1.725E-15
    I_C638 (XI8_xan VSS) capacitor c=1.482E-15
    I_C639 (XI8_xbn VSS) capacitor c=6.414E-16
    I_C640 (XI5_p1 VSS) capacitor c=3.181E-16
    I_C641 (XI5_xp1 VSS) capacitor c=3.301E-16
    I_C642 (XI5_n2 VSS) capacitor c=6.049E-18
    I_C643 (XI5_n1 VSS) capacitor c=6.082E-16
    I_C644 (XI5_xn2 VSS) capacitor c=2.376E-18
    I_C645 (XI5_xn1 VSS) capacitor c=5.375E-16
    I_C646 (XI5_xn VSS) capacitor c=1.718E-15
    I_C647 (XI5_xan VSS) capacitor c=1.471E-15
    I_C648 (XI5_xbn VSS) capacitor c=6.761E-16
    I_C649 (XI13_p1 VSS) capacitor c=3.043E-16
    I_C650 (XI13_xp1 VSS) capacitor c=3.308E-16
    I_C651 (XI13_n2 VSS) capacitor c=5.811E-18
    I_C652 (XI13_n1 VSS) capacitor c=5.827E-16
    I_C653 (XI13_xn2 VSS) capacitor c=3.315E-18
    I_C654 (XI13_xn1 VSS) capacitor c=5.101E-16
    I_C655 (XI13_xn VSS) capacitor c=1.709E-15
    I_C656 (XI13_xan VSS) capacitor c=1.485E-15
    I_C657 (XI13_xbn VSS) capacitor c=6.619E-16
    I_C658 (XI38_p1 VSS) capacitor c=3.441E-16
    I_C659 (XI38_xp1 VSS) capacitor c=3.199E-16
    I_C660 (XI38_n2 VSS) capacitor c=5.072E-18
    I_C661 (XI38_n1 VSS) capacitor c=5.812E-16
    I_C662 (XI38_xn2 VSS) capacitor c=3.167E-18
    I_C663 (XI38_xn1 VSS) capacitor c=5.045E-16
    I_C664 (XI38_xn VSS) capacitor c=1.673E-15
    I_C665 (XI38_xan VSS) capacitor c=1.318E-15
    I_C666 (XI38_xbn VSS) capacitor c=6.040E-16
    I_C667 (XI37_p1 VSS) capacitor c=3.640E-16
    I_C668 (XI37_xp1 VSS) capacitor c=3.476E-16
    I_C669 (XI37_n2 VSS) capacitor c=5.765E-18
    I_C670 (XI37_n1 VSS) capacitor c=5.937E-16
    I_C671 (XI37_xn2 VSS) capacitor c=3.419E-18
    I_C672 (XI37_xn1 VSS) capacitor c=5.003E-16
    I_C673 (XI37_xn VSS) capacitor c=1.723E-15
    I_C674 (XI37_xan VSS) capacitor c=1.339E-15
    I_C675 (XI37_xbn VSS) capacitor c=6.358E-16
    I_C676 (XI25_p1 VSS) capacitor c=2.925E-16
    I_C677 (XI25_xp1 VSS) capacitor c=3.228E-16
    I_C678 (XI25_n2 VSS) capacitor c=9.395E-18
    I_C679 (XI25_n1 VSS) capacitor c=6.046E-16
    I_C680 (XI25_xn2 VSS) capacitor c=3.284E-18
    I_C681 (XI25_xn1 VSS) capacitor c=5.150E-16
    I_C682 (XI25_xn VSS) capacitor c=1.694E-15
    I_C683 (XI25_xan VSS) capacitor c=1.374E-15
    I_C684 (XI25_xbn VSS) capacitor c=6.366E-16
    I_C685 (XI16_p1 VSS) capacitor c=3.120E-16
    I_C686 (XI16_xp1 VSS) capacitor c=3.398E-16
    I_C687 (XI16_n2 VSS) capacitor c=7.578E-18
    I_C688 (XI16_n1 VSS) capacitor c=5.914E-16
    I_C689 (XI16_xn2 VSS) capacitor c=3.007E-18
    I_C690 (XI16_xn1 VSS) capacitor c=5.255E-16
    I_C691 (XI16_xn VSS) capacitor c=1.743E-15
    I_C692 (XI16_xan VSS) capacitor c=1.378E-15
    I_C693 (XI16_xbn VSS) capacitor c=6.700E-16
    I_C694 (XI6_p1 VSS) capacitor c=3.300E-16
    I_C695 (XI6_xp1 VSS) capacitor c=3.300E-16
    I_C696 (XI6_n2 VSS) capacitor c=7.541E-18
    I_C697 (XI6_n1 VSS) capacitor c=5.782E-16
    I_C698 (XI6_xn2 VSS) capacitor c=2.659E-18
    I_C699 (XI6_xn1 VSS) capacitor c=5.042E-16
    I_C700 (XI6_xn VSS) capacitor c=1.683E-15
    I_C701 (XI6_xan VSS) capacitor c=1.424E-15
    I_C702 (XI6_xbn VSS) capacitor c=6.406E-16
    I_C703 (XI4_p1 VSS) capacitor c=3.239E-16
    I_C704 (XI4_xp1 VSS) capacitor c=3.235E-16
    I_C705 (XI4_n2 VSS) capacitor c=7.106E-18
    I_C706 (XI4_n1 VSS) capacitor c=5.854E-16
    I_C707 (XI4_xn2 VSS) capacitor c=3.181E-18
    I_C708 (XI4_xn1 VSS) capacitor c=5.183E-16
    I_C709 (XI4_xn VSS) capacitor c=1.728E-15
    I_C710 (XI4_xan VSS) capacitor c=1.406E-15
    I_C711 (XI4_xbn VSS) capacitor c=6.653E-16
    I_C712 (XI12_p1 VSS) capacitor c=3.551E-16
    I_C713 (XI12_xp1 VSS) capacitor c=3.354E-16
    I_C714 (XI12_n2 VSS) capacitor c=7.486E-18
    I_C715 (XI12_n1 VSS) capacitor c=6.052E-16
    I_C716 (XI12_xn2 VSS) capacitor c=3.545E-18
    I_C717 (XI12_xn1 VSS) capacitor c=5.250E-16
    I_C718 (XI12_xn VSS) capacitor c=1.776E-15
    I_C719 (XI12_xan VSS) capacitor c=1.418E-15
    I_C720 (XI12_xbn VSS) capacitor c=6.317E-16
    I_C721 (XI39_p1 VSS) capacitor c=3.314E-16
    I_C722 (XI39_xp1 VSS) capacitor c=3.065E-16
    I_C723 (XI39_n2 VSS) capacitor c=5.171E-18
    I_C724 (XI39_n1 VSS) capacitor c=5.901E-16
    I_C725 (XI39_xn2 VSS) capacitor c=3.440E-18
    I_C726 (XI39_xn1 VSS) capacitor c=5.151E-16
    I_C727 (XI39_xn VSS) capacitor c=1.718E-15
    I_C728 (XI39_xan VSS) capacitor c=1.398E-15
    I_C729 (XI39_xbn VSS) capacitor c=6.073E-16
    I_C730 (XI31_p1 VSS) capacitor c=3.147E-16
    I_C731 (XI31_xp1 VSS) capacitor c=2.999E-16
    I_C732 (XI31_n2 VSS) capacitor c=5.387E-18
    I_C733 (XI31_n1 VSS) capacitor c=5.807E-16
    I_C734 (XI31_xn2 VSS) capacitor c=3.193E-18
    I_C735 (XI31_xn1 VSS) capacitor c=5.269E-16
    I_C736 (XI31_xn VSS) capacitor c=1.717E-15
    I_C737 (XI31_xan VSS) capacitor c=1.386E-15
    I_C738 (XI31_xbn VSS) capacitor c=6.345E-16
    I_C739 (XI35_p1 VSS) capacitor c=3.118E-16
    I_C740 (XI35_xp1 VSS) capacitor c=3.323E-16
    I_C741 (XI35_n2 VSS) capacitor c=5.157E-18
    I_C742 (XI35_n1 VSS) capacitor c=6.066E-16
    I_C743 (XI35_xn2 VSS) capacitor c=3.251E-18
    I_C744 (XI35_xn1 VSS) capacitor c=5.409E-16
    I_C745 (XI35_xn VSS) capacitor c=1.706E-15
    I_C746 (XI35_xan VSS) capacitor c=1.427E-15
    I_C747 (XI35_xbn VSS) capacitor c=6.571E-16
    I_C748 (XI36_p1 VSS) capacitor c=3.308E-16
    I_C749 (XI36_xp1 VSS) capacitor c=3.340E-16
    I_C750 (XI36_n2 VSS) capacitor c=5.749E-18
    I_C751 (XI36_n1 VSS) capacitor c=5.824E-16
    I_C752 (XI36_xn2 VSS) capacitor c=3.351E-18
    I_C753 (XI36_xn1 VSS) capacitor c=5.093E-16
    I_C754 (XI36_xn VSS) capacitor c=1.707E-15
    I_C755 (XI36_xan VSS) capacitor c=1.392E-15
    I_C756 (XI36_xbn VSS) capacitor c=6.593E-16
    I_C757 (XI9_p1 VSS) capacitor c=3.433E-16
    I_C758 (XI9_xp1 VSS) capacitor c=3.319E-16
    I_C759 (XI9_n2 VSS) capacitor c=5.747E-18
    I_C760 (XI9_n1 VSS) capacitor c=6.049E-16
    I_C761 (XI9_xn2 VSS) capacitor c=2.229E-18
    I_C762 (XI9_xn1 VSS) capacitor c=5.293E-16
    I_C763 (XI9_xn VSS) capacitor c=1.691E-15
    I_C764 (XI9_xan VSS) capacitor c=1.387E-15
    I_C765 (XI9_xbn VSS) capacitor c=6.666E-16
    I_C766 (XI7_p1 VSS) capacitor c=3.390E-16
    I_C767 (XI7_xp1 VSS) capacitor c=3.213E-16
    I_C768 (XI7_n2 VSS) capacitor c=6.156E-18
    I_C769 (XI7_n1 VSS) capacitor c=5.916E-16
    I_C770 (XI7_xn2 VSS) capacitor c=3.001E-18
    I_C771 (XI7_xn1 VSS) capacitor c=5.077E-16
    I_C772 (XI7_xn VSS) capacitor c=1.734E-15
    I_C773 (XI7_xan VSS) capacitor c=1.417E-15
    I_C774 (XI7_xbn VSS) capacitor c=6.227E-16
    I_C775 (XI3_p1 VSS) capacitor c=2.877E-16
    I_C776 (XI3_xp1 VSS) capacitor c=3.348E-16
    I_C777 (XI3_n2 VSS) capacitor c=7.391E-18
    I_C778 (XI3_n1 VSS) capacitor c=5.919E-16
    I_C779 (XI3_xn2 VSS) capacitor c=5.328E-18
    I_C780 (XI3_xn1 VSS) capacitor c=5.379E-16
    I_C781 (XI3_xn VSS) capacitor c=1.725E-15
    I_C782 (XI3_xan VSS) capacitor c=1.479E-15
    I_C783 (XI3_xbn VSS) capacitor c=6.379E-16
    I_C784 (XI41_p1 VSS) capacitor c=3.335E-16
    I_C785 (XI41_xp1 VSS) capacitor c=2.963E-16
    I_C786 (XI41_n2 VSS) capacitor c=7.419E-18
    I_C787 (XI41_n1 VSS) capacitor c=5.803E-16
    I_C788 (XI41_xn2 VSS) capacitor c=3.577E-18
    I_C789 (XI41_xn1 VSS) capacitor c=5.113E-16
    I_C790 (XI41_xn VSS) capacitor c=1.680E-15
    I_C791 (XI41_xan VSS) capacitor c=1.345E-15
    I_C792 (XI41_xbn VSS) capacitor c=6.375E-16
    I_C793 (XI40_p1 VSS) capacitor c=3.357E-16
    I_C794 (XI40_xp1 VSS) capacitor c=3.203E-16
    I_C795 (XI40_n2 VSS) capacitor c=7.222E-18
    I_C796 (XI40_n1 VSS) capacitor c=5.807E-16
    I_C797 (XI40_xn2 VSS) capacitor c=4.659E-18
    I_C798 (XI40_xn1 VSS) capacitor c=5.189E-16
    I_C799 (XI40_xn VSS) capacitor c=1.662E-15
    I_C800 (XI40_xan VSS) capacitor c=1.452E-15
    I_C801 (XI40_xbn VSS) capacitor c=6.541E-16
    I_C802 (XI34_p1 VSS) capacitor c=2.909E-16
    I_C803 (XI34_xp1 VSS) capacitor c=3.269E-16
    I_C804 (XI34_n2 VSS) capacitor c=6.605E-18
    I_C805 (XI34_n1 VSS) capacitor c=5.811E-16
    I_C806 (XI34_xn2 VSS) capacitor c=3.608E-18
    I_C807 (XI34_xn1 VSS) capacitor c=5.017E-16
    I_C808 (XI34_xn VSS) capacitor c=1.748E-15
    I_C809 (XI34_xan VSS) capacitor c=1.416E-15
    I_C810 (XI34_xbn VSS) capacitor c=6.320E-16
    I_C811 (XI2_p1 VSS) capacitor c=2.934E-16
    I_C812 (XI2_xp1 VSS) capacitor c=3.058E-16
    I_C813 (XI2_n2 VSS) capacitor c=5.207E-18
    I_C814 (XI2_n1 VSS) capacitor c=5.839E-16
    I_C815 (XI2_xn2 VSS) capacitor c=3.216E-18
    I_C816 (XI2_xn1 VSS) capacitor c=5.113E-16
    I_C817 (XI2_xn VSS) capacitor c=1.667E-15
    I_C818 (XI2_xan VSS) capacitor c=1.389E-15
    I_C819 (XI2_xbn VSS) capacitor c=6.547E-16
    I_C820 (XI1_p1 VSS) capacitor c=2.985E-16
    I_C821 (XI1_xp1 VSS) capacitor c=3.341E-16
    I_C822 (XI1_n2 VSS) capacitor c=5.558E-18
    I_C823 (XI1_n1 VSS) capacitor c=5.908E-16
    I_C824 (XI1_xn2 VSS) capacitor c=7.139E-18
    I_C825 (XI1_xn1 VSS) capacitor c=5.194E-16
    I_C826 (XI1_xn VSS) capacitor c=1.759E-15
    I_C827 (XI1_xan VSS) capacitor c=1.427E-15
    I_C828 (XI1_xbn VSS) capacitor c=6.621E-16
    I_C829 (XI42_p1 VSS) capacitor c=3.254E-16
    I_C830 (XI42_xp1 VSS) capacitor c=2.990E-16
    I_C831 (XI42_n2 VSS) capacitor c=5.836E-18
    I_C832 (XI42_n1 VSS) capacitor c=6.226E-16
    I_C833 (XI42_xn2 VSS) capacitor c=2.438E-18
    I_C834 (XI42_xn1 VSS) capacitor c=5.249E-16
    I_C835 (XI42_xn VSS) capacitor c=1.702E-15
    I_C836 (XI42_xan VSS) capacitor c=1.313E-15
    I_C837 (XI42_xbn VSS) capacitor c=6.090E-16
    I_C838 (XI77_I29_XP_n1 VSS) capacitor c=3.086E-19
    I_C839 (XI77_I28_XP_n1 VSS) capacitor c=3.183E-18
    I_C840 (XI77_I1_n1 VSS) capacitor c=2.040E-18
    I_C841 (XI77_I0_n1 VSS) capacitor c=1.986E-19
    I_C842 (XI77_I30_XP_n1 VSS) capacitor c=5.957E-18
    I_C843 (XI77_I2_n1 VSS) capacitor c=6.242E-18
    I_C844 (XI77_I31_XP_n1 VSS) capacitor c=2.992E-18
    I_C845 (XI77_I3_n1 VSS) capacitor c=2.914E-18
    I_C846 (XI77_I4_n1 VSS) capacitor c=4.566E-18
    I_C847 (XI77_I7_n1 VSS) capacitor c=5.245E-18
    I_C848 (XI77_I6_n1 VSS) capacitor c=1.966E-18
    I_C849 (XI77_I21_XP_p1 VSS) capacitor c=4.521E-18
    I_C850 (XI77_I20_XP_p1 VSS) capacitor c=8.617E-18
    I_C851 (XI77_I24_XP_p1 VSS) capacitor c=4.854E-18
    I_C852 (XI77_I22_XP_p1 VSS) capacitor c=7.840E-18
    I_C853 (XI77_I23_XP_p1 VSS) capacitor c=3.293E-18
    I_C854 (XI77_I25_XP_p1 VSS) capacitor c=1.001E-18
    I_C855 (XI50_bp5 VSS) capacitor c=3.962E-16
    I_C856 (XI50_bp4 VSS) capacitor c=8.283E-16
    I_C857 (XI50_bp3 VSS) capacitor c=6.079E-16
    I_C858 (XI50_bp2 VSS) capacitor c=3.326E-16
    I_C859 (XI50_bp1 VSS) capacitor c=2.218E-18
    I_C860 (XI50_ap4 VSS) capacitor c=5.155E-16
    I_C861 (XI50_ap5 VSS) capacitor c=6.957E-16
    I_C862 (XI50_ap3 VSS) capacitor c=7.721E-16
    I_C863 (XI50_ap1 VSS) capacitor c=1.019E-17
    I_C864 (XI50_ap2 VSS) capacitor c=6.769E-16
    I_C865 (XI50_bn5 VSS) capacitor c=4.425E-16
    I_C866 (XI50_bn3 VSS) capacitor c=4.467E-16
    I_C867 (XI50_bn4 VSS) capacitor c=7.532E-16
    I_C868 (XI50_bn2 VSS) capacitor c=4.302E-16
    I_C869 (XI50_bn1 VSS) capacitor c=4.093E-20
    I_C870 (XI50_an5 VSS) capacitor c=7.021E-16
    I_C871 (XI50_an4 VSS) capacitor c=7.390E-16
    I_C872 (XI50_an3 VSS) capacitor c=6.841E-16
    I_C873 (XI50_an1 VSS) capacitor c=5.047E-18
    I_C874 (XI50_an2 VSS) capacitor c=4.221E-16
    I_C875 (XI50_bsn VSS) capacitor c=1.312E-15
    I_C876 (XI50_bcon VSS) capacitor c=2.198E-15
    I_C877 (XI50_s1 VSS) capacitor c=2.626E-15
    I_C878 (XI50_asn VSS) capacitor c=1.538E-15
    I_C879 (XI50_acon VSS) capacitor c=2.305E-15
    I_C880 (XI51_bp5 VSS) capacitor c=3.965E-16
    I_C881 (XI51_bp4 VSS) capacitor c=8.339E-16
    I_C882 (XI51_bp3 VSS) capacitor c=6.211E-16
    I_C883 (XI51_bp2 VSS) capacitor c=3.267E-16
    I_C884 (XI51_bp1 VSS) capacitor c=3.451E-18
    I_C885 (XI51_ap4 VSS) capacitor c=5.348E-16
    I_C886 (XI51_ap5 VSS) capacitor c=7.441E-16
    I_C887 (XI51_ap3 VSS) capacitor c=7.735E-16
    I_C888 (XI51_ap1 VSS) capacitor c=1.310E-17
    I_C889 (XI51_ap2 VSS) capacitor c=6.591E-16
    I_C890 (XI51_bn5 VSS) capacitor c=4.443E-16
    I_C891 (XI51_bn3 VSS) capacitor c=4.357E-16
    I_C892 (XI51_bn4 VSS) capacitor c=7.791E-16
    I_C893 (XI51_bn2 VSS) capacitor c=4.185E-16
    I_C894 (XI51_an5 VSS) capacitor c=6.828E-16
    I_C895 (XI51_an4 VSS) capacitor c=7.573E-16
    I_C896 (XI51_an3 VSS) capacitor c=6.857E-16
    I_C897 (XI51_an1 VSS) capacitor c=5.047E-18
    I_C898 (XI51_an2 VSS) capacitor c=4.183E-16
    I_C899 (XI51_bsn VSS) capacitor c=1.355E-15
    I_C900 (XI51_bcon VSS) capacitor c=2.157E-15
    I_C901 (XI51_s1 VSS) capacitor c=2.646E-15
    I_C902 (XI51_asn VSS) capacitor c=1.626E-15
    I_C903 (XI51_acon VSS) capacitor c=2.269E-15
    I_C904 (XI49_bp5 VSS) capacitor c=4.076E-16
    I_C905 (XI49_bp4 VSS) capacitor c=8.388E-16
    I_C906 (XI49_bp3 VSS) capacitor c=5.947E-16
    I_C907 (XI49_bp2 VSS) capacitor c=3.548E-16
    I_C908 (XI49_bp1 VSS) capacitor c=3.505E-18
    I_C909 (XI49_ap4 VSS) capacitor c=5.269E-16
    I_C910 (XI49_ap5 VSS) capacitor c=7.357E-16
    I_C911 (XI49_ap3 VSS) capacitor c=7.684E-16
    I_C912 (XI49_ap1 VSS) capacitor c=1.309E-17
    I_C913 (XI49_ap2 VSS) capacitor c=6.389E-16
    I_C914 (XI49_bn5 VSS) capacitor c=4.566E-16
    I_C915 (XI49_bn3 VSS) capacitor c=4.374E-16
    I_C916 (XI49_bn4 VSS) capacitor c=7.912E-16
    I_C917 (XI49_bn2 VSS) capacitor c=4.147E-16
    I_C918 (XI49_bn1 VSS) capacitor c=1.090E-18
    I_C919 (XI49_an5 VSS) capacitor c=6.915E-16
    I_C920 (XI49_an4 VSS) capacitor c=7.580E-16
    I_C921 (XI49_an3 VSS) capacitor c=6.653E-16
    I_C922 (XI49_an1 VSS) capacitor c=1.447E-17
    I_C923 (XI49_an2 VSS) capacitor c=4.323E-16
    I_C924 (XI49_bsn VSS) capacitor c=1.313E-15
    I_C925 (XI49_bcon VSS) capacitor c=2.152E-15
    I_C926 (XI49_s1 VSS) capacitor c=2.671E-15
    I_C927 (XI49_asn VSS) capacitor c=1.564E-15
    I_C928 (XI49_acon VSS) capacitor c=2.265E-15
    I_C929 (XI52_bp5 VSS) capacitor c=3.745E-16
    I_C930 (XI52_bp4 VSS) capacitor c=8.114E-16
    I_C931 (XI52_bp3 VSS) capacitor c=5.866E-16
    I_C932 (XI52_bp2 VSS) capacitor c=3.268E-16
    I_C933 (XI52_bp1 VSS) capacitor c=5.579E-18
    I_C934 (XI52_ap4 VSS) capacitor c=5.213E-16
    I_C935 (XI52_ap5 VSS) capacitor c=7.402E-16
    I_C936 (XI52_ap3 VSS) capacitor c=7.760E-16
    I_C937 (XI52_ap1 VSS) capacitor c=7.743E-18
    I_C938 (XI52_ap2 VSS) capacitor c=6.683E-16
    I_C939 (XI52_bn5 VSS) capacitor c=4.503E-16
    I_C940 (XI52_bn3 VSS) capacitor c=4.609E-16
    I_C941 (XI52_bn4 VSS) capacitor c=8.059E-16
    I_C942 (XI52_bn2 VSS) capacitor c=4.243E-16
    I_C943 (XI52_an5 VSS) capacitor c=6.831E-16
    I_C944 (XI52_an4 VSS) capacitor c=7.577E-16
    I_C945 (XI52_an3 VSS) capacitor c=6.774E-16
    I_C946 (XI52_an1 VSS) capacitor c=2.584E-18
    I_C947 (XI52_an2 VSS) capacitor c=5.035E-16
    I_C948 (XI52_bsn VSS) capacitor c=1.355E-15
    I_C949 (XI52_bcon VSS) capacitor c=2.203E-15
    I_C950 (XI52_s1 VSS) capacitor c=2.661E-15
    I_C951 (XI52_asn VSS) capacitor c=1.599E-15
    I_C952 (XI52_acon VSS) capacitor c=2.314E-15
    I_C953 (XI48_bp5 VSS) capacitor c=3.880E-16
    I_C954 (XI48_bp4 VSS) capacitor c=8.252E-16
    I_C955 (XI48_bp3 VSS) capacitor c=6.259E-16
    I_C956 (XI48_bp2 VSS) capacitor c=3.469E-16
    I_C957 (XI48_bp1 VSS) capacitor c=6.555E-19
    I_C958 (XI48_ap4 VSS) capacitor c=5.561E-16
    I_C959 (XI48_ap5 VSS) capacitor c=7.943E-16
    I_C960 (XI48_ap3 VSS) capacitor c=7.703E-16
    I_C961 (XI48_ap1 VSS) capacitor c=9.258E-18
    I_C962 (XI48_ap2 VSS) capacitor c=6.714E-16
    I_C963 (XI48_bn5 VSS) capacitor c=4.567E-16
    I_C964 (XI48_bn3 VSS) capacitor c=4.368E-16
    I_C965 (XI48_bn4 VSS) capacitor c=7.981E-16
    I_C966 (XI48_bn2 VSS) capacitor c=4.216E-16
    I_C967 (XI48_bn1 VSS) capacitor c=1.364E-20
    I_C968 (XI48_an5 VSS) capacitor c=6.886E-16
    I_C969 (XI48_an4 VSS) capacitor c=7.629E-16
    I_C970 (XI48_an3 VSS) capacitor c=6.750E-16
    I_C971 (XI48_an1 VSS) capacitor c=5.047E-18
    I_C972 (XI48_an2 VSS) capacitor c=4.798E-16
    I_C973 (XI48_bsn VSS) capacitor c=1.334E-15
    I_C974 (XI48_bcon VSS) capacitor c=2.182E-15
    I_C975 (XI48_s1 VSS) capacitor c=2.637E-15
    I_C976 (XI48_asn VSS) capacitor c=1.759E-15
    I_C977 (XI48_acon VSS) capacitor c=2.320E-15
    I_C978 (XI53_bp5 VSS) capacitor c=3.900E-16
    I_C979 (XI53_bp4 VSS) capacitor c=8.339E-16
    I_C980 (XI53_bp3 VSS) capacitor c=6.063E-16
    I_C981 (XI53_bp2 VSS) capacitor c=3.249E-16
    I_C982 (XI53_bp1 VSS) capacitor c=3.589E-18
    I_C983 (XI53_ap4 VSS) capacitor c=5.445E-16
    I_C984 (XI53_ap5 VSS) capacitor c=7.150E-16
    I_C985 (XI53_ap3 VSS) capacitor c=7.569E-16
    I_C986 (XI53_ap1 VSS) capacitor c=1.118E-17
    I_C987 (XI53_ap2 VSS) capacitor c=6.740E-16
    I_C988 (XI53_bn5 VSS) capacitor c=4.447E-16
    I_C989 (XI53_bn3 VSS) capacitor c=4.528E-16
    I_C990 (XI53_bn4 VSS) capacitor c=7.846E-16
    I_C991 (XI53_bn2 VSS) capacitor c=4.226E-16
    I_C992 (XI53_bn1 VSS) capacitor c=8.532E-19
    I_C993 (XI53_an5 VSS) capacitor c=6.764E-16
    I_C994 (XI53_an4 VSS) capacitor c=7.144E-16
    I_C995 (XI53_an3 VSS) capacitor c=6.494E-16
    I_C996 (XI53_an1 VSS) capacitor c=4.569E-18
    I_C997 (XI53_an2 VSS) capacitor c=4.689E-16
    I_C998 (XI53_bsn VSS) capacitor c=1.329E-15
    I_C999 (XI53_bcon VSS) capacitor c=2.153E-15
    I_C1000 (XI53_s1 VSS) capacitor c=2.600E-15
    I_C1001 (XI53_asn VSS) capacitor c=1.516E-15
    I_C1002 (XI53_acon VSS) capacitor c=2.280E-15
    I_C1003 (XI54_bp5 VSS) capacitor c=3.752E-16
    I_C1004 (XI54_bp4 VSS) capacitor c=8.291E-16
    I_C1005 (XI54_bp3 VSS) capacitor c=6.018E-16
    I_C1006 (XI54_bp2 VSS) capacitor c=3.225E-16
    I_C1007 (XI54_bp1 VSS) capacitor c=2.165E-18
    I_C1008 (XI54_ap4 VSS) capacitor c=5.154E-16
    I_C1009 (XI54_ap5 VSS) capacitor c=7.211E-16
    I_C1010 (XI54_ap3 VSS) capacitor c=7.712E-16
    I_C1011 (XI54_ap1 VSS) capacitor c=1.403E-17
    I_C1012 (XI54_ap2 VSS) capacitor c=6.767E-16
    I_C1013 (XI54_bn5 VSS) capacitor c=4.402E-16
    I_C1014 (XI54_bn3 VSS) capacitor c=4.414E-16
    I_C1015 (XI54_bn4 VSS) capacitor c=7.709E-16
    I_C1016 (XI54_bn2 VSS) capacitor c=4.169E-16
    I_C1017 (XI54_an5 VSS) capacitor c=6.844E-16
    I_C1018 (XI54_an4 VSS) capacitor c=7.362E-16
    I_C1019 (XI54_an3 VSS) capacitor c=6.730E-16
    I_C1020 (XI54_an1 VSS) capacitor c=4.636E-18
    I_C1021 (XI54_an2 VSS) capacitor c=4.492E-16
    I_C1022 (XI54_bsn VSS) capacitor c=1.298E-15
    I_C1023 (XI54_bcon VSS) capacitor c=2.141E-15
    I_C1024 (XI54_s1 VSS) capacitor c=2.625E-15
    I_C1025 (XI54_asn VSS) capacitor c=1.536E-15
    I_C1026 (XI54_acon VSS) capacitor c=2.285E-15
    I_C1027 (XI22_ap1 VSS) capacitor c=4.497E-16
    I_C1028 (XI22_cp VSS) capacitor c=1.360E-17
    I_C1029 (XI22_bp1 VSS) capacitor c=6.615E-16
    I_C1030 (XI22_an2 VSS) capacitor c=7.330E-18
    I_C1031 (XI22_an1 VSS) capacitor c=5.300E-16
    I_C1032 (XI22_bn1 VSS) capacitor c=5.355E-18
    I_C1033 (XI22_bn2 VSS) capacitor c=4.810E-18
    I_C1034 (XI22_abn VSS) capacitor c=9.995E-16
    I_C1035 (XI22_aan VSS) capacitor c=1.169E-15
    I_C1036 (XI22_e VSS) capacitor c=1.336E-15
    I_C1037 (XI22_bbn VSS) capacitor c=1.016E-15
    I_C1038 (XI22_ban VSS) capacitor c=6.673E-16
    I_C1039 (XI11_ap1 VSS) capacitor c=4.493E-16
    I_C1040 (XI11_cp VSS) capacitor c=1.418E-17
    I_C1041 (XI11_bp1 VSS) capacitor c=6.877E-16
    I_C1042 (XI11_an2 VSS) capacitor c=5.647E-18
    I_C1043 (XI11_an1 VSS) capacitor c=5.439E-16
    I_C1044 (XI11_bn1 VSS) capacitor c=4.002E-18
    I_C1045 (XI11_bn2 VSS) capacitor c=1.082E-17
    I_C1046 (XI11_abn VSS) capacitor c=1.081E-15
    I_C1047 (XI11_aan VSS) capacitor c=1.178E-15
    I_C1048 (XI11_e VSS) capacitor c=1.339E-15
    I_C1049 (XI11_bbn VSS) capacitor c=1.034E-15
    I_C1050 (XI11_ban VSS) capacitor c=6.280E-16
    I_C1051 (XI33_ap1 VSS) capacitor c=4.449E-16
    I_C1052 (XI33_cp VSS) capacitor c=7.272E-18
    I_C1053 (XI33_bp1 VSS) capacitor c=6.740E-16
    I_C1054 (XI33_an2 VSS) capacitor c=6.286E-18
    I_C1055 (XI33_an1 VSS) capacitor c=5.274E-16
    I_C1056 (XI33_bn1 VSS) capacitor c=8.694E-18
    I_C1057 (XI33_bn2 VSS) capacitor c=7.052E-18
    I_C1058 (XI33_abn VSS) capacitor c=1.040E-15
    I_C1059 (XI33_aan VSS) capacitor c=1.169E-15
    I_C1060 (XI33_e VSS) capacitor c=1.332E-15
    I_C1061 (XI33_bbn VSS) capacitor c=1.055E-15
    I_C1062 (XI33_ban VSS) capacitor c=6.716E-16
    I_C1063 (XI0_ap1 VSS) capacitor c=4.496E-16
    I_C1064 (XI0_cp VSS) capacitor c=7.617E-18
    I_C1065 (XI0_bp1 VSS) capacitor c=6.810E-16
    I_C1066 (XI0_an2 VSS) capacitor c=6.710E-18
    I_C1067 (XI0_an1 VSS) capacitor c=5.199E-16
    I_C1068 (XI0_bn1 VSS) capacitor c=2.415E-18
    I_C1069 (XI0_bn2 VSS) capacitor c=1.176E-17
    I_C1070 (XI0_abn VSS) capacitor c=9.916E-16
    I_C1071 (XI0_aan VSS) capacitor c=1.156E-15
    I_C1072 (XI0_e VSS) capacitor c=1.305E-15
    I_C1073 (XI0_bbn VSS) capacitor c=9.961E-16
    I_C1074 (XI0_ban VSS) capacitor c=6.684E-16
    I_C1075 (XI77_I40_p1 VSS) capacitor c=5.886E-16
    I_C1076 (XI77_I40_n1 VSS) capacitor c=2.388E-18
    I_C1077 (XI77_I40_n2 VSS) capacitor c=7.059E-18
    I_C1078 (XI77_I40_An VSS) capacitor c=9.819E-16
    I_C1079 (XI77_I40_Bn VSS) capacitor c=8.125E-16
    I_C1080 (XI77_I41_p1 VSS) capacitor c=5.253E-16
    I_C1081 (XI77_I41_n2 VSS) capacitor c=5.363E-18
    I_C1082 (XI77_I41_An VSS) capacitor c=9.571E-16
    I_C1083 (XI77_I41_Bn VSS) capacitor c=8.133E-16
ends MUL8
