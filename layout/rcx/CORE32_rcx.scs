// CORE32 sau layout: Assura RCX -> layout/rcx2scs.py - khong sua tay
simulator lang=spectre
subckt CORE32 A_0 A_1 A_2 A_3 A_4 A_5 A_6 A_7 A_8 A_9 A_10 A_11 A_12 A_13 A_14 A_15 A_16 A_17 A_18 A_19 A_20 A_21 A_22 A_23 A_24 A_25 A_26 A_27 A_28 A_29 A_30 A_31 B_0 B_1 B_2 B_3 B_4 B_5 B_6 B_7 B_8 B_9 B_10 B_11 B_12 B_13 B_14 B_15 B_16 B_17 B_18 B_19 B_20 B_21 B_22 B_23 B_24 B_25 B_26 B_27 B_28 B_29 B_30 B_31 OP_0 OP_1 OP_2 OP_3 MULP_0 MULP_1 MULP_2 MULP_3 MULP_4 MULP_5 MULP_6 MULP_7 MULP_8 MULP_9 MULP_10 MULP_11 MULP_12 MULP_13 MULP_14 MULP_15 MULP_16 MULP_17 MULP_18 MULP_19 MULP_20 MULP_21 MULP_22 MULP_23 MULP_24 MULP_25 MULP_26 MULP_27 MULP_28 MULP_29 MULP_30 MULP_31 MULP_32 MULP_33 MULP_34 MULP_35 MULP_36 MULP_37 MULP_38 MULP_39 MULP_40 MULP_41 MULP_42 MULP_43 MULP_44 MULP_45 MULP_46 MULP_47 MULP_48 MULP_49 MULP_50 MULP_51 MULP_52 MULP_53 MULP_54 MULP_55 MULP_56 MULP_57 MULP_58 MULP_59 MULP_60 MULP_61 MULP_62 MULP_63 DIVQ_0 DIVQ_1 DIVQ_2 DIVQ_3 DIVQ_4 DIVQ_5 DIVQ_6 DIVQ_7 DIVQ_8 DIVQ_9 DIVQ_10 DIVQ_11 DIVQ_12 DIVQ_13 DIVQ_14 DIVQ_15 DIVQ_16 DIVQ_17 DIVQ_18 DIVQ_19 DIVQ_20 DIVQ_21 DIVQ_22 DIVQ_23 DIVQ_24 DIVQ_25 DIVQ_26 DIVQ_27 DIVQ_28 DIVQ_29 DIVQ_30 DIVQ_31 DIVR_0 DIVR_1 DIVR_2 DIVR_3 DIVR_4 DIVR_5 DIVR_6 DIVR_7 DIVR_8 DIVR_9 DIVR_10 DIVR_11 DIVR_12 DIVR_13 DIVR_14 DIVR_15 DIVR_16 DIVR_17 DIVR_18 DIVR_19 DIVR_20 DIVR_21 DIVR_22 DIVR_23 DIVR_24 DIVR_25 DIVR_26 DIVR_27 DIVR_28 DIVR_29 DIVR_30 DIVR_31 DIVV DIVDZ Y_0 Y_1 Y_2 Y_3 Y_4 Y_5 Y_6 Y_7 Y_8 Y_9 Y_10 Y_11 Y_12 Y_13 Y_14 Y_15 Y_16 Y_17 Y_18 Y_19 Y_20 Y_21 Y_22 Y_23 Y_24 Y_25 Y_26 Y_27 Y_28 Y_29 Y_30 Y_31 Y_32 Y_33 Y_34 Y_35 Y_36 Y_37 Y_38 Y_39 Y_40 Y_41 Y_42 Y_43 Y_44 Y_45 Y_46 Y_47 Y_48 Y_49 Y_50 Y_51 Y_52 Y_53 Y_54 Y_55 Y_56 Y_57 Y_58 Y_59 Y_60 Y_61 Y_62 Y_63 Z C V DZ VDD VSS
    I_MXI1_I42_I203_MN1 (XI1_I42_I203_Bn I1_SUB_b3_5 VSS VSS) gpdk090_nmos1v w=0.12u l=0.1u ad=0.0696p as=0.0696p pd=1.16u ps=1.16u
    I_MXI1_I42_I203_MN5 (XI1_I42_I203_n2 I1_SUB_b3_5 VSS VSS) gpdk090_nmos1v w=0.24u l=0.1u ad=0.0528p as=0.0816p pd=0.68u ps=1.16u
    I_MXI1_I42_I203_MN4 (S_0 XI1_I42_I203_An XI1_I42_I203_n2 VSS) gpdk090_nmos1v w=0.24u l=0.1u ad=0.0528p as=0.0528p pd=0.68u ps=0.68u
    I_MXI1_I42_I203_MN2 (XI1_I42_I203_n1 I1_I42_pn0 S_0 VSS) gpdk090_nmos1v w=0.24u l=0.1u ad=0.0528p as=0.0528p pd=0.68u ps=0.68u
    I_MXI1_I42_I203_MN3 (VSS XI1_I42_I203_Bn XI1_I42_I203_n1 VSS) gpdk090_nmos1v w=0.24u l=0.1u ad=0.0816p as=0.0528p pd=1.16u ps=0.68u
    I_MXI1_I42_I203_MN0 (XI1_I42_I203_An I1_I42_pn0 VSS VSS) gpdk090_nmos1v w=0.12u l=0.1u ad=0.0696p as=0.0696p pd=1.16u ps=1.16u
    I_MXI1_I42_I32_MN1 (XI1_I42_I32_Bn I1_bx0 VSS VSS) gpdk090_nmos1v w=0.12u l=0.1u ad=0.0696p as=0.0696p pd=1.16u ps=1.16u
    I_MXI1_I42_I32_MN5 (XI1_I42_I32_n2 I1_bx0 VSS VSS) gpdk090_nmos1v w=0.24u l=0.1u ad=0.0528p as=0.0816p pd=0.68u ps=1.16u
    I_MXI1_I42_I32_MN4 (I1_I42_pn0 XI1_I42_I32_An XI1_I42_I32_n2 VSS) gpdk090_nmos1v w=0.24u l=0.1u ad=0.0528p as=0.0528p pd=0.68u ps=0.68u
    I_MXI1_I42_I32_MN2 (XI1_I42_I32_n1 A_0 I1_I42_pn0 VSS) gpdk090_nmos1v w=0.24u l=0.1u ad=0.0528p as=0.0528p pd=0.68u ps=0.68u
    I_MXI1_I42_I32_MN3 (VSS XI1_I42_I32_Bn XI1_I42_I32_n1 VSS) gpdk090_nmos1v w=0.24u l=0.1u ad=0.0816p as=0.0528p pd=1.16u ps=0.68u
    I_MXI1_I42_I32_MN0 (XI1_I42_I32_An A_0 VSS VSS) gpdk090_nmos1v w=0.12u l=0.1u ad=0.0696p as=0.0696p pd=1.16u ps=1.16u
    I_MXI1_I42_I33_MN1 (XI1_I42_I33_Bn I1_bx1 VSS VSS) gpdk090_nmos1v w=0.12u l=0.1u ad=0.0696p as=0.0696p pd=1.16u ps=1.16u
    I_MXI1_I42_I33_MN5 (XI1_I42_I33_n2 I1_bx1 VSS VSS) gpdk090_nmos1v w=0.24u l=0.1u ad=0.0528p as=0.0816p pd=0.68u ps=1.16u
    I_MXI1_I42_I33_MN4 (I1_I42_pn1 XI1_I42_I33_An XI1_I42_I33_n2 VSS) gpdk090_nmos1v w=0.24u l=0.1u ad=0.0528p as=0.0528p pd=0.68u ps=0.68u
    I_MXI1_I42_I33_MN2 (XI1_I42_I33_n1 A_1 I1_I42_pn1 VSS) gpdk090_nmos1v w=0.24u l=0.1u ad=0.0528p as=0.0528p pd=0.68u ps=0.68u
    I_MXI1_I42_I33_MN3 (VSS XI1_I42_I33_Bn XI1_I42_I33_n1 VSS) gpdk090_nmos1v w=0.24u l=0.1u ad=0.0816p as=0.0528p pd=1.16u ps=0.68u
    I_MXI1_I42_I33_MN0 (XI1_I42_I33_An A_1 VSS VSS) gpdk090_nmos1v w=0.12u l=0.1u ad=0.0696p as=0.0696p pd=1.16u ps=1.16u
    I_MXI1_I42_I36_MN1 (XI1_I42_I36_Bn I1_bx4 VSS VSS) gpdk090_nmos1v w=0.12u l=0.1u ad=0.0696p as=0.0696p pd=1.16u ps=1.16u
    I_MXI1_I42_I36_MN5 (XI1_I42_I36_n2 I1_bx4 VSS VSS) gpdk090_nmos1v w=0.24u l=0.1u ad=0.0528p as=0.0816p pd=0.68u ps=1.16u
    I_MXI1_I42_I36_MN4 (I1_I42_pn4 XI1_I42_I36_An XI1_I42_I36_n2 VSS) gpdk090_nmos1v w=0.24u l=0.1u ad=0.0528p as=0.0528p pd=0.68u ps=0.68u
    I_MXI1_I42_I36_MN2 (XI1_I42_I36_n1 A_4 I1_I42_pn4 VSS) gpdk090_nmos1v w=0.24u l=0.1u ad=0.0528p as=0.0528p pd=0.68u ps=0.68u
    I_MXI1_I42_I36_MN3 (VSS XI1_I42_I36_Bn XI1_I42_I36_n1 VSS) gpdk090_nmos1v w=0.24u l=0.1u ad=0.0816p as=0.0528p pd=1.16u ps=0.68u
    I_MXI1_I42_I36_MN0 (XI1_I42_I36_An A_4 VSS VSS) gpdk090_nmos1v w=0.12u l=0.1u ad=0.0696p as=0.0696p pd=1.16u ps=1.16u
    I_MXI1_I42_I40_MN1 (XI1_I42_I40_Bn I1_bx8 VSS VSS) gpdk090_nmos1v w=0.12u l=0.1u ad=0.0696p as=0.0696p pd=1.16u ps=1.16u
    I_MXI1_I42_I40_MN5 (XI1_I42_I40_n2 I1_bx8 VSS VSS) gpdk090_nmos1v w=0.24u l=0.1u ad=0.0528p as=0.0816p pd=0.68u ps=1.16u
    I_MXI1_I42_I40_MN4 (I1_I42_pn8 XI1_I42_I40_An XI1_I42_I40_n2 VSS) gpdk090_nmos1v w=0.24u l=0.1u ad=0.0528p as=0.0528p pd=0.68u ps=0.68u
    I_MXI1_I42_I40_MN2 (XI1_I42_I40_n1 A_8 I1_I42_pn8 VSS) gpdk090_nmos1v w=0.24u l=0.1u ad=0.0528p as=0.0528p pd=0.68u ps=0.68u
    I_MXI1_I42_I40_MN3 (VSS XI1_I42_I40_Bn XI1_I42_I40_n1 VSS) gpdk090_nmos1v w=0.24u l=0.1u ad=0.0816p as=0.0528p pd=1.16u ps=0.68u
    I_MXI1_I42_I40_MN0 (XI1_I42_I40_An A_8 VSS VSS) gpdk090_nmos1v w=0.12u l=0.1u ad=0.0696p as=0.0696p pd=1.16u ps=1.16u
    I_MXI1_I42_I41_MN1 (XI1_I42_I41_Bn I1_bx9 VSS VSS) gpdk090_nmos1v w=0.12u l=0.1u ad=0.0696p as=0.0696p pd=1.16u ps=1.16u
    I_MXI1_I42_I41_MN5 (XI1_I42_I41_n2 I1_bx9 VSS VSS) gpdk090_nmos1v w=0.24u l=0.1u ad=0.0528p as=0.0816p pd=0.68u ps=1.16u
    I_MXI1_I42_I41_MN4 (I1_I42_pn9 XI1_I42_I41_An XI1_I42_I41_n2 VSS) gpdk090_nmos1v w=0.24u l=0.1u ad=0.0528p as=0.0528p pd=0.68u ps=0.68u
    I_MXI1_I42_I41_MN2 (XI1_I42_I41_n1 A_9 I1_I42_pn9 VSS) gpdk090_nmos1v w=0.24u l=0.1u ad=0.0528p as=0.0528p pd=0.68u ps=0.68u
    I_MXI1_I42_I41_MN3 (VSS XI1_I42_I41_Bn XI1_I42_I41_n1 VSS) gpdk090_nmos1v w=0.24u l=0.1u ad=0.0816p as=0.0528p pd=1.16u ps=0.68u
    I_MXI1_I42_I41_MN0 (XI1_I42_I41_An A_9 VSS VSS) gpdk090_nmos1v w=0.12u l=0.1u ad=0.0696p as=0.0696p pd=1.16u ps=1.16u
    I_MXI1_I42_I39_MN1 (XI1_I42_I39_Bn I1_bx7 VSS VSS) gpdk090_nmos1v w=0.12u l=0.1u ad=0.0696p as=0.0696p pd=1.16u ps=1.16u
    I_MXI1_I42_I39_MN5 (XI1_I42_I39_n2 I1_bx7 VSS VSS) gpdk090_nmos1v w=0.24u l=0.1u ad=0.0528p as=0.0816p pd=0.68u ps=1.16u
    I_MXI1_I42_I39_MN4 (I1_I42_pn7 XI1_I42_I39_An XI1_I42_I39_n2 VSS) gpdk090_nmos1v w=0.24u l=0.1u ad=0.0528p as=0.0528p pd=0.68u ps=0.68u
    I_MXI1_I42_I39_MN2 (XI1_I42_I39_n1 A_7 I1_I42_pn7 VSS) gpdk090_nmos1v w=0.24u l=0.1u ad=0.0528p as=0.0528p pd=0.68u ps=0.68u
    I_MXI1_I42_I39_MN3 (VSS XI1_I42_I39_Bn XI1_I42_I39_n1 VSS) gpdk090_nmos1v w=0.24u l=0.1u ad=0.0816p as=0.0528p pd=1.16u ps=0.68u
    I_MXI1_I42_I39_MN0 (XI1_I42_I39_An A_7 VSS VSS) gpdk090_nmos1v w=0.12u l=0.1u ad=0.0696p as=0.0696p pd=1.16u ps=1.16u
    I_MXI1_I42_I37_MN1 (XI1_I42_I37_Bn I1_bx5 VSS VSS) gpdk090_nmos1v w=0.12u l=0.1u ad=0.0696p as=0.0696p pd=1.16u ps=1.16u
    I_MXI1_I42_I37_MN5 (XI1_I42_I37_n2 I1_bx5 VSS VSS) gpdk090_nmos1v w=0.24u l=0.1u ad=0.0528p as=0.0816p pd=0.68u ps=1.16u
    I_MXI1_I42_I37_MN4 (I1_I42_pn5 XI1_I42_I37_An XI1_I42_I37_n2 VSS) gpdk090_nmos1v w=0.24u l=0.1u ad=0.0528p as=0.0528p pd=0.68u ps=0.68u
    I_MXI1_I42_I37_MN2 (XI1_I42_I37_n1 A_5 I1_I42_pn5 VSS) gpdk090_nmos1v w=0.24u l=0.1u ad=0.0528p as=0.0528p pd=0.68u ps=0.68u
    I_MXI1_I42_I37_MN3 (VSS XI1_I42_I37_Bn XI1_I42_I37_n1 VSS) gpdk090_nmos1v w=0.24u l=0.1u ad=0.0816p as=0.0528p pd=1.16u ps=0.68u
    I_MXI1_I42_I37_MN0 (XI1_I42_I37_An A_5 VSS VSS) gpdk090_nmos1v w=0.12u l=0.1u ad=0.0696p as=0.0696p pd=1.16u ps=1.16u
    I_MXI1_I42_I204_MN1 (XI1_I42_I204_Bn I1_I42_G0_0 VSS VSS) gpdk090_nmos1v w=0.12u l=0.1u ad=0.0696p as=0.0696p pd=1.16u ps=1.16u
    I_MXI1_I42_I204_MN5 (XI1_I42_I204_n2 I1_I42_G0_0 VSS VSS) gpdk090_nmos1v w=0.24u l=0.1u ad=0.0528p as=0.0816p pd=0.68u ps=1.16u
    I_MXI1_I42_I204_MN4 (S_1 XI1_I42_I204_An XI1_I42_I204_n2 VSS) gpdk090_nmos1v w=0.24u l=0.1u ad=0.0528p as=0.0528p pd=0.68u ps=0.68u
    I_MXI1_I42_I204_MN2 (XI1_I42_I204_n1 I1_I42_pn1 S_1 VSS) gpdk090_nmos1v w=0.24u l=0.1u ad=0.0528p as=0.0528p pd=0.68u ps=0.68u
    I_MXI1_I42_I204_MN3 (VSS XI1_I42_I204_Bn XI1_I42_I204_n1 VSS) gpdk090_nmos1v w=0.24u l=0.1u ad=0.0816p as=0.0528p pd=1.16u ps=0.68u
    I_MXI1_I42_I204_MN0 (XI1_I42_I204_An I1_I42_pn1 VSS VSS) gpdk090_nmos1v w=0.12u l=0.1u ad=0.0696p as=0.0696p pd=1.16u ps=1.16u
    I_MXI1_I42_I42_MN1 (XI1_I42_I42_Bn I1_bx10 VSS VSS) gpdk090_nmos1v w=0.12u l=0.1u ad=0.0696p as=0.0696p pd=1.16u ps=1.16u
    I_MXI1_I42_I42_MN5 (XI1_I42_I42_n2 I1_bx10 VSS VSS) gpdk090_nmos1v w=0.24u l=0.1u ad=0.0528p as=0.0816p pd=0.68u ps=1.16u
    I_MXI1_I42_I42_MN4 (I1_I42_pn10 XI1_I42_I42_An XI1_I42_I42_n2 VSS) gpdk090_nmos1v w=0.24u l=0.1u ad=0.0528p as=0.0528p pd=0.68u ps=0.68u
    I_MXI1_I42_I42_MN2 (XI1_I42_I42_n1 A_10 I1_I42_pn10 VSS) gpdk090_nmos1v w=0.24u l=0.1u ad=0.0528p as=0.0528p pd=0.68u ps=0.68u
    I_MXI1_I42_I42_MN3 (VSS XI1_I42_I42_Bn XI1_I42_I42_n1 VSS) gpdk090_nmos1v w=0.24u l=0.1u ad=0.0816p as=0.0528p pd=1.16u ps=0.68u
    I_MXI1_I42_I42_MN0 (XI1_I42_I42_An A_10 VSS VSS) gpdk090_nmos1v w=0.12u l=0.1u ad=0.0696p as=0.0696p pd=1.16u ps=1.16u
    I_MXI1_I42_I211_MN1 (XI1_I42_I211_Bn I1_I42_G7_0 VSS VSS) gpdk090_nmos1v w=0.12u l=0.1u ad=0.0696p as=0.0696p pd=1.16u ps=1.16u
    I_MXI1_I42_I211_MN5 (XI1_I42_I211_n2 I1_I42_G7_0 VSS VSS) gpdk090_nmos1v w=0.24u l=0.1u ad=0.0528p as=0.0816p pd=0.68u ps=1.16u
    I_MXI1_I42_I211_MN4 (S_8 XI1_I42_I211_An XI1_I42_I211_n2 VSS) gpdk090_nmos1v w=0.24u l=0.1u ad=0.0528p as=0.0528p pd=0.68u ps=0.68u
    I_MXI1_I42_I211_MN2 (XI1_I42_I211_n1 I1_I42_pn8 S_8 VSS) gpdk090_nmos1v w=0.24u l=0.1u ad=0.0528p as=0.0528p pd=0.68u ps=0.68u
    I_MXI1_I42_I211_MN3 (VSS XI1_I42_I211_Bn XI1_I42_I211_n1 VSS) gpdk090_nmos1v w=0.24u l=0.1u ad=0.0816p as=0.0528p pd=1.16u ps=0.68u
    I_MXI1_I42_I211_MN0 (XI1_I42_I211_An I1_I42_pn8 VSS VSS) gpdk090_nmos1v w=0.12u l=0.1u ad=0.0696p as=0.0696p pd=1.16u ps=1.16u
    I_MXI1_I42_I209_MN1 (XI1_I42_I209_Bn I1_I42_G5_0 VSS VSS) gpdk090_nmos1v w=0.12u l=0.1u ad=0.0696p as=0.0696p pd=1.16u ps=1.16u
    I_MXI1_I42_I209_MN5 (XI1_I42_I209_n2 I1_I42_G5_0 VSS VSS) gpdk090_nmos1v w=0.24u l=0.1u ad=0.0528p as=0.0816p pd=0.68u ps=1.16u
    I_MXI1_I42_I209_MN4 (S_6 XI1_I42_I209_An XI1_I42_I209_n2 VSS) gpdk090_nmos1v w=0.24u l=0.1u ad=0.0528p as=0.0528p pd=0.68u ps=0.68u
    I_MXI1_I42_I209_MN2 (XI1_I42_I209_n1 I1_I42_pn6 S_6 VSS) gpdk090_nmos1v w=0.24u l=0.1u ad=0.0528p as=0.0528p pd=0.68u ps=0.68u
    I_MXI1_I42_I209_MN3 (VSS XI1_I42_I209_Bn XI1_I42_I209_n1 VSS) gpdk090_nmos1v w=0.24u l=0.1u ad=0.0816p as=0.0528p pd=1.16u ps=0.68u
    I_MXI1_I42_I209_MN0 (XI1_I42_I209_An I1_I42_pn6 VSS VSS) gpdk090_nmos1v w=0.12u l=0.1u ad=0.0696p as=0.0696p pd=1.16u ps=1.16u
    I_MXI1_I42_I210_MN1 (XI1_I42_I210_Bn I1_I42_G6_0 VSS VSS) gpdk090_nmos1v w=0.12u l=0.1u ad=0.0696p as=0.0696p pd=1.16u ps=1.16u
    I_MXI1_I42_I210_MN5 (XI1_I42_I210_n2 I1_I42_G6_0 VSS VSS) gpdk090_nmos1v w=0.24u l=0.1u ad=0.0528p as=0.0816p pd=0.68u ps=1.16u
    I_MXI1_I42_I210_MN4 (S_7 XI1_I42_I210_An XI1_I42_I210_n2 VSS) gpdk090_nmos1v w=0.24u l=0.1u ad=0.0528p as=0.0528p pd=0.68u ps=0.68u
    I_MXI1_I42_I210_MN2 (XI1_I42_I210_n1 I1_I42_pn7 S_7 VSS) gpdk090_nmos1v w=0.24u l=0.1u ad=0.0528p as=0.0528p pd=0.68u ps=0.68u
    I_MXI1_I42_I210_MN3 (VSS XI1_I42_I210_Bn XI1_I42_I210_n1 VSS) gpdk090_nmos1v w=0.24u l=0.1u ad=0.0816p as=0.0528p pd=1.16u ps=0.68u
    I_MXI1_I42_I210_MN0 (XI1_I42_I210_An I1_I42_pn7 VSS VSS) gpdk090_nmos1v w=0.12u l=0.1u ad=0.0696p as=0.0696p pd=1.16u ps=1.16u
    I_MXI1_I42_I38_MN1 (XI1_I42_I38_Bn I1_bx6 VSS VSS) gpdk090_nmos1v w=0.12u l=0.1u ad=0.0696p as=0.0696p pd=1.16u ps=1.16u
    I_MXI1_I42_I38_MN5 (XI1_I42_I38_n2 I1_bx6 VSS VSS) gpdk090_nmos1v w=0.24u l=0.1u ad=0.0528p as=0.0816p pd=0.68u ps=1.16u
    I_MXI1_I42_I38_MN4 (I1_I42_pn6 XI1_I42_I38_An XI1_I42_I38_n2 VSS) gpdk090_nmos1v w=0.24u l=0.1u ad=0.0528p as=0.0528p pd=0.68u ps=0.68u
    I_MXI1_I42_I38_MN2 (XI1_I42_I38_n1 A_6 I1_I42_pn6 VSS) gpdk090_nmos1v w=0.24u l=0.1u ad=0.0528p as=0.0528p pd=0.68u ps=0.68u
    I_MXI1_I42_I38_MN3 (VSS XI1_I42_I38_Bn XI1_I42_I38_n1 VSS) gpdk090_nmos1v w=0.24u l=0.1u ad=0.0816p as=0.0528p pd=1.16u ps=0.68u
    I_MXI1_I42_I38_MN0 (XI1_I42_I38_An A_6 VSS VSS) gpdk090_nmos1v w=0.12u l=0.1u ad=0.0696p as=0.0696p pd=1.16u ps=1.16u
    I_MXI1_I42_I208_MN1 (XI1_I42_I208_Bn I1_I42_G4_0 VSS VSS) gpdk090_nmos1v w=0.12u l=0.1u ad=0.0696p as=0.0696p pd=1.16u ps=1.16u
    I_MXI1_I42_I208_MN5 (XI1_I42_I208_n2 I1_I42_G4_0 VSS VSS) gpdk090_nmos1v w=0.24u l=0.1u ad=0.0528p as=0.0816p pd=0.68u ps=1.16u
    I_MXI1_I42_I208_MN4 (S_5 XI1_I42_I208_An XI1_I42_I208_n2 VSS) gpdk090_nmos1v w=0.24u l=0.1u ad=0.0528p as=0.0528p pd=0.68u ps=0.68u
    I_MXI1_I42_I208_MN2 (XI1_I42_I208_n1 I1_I42_pn5 S_5 VSS) gpdk090_nmos1v w=0.24u l=0.1u ad=0.0528p as=0.0528p pd=0.68u ps=0.68u
    I_MXI1_I42_I208_MN3 (VSS XI1_I42_I208_Bn XI1_I42_I208_n1 VSS) gpdk090_nmos1v w=0.24u l=0.1u ad=0.0816p as=0.0528p pd=1.16u ps=0.68u
    I_MXI1_I42_I208_MN0 (XI1_I42_I208_An I1_I42_pn5 VSS VSS) gpdk090_nmos1v w=0.12u l=0.1u ad=0.0696p as=0.0696p pd=1.16u ps=1.16u
    I_MXI1_I42_I205_MN1 (XI1_I42_I205_Bn I1_I42_G1_0 VSS VSS) gpdk090_nmos1v w=0.12u l=0.1u ad=0.0696p as=0.0696p pd=1.16u ps=1.16u
    I_MXI1_I42_I205_MN5 (XI1_I42_I205_n2 I1_I42_G1_0 VSS VSS) gpdk090_nmos1v w=0.24u l=0.1u ad=0.0528p as=0.0816p pd=0.68u ps=1.16u
    I_MXI1_I42_I205_MN4 (S_2 XI1_I42_I205_An XI1_I42_I205_n2 VSS) gpdk090_nmos1v w=0.24u l=0.1u ad=0.0528p as=0.0528p pd=0.68u ps=0.68u
    I_MXI1_I42_I205_MN2 (XI1_I42_I205_n1 I1_I42_pn2 S_2 VSS) gpdk090_nmos1v w=0.24u l=0.1u ad=0.0528p as=0.0528p pd=0.68u ps=0.68u
    I_MXI1_I42_I205_MN3 (VSS XI1_I42_I205_Bn XI1_I42_I205_n1 VSS) gpdk090_nmos1v w=0.24u l=0.1u ad=0.0816p as=0.0528p pd=1.16u ps=0.68u
    I_MXI1_I42_I205_MN0 (XI1_I42_I205_An I1_I42_pn2 VSS VSS) gpdk090_nmos1v w=0.12u l=0.1u ad=0.0696p as=0.0696p pd=1.16u ps=1.16u
    I_MXI1_I42_I34_MN1 (XI1_I42_I34_Bn I1_bx2 VSS VSS) gpdk090_nmos1v w=0.12u l=0.1u ad=0.0696p as=0.0696p pd=1.16u ps=1.16u
    I_MXI1_I42_I34_MN5 (XI1_I42_I34_n2 I1_bx2 VSS VSS) gpdk090_nmos1v w=0.24u l=0.1u ad=0.0528p as=0.0816p pd=0.68u ps=1.16u
    I_MXI1_I42_I34_MN4 (I1_I42_pn2 XI1_I42_I34_An XI1_I42_I34_n2 VSS) gpdk090_nmos1v w=0.24u l=0.1u ad=0.0528p as=0.0528p pd=0.68u ps=0.68u
    I_MXI1_I42_I34_MN2 (XI1_I42_I34_n1 A_2 I1_I42_pn2 VSS) gpdk090_nmos1v w=0.24u l=0.1u ad=0.0528p as=0.0528p pd=0.68u ps=0.68u
    I_MXI1_I42_I34_MN3 (VSS XI1_I42_I34_Bn XI1_I42_I34_n1 VSS) gpdk090_nmos1v w=0.24u l=0.1u ad=0.0816p as=0.0528p pd=1.16u ps=0.68u
    I_MXI1_I42_I34_MN0 (XI1_I42_I34_An A_2 VSS VSS) gpdk090_nmos1v w=0.12u l=0.1u ad=0.0696p as=0.0696p pd=1.16u ps=1.16u
    I_MXI1_I42_I35_MN1 (XI1_I42_I35_Bn I1_bx3 VSS VSS) gpdk090_nmos1v w=0.12u l=0.1u ad=0.0696p as=0.0696p pd=1.16u ps=1.16u
    I_MXI1_I42_I35_MN5 (XI1_I42_I35_n2 I1_bx3 VSS VSS) gpdk090_nmos1v w=0.24u l=0.1u ad=0.0528p as=0.0816p pd=0.68u ps=1.16u
    I_MXI1_I42_I35_MN4 (I1_I42_pn3 XI1_I42_I35_An XI1_I42_I35_n2 VSS) gpdk090_nmos1v w=0.24u l=0.1u ad=0.0528p as=0.0528p pd=0.68u ps=0.68u
    I_MXI1_I42_I35_MN2 (XI1_I42_I35_n1 A_3 I1_I42_pn3 VSS) gpdk090_nmos1v w=0.24u l=0.1u ad=0.0528p as=0.0528p pd=0.68u ps=0.68u
    I_MXI1_I42_I35_MN3 (VSS XI1_I42_I35_Bn XI1_I42_I35_n1 VSS) gpdk090_nmos1v w=0.24u l=0.1u ad=0.0816p as=0.0528p pd=1.16u ps=0.68u
    I_MXI1_I42_I35_MN0 (XI1_I42_I35_An A_3 VSS VSS) gpdk090_nmos1v w=0.12u l=0.1u ad=0.0696p as=0.0696p pd=1.16u ps=1.16u
    I_MXI1_I42_I62_MN1 (XI1_I42_I62_Bn I1_bx30 VSS VSS) gpdk090_nmos1v w=0.12u l=0.1u ad=0.0696p as=0.0696p pd=1.16u ps=1.16u
    I_MXI1_I42_I62_MN5 (XI1_I42_I62_n2 I1_bx30 VSS VSS) gpdk090_nmos1v w=0.24u l=0.1u ad=0.0528p as=0.0816p pd=0.68u ps=1.16u
    I_MXI1_I42_I62_MN4 (I1_I42_pn30 XI1_I42_I62_An XI1_I42_I62_n2 VSS) gpdk090_nmos1v w=0.24u l=0.1u ad=0.0528p as=0.0528p pd=0.68u ps=0.68u
    I_MXI1_I42_I62_MN2 (XI1_I42_I62_n1 A_30 I1_I42_pn30 VSS) gpdk090_nmos1v w=0.24u l=0.1u ad=0.0528p as=0.0528p pd=0.68u ps=0.68u
    I_MXI1_I42_I62_MN3 (VSS XI1_I42_I62_Bn XI1_I42_I62_n1 VSS) gpdk090_nmos1v w=0.24u l=0.1u ad=0.0816p as=0.0528p pd=1.16u ps=0.68u
    I_MXI1_I42_I62_MN0 (XI1_I42_I62_An A_30 VSS VSS) gpdk090_nmos1v w=0.12u l=0.1u ad=0.0696p as=0.0696p pd=1.16u ps=1.16u
    I_MXI1_I42_I233_MN1 (XI1_I42_I233_Bn I1_I42_G29_0 VSS VSS) gpdk090_nmos1v w=0.12u l=0.1u ad=0.0696p as=0.0696p pd=1.16u ps=1.16u
    I_MXI1_I42_I233_MN5 (XI1_I42_I233_n2 I1_I42_G29_0 VSS VSS) gpdk090_nmos1v w=0.24u l=0.1u ad=0.0528p as=0.0816p pd=0.68u ps=1.16u
    I_MXI1_I42_I233_MN4 (S_30 XI1_I42_I233_An XI1_I42_I233_n2 VSS) gpdk090_nmos1v w=0.24u l=0.1u ad=0.0528p as=0.0528p pd=0.68u ps=0.68u
    I_MXI1_I42_I233_MN2 (XI1_I42_I233_n1 I1_I42_pn30 S_30 VSS) gpdk090_nmos1v w=0.24u l=0.1u ad=0.0528p as=0.0528p pd=0.68u ps=0.68u
    I_MXI1_I42_I233_MN3 (VSS XI1_I42_I233_Bn XI1_I42_I233_n1 VSS) gpdk090_nmos1v w=0.24u l=0.1u ad=0.0816p as=0.0528p pd=1.16u ps=0.68u
    I_MXI1_I42_I233_MN0 (XI1_I42_I233_An I1_I42_pn30 VSS VSS) gpdk090_nmos1v w=0.12u l=0.1u ad=0.0696p as=0.0696p pd=1.16u ps=1.16u
    I_MXI1_I42_I43_MN1 (XI1_I42_I43_Bn I1_bx11 VSS VSS) gpdk090_nmos1v w=0.12u l=0.1u ad=0.0696p as=0.0696p pd=1.16u ps=1.16u
    I_MXI1_I42_I43_MN5 (XI1_I42_I43_n2 I1_bx11 VSS VSS) gpdk090_nmos1v w=0.24u l=0.1u ad=0.0528p as=0.0816p pd=0.68u ps=1.16u
    I_MXI1_I42_I43_MN4 (I1_I42_pn11 XI1_I42_I43_An XI1_I42_I43_n2 VSS) gpdk090_nmos1v w=0.24u l=0.1u ad=0.0528p as=0.0528p pd=0.68u ps=0.68u
    I_MXI1_I42_I43_MN2 (XI1_I42_I43_n1 A_11 I1_I42_pn11 VSS) gpdk090_nmos1v w=0.24u l=0.1u ad=0.0528p as=0.0528p pd=0.68u ps=0.68u
    I_MXI1_I42_I43_MN3 (VSS XI1_I42_I43_Bn XI1_I42_I43_n1 VSS) gpdk090_nmos1v w=0.24u l=0.1u ad=0.0816p as=0.0528p pd=1.16u ps=0.68u
    I_MXI1_I42_I43_MN0 (XI1_I42_I43_An A_11 VSS VSS) gpdk090_nmos1v w=0.12u l=0.1u ad=0.0696p as=0.0696p pd=1.16u ps=1.16u
    I_MXI1_I42_I44_MN1 (XI1_I42_I44_Bn I1_bx12 VSS VSS) gpdk090_nmos1v w=0.12u l=0.1u ad=0.0696p as=0.0696p pd=1.16u ps=1.16u
    I_MXI1_I42_I44_MN5 (XI1_I42_I44_n2 I1_bx12 VSS VSS) gpdk090_nmos1v w=0.24u l=0.1u ad=0.0528p as=0.0816p pd=0.68u ps=1.16u
    I_MXI1_I42_I44_MN4 (I1_I42_pn12 XI1_I42_I44_An XI1_I42_I44_n2 VSS) gpdk090_nmos1v w=0.24u l=0.1u ad=0.0528p as=0.0528p pd=0.68u ps=0.68u
    I_MXI1_I42_I44_MN2 (XI1_I42_I44_n1 A_12 I1_I42_pn12 VSS) gpdk090_nmos1v w=0.24u l=0.1u ad=0.0528p as=0.0528p pd=0.68u ps=0.68u
    I_MXI1_I42_I44_MN3 (VSS XI1_I42_I44_Bn XI1_I42_I44_n1 VSS) gpdk090_nmos1v w=0.24u l=0.1u ad=0.0816p as=0.0528p pd=1.16u ps=0.68u
    I_MXI1_I42_I44_MN0 (XI1_I42_I44_An A_12 VSS VSS) gpdk090_nmos1v w=0.12u l=0.1u ad=0.0696p as=0.0696p pd=1.16u ps=1.16u
    I_MXI1_I42_I63_MN1 (XI1_I42_I63_Bn I1_bx31 VSS VSS) gpdk090_nmos1v w=0.12u l=0.1u ad=0.0696p as=0.0696p pd=1.16u ps=1.16u
    I_MXI1_I42_I63_MN5 (XI1_I42_I63_n2 I1_bx31 VSS VSS) gpdk090_nmos1v w=0.24u l=0.1u ad=0.0528p as=0.0816p pd=0.68u ps=1.16u
    I_MXI1_I42_I63_MN4 (I1_I42_pn31 XI1_I42_I63_An XI1_I42_I63_n2 VSS) gpdk090_nmos1v w=0.24u l=0.1u ad=0.0528p as=0.0528p pd=0.68u ps=0.68u
    I_MXI1_I42_I63_MN2 (XI1_I42_I63_n1 A_31 I1_I42_pn31 VSS) gpdk090_nmos1v w=0.24u l=0.1u ad=0.0528p as=0.0528p pd=0.68u ps=0.68u
    I_MXI1_I42_I63_MN3 (VSS XI1_I42_I63_Bn XI1_I42_I63_n1 VSS) gpdk090_nmos1v w=0.24u l=0.1u ad=0.0816p as=0.0528p pd=1.16u ps=0.68u
    I_MXI1_I42_I63_MN0 (XI1_I42_I63_An A_31 VSS VSS) gpdk090_nmos1v w=0.12u l=0.1u ad=0.0696p as=0.0696p pd=1.16u ps=1.16u
    I_MXI1_I42_I234_MN1 (XI1_I42_I234_Bn CM VSS VSS) gpdk090_nmos1v w=0.12u l=0.1u ad=0.0696p as=0.0696p pd=1.16u ps=1.16u
    I_MXI1_I42_I234_MN5 (XI1_I42_I234_n2 CM VSS VSS) gpdk090_nmos1v w=0.24u l=0.1u ad=0.0528p as=0.0816p pd=0.68u ps=1.16u
    I_MXI1_I42_I234_MN4 (S_31 XI1_I42_I234_An XI1_I42_I234_n2 VSS) gpdk090_nmos1v w=0.24u l=0.1u ad=0.0528p as=0.0528p pd=0.68u ps=0.68u
    I_MXI1_I42_I234_MN2 (XI1_I42_I234_n1 I1_I42_pn31 S_31 VSS) gpdk090_nmos1v w=0.24u l=0.1u ad=0.0528p as=0.0528p pd=0.68u ps=0.68u
    I_MXI1_I42_I234_MN3 (VSS XI1_I42_I234_Bn XI1_I42_I234_n1 VSS) gpdk090_nmos1v w=0.24u l=0.1u ad=0.0816p as=0.0528p pd=1.16u ps=0.68u
    I_MXI1_I42_I234_MN0 (XI1_I42_I234_An I1_I42_pn31 VSS VSS) gpdk090_nmos1v w=0.12u l=0.1u ad=0.0696p as=0.0696p pd=1.16u ps=1.16u
    I_MXI1_I42_I232_MN1 (XI1_I42_I232_Bn I1_I42_G28_0 VSS VSS) gpdk090_nmos1v w=0.12u l=0.1u ad=0.0696p as=0.0696p pd=1.16u ps=1.16u
    I_MXI1_I42_I232_MN5 (XI1_I42_I232_n2 I1_I42_G28_0 VSS VSS) gpdk090_nmos1v w=0.24u l=0.1u ad=0.0528p as=0.0816p pd=0.68u ps=1.16u
    I_MXI1_I42_I232_MN4 (S_29 XI1_I42_I232_An XI1_I42_I232_n2 VSS) gpdk090_nmos1v w=0.24u l=0.1u ad=0.0528p as=0.0528p pd=0.68u ps=0.68u
    I_MXI1_I42_I232_MN2 (XI1_I42_I232_n1 I1_I42_pn29 S_29 VSS) gpdk090_nmos1v w=0.24u l=0.1u ad=0.0528p as=0.0528p pd=0.68u ps=0.68u
    I_MXI1_I42_I232_MN3 (VSS XI1_I42_I232_Bn XI1_I42_I232_n1 VSS) gpdk090_nmos1v w=0.24u l=0.1u ad=0.0816p as=0.0528p pd=1.16u ps=0.68u
    I_MXI1_I42_I232_MN0 (XI1_I42_I232_An I1_I42_pn29 VSS VSS) gpdk090_nmos1v w=0.12u l=0.1u ad=0.0696p as=0.0696p pd=1.16u ps=1.16u
    I_MXI1_I42_I45_MN1 (XI1_I42_I45_Bn I1_bx13 VSS VSS) gpdk090_nmos1v w=0.12u l=0.1u ad=0.0696p as=0.0696p pd=1.16u ps=1.16u
    I_MXI1_I42_I45_MN5 (XI1_I42_I45_n2 I1_bx13 VSS VSS) gpdk090_nmos1v w=0.24u l=0.1u ad=0.0528p as=0.0816p pd=0.68u ps=1.16u
    I_MXI1_I42_I45_MN4 (I1_I42_pn13 XI1_I42_I45_An XI1_I42_I45_n2 VSS) gpdk090_nmos1v w=0.24u l=0.1u ad=0.0528p as=0.0528p pd=0.68u ps=0.68u
    I_MXI1_I42_I45_MN2 (XI1_I42_I45_n1 A_13 I1_I42_pn13 VSS) gpdk090_nmos1v w=0.24u l=0.1u ad=0.0528p as=0.0528p pd=0.68u ps=0.68u
    I_MXI1_I42_I45_MN3 (VSS XI1_I42_I45_Bn XI1_I42_I45_n1 VSS) gpdk090_nmos1v w=0.24u l=0.1u ad=0.0816p as=0.0528p pd=1.16u ps=0.68u
    I_MXI1_I42_I45_MN0 (XI1_I42_I45_An A_13 VSS VSS) gpdk090_nmos1v w=0.12u l=0.1u ad=0.0696p as=0.0696p pd=1.16u ps=1.16u
    I_MXI1_I42_I61_MN1 (XI1_I42_I61_Bn I1_bx29 VSS VSS) gpdk090_nmos1v w=0.12u l=0.1u ad=0.0696p as=0.0696p pd=1.16u ps=1.16u
    I_MXI1_I42_I61_MN5 (XI1_I42_I61_n2 I1_bx29 VSS VSS) gpdk090_nmos1v w=0.24u l=0.1u ad=0.0528p as=0.0816p pd=0.68u ps=1.16u
    I_MXI1_I42_I61_MN4 (I1_I42_pn29 XI1_I42_I61_An XI1_I42_I61_n2 VSS) gpdk090_nmos1v w=0.24u l=0.1u ad=0.0528p as=0.0528p pd=0.68u ps=0.68u
    I_MXI1_I42_I61_MN2 (XI1_I42_I61_n1 A_29 I1_I42_pn29 VSS) gpdk090_nmos1v w=0.24u l=0.1u ad=0.0528p as=0.0528p pd=0.68u ps=0.68u
    I_MXI1_I42_I61_MN3 (VSS XI1_I42_I61_Bn XI1_I42_I61_n1 VSS) gpdk090_nmos1v w=0.24u l=0.1u ad=0.0816p as=0.0528p pd=1.16u ps=0.68u
    I_MXI1_I42_I61_MN0 (XI1_I42_I61_An A_29 VSS VSS) gpdk090_nmos1v w=0.12u l=0.1u ad=0.0696p as=0.0696p pd=1.16u ps=1.16u
    I_MXI1_I42_I231_MN1 (XI1_I42_I231_Bn I1_I42_G27_0 VSS VSS) gpdk090_nmos1v w=0.12u l=0.1u ad=0.0696p as=0.0696p pd=1.16u ps=1.16u
    I_MXI1_I42_I231_MN5 (XI1_I42_I231_n2 I1_I42_G27_0 VSS VSS) gpdk090_nmos1v w=0.24u l=0.1u ad=0.0528p as=0.0816p pd=0.68u ps=1.16u
    I_MXI1_I42_I231_MN4 (S_28 XI1_I42_I231_An XI1_I42_I231_n2 VSS) gpdk090_nmos1v w=0.24u l=0.1u ad=0.0528p as=0.0528p pd=0.68u ps=0.68u
    I_MXI1_I42_I231_MN2 (XI1_I42_I231_n1 I1_I42_pn28 S_28 VSS) gpdk090_nmos1v w=0.24u l=0.1u ad=0.0528p as=0.0528p pd=0.68u ps=0.68u
    I_MXI1_I42_I231_MN3 (VSS XI1_I42_I231_Bn XI1_I42_I231_n1 VSS) gpdk090_nmos1v w=0.24u l=0.1u ad=0.0816p as=0.0528p pd=1.16u ps=0.68u
    I_MXI1_I42_I231_MN0 (XI1_I42_I231_An I1_I42_pn28 VSS VSS) gpdk090_nmos1v w=0.12u l=0.1u ad=0.0696p as=0.0696p pd=1.16u ps=1.16u
    I_MXI1_I42_I46_MN1 (XI1_I42_I46_Bn I1_bx14 VSS VSS) gpdk090_nmos1v w=0.12u l=0.1u ad=0.0696p as=0.0696p pd=1.16u ps=1.16u
    I_MXI1_I42_I46_MN5 (XI1_I42_I46_n2 I1_bx14 VSS VSS) gpdk090_nmos1v w=0.24u l=0.1u ad=0.0528p as=0.0816p pd=0.68u ps=1.16u
    I_MXI1_I42_I46_MN4 (I1_I42_pn14 XI1_I42_I46_An XI1_I42_I46_n2 VSS) gpdk090_nmos1v w=0.24u l=0.1u ad=0.0528p as=0.0528p pd=0.68u ps=0.68u
    I_MXI1_I42_I46_MN2 (XI1_I42_I46_n1 A_14 I1_I42_pn14 VSS) gpdk090_nmos1v w=0.24u l=0.1u ad=0.0528p as=0.0528p pd=0.68u ps=0.68u
    I_MXI1_I42_I46_MN3 (VSS XI1_I42_I46_Bn XI1_I42_I46_n1 VSS) gpdk090_nmos1v w=0.24u l=0.1u ad=0.0816p as=0.0528p pd=1.16u ps=0.68u
    I_MXI1_I42_I46_MN0 (XI1_I42_I46_An A_14 VSS VSS) gpdk090_nmos1v w=0.12u l=0.1u ad=0.0696p as=0.0696p pd=1.16u ps=1.16u
    I_MXI1_I42_I60_MN1 (XI1_I42_I60_Bn I1_bx28 VSS VSS) gpdk090_nmos1v w=0.12u l=0.1u ad=0.0696p as=0.0696p pd=1.16u ps=1.16u
    I_MXI1_I42_I60_MN5 (XI1_I42_I60_n2 I1_bx28 VSS VSS) gpdk090_nmos1v w=0.24u l=0.1u ad=0.0528p as=0.0816p pd=0.68u ps=1.16u
    I_MXI1_I42_I60_MN4 (I1_I42_pn28 XI1_I42_I60_An XI1_I42_I60_n2 VSS) gpdk090_nmos1v w=0.24u l=0.1u ad=0.0528p as=0.0528p pd=0.68u ps=0.68u
    I_MXI1_I42_I60_MN2 (XI1_I42_I60_n1 A_28 I1_I42_pn28 VSS) gpdk090_nmos1v w=0.24u l=0.1u ad=0.0528p as=0.0528p pd=0.68u ps=0.68u
    I_MXI1_I42_I60_MN3 (VSS XI1_I42_I60_Bn XI1_I42_I60_n1 VSS) gpdk090_nmos1v w=0.24u l=0.1u ad=0.0816p as=0.0528p pd=1.16u ps=0.68u
    I_MXI1_I42_I60_MN0 (XI1_I42_I60_An A_28 VSS VSS) gpdk090_nmos1v w=0.12u l=0.1u ad=0.0696p as=0.0696p pd=1.16u ps=1.16u
    I_MXI1_I42_I230_MN1 (XI1_I42_I230_Bn I1_I42_G26_0 VSS VSS) gpdk090_nmos1v w=0.12u l=0.1u ad=0.0696p as=0.0696p pd=1.16u ps=1.16u
    I_MXI1_I42_I230_MN5 (XI1_I42_I230_n2 I1_I42_G26_0 VSS VSS) gpdk090_nmos1v w=0.24u l=0.1u ad=0.0528p as=0.0816p pd=0.68u ps=1.16u
    I_MXI1_I42_I230_MN4 (S_27 XI1_I42_I230_An XI1_I42_I230_n2 VSS) gpdk090_nmos1v w=0.24u l=0.1u ad=0.0528p as=0.0528p pd=0.68u ps=0.68u
    I_MXI1_I42_I230_MN2 (XI1_I42_I230_n1 I1_I42_pn27 S_27 VSS) gpdk090_nmos1v w=0.24u l=0.1u ad=0.0528p as=0.0528p pd=0.68u ps=0.68u
    I_MXI1_I42_I230_MN3 (VSS XI1_I42_I230_Bn XI1_I42_I230_n1 VSS) gpdk090_nmos1v w=0.24u l=0.1u ad=0.0816p as=0.0528p pd=1.16u ps=0.68u
    I_MXI1_I42_I230_MN0 (XI1_I42_I230_An I1_I42_pn27 VSS VSS) gpdk090_nmos1v w=0.12u l=0.1u ad=0.0696p as=0.0696p pd=1.16u ps=1.16u
    I_MXI1_I42_I59_MN1 (XI1_I42_I59_Bn I1_bx27 VSS VSS) gpdk090_nmos1v w=0.12u l=0.1u ad=0.0696p as=0.0696p pd=1.16u ps=1.16u
    I_MXI1_I42_I59_MN5 (XI1_I42_I59_n2 I1_bx27 VSS VSS) gpdk090_nmos1v w=0.24u l=0.1u ad=0.0528p as=0.0816p pd=0.68u ps=1.16u
    I_MXI1_I42_I59_MN4 (I1_I42_pn27 XI1_I42_I59_An XI1_I42_I59_n2 VSS) gpdk090_nmos1v w=0.24u l=0.1u ad=0.0528p as=0.0528p pd=0.68u ps=0.68u
    I_MXI1_I42_I59_MN2 (XI1_I42_I59_n1 A_27 I1_I42_pn27 VSS) gpdk090_nmos1v w=0.24u l=0.1u ad=0.0528p as=0.0528p pd=0.68u ps=0.68u
    I_MXI1_I42_I59_MN3 (VSS XI1_I42_I59_Bn XI1_I42_I59_n1 VSS) gpdk090_nmos1v w=0.24u l=0.1u ad=0.0816p as=0.0528p pd=1.16u ps=0.68u
    I_MXI1_I42_I59_MN0 (XI1_I42_I59_An A_27 VSS VSS) gpdk090_nmos1v w=0.12u l=0.1u ad=0.0696p as=0.0696p pd=1.16u ps=1.16u
    I_MXI1_I42_I229_MN1 (XI1_I42_I229_Bn I1_I42_G25_0 VSS VSS) gpdk090_nmos1v w=0.12u l=0.1u ad=0.0696p as=0.0696p pd=1.16u ps=1.16u
    I_MXI1_I42_I229_MN5 (XI1_I42_I229_n2 I1_I42_G25_0 VSS VSS) gpdk090_nmos1v w=0.24u l=0.1u ad=0.0528p as=0.0816p pd=0.68u ps=1.16u
    I_MXI1_I42_I229_MN4 (S_26 XI1_I42_I229_An XI1_I42_I229_n2 VSS) gpdk090_nmos1v w=0.24u l=0.1u ad=0.0528p as=0.0528p pd=0.68u ps=0.68u
    I_MXI1_I42_I229_MN2 (XI1_I42_I229_n1 I1_I42_pn26 S_26 VSS) gpdk090_nmos1v w=0.24u l=0.1u ad=0.0528p as=0.0528p pd=0.68u ps=0.68u
    I_MXI1_I42_I229_MN3 (VSS XI1_I42_I229_Bn XI1_I42_I229_n1 VSS) gpdk090_nmos1v w=0.24u l=0.1u ad=0.0816p as=0.0528p pd=1.16u ps=0.68u
    I_MXI1_I42_I229_MN0 (XI1_I42_I229_An I1_I42_pn26 VSS VSS) gpdk090_nmos1v w=0.12u l=0.1u ad=0.0696p as=0.0696p pd=1.16u ps=1.16u
    I_MXI1_I42_I227_MN1 (XI1_I42_I227_Bn I1_I42_G23_0 VSS VSS) gpdk090_nmos1v w=0.12u l=0.1u ad=0.0696p as=0.0696p pd=1.16u ps=1.16u
    I_MXI1_I42_I227_MN5 (XI1_I42_I227_n2 I1_I42_G23_0 VSS VSS) gpdk090_nmos1v w=0.24u l=0.1u ad=0.0528p as=0.0816p pd=0.68u ps=1.16u
    I_MXI1_I42_I227_MN4 (S_24 XI1_I42_I227_An XI1_I42_I227_n2 VSS) gpdk090_nmos1v w=0.24u l=0.1u ad=0.0528p as=0.0528p pd=0.68u ps=0.68u
    I_MXI1_I42_I227_MN2 (XI1_I42_I227_n1 I1_I42_pn24 S_24 VSS) gpdk090_nmos1v w=0.24u l=0.1u ad=0.0528p as=0.0528p pd=0.68u ps=0.68u
    I_MXI1_I42_I227_MN3 (VSS XI1_I42_I227_Bn XI1_I42_I227_n1 VSS) gpdk090_nmos1v w=0.24u l=0.1u ad=0.0816p as=0.0528p pd=1.16u ps=0.68u
    I_MXI1_I42_I227_MN0 (XI1_I42_I227_An I1_I42_pn24 VSS VSS) gpdk090_nmos1v w=0.12u l=0.1u ad=0.0696p as=0.0696p pd=1.16u ps=1.16u
    I_MXI1_I42_I226_MN1 (XI1_I42_I226_Bn I1_I42_G22_0 VSS VSS) gpdk090_nmos1v w=0.12u l=0.1u ad=0.0696p as=0.0696p pd=1.16u ps=1.16u
    I_MXI1_I42_I226_MN5 (XI1_I42_I226_n2 I1_I42_G22_0 VSS VSS) gpdk090_nmos1v w=0.24u l=0.1u ad=0.0528p as=0.0816p pd=0.68u ps=1.16u
    I_MXI1_I42_I226_MN4 (S_23 XI1_I42_I226_An XI1_I42_I226_n2 VSS) gpdk090_nmos1v w=0.24u l=0.1u ad=0.0528p as=0.0528p pd=0.68u ps=0.68u
    I_MXI1_I42_I226_MN2 (XI1_I42_I226_n1 I1_I42_pn23 S_23 VSS) gpdk090_nmos1v w=0.24u l=0.1u ad=0.0528p as=0.0528p pd=0.68u ps=0.68u
    I_MXI1_I42_I226_MN3 (VSS XI1_I42_I226_Bn XI1_I42_I226_n1 VSS) gpdk090_nmos1v w=0.24u l=0.1u ad=0.0816p as=0.0528p pd=1.16u ps=0.68u
    I_MXI1_I42_I226_MN0 (XI1_I42_I226_An I1_I42_pn23 VSS VSS) gpdk090_nmos1v w=0.12u l=0.1u ad=0.0696p as=0.0696p pd=1.16u ps=1.16u
    I_MXI1_I42_I222_MN1 (XI1_I42_I222_Bn I1_I42_G18_0 VSS VSS) gpdk090_nmos1v w=0.12u l=0.1u ad=0.0696p as=0.0696p pd=1.16u ps=1.16u
    I_MXI1_I42_I222_MN5 (XI1_I42_I222_n2 I1_I42_G18_0 VSS VSS) gpdk090_nmos1v w=0.24u l=0.1u ad=0.0528p as=0.0816p pd=0.68u ps=1.16u
    I_MXI1_I42_I222_MN4 (S_19 XI1_I42_I222_An XI1_I42_I222_n2 VSS) gpdk090_nmos1v w=0.24u l=0.1u ad=0.0528p as=0.0528p pd=0.68u ps=0.68u
    I_MXI1_I42_I222_MN2 (XI1_I42_I222_n1 I1_I42_pn19 S_19 VSS) gpdk090_nmos1v w=0.24u l=0.1u ad=0.0528p as=0.0528p pd=0.68u ps=0.68u
    I_MXI1_I42_I222_MN3 (VSS XI1_I42_I222_Bn XI1_I42_I222_n1 VSS) gpdk090_nmos1v w=0.24u l=0.1u ad=0.0816p as=0.0528p pd=1.16u ps=0.68u
    I_MXI1_I42_I222_MN0 (XI1_I42_I222_An I1_I42_pn19 VSS VSS) gpdk090_nmos1v w=0.12u l=0.1u ad=0.0696p as=0.0696p pd=1.16u ps=1.16u
    I_MXI1_I42_I47_MN1 (XI1_I42_I47_Bn I1_bx15 VSS VSS) gpdk090_nmos1v w=0.12u l=0.1u ad=0.0696p as=0.0696p pd=1.16u ps=1.16u
    I_MXI1_I42_I47_MN5 (XI1_I42_I47_n2 I1_bx15 VSS VSS) gpdk090_nmos1v w=0.24u l=0.1u ad=0.0528p as=0.0816p pd=0.68u ps=1.16u
    I_MXI1_I42_I47_MN4 (I1_I42_pn15 XI1_I42_I47_An XI1_I42_I47_n2 VSS) gpdk090_nmos1v w=0.24u l=0.1u ad=0.0528p as=0.0528p pd=0.68u ps=0.68u
    I_MXI1_I42_I47_MN2 (XI1_I42_I47_n1 A_15 I1_I42_pn15 VSS) gpdk090_nmos1v w=0.24u l=0.1u ad=0.0528p as=0.0528p pd=0.68u ps=0.68u
    I_MXI1_I42_I47_MN3 (VSS XI1_I42_I47_Bn XI1_I42_I47_n1 VSS) gpdk090_nmos1v w=0.24u l=0.1u ad=0.0816p as=0.0528p pd=1.16u ps=0.68u
    I_MXI1_I42_I47_MN0 (XI1_I42_I47_An A_15 VSS VSS) gpdk090_nmos1v w=0.12u l=0.1u ad=0.0696p as=0.0696p pd=1.16u ps=1.16u
    I_MXI1_I42_I58_MN1 (XI1_I42_I58_Bn I1_bx26 VSS VSS) gpdk090_nmos1v w=0.12u l=0.1u ad=0.0696p as=0.0696p pd=1.16u ps=1.16u
    I_MXI1_I42_I58_MN5 (XI1_I42_I58_n2 I1_bx26 VSS VSS) gpdk090_nmos1v w=0.24u l=0.1u ad=0.0528p as=0.0816p pd=0.68u ps=1.16u
    I_MXI1_I42_I58_MN4 (I1_I42_pn26 XI1_I42_I58_An XI1_I42_I58_n2 VSS) gpdk090_nmos1v w=0.24u l=0.1u ad=0.0528p as=0.0528p pd=0.68u ps=0.68u
    I_MXI1_I42_I58_MN2 (XI1_I42_I58_n1 A_26 I1_I42_pn26 VSS) gpdk090_nmos1v w=0.24u l=0.1u ad=0.0528p as=0.0528p pd=0.68u ps=0.68u
    I_MXI1_I42_I58_MN3 (VSS XI1_I42_I58_Bn XI1_I42_I58_n1 VSS) gpdk090_nmos1v w=0.24u l=0.1u ad=0.0816p as=0.0528p pd=1.16u ps=0.68u
    I_MXI1_I42_I58_MN0 (XI1_I42_I58_An A_26 VSS VSS) gpdk090_nmos1v w=0.12u l=0.1u ad=0.0696p as=0.0696p pd=1.16u ps=1.16u
    I_MXI1_I42_I228_MN1 (XI1_I42_I228_Bn I1_I42_G24_0 VSS VSS) gpdk090_nmos1v w=0.12u l=0.1u ad=0.0696p as=0.0696p pd=1.16u ps=1.16u
    I_MXI1_I42_I228_MN5 (XI1_I42_I228_n2 I1_I42_G24_0 VSS VSS) gpdk090_nmos1v w=0.24u l=0.1u ad=0.0528p as=0.0816p pd=0.68u ps=1.16u
    I_MXI1_I42_I228_MN4 (S_25 XI1_I42_I228_An XI1_I42_I228_n2 VSS) gpdk090_nmos1v w=0.24u l=0.1u ad=0.0528p as=0.0528p pd=0.68u ps=0.68u
    I_MXI1_I42_I228_MN2 (XI1_I42_I228_n1 I1_I42_pn25 S_25 VSS) gpdk090_nmos1v w=0.24u l=0.1u ad=0.0528p as=0.0528p pd=0.68u ps=0.68u
    I_MXI1_I42_I228_MN3 (VSS XI1_I42_I228_Bn XI1_I42_I228_n1 VSS) gpdk090_nmos1v w=0.24u l=0.1u ad=0.0816p as=0.0528p pd=1.16u ps=0.68u
    I_MXI1_I42_I228_MN0 (XI1_I42_I228_An I1_I42_pn25 VSS VSS) gpdk090_nmos1v w=0.12u l=0.1u ad=0.0696p as=0.0696p pd=1.16u ps=1.16u
    I_MXI1_I42_I56_MN1 (XI1_I42_I56_Bn I1_bx24 VSS VSS) gpdk090_nmos1v w=0.12u l=0.1u ad=0.0696p as=0.0696p pd=1.16u ps=1.16u
    I_MXI1_I42_I56_MN5 (XI1_I42_I56_n2 I1_bx24 VSS VSS) gpdk090_nmos1v w=0.24u l=0.1u ad=0.0528p as=0.0816p pd=0.68u ps=1.16u
    I_MXI1_I42_I56_MN4 (I1_I42_pn24 XI1_I42_I56_An XI1_I42_I56_n2 VSS) gpdk090_nmos1v w=0.24u l=0.1u ad=0.0528p as=0.0528p pd=0.68u ps=0.68u
    I_MXI1_I42_I56_MN2 (XI1_I42_I56_n1 A_24 I1_I42_pn24 VSS) gpdk090_nmos1v w=0.24u l=0.1u ad=0.0528p as=0.0528p pd=0.68u ps=0.68u
    I_MXI1_I42_I56_MN3 (VSS XI1_I42_I56_Bn XI1_I42_I56_n1 VSS) gpdk090_nmos1v w=0.24u l=0.1u ad=0.0816p as=0.0528p pd=1.16u ps=0.68u
    I_MXI1_I42_I56_MN0 (XI1_I42_I56_An A_24 VSS VSS) gpdk090_nmos1v w=0.12u l=0.1u ad=0.0696p as=0.0696p pd=1.16u ps=1.16u
    I_MXI1_I42_I55_MN1 (XI1_I42_I55_Bn I1_bx23 VSS VSS) gpdk090_nmos1v w=0.12u l=0.1u ad=0.0696p as=0.0696p pd=1.16u ps=1.16u
    I_MXI1_I42_I55_MN5 (XI1_I42_I55_n2 I1_bx23 VSS VSS) gpdk090_nmos1v w=0.24u l=0.1u ad=0.0528p as=0.0816p pd=0.68u ps=1.16u
    I_MXI1_I42_I55_MN4 (I1_I42_pn23 XI1_I42_I55_An XI1_I42_I55_n2 VSS) gpdk090_nmos1v w=0.24u l=0.1u ad=0.0528p as=0.0528p pd=0.68u ps=0.68u
    I_MXI1_I42_I55_MN2 (XI1_I42_I55_n1 A_23 I1_I42_pn23 VSS) gpdk090_nmos1v w=0.24u l=0.1u ad=0.0528p as=0.0528p pd=0.68u ps=0.68u
    I_MXI1_I42_I55_MN3 (VSS XI1_I42_I55_Bn XI1_I42_I55_n1 VSS) gpdk090_nmos1v w=0.24u l=0.1u ad=0.0816p as=0.0528p pd=1.16u ps=0.68u
    I_MXI1_I42_I55_MN0 (XI1_I42_I55_An A_23 VSS VSS) gpdk090_nmos1v w=0.12u l=0.1u ad=0.0696p as=0.0696p pd=1.16u ps=1.16u
    I_MXI1_I42_I225_MN1 (XI1_I42_I225_Bn I1_I42_G21_0 VSS VSS) gpdk090_nmos1v w=0.12u l=0.1u ad=0.0696p as=0.0696p pd=1.16u ps=1.16u
    I_MXI1_I42_I225_MN5 (XI1_I42_I225_n2 I1_I42_G21_0 VSS VSS) gpdk090_nmos1v w=0.24u l=0.1u ad=0.0528p as=0.0816p pd=0.68u ps=1.16u
    I_MXI1_I42_I225_MN4 (S_22 XI1_I42_I225_An XI1_I42_I225_n2 VSS) gpdk090_nmos1v w=0.24u l=0.1u ad=0.0528p as=0.0528p pd=0.68u ps=0.68u
    I_MXI1_I42_I225_MN2 (XI1_I42_I225_n1 I1_I42_pn22 S_22 VSS) gpdk090_nmos1v w=0.24u l=0.1u ad=0.0528p as=0.0528p pd=0.68u ps=0.68u
    I_MXI1_I42_I225_MN3 (VSS XI1_I42_I225_Bn XI1_I42_I225_n1 VSS) gpdk090_nmos1v w=0.24u l=0.1u ad=0.0816p as=0.0528p pd=1.16u ps=0.68u
    I_MXI1_I42_I225_MN0 (XI1_I42_I225_An I1_I42_pn22 VSS VSS) gpdk090_nmos1v w=0.12u l=0.1u ad=0.0696p as=0.0696p pd=1.16u ps=1.16u
    I_MXI1_I42_I53_MN1 (XI1_I42_I53_Bn I1_bx21 VSS VSS) gpdk090_nmos1v w=0.12u l=0.1u ad=0.0696p as=0.0696p pd=1.16u ps=1.16u
    I_MXI1_I42_I53_MN5 (XI1_I42_I53_n2 I1_bx21 VSS VSS) gpdk090_nmos1v w=0.24u l=0.1u ad=0.0528p as=0.0816p pd=0.68u ps=1.16u
    I_MXI1_I42_I53_MN4 (I1_I42_pn21 XI1_I42_I53_An XI1_I42_I53_n2 VSS) gpdk090_nmos1v w=0.24u l=0.1u ad=0.0528p as=0.0528p pd=0.68u ps=0.68u
    I_MXI1_I42_I53_MN2 (XI1_I42_I53_n1 A_21 I1_I42_pn21 VSS) gpdk090_nmos1v w=0.24u l=0.1u ad=0.0528p as=0.0528p pd=0.68u ps=0.68u
    I_MXI1_I42_I53_MN3 (VSS XI1_I42_I53_Bn XI1_I42_I53_n1 VSS) gpdk090_nmos1v w=0.24u l=0.1u ad=0.0816p as=0.0528p pd=1.16u ps=0.68u
    I_MXI1_I42_I53_MN0 (XI1_I42_I53_An A_21 VSS VSS) gpdk090_nmos1v w=0.12u l=0.1u ad=0.0696p as=0.0696p pd=1.16u ps=1.16u
    I_MXI1_I42_I224_MN1 (XI1_I42_I224_Bn I1_I42_G20_0 VSS VSS) gpdk090_nmos1v w=0.12u l=0.1u ad=0.0696p as=0.0696p pd=1.16u ps=1.16u
    I_MXI1_I42_I224_MN5 (XI1_I42_I224_n2 I1_I42_G20_0 VSS VSS) gpdk090_nmos1v w=0.24u l=0.1u ad=0.0528p as=0.0816p pd=0.68u ps=1.16u
    I_MXI1_I42_I224_MN4 (S_21 XI1_I42_I224_An XI1_I42_I224_n2 VSS) gpdk090_nmos1v w=0.24u l=0.1u ad=0.0528p as=0.0528p pd=0.68u ps=0.68u
    I_MXI1_I42_I224_MN2 (XI1_I42_I224_n1 I1_I42_pn21 S_21 VSS) gpdk090_nmos1v w=0.24u l=0.1u ad=0.0528p as=0.0528p pd=0.68u ps=0.68u
    I_MXI1_I42_I224_MN3 (VSS XI1_I42_I224_Bn XI1_I42_I224_n1 VSS) gpdk090_nmos1v w=0.24u l=0.1u ad=0.0816p as=0.0528p pd=1.16u ps=0.68u
    I_MXI1_I42_I224_MN0 (XI1_I42_I224_An I1_I42_pn21 VSS VSS) gpdk090_nmos1v w=0.12u l=0.1u ad=0.0696p as=0.0696p pd=1.16u ps=1.16u
    I_MXI1_I42_I52_MN1 (XI1_I42_I52_Bn I1_bx20 VSS VSS) gpdk090_nmos1v w=0.12u l=0.1u ad=0.0696p as=0.0696p pd=1.16u ps=1.16u
    I_MXI1_I42_I52_MN5 (XI1_I42_I52_n2 I1_bx20 VSS VSS) gpdk090_nmos1v w=0.24u l=0.1u ad=0.0528p as=0.0816p pd=0.68u ps=1.16u
    I_MXI1_I42_I52_MN4 (I1_I42_pn20 XI1_I42_I52_An XI1_I42_I52_n2 VSS) gpdk090_nmos1v w=0.24u l=0.1u ad=0.0528p as=0.0528p pd=0.68u ps=0.68u
    I_MXI1_I42_I52_MN2 (XI1_I42_I52_n1 A_20 I1_I42_pn20 VSS) gpdk090_nmos1v w=0.24u l=0.1u ad=0.0528p as=0.0528p pd=0.68u ps=0.68u
    I_MXI1_I42_I52_MN3 (VSS XI1_I42_I52_Bn XI1_I42_I52_n1 VSS) gpdk090_nmos1v w=0.24u l=0.1u ad=0.0816p as=0.0528p pd=1.16u ps=0.68u
    I_MXI1_I42_I52_MN0 (XI1_I42_I52_An A_20 VSS VSS) gpdk090_nmos1v w=0.12u l=0.1u ad=0.0696p as=0.0696p pd=1.16u ps=1.16u
    I_MXI1_I42_I223_MN1 (XI1_I42_I223_Bn I1_I42_G19_0 VSS VSS) gpdk090_nmos1v w=0.12u l=0.1u ad=0.0696p as=0.0696p pd=1.16u ps=1.16u
    I_MXI1_I42_I223_MN5 (XI1_I42_I223_n2 I1_I42_G19_0 VSS VSS) gpdk090_nmos1v w=0.24u l=0.1u ad=0.0528p as=0.0816p pd=0.68u ps=1.16u
    I_MXI1_I42_I223_MN4 (S_20 XI1_I42_I223_An XI1_I42_I223_n2 VSS) gpdk090_nmos1v w=0.24u l=0.1u ad=0.0528p as=0.0528p pd=0.68u ps=0.68u
    I_MXI1_I42_I223_MN2 (XI1_I42_I223_n1 I1_I42_pn20 S_20 VSS) gpdk090_nmos1v w=0.24u l=0.1u ad=0.0528p as=0.0528p pd=0.68u ps=0.68u
    I_MXI1_I42_I223_MN3 (VSS XI1_I42_I223_Bn XI1_I42_I223_n1 VSS) gpdk090_nmos1v w=0.24u l=0.1u ad=0.0816p as=0.0528p pd=1.16u ps=0.68u
    I_MXI1_I42_I223_MN0 (XI1_I42_I223_An I1_I42_pn20 VSS VSS) gpdk090_nmos1v w=0.12u l=0.1u ad=0.0696p as=0.0696p pd=1.16u ps=1.16u
    I_MXI1_I42_I51_MN1 (XI1_I42_I51_Bn I1_bx19 VSS VSS) gpdk090_nmos1v w=0.12u l=0.1u ad=0.0696p as=0.0696p pd=1.16u ps=1.16u
    I_MXI1_I42_I51_MN5 (XI1_I42_I51_n2 I1_bx19 VSS VSS) gpdk090_nmos1v w=0.24u l=0.1u ad=0.0528p as=0.0816p pd=0.68u ps=1.16u
    I_MXI1_I42_I51_MN4 (I1_I42_pn19 XI1_I42_I51_An XI1_I42_I51_n2 VSS) gpdk090_nmos1v w=0.24u l=0.1u ad=0.0528p as=0.0528p pd=0.68u ps=0.68u
    I_MXI1_I42_I51_MN2 (XI1_I42_I51_n1 A_19 I1_I42_pn19 VSS) gpdk090_nmos1v w=0.24u l=0.1u ad=0.0528p as=0.0528p pd=0.68u ps=0.68u
    I_MXI1_I42_I51_MN3 (VSS XI1_I42_I51_Bn XI1_I42_I51_n1 VSS) gpdk090_nmos1v w=0.24u l=0.1u ad=0.0816p as=0.0528p pd=1.16u ps=0.68u
    I_MXI1_I42_I51_MN0 (XI1_I42_I51_An A_19 VSS VSS) gpdk090_nmos1v w=0.12u l=0.1u ad=0.0696p as=0.0696p pd=1.16u ps=1.16u
    I_MXI1_I42_I221_MN1 (XI1_I42_I221_Bn I1_I42_G17_0 VSS VSS) gpdk090_nmos1v w=0.12u l=0.1u ad=0.0696p as=0.0696p pd=1.16u ps=1.16u
    I_MXI1_I42_I221_MN5 (XI1_I42_I221_n2 I1_I42_G17_0 VSS VSS) gpdk090_nmos1v w=0.24u l=0.1u ad=0.0528p as=0.0816p pd=0.68u ps=1.16u
    I_MXI1_I42_I221_MN4 (S_18 XI1_I42_I221_An XI1_I42_I221_n2 VSS) gpdk090_nmos1v w=0.24u l=0.1u ad=0.0528p as=0.0528p pd=0.68u ps=0.68u
    I_MXI1_I42_I221_MN2 (XI1_I42_I221_n1 I1_I42_pn18 S_18 VSS) gpdk090_nmos1v w=0.24u l=0.1u ad=0.0528p as=0.0528p pd=0.68u ps=0.68u
    I_MXI1_I42_I221_MN3 (VSS XI1_I42_I221_Bn XI1_I42_I221_n1 VSS) gpdk090_nmos1v w=0.24u l=0.1u ad=0.0816p as=0.0528p pd=1.16u ps=0.68u
    I_MXI1_I42_I221_MN0 (XI1_I42_I221_An I1_I42_pn18 VSS VSS) gpdk090_nmos1v w=0.12u l=0.1u ad=0.0696p as=0.0696p pd=1.16u ps=1.16u
    I_MXI1_I42_I50_MN1 (XI1_I42_I50_Bn I1_bx18 VSS VSS) gpdk090_nmos1v w=0.12u l=0.1u ad=0.0696p as=0.0696p pd=1.16u ps=1.16u
    I_MXI1_I42_I50_MN5 (XI1_I42_I50_n2 I1_bx18 VSS VSS) gpdk090_nmos1v w=0.24u l=0.1u ad=0.0528p as=0.0816p pd=0.68u ps=1.16u
    I_MXI1_I42_I50_MN4 (I1_I42_pn18 XI1_I42_I50_An XI1_I42_I50_n2 VSS) gpdk090_nmos1v w=0.24u l=0.1u ad=0.0528p as=0.0528p pd=0.68u ps=0.68u
    I_MXI1_I42_I50_MN2 (XI1_I42_I50_n1 A_18 I1_I42_pn18 VSS) gpdk090_nmos1v w=0.24u l=0.1u ad=0.0528p as=0.0528p pd=0.68u ps=0.68u
    I_MXI1_I42_I50_MN3 (VSS XI1_I42_I50_Bn XI1_I42_I50_n1 VSS) gpdk090_nmos1v w=0.24u l=0.1u ad=0.0816p as=0.0528p pd=1.16u ps=0.68u
    I_MXI1_I42_I50_MN0 (XI1_I42_I50_An A_18 VSS VSS) gpdk090_nmos1v w=0.12u l=0.1u ad=0.0696p as=0.0696p pd=1.16u ps=1.16u
    I_MXI1_I42_I220_MN1 (XI1_I42_I220_Bn I1_I42_G16_0 VSS VSS) gpdk090_nmos1v w=0.12u l=0.1u ad=0.0696p as=0.0696p pd=1.16u ps=1.16u
    I_MXI1_I42_I220_MN5 (XI1_I42_I220_n2 I1_I42_G16_0 VSS VSS) gpdk090_nmos1v w=0.24u l=0.1u ad=0.0528p as=0.0816p pd=0.68u ps=1.16u
    I_MXI1_I42_I220_MN4 (S_17 XI1_I42_I220_An XI1_I42_I220_n2 VSS) gpdk090_nmos1v w=0.24u l=0.1u ad=0.0528p as=0.0528p pd=0.68u ps=0.68u
    I_MXI1_I42_I220_MN2 (XI1_I42_I220_n1 I1_I42_pn17 S_17 VSS) gpdk090_nmos1v w=0.24u l=0.1u ad=0.0528p as=0.0528p pd=0.68u ps=0.68u
    I_MXI1_I42_I220_MN3 (VSS XI1_I42_I220_Bn XI1_I42_I220_n1 VSS) gpdk090_nmos1v w=0.24u l=0.1u ad=0.0816p as=0.0528p pd=1.16u ps=0.68u
    I_MXI1_I42_I220_MN0 (XI1_I42_I220_An I1_I42_pn17 VSS VSS) gpdk090_nmos1v w=0.12u l=0.1u ad=0.0696p as=0.0696p pd=1.16u ps=1.16u
    I_MXI1_I42_I48_MN1 (XI1_I42_I48_Bn I1_bx16 VSS VSS) gpdk090_nmos1v w=0.12u l=0.1u ad=0.0696p as=0.0696p pd=1.16u ps=1.16u
    I_MXI1_I42_I48_MN5 (XI1_I42_I48_n2 I1_bx16 VSS VSS) gpdk090_nmos1v w=0.24u l=0.1u ad=0.0528p as=0.0816p pd=0.68u ps=1.16u
    I_MXI1_I42_I48_MN4 (I1_I42_pn16 XI1_I42_I48_An XI1_I42_I48_n2 VSS) gpdk090_nmos1v w=0.24u l=0.1u ad=0.0528p as=0.0528p pd=0.68u ps=0.68u
    I_MXI1_I42_I48_MN2 (XI1_I42_I48_n1 A_16 I1_I42_pn16 VSS) gpdk090_nmos1v w=0.24u l=0.1u ad=0.0528p as=0.0528p pd=0.68u ps=0.68u
    I_MXI1_I42_I48_MN3 (VSS XI1_I42_I48_Bn XI1_I42_I48_n1 VSS) gpdk090_nmos1v w=0.24u l=0.1u ad=0.0816p as=0.0528p pd=1.16u ps=0.68u
    I_MXI1_I42_I48_MN0 (XI1_I42_I48_An A_16 VSS VSS) gpdk090_nmos1v w=0.12u l=0.1u ad=0.0696p as=0.0696p pd=1.16u ps=1.16u
    I_MXI1_I42_I57_MN1 (XI1_I42_I57_Bn I1_bx25 VSS VSS) gpdk090_nmos1v w=0.12u l=0.1u ad=0.0696p as=0.0696p pd=1.16u ps=1.16u
    I_MXI1_I42_I57_MN5 (XI1_I42_I57_n2 I1_bx25 VSS VSS) gpdk090_nmos1v w=0.24u l=0.1u ad=0.0528p as=0.0816p pd=0.68u ps=1.16u
    I_MXI1_I42_I57_MN4 (I1_I42_pn25 XI1_I42_I57_An XI1_I42_I57_n2 VSS) gpdk090_nmos1v w=0.24u l=0.1u ad=0.0528p as=0.0528p pd=0.68u ps=0.68u
    I_MXI1_I42_I57_MN2 (XI1_I42_I57_n1 A_25 I1_I42_pn25 VSS) gpdk090_nmos1v w=0.24u l=0.1u ad=0.0528p as=0.0528p pd=0.68u ps=0.68u
    I_MXI1_I42_I57_MN3 (VSS XI1_I42_I57_Bn XI1_I42_I57_n1 VSS) gpdk090_nmos1v w=0.24u l=0.1u ad=0.0816p as=0.0528p pd=1.16u ps=0.68u
    I_MXI1_I42_I57_MN0 (XI1_I42_I57_An A_25 VSS VSS) gpdk090_nmos1v w=0.12u l=0.1u ad=0.0696p as=0.0696p pd=1.16u ps=1.16u
    I_MXI1_I42_I54_MN1 (XI1_I42_I54_Bn I1_bx22 VSS VSS) gpdk090_nmos1v w=0.12u l=0.1u ad=0.0696p as=0.0696p pd=1.16u ps=1.16u
    I_MXI1_I42_I54_MN5 (XI1_I42_I54_n2 I1_bx22 VSS VSS) gpdk090_nmos1v w=0.24u l=0.1u ad=0.0528p as=0.0816p pd=0.68u ps=1.16u
    I_MXI1_I42_I54_MN4 (I1_I42_pn22 XI1_I42_I54_An XI1_I42_I54_n2 VSS) gpdk090_nmos1v w=0.24u l=0.1u ad=0.0528p as=0.0528p pd=0.68u ps=0.68u
    I_MXI1_I42_I54_MN2 (XI1_I42_I54_n1 A_22 I1_I42_pn22 VSS) gpdk090_nmos1v w=0.24u l=0.1u ad=0.0528p as=0.0528p pd=0.68u ps=0.68u
    I_MXI1_I42_I54_MN3 (VSS XI1_I42_I54_Bn XI1_I42_I54_n1 VSS) gpdk090_nmos1v w=0.24u l=0.1u ad=0.0816p as=0.0528p pd=1.16u ps=0.68u
    I_MXI1_I42_I54_MN0 (XI1_I42_I54_An A_22 VSS VSS) gpdk090_nmos1v w=0.12u l=0.1u ad=0.0696p as=0.0696p pd=1.16u ps=1.16u
    I_MXI1_I42_I49_MN1 (XI1_I42_I49_Bn I1_bx17 VSS VSS) gpdk090_nmos1v w=0.12u l=0.1u ad=0.0696p as=0.0696p pd=1.16u ps=1.16u
    I_MXI1_I42_I49_MN5 (XI1_I42_I49_n2 I1_bx17 VSS VSS) gpdk090_nmos1v w=0.24u l=0.1u ad=0.0528p as=0.0816p pd=0.68u ps=1.16u
    I_MXI1_I42_I49_MN4 (I1_I42_pn17 XI1_I42_I49_An XI1_I42_I49_n2 VSS) gpdk090_nmos1v w=0.24u l=0.1u ad=0.0528p as=0.0528p pd=0.68u ps=0.68u
    I_MXI1_I42_I49_MN2 (XI1_I42_I49_n1 A_17 I1_I42_pn17 VSS) gpdk090_nmos1v w=0.24u l=0.1u ad=0.0528p as=0.0528p pd=0.68u ps=0.68u
    I_MXI1_I42_I49_MN3 (VSS XI1_I42_I49_Bn XI1_I42_I49_n1 VSS) gpdk090_nmos1v w=0.24u l=0.1u ad=0.0816p as=0.0528p pd=1.16u ps=0.68u
    I_MXI1_I42_I49_MN0 (XI1_I42_I49_An A_17 VSS VSS) gpdk090_nmos1v w=0.12u l=0.1u ad=0.0696p as=0.0696p pd=1.16u ps=1.16u
    I_MXI3_I69_MN1 (I3_SEL_DIV_b3_8 I3_SEL_DIV_b2_2 VSS VSS) gpdk090_nmos1v w=0.24u l=0.1u ad=0.0528p as=0.0816p pd=0.68u ps=1.16u
    I_MXI3_I69_MN1_1 (VSS I3_SEL_DIV_b2_2 I3_SEL_DIV_b3_8 VSS) gpdk090_nmos1v w=0.24u l=0.1u ad=0.0816p as=0.0528p pd=1.16u ps=0.68u
    I_MXI3_I70_MN1 (I3_SEL_DIV_b3_9 I3_SEL_DIV_b2_2 VSS VSS) gpdk090_nmos1v w=0.24u l=0.1u ad=0.0528p as=0.0816p pd=0.68u ps=1.16u
    I_MXI3_I70_MN1_1 (VSS I3_SEL_DIV_b2_2 I3_SEL_DIV_b3_9 VSS) gpdk090_nmos1v w=0.24u l=0.1u ad=0.0816p as=0.0528p pd=1.16u ps=0.68u
    I_MXI3_I54_MN1 (I3_SEL_MUL_b3_9 I3_SEL_MUL_b2_2 VSS VSS) gpdk090_nmos1v w=0.24u l=0.1u ad=0.0528p as=0.0816p pd=0.68u ps=1.16u
    I_MXI3_I54_MN1_1 (VSS I3_SEL_MUL_b2_2 I3_SEL_MUL_b3_9 VSS) gpdk090_nmos1v w=0.24u l=0.1u ad=0.0816p as=0.0528p pd=1.16u ps=0.68u
    I_MXI3_I55_MN1 (I3_SEL_MUL_b3_10 I3_SEL_MUL_b2_2 VSS VSS) gpdk090_nmos1v w=0.24u l=0.1u ad=0.0528p as=0.0816p pd=0.68u ps=1.16u
    I_MXI3_I55_MN1_1 (VSS I3_SEL_MUL_b2_2 I3_SEL_MUL_b3_10 VSS) gpdk090_nmos1v w=0.24u l=0.1u ad=0.0816p as=0.0528p pd=1.16u ps=0.68u
    I_MXI3_I71_MN1 (I3_SEL_DIV_b3_10 I3_SEL_DIV_b2_2 VSS VSS) gpdk090_nmos1v w=0.24u l=0.1u ad=0.0528p as=0.0816p pd=0.68u ps=1.16u
    I_MXI3_I71_MN1_1 (VSS I3_SEL_DIV_b2_2 I3_SEL_DIV_b3_10 VSS) gpdk090_nmos1v w=0.24u l=0.1u ad=0.0816p as=0.0528p pd=1.16u ps=0.68u
    I_MXI3_I53_MN1 (I3_SEL_MUL_b3_8 I3_SEL_MUL_b2_2 VSS VSS) gpdk090_nmos1v w=0.24u l=0.1u ad=0.0528p as=0.0816p pd=0.68u ps=1.16u
    I_MXI3_I53_MN1_1 (VSS I3_SEL_MUL_b2_2 I3_SEL_MUL_b3_8 VSS) gpdk090_nmos1v w=0.24u l=0.1u ad=0.0816p as=0.0528p pd=1.16u ps=0.68u
    I_MXI3_I44_MN1 (I3_SEL_MUL_b2_2 I3_SEL_MUL_b1_0 VSS VSS) gpdk090_nmos1v w=0.24u l=0.1u ad=0.0528p as=0.0816p pd=0.68u ps=1.16u
    I_MXI3_I44_MN1_1 (VSS I3_SEL_MUL_b1_0 I3_SEL_MUL_b2_2 VSS) gpdk090_nmos1v w=0.24u l=0.1u ad=0.0816p as=0.0528p pd=1.16u ps=0.68u
    I_MXI3_I60_MN1 (I3_SEL_DIV_b2_2 I3_SEL_DIV_b1_0 VSS VSS) gpdk090_nmos1v w=0.24u l=0.1u ad=0.0528p as=0.0816p pd=0.68u ps=1.16u
    I_MXI3_I60_MN1_1 (VSS I3_SEL_DIV_b1_0 I3_SEL_DIV_b2_2 VSS) gpdk090_nmos1v w=0.24u l=0.1u ad=0.0816p as=0.0528p pd=1.16u ps=0.68u
    I_MXI3_I46_MN1 (I3_SEL_MUL_b3_1 I3_SEL_MUL_b2_0 VSS VSS) gpdk090_nmos1v w=0.24u l=0.1u ad=0.0528p as=0.0816p pd=0.68u ps=1.16u
    I_MXI3_I46_MN1_1 (VSS I3_SEL_MUL_b2_0 I3_SEL_MUL_b3_1 VSS) gpdk090_nmos1v w=0.24u l=0.1u ad=0.0816p as=0.0528p pd=1.16u ps=0.68u
    I_MXI3_I62_MN1 (I3_SEL_DIV_b3_1 I3_SEL_DIV_b2_0 VSS VSS) gpdk090_nmos1v w=0.24u l=0.1u ad=0.0528p as=0.0816p pd=0.68u ps=1.16u
    I_MXI3_I62_MN1_1 (VSS I3_SEL_DIV_b2_0 I3_SEL_DIV_b3_1 VSS) gpdk090_nmos1v w=0.24u l=0.1u ad=0.0816p as=0.0528p pd=1.16u ps=0.68u
    I_MXI3_I25_MN1 (I3_SEL_XOR_b3_1 I3_SEL_XOR_b2_0 VSS VSS) gpdk090_nmos1v w=0.24u l=0.1u ad=0.0528p as=0.0816p pd=0.68u ps=1.16u
    I_MXI3_I25_MN1_1 (VSS I3_SEL_XOR_b2_0 I3_SEL_XOR_b3_1 VSS) gpdk090_nmos1v w=0.24u l=0.1u ad=0.0816p as=0.0528p pd=1.16u ps=0.68u
    I_MXI3_I24_MN1 (I3_SEL_XOR_b3_0 I3_SEL_XOR_b2_0 VSS VSS) gpdk090_nmos1v w=0.24u l=0.1u ad=0.0528p as=0.0816p pd=0.68u ps=1.16u
    I_MXI3_I24_MN1_1 (VSS I3_SEL_XOR_b2_0 I3_SEL_XOR_b3_0 VSS) gpdk090_nmos1v w=0.24u l=0.1u ad=0.0816p as=0.0528p pd=1.16u ps=0.68u
    I_MXI3_I61_MN1 (I3_SEL_DIV_b3_0 I3_SEL_DIV_b2_0 VSS VSS) gpdk090_nmos1v w=0.24u l=0.1u ad=0.0528p as=0.0816p pd=0.68u ps=1.16u
    I_MXI3_I61_MN1_1 (VSS I3_SEL_DIV_b2_0 I3_SEL_DIV_b3_0 VSS) gpdk090_nmos1v w=0.24u l=0.1u ad=0.0816p as=0.0528p pd=1.16u ps=0.68u
    I_MXI3_I68_MN1 (I3_SEL_DIV_b3_7 I3_SEL_DIV_b2_1 VSS VSS) gpdk090_nmos1v w=0.24u l=0.1u ad=0.0528p as=0.0816p pd=0.68u ps=1.16u
    I_MXI3_I68_MN1_1 (VSS I3_SEL_DIV_b2_1 I3_SEL_DIV_b3_7 VSS) gpdk090_nmos1v w=0.24u l=0.1u ad=0.0816p as=0.0528p pd=1.16u ps=0.68u
    I_MXI3_I59_MN1 (I3_SEL_DIV_b2_1 I3_SEL_DIV_b1_0 VSS VSS) gpdk090_nmos1v w=0.24u l=0.1u ad=0.0528p as=0.0816p pd=0.68u ps=1.16u
    I_MXI3_I59_MN1_1 (VSS I3_SEL_DIV_b1_0 I3_SEL_DIV_b2_1 VSS) gpdk090_nmos1v w=0.24u l=0.1u ad=0.0816p as=0.0528p pd=1.16u ps=0.68u
    I_MXI3_I57_MN1 (I3_SEL_DIV_b1_0 I3_SEL_DIV_b0 VSS VSS) gpdk090_nmos1v w=0.24u l=0.1u ad=0.0528p as=0.0816p pd=0.68u ps=1.16u
    I_MXI3_I57_MN1_1 (VSS I3_SEL_DIV_b0 I3_SEL_DIV_b1_0 VSS) gpdk090_nmos1v w=0.24u l=0.1u ad=0.0816p as=0.0528p pd=1.16u ps=0.68u
    I_MXI3_I42_MN1 (I3_SEL_MUL_b2_0 I3_SEL_MUL_b1_0 VSS VSS) gpdk090_nmos1v w=0.24u l=0.1u ad=0.0528p as=0.0816p pd=0.68u ps=1.16u
    I_MXI3_I42_MN1_1 (VSS I3_SEL_MUL_b1_0 I3_SEL_MUL_b2_0 VSS) gpdk090_nmos1v w=0.24u l=0.1u ad=0.0816p as=0.0528p pd=1.16u ps=0.68u
    I_MXI3_I58_MN1 (I3_SEL_DIV_b2_0 I3_SEL_DIV_b1_0 VSS VSS) gpdk090_nmos1v w=0.24u l=0.1u ad=0.0528p as=0.0816p pd=0.68u ps=1.16u
    I_MXI3_I58_MN1_1 (VSS I3_SEL_DIV_b1_0 I3_SEL_DIV_b2_0 VSS) gpdk090_nmos1v w=0.24u l=0.1u ad=0.0816p as=0.0528p pd=1.16u ps=0.68u
    I_MXI3_I77_MN1 (I3_SEL_AS_b3_1 I3_SEL_AS_b2_0 VSS VSS) gpdk090_nmos1v w=0.24u l=0.1u ad=0.0528p as=0.0816p pd=0.68u ps=1.16u
    I_MXI3_I77_MN1_1 (VSS I3_SEL_AS_b2_0 I3_SEL_AS_b3_1 VSS) gpdk090_nmos1v w=0.24u l=0.1u ad=0.0816p as=0.0528p pd=1.16u ps=0.68u
    I_MXI3_I35_MN1 (I3_SEL_NOT_b3_1 I3_SEL_NOT_b2_0 VSS VSS) gpdk090_nmos1v w=0.24u l=0.1u ad=0.0528p as=0.0816p pd=0.68u ps=1.16u
    I_MXI3_I35_MN1_1 (VSS I3_SEL_NOT_b2_0 I3_SEL_NOT_b3_1 VSS) gpdk090_nmos1v w=0.24u l=0.1u ad=0.0816p as=0.0528p pd=1.16u ps=0.68u
    I_MXI3_I5_MN1 (I3_SEL_AND_b3_1 I3_SEL_AND_b2_0 VSS VSS) gpdk090_nmos1v w=0.24u l=0.1u ad=0.0528p as=0.0816p pd=0.68u ps=1.16u
    I_MXI3_I5_MN1_1 (VSS I3_SEL_AND_b2_0 I3_SEL_AND_b3_1 VSS) gpdk090_nmos1v w=0.24u l=0.1u ad=0.0816p as=0.0528p pd=1.16u ps=0.68u
    I_MXI3_I15_MN1 (I3_SEL_OR_b3_1 I3_SEL_OR_b2_0 VSS VSS) gpdk090_nmos1v w=0.24u l=0.1u ad=0.0528p as=0.0816p pd=0.68u ps=1.16u
    I_MXI3_I15_MN1_1 (VSS I3_SEL_OR_b2_0 I3_SEL_OR_b3_1 VSS) gpdk090_nmos1v w=0.24u l=0.1u ad=0.0816p as=0.0528p pd=1.16u ps=0.68u
    I_MXI3_I76_MN1 (I3_SEL_AS_b3_0 I3_SEL_AS_b2_0 VSS VSS) gpdk090_nmos1v w=0.24u l=0.1u ad=0.0528p as=0.0816p pd=0.68u ps=1.16u
    I_MXI3_I76_MN1_1 (VSS I3_SEL_AS_b2_0 I3_SEL_AS_b3_0 VSS) gpdk090_nmos1v w=0.24u l=0.1u ad=0.0816p as=0.0528p pd=1.16u ps=0.68u
    I_MXI3_I14_MN1 (I3_SEL_OR_b3_0 I3_SEL_OR_b2_0 VSS VSS) gpdk090_nmos1v w=0.24u l=0.1u ad=0.0528p as=0.0816p pd=0.68u ps=1.16u
    I_MXI3_I14_MN1_1 (VSS I3_SEL_OR_b2_0 I3_SEL_OR_b3_0 VSS) gpdk090_nmos1v w=0.24u l=0.1u ad=0.0816p as=0.0528p pd=1.16u ps=0.68u
    I_MXI3_I4_MN1 (I3_SEL_AND_b3_0 I3_SEL_AND_b2_0 VSS VSS) gpdk090_nmos1v w=0.24u l=0.1u ad=0.0528p as=0.0816p pd=0.68u ps=1.16u
    I_MXI3_I4_MN1_1 (VSS I3_SEL_AND_b2_0 I3_SEL_AND_b3_0 VSS) gpdk090_nmos1v w=0.24u l=0.1u ad=0.0816p as=0.0528p pd=1.16u ps=0.68u
    I_MXI3_I45_MN1 (I3_SEL_MUL_b3_0 I3_SEL_MUL_b2_0 VSS VSS) gpdk090_nmos1v w=0.24u l=0.1u ad=0.0528p as=0.0816p pd=0.68u ps=1.16u
    I_MXI3_I45_MN1_1 (VSS I3_SEL_MUL_b2_0 I3_SEL_MUL_b3_0 VSS) gpdk090_nmos1v w=0.24u l=0.1u ad=0.0816p as=0.0528p pd=1.16u ps=0.68u
    I_MXI3_I34_MN1 (I3_SEL_NOT_b3_0 I3_SEL_NOT_b2_0 VSS VSS) gpdk090_nmos1v w=0.24u l=0.1u ad=0.0528p as=0.0816p pd=0.68u ps=1.16u
    I_MXI3_I34_MN1_1 (VSS I3_SEL_NOT_b2_0 I3_SEL_NOT_b3_0 VSS) gpdk090_nmos1v w=0.24u l=0.1u ad=0.0816p as=0.0528p pd=1.16u ps=0.68u
    I_MXI3_I67_MN1 (I3_SEL_DIV_b3_6 I3_SEL_DIV_b2_1 VSS VSS) gpdk090_nmos1v w=0.24u l=0.1u ad=0.0528p as=0.0816p pd=0.68u ps=1.16u
    I_MXI3_I67_MN1_1 (VSS I3_SEL_DIV_b2_1 I3_SEL_DIV_b3_6 VSS) gpdk090_nmos1v w=0.24u l=0.1u ad=0.0816p as=0.0528p pd=1.16u ps=0.68u
    I_MXI3_I51_MN1 (I3_SEL_MUL_b3_6 I3_SEL_MUL_b2_1 VSS VSS) gpdk090_nmos1v w=0.24u l=0.1u ad=0.0528p as=0.0816p pd=0.68u ps=1.16u
    I_MXI3_I51_MN1_1 (VSS I3_SEL_MUL_b2_1 I3_SEL_MUL_b3_6 VSS) gpdk090_nmos1v w=0.24u l=0.1u ad=0.0816p as=0.0528p pd=1.16u ps=0.68u
    I_MXI3_I52_MN1 (I3_SEL_MUL_b3_7 I3_SEL_MUL_b2_1 VSS VSS) gpdk090_nmos1v w=0.24u l=0.1u ad=0.0528p as=0.0816p pd=0.68u ps=1.16u
    I_MXI3_I52_MN1_1 (VSS I3_SEL_MUL_b2_1 I3_SEL_MUL_b3_7 VSS) gpdk090_nmos1v w=0.24u l=0.1u ad=0.0816p as=0.0528p pd=1.16u ps=0.68u
    I_MXI3_I43_MN1 (I3_SEL_MUL_b2_1 I3_SEL_MUL_b1_0 VSS VSS) gpdk090_nmos1v w=0.24u l=0.1u ad=0.0528p as=0.0816p pd=0.68u ps=1.16u
    I_MXI3_I43_MN1_1 (VSS I3_SEL_MUL_b1_0 I3_SEL_MUL_b2_1 VSS) gpdk090_nmos1v w=0.24u l=0.1u ad=0.0816p as=0.0528p pd=1.16u ps=0.68u
    I_MXI3_I41_MN1 (I3_SEL_MUL_b1_0 I3_SEL_MUL_b0 VSS VSS) gpdk090_nmos1v w=0.24u l=0.1u ad=0.0528p as=0.0816p pd=0.68u ps=1.16u
    I_MXI3_I41_MN1_1 (VSS I3_SEL_MUL_b0 I3_SEL_MUL_b1_0 VSS) gpdk090_nmos1v w=0.24u l=0.1u ad=0.0816p as=0.0528p pd=1.16u ps=0.68u
    I_MXI1_I5_MN1 (I1_SUB_b3_1 I1_SUB_b2_0 VSS VSS) gpdk090_nmos1v w=0.24u l=0.1u ad=0.0528p as=0.0816p pd=0.68u ps=1.16u
    I_MXI1_I5_MN1_1 (VSS I1_SUB_b2_0 I1_SUB_b3_1 VSS) gpdk090_nmos1v w=0.24u l=0.1u ad=0.0816p as=0.0528p pd=1.16u ps=0.68u
    I_MXI1_I4_MN1 (I1_SUB_b3_0 I1_SUB_b2_0 VSS VSS) gpdk090_nmos1v w=0.24u l=0.1u ad=0.0528p as=0.0816p pd=0.68u ps=1.16u
    I_MXI1_I4_MN1_1 (VSS I1_SUB_b2_0 I1_SUB_b3_0 VSS) gpdk090_nmos1v w=0.24u l=0.1u ad=0.0816p as=0.0528p pd=1.16u ps=0.68u
    I_MXI3_I31_MN1 (I3_SEL_NOT_b1_0 I3_SEL_NOT_b0 VSS VSS) gpdk090_nmos1v w=0.24u l=0.1u ad=0.0528p as=0.0816p pd=0.68u ps=1.16u
    I_MXI3_I31_MN1_1 (VSS I3_SEL_NOT_b0 I3_SEL_NOT_b1_0 VSS) gpdk090_nmos1v w=0.24u l=0.1u ad=0.0816p as=0.0528p pd=1.16u ps=0.68u
    I_MXI3_I11_MN1 (I3_SEL_OR_b1_0 I3_SEL_OR_b0 VSS VSS) gpdk090_nmos1v w=0.24u l=0.1u ad=0.0528p as=0.0816p pd=0.68u ps=1.16u
    I_MXI3_I11_MN1_1 (VSS I3_SEL_OR_b0 I3_SEL_OR_b1_0 VSS) gpdk090_nmos1v w=0.24u l=0.1u ad=0.0816p as=0.0528p pd=1.16u ps=0.68u
    I_MXI3_I21_MN1 (I3_SEL_XOR_b1_0 I3_SEL_XOR_b0 VSS VSS) gpdk090_nmos1v w=0.24u l=0.1u ad=0.0528p as=0.0816p pd=0.68u ps=1.16u
    I_MXI3_I21_MN1_1 (VSS I3_SEL_XOR_b0 I3_SEL_XOR_b1_0 VSS) gpdk090_nmos1v w=0.24u l=0.1u ad=0.0816p as=0.0528p pd=1.16u ps=0.68u
    I_MXI1_I1_MN1 (I1_SUB_b1_0 I1_SUB_b0 VSS VSS) gpdk090_nmos1v w=0.24u l=0.1u ad=0.0528p as=0.0816p pd=0.68u ps=1.16u
    I_MXI1_I1_MN1_1 (VSS I1_SUB_b0 I1_SUB_b1_0 VSS) gpdk090_nmos1v w=0.24u l=0.1u ad=0.0816p as=0.0528p pd=1.16u ps=0.68u
    I_MXI3_I22_MN1 (I3_SEL_XOR_b2_0 I3_SEL_XOR_b1_0 VSS VSS) gpdk090_nmos1v w=0.24u l=0.1u ad=0.0528p as=0.0816p pd=0.68u ps=1.16u
    I_MXI3_I22_MN1_1 (VSS I3_SEL_XOR_b1_0 I3_SEL_XOR_b2_0 VSS) gpdk090_nmos1v w=0.24u l=0.1u ad=0.0816p as=0.0528p pd=1.16u ps=0.68u
    I_MXI3_I32_MN1 (I3_SEL_NOT_b2_0 I3_SEL_NOT_b1_0 VSS VSS) gpdk090_nmos1v w=0.24u l=0.1u ad=0.0528p as=0.0816p pd=0.68u ps=1.16u
    I_MXI3_I32_MN1_1 (VSS I3_SEL_NOT_b1_0 I3_SEL_NOT_b2_0 VSS) gpdk090_nmos1v w=0.24u l=0.1u ad=0.0816p as=0.0528p pd=1.16u ps=0.68u
    I_MXI3_I26_MN1 (I3_SEL_XOR_b3_2 I3_SEL_XOR_b2_0 VSS VSS) gpdk090_nmos1v w=0.24u l=0.1u ad=0.0528p as=0.0816p pd=0.68u ps=1.16u
    I_MXI3_I26_MN1_1 (VSS I3_SEL_XOR_b2_0 I3_SEL_XOR_b3_2 VSS) gpdk090_nmos1v w=0.24u l=0.1u ad=0.0816p as=0.0528p pd=1.16u ps=0.68u
    I_MXI3_I36_MN1 (I3_SEL_NOT_b3_2 I3_SEL_NOT_b2_0 VSS VSS) gpdk090_nmos1v w=0.24u l=0.1u ad=0.0528p as=0.0816p pd=0.68u ps=1.16u
    I_MXI3_I36_MN1_1 (VSS I3_SEL_NOT_b2_0 I3_SEL_NOT_b3_2 VSS) gpdk090_nmos1v w=0.24u l=0.1u ad=0.0816p as=0.0528p pd=1.16u ps=0.68u
    I_MXI3_I50_MN1 (I3_SEL_MUL_b3_5 I3_SEL_MUL_b2_1 VSS VSS) gpdk090_nmos1v w=0.24u l=0.1u ad=0.0528p as=0.0816p pd=0.68u ps=1.16u
    I_MXI3_I50_MN1_1 (VSS I3_SEL_MUL_b2_1 I3_SEL_MUL_b3_5 VSS) gpdk090_nmos1v w=0.24u l=0.1u ad=0.0816p as=0.0528p pd=1.16u ps=0.68u
    I_MXI3_I66_MN1 (I3_SEL_DIV_b3_5 I3_SEL_DIV_b2_1 VSS VSS) gpdk090_nmos1v w=0.24u l=0.1u ad=0.0528p as=0.0816p pd=0.68u ps=1.16u
    I_MXI3_I66_MN1_1 (VSS I3_SEL_DIV_b2_1 I3_SEL_DIV_b3_5 VSS) gpdk090_nmos1v w=0.24u l=0.1u ad=0.0816p as=0.0528p pd=1.16u ps=0.68u
    I_MXI3_I1_MN1 (I3_SEL_AND_b1_0 I3_SEL_AND_b0 VSS VSS) gpdk090_nmos1v w=0.24u l=0.1u ad=0.0528p as=0.0816p pd=0.68u ps=1.16u
    I_MXI3_I1_MN1_1 (VSS I3_SEL_AND_b0 I3_SEL_AND_b1_0 VSS) gpdk090_nmos1v w=0.24u l=0.1u ad=0.0816p as=0.0528p pd=1.16u ps=0.68u
    I_MXI3_I73_MN1 (I3_SEL_AS_b1_0 I3_SEL_AS_b0 VSS VSS) gpdk090_nmos1v w=0.24u l=0.1u ad=0.0528p as=0.0816p pd=0.68u ps=1.16u
    I_MXI3_I73_MN1_1 (VSS I3_SEL_AS_b0 I3_SEL_AS_b1_0 VSS) gpdk090_nmos1v w=0.24u l=0.1u ad=0.0816p as=0.0528p pd=1.16u ps=0.68u
    I_MXI3_I33_MN1 (I3_SEL_NOT_b2_1 I3_SEL_NOT_b1_0 VSS VSS) gpdk090_nmos1v w=0.24u l=0.1u ad=0.0528p as=0.0816p pd=0.68u ps=1.16u
    I_MXI3_I33_MN1_1 (VSS I3_SEL_NOT_b1_0 I3_SEL_NOT_b2_1 VSS) gpdk090_nmos1v w=0.24u l=0.1u ad=0.0816p as=0.0528p pd=1.16u ps=0.68u
    I_MXI3_I23_MN1 (I3_SEL_XOR_b2_1 I3_SEL_XOR_b1_0 VSS VSS) gpdk090_nmos1v w=0.24u l=0.1u ad=0.0528p as=0.0816p pd=0.68u ps=1.16u
    I_MXI3_I23_MN1_1 (VSS I3_SEL_XOR_b1_0 I3_SEL_XOR_b2_1 VSS) gpdk090_nmos1v w=0.24u l=0.1u ad=0.0816p as=0.0528p pd=1.16u ps=0.68u
    I_MXI3_I2_MN1 (I3_SEL_AND_b2_0 I3_SEL_AND_b1_0 VSS VSS) gpdk090_nmos1v w=0.24u l=0.1u ad=0.0528p as=0.0816p pd=0.68u ps=1.16u
    I_MXI3_I2_MN1_1 (VSS I3_SEL_AND_b1_0 I3_SEL_AND_b2_0 VSS) gpdk090_nmos1v w=0.24u l=0.1u ad=0.0816p as=0.0528p pd=1.16u ps=0.68u
    I_MXI1_I3_MN1 (I1_SUB_b2_1 I1_SUB_b1_0 VSS VSS) gpdk090_nmos1v w=0.24u l=0.1u ad=0.0528p as=0.0816p pd=0.68u ps=1.16u
    I_MXI1_I3_MN1_1 (VSS I1_SUB_b1_0 I1_SUB_b2_1 VSS) gpdk090_nmos1v w=0.24u l=0.1u ad=0.0816p as=0.0528p pd=1.16u ps=0.68u
    I_MXI1_I2_MN1 (I1_SUB_b2_0 I1_SUB_b1_0 VSS VSS) gpdk090_nmos1v w=0.24u l=0.1u ad=0.0528p as=0.0816p pd=0.68u ps=1.16u
    I_MXI1_I2_MN1_1 (VSS I1_SUB_b1_0 I1_SUB_b2_0 VSS) gpdk090_nmos1v w=0.24u l=0.1u ad=0.0816p as=0.0528p pd=1.16u ps=0.68u
    I_MXI1_I9_MN1 (I1_SUB_b3_5 I1_SUB_b2_1 VSS VSS) gpdk090_nmos1v w=0.24u l=0.1u ad=0.0528p as=0.0816p pd=0.68u ps=1.16u
    I_MXI1_I9_MN1_1 (VSS I1_SUB_b2_1 I1_SUB_b3_5 VSS) gpdk090_nmos1v w=0.24u l=0.1u ad=0.0816p as=0.0528p pd=1.16u ps=0.68u
    I_MXI3_I74_MN1 (I3_SEL_AS_b2_0 I3_SEL_AS_b1_0 VSS VSS) gpdk090_nmos1v w=0.24u l=0.1u ad=0.0528p as=0.0816p pd=0.68u ps=1.16u
    I_MXI3_I74_MN1_1 (VSS I3_SEL_AS_b1_0 I3_SEL_AS_b2_0 VSS) gpdk090_nmos1v w=0.24u l=0.1u ad=0.0816p as=0.0528p pd=1.16u ps=0.68u
    I_MXI3_I12_MN1 (I3_SEL_OR_b2_0 I3_SEL_OR_b1_0 VSS VSS) gpdk090_nmos1v w=0.24u l=0.1u ad=0.0528p as=0.0816p pd=0.68u ps=1.16u
    I_MXI3_I12_MN1_1 (VSS I3_SEL_OR_b1_0 I3_SEL_OR_b2_0 VSS) gpdk090_nmos1v w=0.24u l=0.1u ad=0.0816p as=0.0528p pd=1.16u ps=0.68u
    I_MXI3_I78_MN1 (I3_SEL_AS_b3_2 I3_SEL_AS_b2_0 VSS VSS) gpdk090_nmos1v w=0.24u l=0.1u ad=0.0528p as=0.0816p pd=0.68u ps=1.16u
    I_MXI3_I78_MN1_1 (VSS I3_SEL_AS_b2_0 I3_SEL_AS_b3_2 VSS) gpdk090_nmos1v w=0.24u l=0.1u ad=0.0816p as=0.0528p pd=1.16u ps=0.68u
    I_MXI1_I6_MN1 (I1_SUB_b3_2 I1_SUB_b2_0 VSS VSS) gpdk090_nmos1v w=0.24u l=0.1u ad=0.0528p as=0.0816p pd=0.68u ps=1.16u
    I_MXI1_I6_MN1_1 (VSS I1_SUB_b2_0 I1_SUB_b3_2 VSS) gpdk090_nmos1v w=0.24u l=0.1u ad=0.0816p as=0.0528p pd=1.16u ps=0.68u
    I_MXI3_I16_MN1 (I3_SEL_OR_b3_2 I3_SEL_OR_b2_0 VSS VSS) gpdk090_nmos1v w=0.24u l=0.1u ad=0.0528p as=0.0816p pd=0.68u ps=1.16u
    I_MXI3_I16_MN1_1 (VSS I3_SEL_OR_b2_0 I3_SEL_OR_b3_2 VSS) gpdk090_nmos1v w=0.24u l=0.1u ad=0.0816p as=0.0528p pd=1.16u ps=0.68u
    I_MXI3_I6_MN1 (I3_SEL_AND_b3_2 I3_SEL_AND_b2_0 VSS VSS) gpdk090_nmos1v w=0.24u l=0.1u ad=0.0528p as=0.0816p pd=0.68u ps=1.16u
    I_MXI3_I6_MN1_1 (VSS I3_SEL_AND_b2_0 I3_SEL_AND_b3_2 VSS) gpdk090_nmos1v w=0.24u l=0.1u ad=0.0816p as=0.0528p pd=1.16u ps=0.68u
    I_MXI3_I65_MN1 (I3_SEL_DIV_b3_4 I3_SEL_DIV_b2_1 VSS VSS) gpdk090_nmos1v w=0.24u l=0.1u ad=0.0528p as=0.0816p pd=0.68u ps=1.16u
    I_MXI3_I65_MN1_1 (VSS I3_SEL_DIV_b2_1 I3_SEL_DIV_b3_4 VSS) gpdk090_nmos1v w=0.24u l=0.1u ad=0.0816p as=0.0528p pd=1.16u ps=0.68u
    I_MXI3_I39_MN1 (I3_SEL_NOT_b3_5 I3_SEL_NOT_b2_1 VSS VSS) gpdk090_nmos1v w=0.24u l=0.1u ad=0.0528p as=0.0816p pd=0.68u ps=1.16u
    I_MXI3_I39_MN1_1 (VSS I3_SEL_NOT_b2_1 I3_SEL_NOT_b3_5 VSS) gpdk090_nmos1v w=0.24u l=0.1u ad=0.0816p as=0.0528p pd=1.16u ps=0.68u
    I_MXI3_I29_MN1 (I3_SEL_XOR_b3_5 I3_SEL_XOR_b2_1 VSS VSS) gpdk090_nmos1v w=0.24u l=0.1u ad=0.0528p as=0.0816p pd=0.68u ps=1.16u
    I_MXI3_I29_MN1_1 (VSS I3_SEL_XOR_b2_1 I3_SEL_XOR_b3_5 VSS) gpdk090_nmos1v w=0.24u l=0.1u ad=0.0816p as=0.0528p pd=1.16u ps=0.68u
    I_MXI3_I3_MN1 (I3_SEL_AND_b2_1 I3_SEL_AND_b1_0 VSS VSS) gpdk090_nmos1v w=0.24u l=0.1u ad=0.0528p as=0.0816p pd=0.68u ps=1.16u
    I_MXI3_I3_MN1_1 (VSS I3_SEL_AND_b1_0 I3_SEL_AND_b2_1 VSS) gpdk090_nmos1v w=0.24u l=0.1u ad=0.0816p as=0.0528p pd=1.16u ps=0.68u
    I_MXI3_I75_MN1 (I3_SEL_AS_b2_1 I3_SEL_AS_b1_0 VSS VSS) gpdk090_nmos1v w=0.24u l=0.1u ad=0.0528p as=0.0816p pd=0.68u ps=1.16u
    I_MXI3_I75_MN1_1 (VSS I3_SEL_AS_b1_0 I3_SEL_AS_b2_1 VSS) gpdk090_nmos1v w=0.24u l=0.1u ad=0.0816p as=0.0528p pd=1.16u ps=0.68u
    I_MXI3_I49_MN1 (I3_SEL_MUL_b3_4 I3_SEL_MUL_b2_1 VSS VSS) gpdk090_nmos1v w=0.24u l=0.1u ad=0.0528p as=0.0816p pd=0.68u ps=1.16u
    I_MXI3_I49_MN1_1 (VSS I3_SEL_MUL_b2_1 I3_SEL_MUL_b3_4 VSS) gpdk090_nmos1v w=0.24u l=0.1u ad=0.0816p as=0.0528p pd=1.16u ps=0.68u
    I_MXI3_I9_MN1 (I3_SEL_AND_b3_5 I3_SEL_AND_b2_1 VSS VSS) gpdk090_nmos1v w=0.24u l=0.1u ad=0.0528p as=0.0816p pd=0.68u ps=1.16u
    I_MXI3_I9_MN1_1 (VSS I3_SEL_AND_b2_1 I3_SEL_AND_b3_5 VSS) gpdk090_nmos1v w=0.24u l=0.1u ad=0.0816p as=0.0528p pd=1.16u ps=0.68u
    I_MXI3_I13_MN1 (I3_SEL_OR_b2_1 I3_SEL_OR_b1_0 VSS VSS) gpdk090_nmos1v w=0.24u l=0.1u ad=0.0528p as=0.0816p pd=0.68u ps=1.16u
    I_MXI3_I13_MN1_1 (VSS I3_SEL_OR_b1_0 I3_SEL_OR_b2_1 VSS) gpdk090_nmos1v w=0.24u l=0.1u ad=0.0816p as=0.0528p pd=1.16u ps=0.68u
    I_MXI3_I81_MN1 (I3_SEL_AS_b3_5 I3_SEL_AS_b2_1 VSS VSS) gpdk090_nmos1v w=0.24u l=0.1u ad=0.0528p as=0.0816p pd=0.68u ps=1.16u
    I_MXI3_I81_MN1_1 (VSS I3_SEL_AS_b2_1 I3_SEL_AS_b3_5 VSS) gpdk090_nmos1v w=0.24u l=0.1u ad=0.0816p as=0.0528p pd=1.16u ps=0.68u
    I_MXI3_I19_MN1 (I3_SEL_OR_b3_5 I3_SEL_OR_b2_1 VSS VSS) gpdk090_nmos1v w=0.24u l=0.1u ad=0.0528p as=0.0816p pd=0.68u ps=1.16u
    I_MXI3_I19_MN1_1 (VSS I3_SEL_OR_b2_1 I3_SEL_OR_b3_5 VSS) gpdk090_nmos1v w=0.24u l=0.1u ad=0.0816p as=0.0528p pd=1.16u ps=0.68u
    I_MXI3_I47_MN1 (I3_SEL_MUL_b3_2 I3_SEL_MUL_b2_0 VSS VSS) gpdk090_nmos1v w=0.24u l=0.1u ad=0.0528p as=0.0816p pd=0.68u ps=1.16u
    I_MXI3_I47_MN1_1 (VSS I3_SEL_MUL_b2_0 I3_SEL_MUL_b3_2 VSS) gpdk090_nmos1v w=0.24u l=0.1u ad=0.0816p as=0.0528p pd=1.16u ps=0.68u
    I_MXI3_I63_MN1 (I3_SEL_DIV_b3_2 I3_SEL_DIV_b2_0 VSS VSS) gpdk090_nmos1v w=0.24u l=0.1u ad=0.0528p as=0.0816p pd=0.68u ps=1.16u
    I_MXI3_I63_MN1_1 (VSS I3_SEL_DIV_b2_0 I3_SEL_DIV_b3_2 VSS) gpdk090_nmos1v w=0.24u l=0.1u ad=0.0816p as=0.0528p pd=1.16u ps=0.68u
    I_MXI3_I64_MN1 (I3_SEL_DIV_b3_3 I3_SEL_DIV_b2_0 VSS VSS) gpdk090_nmos1v w=0.24u l=0.1u ad=0.0528p as=0.0816p pd=0.68u ps=1.16u
    I_MXI3_I64_MN1_1 (VSS I3_SEL_DIV_b2_0 I3_SEL_DIV_b3_3 VSS) gpdk090_nmos1v w=0.24u l=0.1u ad=0.0816p as=0.0528p pd=1.16u ps=0.68u
    I_MXI1_I8_MN1 (I1_SUB_b3_4 I1_SUB_b2_1 VSS VSS) gpdk090_nmos1v w=0.24u l=0.1u ad=0.0528p as=0.0816p pd=0.68u ps=1.16u
    I_MXI1_I8_MN1_1 (VSS I1_SUB_b2_1 I1_SUB_b3_4 VSS) gpdk090_nmos1v w=0.24u l=0.1u ad=0.0816p as=0.0528p pd=1.16u ps=0.68u
    I_MXI3_I80_MN1 (I3_SEL_AS_b3_4 I3_SEL_AS_b2_1 VSS VSS) gpdk090_nmos1v w=0.24u l=0.1u ad=0.0528p as=0.0816p pd=0.68u ps=1.16u
    I_MXI3_I80_MN1_1 (VSS I3_SEL_AS_b2_1 I3_SEL_AS_b3_4 VSS) gpdk090_nmos1v w=0.24u l=0.1u ad=0.0816p as=0.0528p pd=1.16u ps=0.68u
    I_MXI3_I79_MN1 (I3_SEL_AS_b3_3 I3_SEL_AS_b2_1 VSS VSS) gpdk090_nmos1v w=0.24u l=0.1u ad=0.0528p as=0.0816p pd=0.68u ps=1.16u
    I_MXI3_I79_MN1_1 (VSS I3_SEL_AS_b2_1 I3_SEL_AS_b3_3 VSS) gpdk090_nmos1v w=0.24u l=0.1u ad=0.0816p as=0.0528p pd=1.16u ps=0.68u
    I_MXI3_I38_MN1 (I3_SEL_NOT_b3_4 I3_SEL_NOT_b2_1 VSS VSS) gpdk090_nmos1v w=0.24u l=0.1u ad=0.0528p as=0.0816p pd=0.68u ps=1.16u
    I_MXI3_I38_MN1_1 (VSS I3_SEL_NOT_b2_1 I3_SEL_NOT_b3_4 VSS) gpdk090_nmos1v w=0.24u l=0.1u ad=0.0816p as=0.0528p pd=1.16u ps=0.68u
    I_MXI3_I28_MN1 (I3_SEL_XOR_b3_4 I3_SEL_XOR_b2_1 VSS VSS) gpdk090_nmos1v w=0.24u l=0.1u ad=0.0528p as=0.0816p pd=0.68u ps=1.16u
    I_MXI3_I28_MN1_1 (VSS I3_SEL_XOR_b2_1 I3_SEL_XOR_b3_4 VSS) gpdk090_nmos1v w=0.24u l=0.1u ad=0.0816p as=0.0528p pd=1.16u ps=0.68u
    I_MXI3_I37_MN1 (I3_SEL_NOT_b3_3 I3_SEL_NOT_b2_1 VSS VSS) gpdk090_nmos1v w=0.24u l=0.1u ad=0.0528p as=0.0816p pd=0.68u ps=1.16u
    I_MXI3_I37_MN1_1 (VSS I3_SEL_NOT_b2_1 I3_SEL_NOT_b3_3 VSS) gpdk090_nmos1v w=0.24u l=0.1u ad=0.0816p as=0.0528p pd=1.16u ps=0.68u
    I_MXI1_I7_MN1 (I1_SUB_b3_3 I1_SUB_b2_1 VSS VSS) gpdk090_nmos1v w=0.24u l=0.1u ad=0.0528p as=0.0816p pd=0.68u ps=1.16u
    I_MXI1_I7_MN1_1 (VSS I1_SUB_b2_1 I1_SUB_b3_3 VSS) gpdk090_nmos1v w=0.24u l=0.1u ad=0.0816p as=0.0528p pd=1.16u ps=0.68u
    I_MXI3_I27_MN1 (I3_SEL_XOR_b3_3 I3_SEL_XOR_b2_1 VSS VSS) gpdk090_nmos1v w=0.24u l=0.1u ad=0.0528p as=0.0816p pd=0.68u ps=1.16u
    I_MXI3_I27_MN1_1 (VSS I3_SEL_XOR_b2_1 I3_SEL_XOR_b3_3 VSS) gpdk090_nmos1v w=0.24u l=0.1u ad=0.0816p as=0.0528p pd=1.16u ps=0.68u
    I_MXI3_I48_MN1 (I3_SEL_MUL_b3_3 I3_SEL_MUL_b2_0 VSS VSS) gpdk090_nmos1v w=0.24u l=0.1u ad=0.0528p as=0.0816p pd=0.68u ps=1.16u
    I_MXI3_I48_MN1_1 (VSS I3_SEL_MUL_b2_0 I3_SEL_MUL_b3_3 VSS) gpdk090_nmos1v w=0.24u l=0.1u ad=0.0816p as=0.0528p pd=1.16u ps=0.68u
    I_MXI3_I18_MN1 (I3_SEL_OR_b3_4 I3_SEL_OR_b2_1 VSS VSS) gpdk090_nmos1v w=0.24u l=0.1u ad=0.0528p as=0.0816p pd=0.68u ps=1.16u
    I_MXI3_I18_MN1_1 (VSS I3_SEL_OR_b2_1 I3_SEL_OR_b3_4 VSS) gpdk090_nmos1v w=0.24u l=0.1u ad=0.0816p as=0.0528p pd=1.16u ps=0.68u
    I_MXI3_I8_MN1 (I3_SEL_AND_b3_4 I3_SEL_AND_b2_1 VSS VSS) gpdk090_nmos1v w=0.24u l=0.1u ad=0.0528p as=0.0816p pd=0.68u ps=1.16u
    I_MXI3_I8_MN1_1 (VSS I3_SEL_AND_b2_1 I3_SEL_AND_b3_4 VSS) gpdk090_nmos1v w=0.24u l=0.1u ad=0.0816p as=0.0528p pd=1.16u ps=0.68u
    I_MXI3_I7_MN1 (I3_SEL_AND_b3_3 I3_SEL_AND_b2_1 VSS VSS) gpdk090_nmos1v w=0.24u l=0.1u ad=0.0528p as=0.0816p pd=0.68u ps=1.16u
    I_MXI3_I7_MN1_1 (VSS I3_SEL_AND_b2_1 I3_SEL_AND_b3_3 VSS) gpdk090_nmos1v w=0.24u l=0.1u ad=0.0816p as=0.0528p pd=1.16u ps=0.68u
    I_MXI3_I17_MN1 (I3_SEL_OR_b3_3 I3_SEL_OR_b2_1 VSS VSS) gpdk090_nmos1v w=0.24u l=0.1u ad=0.0528p as=0.0816p pd=0.68u ps=1.16u
    I_MXI3_I17_MN1_1 (VSS I3_SEL_OR_b2_1 I3_SEL_OR_b3_3 VSS) gpdk090_nmos1v w=0.24u l=0.1u ad=0.0816p as=0.0528p pd=1.16u ps=0.68u
    I_MXI3_I188_MN2 (I3_q8_2 I3_o8_2 VSS VSS) gpdk090_nmos1v w=0.12u l=0.1u ad=0.0468p as=0.0696p pd=0.68u ps=1.16u
    I_MXI3_I188_MN0 (XI3_I188_n1 I3_SEL_AS_b3_1 I3_q8_2 VSS) gpdk090_nmos1v w=0.24u l=0.1u ad=0.0528p as=0.0468p pd=0.68u ps=0.68u
    I_MXI3_I188_MN1 (VSS S_8 XI3_I188_n1 VSS) gpdk090_nmos1v w=0.24u l=0.1u ad=0.0816p as=0.0528p pd=1.16u ps=0.68u
    I_MXI3_I200_MN2 (I3_q9_2 I3_o9_2 VSS VSS) gpdk090_nmos1v w=0.12u l=0.1u ad=0.0468p as=0.0696p pd=0.68u ps=1.16u
    I_MXI3_I200_MN0 (XI3_I200_n1 I3_SEL_AS_b3_1 I3_q9_2 VSS) gpdk090_nmos1v w=0.24u l=0.1u ad=0.0528p as=0.0468p pd=0.68u ps=0.68u
    I_MXI3_I200_MN1 (VSS S_9 XI3_I200_n1 VSS) gpdk090_nmos1v w=0.24u l=0.1u ad=0.0816p as=0.0528p pd=1.16u ps=0.68u
    I_MXI3_I176_MN2 (I3_q7_2 I3_o7_2 VSS VSS) gpdk090_nmos1v w=0.12u l=0.1u ad=0.0468p as=0.0696p pd=0.68u ps=1.16u
    I_MXI3_I176_MN0 (XI3_I176_n1 I3_SEL_AS_b3_1 I3_q7_2 VSS) gpdk090_nmos1v w=0.24u l=0.1u ad=0.0528p as=0.0468p pd=0.68u ps=0.68u
    I_MXI3_I176_MN1 (VSS S_7 XI3_I176_n1 VSS) gpdk090_nmos1v w=0.24u l=0.1u ad=0.0816p as=0.0528p pd=1.16u ps=0.68u
    I_MXI3_I164_MN2 (I3_q6_2 I3_o6_2 VSS VSS) gpdk090_nmos1v w=0.12u l=0.1u ad=0.0468p as=0.0696p pd=0.68u ps=1.16u
    I_MXI3_I164_MN0 (XI3_I164_n1 I3_SEL_AS_b3_1 I3_q6_2 VSS) gpdk090_nmos1v w=0.24u l=0.1u ad=0.0528p as=0.0468p pd=0.68u ps=0.68u
    I_MXI3_I164_MN1 (VSS S_6 XI3_I164_n1 VSS) gpdk090_nmos1v w=0.24u l=0.1u ad=0.0816p as=0.0528p pd=1.16u ps=0.68u
    I_MXI3_I212_MN2 (I3_q10_2 I3_o10_2 VSS VSS) gpdk090_nmos1v w=0.12u l=0.1u ad=0.0468p as=0.0696p pd=0.68u ps=1.16u
    I_MXI3_I212_MN0 (XI3_I212_n1 I3_SEL_AS_b3_1 I3_q10_2 VSS) gpdk090_nmos1v w=0.24u l=0.1u ad=0.0528p as=0.0468p pd=0.68u ps=0.68u
    I_MXI3_I212_MN1 (VSS S_10 XI3_I212_n1 VSS) gpdk090_nmos1v w=0.24u l=0.1u ad=0.0816p as=0.0528p pd=1.16u ps=0.68u
    I_MXI3_I92_MN2 (I3_q0_2 I3_o0_2 VSS VSS) gpdk090_nmos1v w=0.12u l=0.1u ad=0.0468p as=0.0696p pd=0.68u ps=1.16u
    I_MXI3_I92_MN0 (XI3_I92_n1 I3_SEL_AS_b3_0 I3_q0_2 VSS) gpdk090_nmos1v w=0.24u l=0.1u ad=0.0528p as=0.0468p pd=0.68u ps=0.68u
    I_MXI3_I92_MN1 (VSS S_0 XI3_I92_n1 VSS) gpdk090_nmos1v w=0.24u l=0.1u ad=0.0816p as=0.0528p pd=1.16u ps=0.68u
    I_MXI3_I104_MN2 (I3_q1_2 I3_o1_2 VSS VSS) gpdk090_nmos1v w=0.12u l=0.1u ad=0.0468p as=0.0696p pd=0.68u ps=1.16u
    I_MXI3_I104_MN0 (XI3_I104_n1 I3_SEL_AS_b3_0 I3_q1_2 VSS) gpdk090_nmos1v w=0.24u l=0.1u ad=0.0528p as=0.0468p pd=0.68u ps=0.68u
    I_MXI3_I104_MN1 (VSS S_1 XI3_I104_n1 VSS) gpdk090_nmos1v w=0.24u l=0.1u ad=0.0816p as=0.0528p pd=1.16u ps=0.68u
    I_MXI3_I140_MN2 (I3_q4_2 I3_o4_2 VSS VSS) gpdk090_nmos1v w=0.12u l=0.1u ad=0.0468p as=0.0696p pd=0.68u ps=1.16u
    I_MXI3_I140_MN0 (XI3_I140_n1 I3_SEL_AS_b3_0 I3_q4_2 VSS) gpdk090_nmos1v w=0.24u l=0.1u ad=0.0528p as=0.0468p pd=0.68u ps=0.68u
    I_MXI3_I140_MN1 (VSS S_4 XI3_I140_n1 VSS) gpdk090_nmos1v w=0.24u l=0.1u ad=0.0816p as=0.0528p pd=1.16u ps=0.68u
    I_MXI3_I116_MN2 (I3_q2_2 I3_o2_2 VSS VSS) gpdk090_nmos1v w=0.12u l=0.1u ad=0.0468p as=0.0696p pd=0.68u ps=1.16u
    I_MXI3_I116_MN0 (XI3_I116_n1 I3_SEL_AS_b3_0 I3_q2_2 VSS) gpdk090_nmos1v w=0.24u l=0.1u ad=0.0528p as=0.0468p pd=0.68u ps=0.68u
    I_MXI3_I116_MN1 (VSS S_2 XI3_I116_n1 VSS) gpdk090_nmos1v w=0.24u l=0.1u ad=0.0816p as=0.0528p pd=1.16u ps=0.68u
    I_MXI3_I128_MN2 (I3_q3_2 I3_o3_2 VSS VSS) gpdk090_nmos1v w=0.12u l=0.1u ad=0.0468p as=0.0696p pd=0.68u ps=1.16u
    I_MXI3_I128_MN0 (XI3_I128_n1 I3_SEL_AS_b3_0 I3_q3_2 VSS) gpdk090_nmos1v w=0.24u l=0.1u ad=0.0528p as=0.0468p pd=0.68u ps=0.68u
    I_MXI3_I128_MN1 (VSS S_3 XI3_I128_n1 VSS) gpdk090_nmos1v w=0.24u l=0.1u ad=0.0816p as=0.0528p pd=1.16u ps=0.68u
    I_MXI3_I152_MN2 (I3_q5_2 I3_o5_2 VSS VSS) gpdk090_nmos1v w=0.12u l=0.1u ad=0.0468p as=0.0696p pd=0.68u ps=1.16u
    I_MXI3_I152_MN0 (XI3_I152_n1 I3_SEL_AS_b3_0 I3_q5_2 VSS) gpdk090_nmos1v w=0.24u l=0.1u ad=0.0528p as=0.0468p pd=0.68u ps=0.68u
    I_MXI3_I152_MN1 (VSS S_5 XI3_I152_n1 VSS) gpdk090_nmos1v w=0.24u l=0.1u ad=0.0816p as=0.0528p pd=1.16u ps=0.68u
    I_MXI1_I42_I158_XG_MN2 (I1_I42_G9_0n I1_I42_G9_2 VSS VSS) gpdk090_nmos1v w=0.12u l=0.1u ad=0.0468p as=0.0696p pd=0.68u ps=1.16u
    I_MXI1_I42_I158_XG_MN0 (XI1_I42_I158_XG_n1 I1_I42_P9_2 I1_I42_G9_0n VSS) gpdk090_nmos1v w=0.24u l=0.1u ad=0.0528p as=0.0468p pd=0.68u ps=0.68u
    I_MXI1_I42_I158_XG_MN1 (VSS I1_I42_G1_0 XI1_I42_I158_XG_n1 VSS) gpdk090_nmos1v w=0.24u l=0.1u ad=0.0816p as=0.0528p pd=1.16u ps=0.68u
    I_MXI1_I42_I105_XG_MN2 (I1_I42_G9_6n I1_I42_G9_8 VSS VSS) gpdk090_nmos1v w=0.12u l=0.1u ad=0.0468p as=0.0696p pd=0.68u ps=1.16u
    I_MXI1_I42_I105_XG_MN0 (XI1_I42_I105_XG_n1 I1_I42_P9_8 I1_I42_G9_6n VSS) gpdk090_nmos1v w=0.24u l=0.1u ad=0.0528p as=0.0468p pd=0.68u ps=0.68u
    I_MXI1_I42_I105_XG_MN1 (VSS I1_I42_G7_6 XI1_I42_I105_XG_n1 VSS) gpdk090_nmos1v w=0.24u l=0.1u ad=0.0816p as=0.0528p pd=1.16u ps=0.68u
    I_MXI1_I42_I103_XG_MN2 (I1_I42_G7_4n I1_I42_G7_6 VSS VSS) gpdk090_nmos1v w=0.12u l=0.1u ad=0.0468p as=0.0696p pd=0.68u ps=1.16u
    I_MXI1_I42_I103_XG_MN0 (XI1_I42_I103_XG_n1 I1_I42_P7_6 I1_I42_G7_4n VSS) gpdk090_nmos1v w=0.24u l=0.1u ad=0.0528p as=0.0468p pd=0.68u ps=0.68u
    I_MXI1_I42_I103_XG_MN1 (VSS I1_I42_G5_4 XI1_I42_I103_XG_n1 VSS) gpdk090_nmos1v w=0.24u l=0.1u ad=0.0816p as=0.0528p pd=1.16u ps=0.68u
    I_MXI1_I42_I101_XG_MN2 (I1_I42_G5_2n I1_I42_G5_4 VSS VSS) gpdk090_nmos1v w=0.12u l=0.1u ad=0.0468p as=0.0696p pd=0.68u ps=1.16u
    I_MXI1_I42_I101_XG_MN0 (XI1_I42_I101_XG_n1 I1_I42_P5_4 I1_I42_G5_2n VSS) gpdk090_nmos1v w=0.24u l=0.1u ad=0.0528p as=0.0468p pd=0.68u ps=0.68u
    I_MXI1_I42_I101_XG_MN1 (VSS I1_I42_G3_2 XI1_I42_I101_XG_n1 VSS) gpdk090_nmos1v w=0.24u l=0.1u ad=0.0816p as=0.0528p pd=1.16u ps=0.68u
    I_MXI1_I42_I104_XG_MN2 (I1_I42_G8_5n I1_I42_G8_7 VSS VSS) gpdk090_nmos1v w=0.12u l=0.1u ad=0.0468p as=0.0696p pd=0.68u ps=1.16u
    I_MXI1_I42_I104_XG_MN0 (XI1_I42_I104_XG_n1 I1_I42_P8_7 I1_I42_G8_5n VSS) gpdk090_nmos1v w=0.24u l=0.1u ad=0.0528p as=0.0468p pd=0.68u ps=0.68u
    I_MXI1_I42_I104_XG_MN1 (VSS I1_I42_G6_5 XI1_I42_I104_XG_n1 VSS) gpdk090_nmos1v w=0.24u l=0.1u ad=0.0816p as=0.0528p pd=1.16u ps=0.68u
    I_MXI1_I42_I102_XG_MN2 (I1_I42_G6_3n I1_I42_G6_5 VSS VSS) gpdk090_nmos1v w=0.12u l=0.1u ad=0.0468p as=0.0696p pd=0.68u ps=1.16u
    I_MXI1_I42_I102_XG_MN0 (XI1_I42_I102_XG_n1 I1_I42_P6_5 I1_I42_G6_3n VSS) gpdk090_nmos1v w=0.24u l=0.1u ad=0.0528p as=0.0468p pd=0.68u ps=0.68u
    I_MXI1_I42_I102_XG_MN1 (VSS I1_I42_G4_3 XI1_I42_I102_XG_n1 VSS) gpdk090_nmos1v w=0.24u l=0.1u ad=0.0816p as=0.0528p pd=1.16u ps=0.68u
    I_MXI1_I42_I100_XG_MN2 (I1_I42_G4_1n I1_I42_G4_3 VSS VSS) gpdk090_nmos1v w=0.12u l=0.1u ad=0.0468p as=0.0696p pd=0.68u ps=1.16u
    I_MXI1_I42_I100_XG_MN0 (XI1_I42_I100_XG_n1 I1_I42_P4_3 I1_I42_G4_1n VSS) gpdk090_nmos1v w=0.24u l=0.1u ad=0.0528p as=0.0468p pd=0.68u ps=0.68u
    I_MXI1_I42_I100_XG_MN1 (VSS I1_I42_G2_1 XI1_I42_I100_XG_n1 VSS) gpdk090_nmos1v w=0.24u l=0.1u ad=0.0816p as=0.0528p pd=1.16u ps=0.68u
    I_MXI1_I42_I99_XG_MN2 (I1_I42_G3_0n I1_I42_G3_2 VSS VSS) gpdk090_nmos1v w=0.12u l=0.1u ad=0.0468p as=0.0696p pd=0.68u ps=1.16u
    I_MXI1_I42_I99_XG_MN0 (XI1_I42_I99_XG_n1 I1_I42_P3_2 I1_I42_G3_0n VSS) gpdk090_nmos1v w=0.24u l=0.1u ad=0.0528p as=0.0468p pd=0.68u ps=0.68u
    I_MXI1_I42_I99_XG_MN1 (VSS I1_I42_G1_0 XI1_I42_I99_XG_n1 VSS) gpdk090_nmos1v w=0.24u l=0.1u ad=0.0816p as=0.0528p pd=1.16u ps=0.68u
    I_MXI1_I42_I98_XG_MN2 (I1_I42_G2_0n I1_I42_G2_1 VSS VSS) gpdk090_nmos1v w=0.12u l=0.1u ad=0.0468p as=0.0696p pd=0.68u ps=1.16u
    I_MXI1_I42_I98_XG_MN0 (XI1_I42_I98_XG_n1 I1_I42_P2_1 I1_I42_G2_0n VSS) gpdk090_nmos1v w=0.24u l=0.1u ad=0.0528p as=0.0468p pd=0.68u ps=0.68u
    I_MXI1_I42_I98_XG_MN1 (VSS I1_I42_G0_0 XI1_I42_I98_XG_n1 VSS) gpdk090_nmos1v w=0.24u l=0.1u ad=0.0816p as=0.0528p pd=1.16u ps=0.68u
    I_MXI1_I42_I168_XG_MN2 (I1_I42_G17_2n I1_I42_G17_10 VSS VSS) gpdk090_nmos1v w=0.12u l=0.1u ad=0.0468p as=0.0696p pd=0.68u ps=1.16u
    I_MXI1_I42_I168_XG_MN0 (XI1_I42_I168_XG_n1 I1_I42_P17_10 I1_I42_G17_2n VSS) gpdk090_nmos1v w=0.24u l=0.1u ad=0.0528p as=0.0468p pd=0.68u ps=0.68u
    I_MXI1_I42_I168_XG_MN1 (VSS I1_I42_G9_2 XI1_I42_I168_XG_n1 VSS) gpdk090_nmos1v w=0.24u l=0.1u ad=0.0816p as=0.0528p pd=1.16u ps=0.68u
    I_MXI3_I224_MN2 (I3_q11_2 I3_o11_2 VSS VSS) gpdk090_nmos1v w=0.12u l=0.1u ad=0.0468p as=0.0696p pd=0.68u ps=1.16u
    I_MXI3_I224_MN0 (XI3_I224_n1 I3_SEL_AS_b3_2 I3_q11_2 VSS) gpdk090_nmos1v w=0.24u l=0.1u ad=0.0528p as=0.0468p pd=0.68u ps=0.68u
    I_MXI3_I224_MN1 (VSS S_11 XI3_I224_n1 VSS) gpdk090_nmos1v w=0.24u l=0.1u ad=0.0816p as=0.0528p pd=1.16u ps=0.68u
    I_MXI1_I42_I106_XG_MN2 (I1_I42_G10_7n I1_I42_G10_9 VSS VSS) gpdk090_nmos1v w=0.12u l=0.1u ad=0.0468p as=0.0696p pd=0.68u ps=1.16u
    I_MXI1_I42_I106_XG_MN0 (XI1_I42_I106_XG_n1 I1_I42_P10_9 I1_I42_G10_7n VSS) gpdk090_nmos1v w=0.24u l=0.1u ad=0.0528p as=0.0468p pd=0.68u ps=0.68u
    I_MXI1_I42_I106_XG_MN1 (VSS I1_I42_G8_7 XI1_I42_I106_XG_n1 VSS) gpdk090_nmos1v w=0.24u l=0.1u ad=0.0816p as=0.0528p pd=1.16u ps=0.68u
    I_MXI1_I42_I157_XG_MN2 (I1_I42_G8_0n I1_I42_G8_1 VSS VSS) gpdk090_nmos1v w=0.12u l=0.1u ad=0.0468p as=0.0696p pd=0.68u ps=1.16u
    I_MXI1_I42_I157_XG_MN0 (XI1_I42_I157_XG_n1 I1_I42_P8_1 I1_I42_G8_0n VSS) gpdk090_nmos1v w=0.24u l=0.1u ad=0.0528p as=0.0468p pd=0.68u ps=0.68u
    I_MXI1_I42_I157_XG_MN1 (VSS I1_I42_G0_0 XI1_I42_I157_XG_n1 VSS) gpdk090_nmos1v w=0.24u l=0.1u ad=0.0816p as=0.0528p pd=1.16u ps=0.68u
    I_MXI3_I452_MN2 (I3_q30_2 I3_o30_2 VSS VSS) gpdk090_nmos1v w=0.12u l=0.1u ad=0.0468p as=0.0696p pd=0.68u ps=1.16u
    I_MXI3_I452_MN0 (XI3_I452_n1 I3_SEL_AS_b3_5 I3_q30_2 VSS) gpdk090_nmos1v w=0.24u l=0.1u ad=0.0528p as=0.0468p pd=0.68u ps=0.68u
    I_MXI3_I452_MN1 (VSS S_30 XI3_I452_n1 VSS) gpdk090_nmos1v w=0.24u l=0.1u ad=0.0816p as=0.0528p pd=1.16u ps=0.68u
    I_MXI3_I464_MN2 (I3_q31_2 I3_o31_2 VSS VSS) gpdk090_nmos1v w=0.12u l=0.1u ad=0.0468p as=0.0696p pd=0.68u ps=1.16u
    I_MXI3_I464_MN0 (XI3_I464_n1 I3_SEL_AS_b3_5 I3_q31_2 VSS) gpdk090_nmos1v w=0.24u l=0.1u ad=0.0528p as=0.0468p pd=0.68u ps=0.68u
    I_MXI3_I464_MN1 (VSS S_31 XI3_I464_n1 VSS) gpdk090_nmos1v w=0.24u l=0.1u ad=0.0816p as=0.0528p pd=1.16u ps=0.68u
    I_MXI1_I42_I176_XG_MN2 (I1_I42_G25_10n I1_I42_G25_18 VSS VSS) gpdk090_nmos1v w=0.12u l=0.1u ad=0.0468p as=0.0696p pd=0.68u ps=1.16u
    I_MXI1_I42_I176_XG_MN0 (XI1_I42_I176_XG_n1 I1_I42_P25_18 I1_I42_G25_10n VSS) gpdk090_nmos1v w=0.24u l=0.1u ad=0.0528p as=0.0468p pd=0.68u ps=0.68u
    I_MXI1_I42_I176_XG_MN1 (VSS I1_I42_G17_10 XI1_I42_I176_XG_n1 VSS) gpdk090_nmos1v w=0.24u l=0.1u ad=0.0816p as=0.0528p pd=1.16u ps=0.68u
    I_MXI1_I42_I164_XG_MN2 (I1_I42_G13_0n I1_I42_G13_6 VSS VSS) gpdk090_nmos1v w=0.12u l=0.1u ad=0.0468p as=0.0696p pd=0.68u ps=1.16u
    I_MXI1_I42_I164_XG_MN0 (XI1_I42_I164_XG_n1 I1_I42_P13_6 I1_I42_G13_0n VSS) gpdk090_nmos1v w=0.24u l=0.1u ad=0.0528p as=0.0468p pd=0.68u ps=0.68u
    I_MXI1_I42_I164_XG_MN1 (VSS I1_I42_G5_0 XI1_I42_I164_XG_n1 VSS) gpdk090_nmos1v w=0.24u l=0.1u ad=0.0816p as=0.0528p pd=1.16u ps=0.68u
    I_MXI1_I42_I107_XG_MN2 (I1_I42_G11_8n I1_I42_G11_10 VSS VSS) gpdk090_nmos1v w=0.12u l=0.1u ad=0.0468p as=0.0696p pd=0.68u ps=1.16u
    I_MXI1_I42_I107_XG_MN0 (XI1_I42_I107_XG_n1 I1_I42_P11_10 I1_I42_G11_8n VSS) gpdk090_nmos1v w=0.24u l=0.1u ad=0.0528p as=0.0468p pd=0.68u ps=0.68u
    I_MXI1_I42_I107_XG_MN1 (VSS I1_I42_G9_8 XI1_I42_I107_XG_n1 VSS) gpdk090_nmos1v w=0.24u l=0.1u ad=0.0816p as=0.0528p pd=1.16u ps=0.68u
    I_MXI1_I42_I109_XG_MN2 (I1_I42_G13_10n I1_I42_G13_12 VSS VSS) gpdk090_nmos1v w=0.12u l=0.1u ad=0.0468p as=0.0696p pd=0.68u ps=1.16u
    I_MXI1_I42_I109_XG_MN0 (XI1_I42_I109_XG_n1 I1_I42_P13_12 I1_I42_G13_10n VSS) gpdk090_nmos1v w=0.24u l=0.1u ad=0.0528p as=0.0468p pd=0.68u ps=0.68u
    I_MXI1_I42_I109_XG_MN1 (VSS I1_I42_G11_10 XI1_I42_I109_XG_n1 VSS) gpdk090_nmos1v w=0.24u l=0.1u ad=0.0816p as=0.0528p pd=1.16u ps=0.68u
    I_MXI1_I42_I167_XG_MN2 (I1_I42_G16_1n I1_I42_G16_9 VSS VSS) gpdk090_nmos1v w=0.12u l=0.1u ad=0.0468p as=0.0696p pd=0.68u ps=1.16u
    I_MXI1_I42_I167_XG_MN0 (XI1_I42_I167_XG_n1 I1_I42_P16_9 I1_I42_G16_1n VSS) gpdk090_nmos1v w=0.24u l=0.1u ad=0.0528p as=0.0468p pd=0.68u ps=0.68u
    I_MXI1_I42_I167_XG_MN1 (VSS I1_I42_G8_1 XI1_I42_I167_XG_n1 VSS) gpdk090_nmos1v w=0.24u l=0.1u ad=0.0816p as=0.0528p pd=1.16u ps=0.68u
    I_MXI1_I42_I180_XG_MN2 (I1_I42_G29_14n I1_I42_G29_22 VSS VSS) gpdk090_nmos1v w=0.12u l=0.1u ad=0.0468p as=0.0696p pd=0.68u ps=1.16u
    I_MXI1_I42_I180_XG_MN0 (XI1_I42_I180_XG_n1 I1_I42_P29_22 I1_I42_G29_14n VSS) gpdk090_nmos1v w=0.24u l=0.1u ad=0.0528p as=0.0468p pd=0.68u ps=0.68u
    I_MXI1_I42_I180_XG_MN1 (VSS I1_I42_G21_14 XI1_I42_I180_XG_n1 VSS) gpdk090_nmos1v w=0.24u l=0.1u ad=0.0816p as=0.0528p pd=1.16u ps=0.68u
    I_MXI1_I42_I172_XG_MN2 (I1_I42_G21_6n I1_I42_G21_14 VSS VSS) gpdk090_nmos1v w=0.12u l=0.1u ad=0.0468p as=0.0696p pd=0.68u ps=1.16u
    I_MXI1_I42_I172_XG_MN0 (XI1_I42_I172_XG_n1 I1_I42_P21_14 I1_I42_G21_6n VSS) gpdk090_nmos1v w=0.24u l=0.1u ad=0.0528p as=0.0468p pd=0.68u ps=0.68u
    I_MXI1_I42_I172_XG_MN1 (VSS I1_I42_G13_6 XI1_I42_I172_XG_n1 VSS) gpdk090_nmos1v w=0.24u l=0.1u ad=0.0816p as=0.0528p pd=1.16u ps=0.68u
    I_MXI1_I42_I162_XG_MN2 (I1_I42_G11_0n I1_I42_G11_4 VSS VSS) gpdk090_nmos1v w=0.12u l=0.1u ad=0.0468p as=0.0696p pd=0.68u ps=1.16u
    I_MXI1_I42_I162_XG_MN0 (XI1_I42_I162_XG_n1 I1_I42_P11_4 I1_I42_G11_0n VSS) gpdk090_nmos1v w=0.24u l=0.1u ad=0.0528p as=0.0468p pd=0.68u ps=0.68u
    I_MXI1_I42_I162_XG_MN1 (VSS I1_I42_G3_0np XI1_I42_I162_XG_n1 VSS) gpdk090_nmos1v w=0.24u l=0.1u ad=0.0816p as=0.0528p pd=1.16u ps=0.68u
    I_MXI1_I42_I160_XG_MN2 (I1_I42_G10_0n I1_I42_G10_3 VSS VSS) gpdk090_nmos1v w=0.12u l=0.1u ad=0.0468p as=0.0696p pd=0.68u ps=1.16u
    I_MXI1_I42_I160_XG_MN0 (XI1_I42_I160_XG_n1 I1_I42_P10_3 I1_I42_G10_0n VSS) gpdk090_nmos1v w=0.24u l=0.1u ad=0.0528p as=0.0468p pd=0.68u ps=0.68u
    I_MXI1_I42_I160_XG_MN1 (VSS I1_I42_G2_0np XI1_I42_I160_XG_n1 VSS) gpdk090_nmos1v w=0.24u l=0.1u ad=0.0816p as=0.0528p pd=1.16u ps=0.68u
    I_MXI1_I42_I108_XG_MN2 (I1_I42_G12_9n I1_I42_G12_11 VSS VSS) gpdk090_nmos1v w=0.12u l=0.1u ad=0.0468p as=0.0696p pd=0.68u ps=1.16u
    I_MXI1_I42_I108_XG_MN0 (XI1_I42_I108_XG_n1 I1_I42_P12_11 I1_I42_G12_9n VSS) gpdk090_nmos1v w=0.24u l=0.1u ad=0.0528p as=0.0468p pd=0.68u ps=0.68u
    I_MXI1_I42_I108_XG_MN1 (VSS I1_I42_G10_9 XI1_I42_I108_XG_n1 VSS) gpdk090_nmos1v w=0.24u l=0.1u ad=0.0816p as=0.0528p pd=1.16u ps=0.68u
    I_MXI3_I236_MN2 (I3_q12_2 I3_o12_2 VSS VSS) gpdk090_nmos1v w=0.12u l=0.1u ad=0.0468p as=0.0696p pd=0.68u ps=1.16u
    I_MXI3_I236_MN0 (XI3_I236_n1 I3_SEL_AS_b3_2 I3_q12_2 VSS) gpdk090_nmos1v w=0.24u l=0.1u ad=0.0528p as=0.0468p pd=0.68u ps=0.68u
    I_MXI3_I236_MN1 (VSS S_12 XI3_I236_n1 VSS) gpdk090_nmos1v w=0.24u l=0.1u ad=0.0816p as=0.0528p pd=1.16u ps=0.68u
    I_MXI3_I440_MN2 (I3_q29_2 I3_o29_2 VSS VSS) gpdk090_nmos1v w=0.12u l=0.1u ad=0.0468p as=0.0696p pd=0.68u ps=1.16u
    I_MXI3_I440_MN0 (XI3_I440_n1 I3_SEL_AS_b3_5 I3_q29_2 VSS) gpdk090_nmos1v w=0.24u l=0.1u ad=0.0528p as=0.0468p pd=0.68u ps=0.68u
    I_MXI3_I440_MN1 (VSS S_29 XI3_I440_n1 VSS) gpdk090_nmos1v w=0.24u l=0.1u ad=0.0816p as=0.0528p pd=1.16u ps=0.68u
    I_MXI1_I42_I125_XG_MN2 (I1_I42_G29_26n I1_I42_G29_28 VSS VSS) gpdk090_nmos1v w=0.12u l=0.1u ad=0.0468p as=0.0696p pd=0.68u ps=1.16u
    I_MXI1_I42_I125_XG_MN0 (XI1_I42_I125_XG_n1 I1_I42_P29_28 I1_I42_G29_26n VSS) gpdk090_nmos1v w=0.24u l=0.1u ad=0.0528p as=0.0468p pd=0.68u ps=0.68u
    I_MXI1_I42_I125_XG_MN1 (VSS I1_I42_G27_26 XI1_I42_I125_XG_n1 VSS) gpdk090_nmos1v w=0.24u l=0.1u ad=0.0816p as=0.0528p pd=1.16u ps=0.68u
    I_MXI1_I42_I127_XG_MN2 (I1_I42_G31_28n I1_I42_G31_30 VSS VSS) gpdk090_nmos1v w=0.12u l=0.1u ad=0.0468p as=0.0696p pd=0.68u ps=1.16u
    I_MXI1_I42_I127_XG_MN0 (XI1_I42_I127_XG_n1 I1_I42_P31_30 I1_I42_G31_28n VSS) gpdk090_nmos1v w=0.24u l=0.1u ad=0.0528p as=0.0468p pd=0.68u ps=0.68u
    I_MXI1_I42_I127_XG_MN1 (VSS I1_I42_G29_28 XI1_I42_I127_XG_n1 VSS) gpdk090_nmos1v w=0.24u l=0.1u ad=0.0816p as=0.0528p pd=1.16u ps=0.68u
    I_MXI1_I42_I182_XG_MN2 (I1_I42_G31_16n I1_I42_G31_24 VSS VSS) gpdk090_nmos1v w=0.12u l=0.1u ad=0.0468p as=0.0696p pd=0.68u ps=1.16u
    I_MXI1_I42_I182_XG_MN0 (XI1_I42_I182_XG_n1 I1_I42_P31_24 I1_I42_G31_16n VSS) gpdk090_nmos1v w=0.24u l=0.1u ad=0.0528p as=0.0468p pd=0.68u ps=0.68u
    I_MXI1_I42_I182_XG_MN1 (VSS I1_I42_G23_16 XI1_I42_I182_XG_n1 VSS) gpdk090_nmos1v w=0.24u l=0.1u ad=0.0816p as=0.0528p pd=1.16u ps=0.68u
    I_MXI1_I42_I174_XG_MN2 (I1_I42_G23_8n I1_I42_G23_16 VSS VSS) gpdk090_nmos1v w=0.12u l=0.1u ad=0.0468p as=0.0696p pd=0.68u ps=1.16u
    I_MXI1_I42_I174_XG_MN0 (XI1_I42_I174_XG_n1 I1_I42_P23_16 I1_I42_G23_8n VSS) gpdk090_nmos1v w=0.24u l=0.1u ad=0.0528p as=0.0468p pd=0.68u ps=0.68u
    I_MXI1_I42_I174_XG_MN1 (VSS I1_I42_G15_8 XI1_I42_I174_XG_n1 VSS) gpdk090_nmos1v w=0.24u l=0.1u ad=0.0816p as=0.0528p pd=1.16u ps=0.68u
    I_MXI1_I42_I166_XG_MN2 (I1_I42_G15_0n I1_I42_G15_8 VSS VSS) gpdk090_nmos1v w=0.12u l=0.1u ad=0.0468p as=0.0696p pd=0.68u ps=1.16u
    I_MXI1_I42_I166_XG_MN0 (XI1_I42_I166_XG_n1 I1_I42_P15_8 I1_I42_G15_0n VSS) gpdk090_nmos1v w=0.24u l=0.1u ad=0.0528p as=0.0468p pd=0.68u ps=0.68u
    I_MXI1_I42_I166_XG_MN1 (VSS I1_I42_G7_0 XI1_I42_I166_XG_n1 VSS) gpdk090_nmos1v w=0.24u l=0.1u ad=0.0816p as=0.0528p pd=1.16u ps=0.68u
    I_MXI1_I42_I170_XG_MN2 (I1_I42_G19_4n I1_I42_G19_12 VSS VSS) gpdk090_nmos1v w=0.12u l=0.1u ad=0.0468p as=0.0696p pd=0.68u ps=1.16u
    I_MXI1_I42_I170_XG_MN0 (XI1_I42_I170_XG_n1 I1_I42_P19_12 I1_I42_G19_4n VSS) gpdk090_nmos1v w=0.24u l=0.1u ad=0.0528p as=0.0468p pd=0.68u ps=0.68u
    I_MXI1_I42_I170_XG_MN1 (VSS I1_I42_G11_4 XI1_I42_I170_XG_n1 VSS) gpdk090_nmos1v w=0.24u l=0.1u ad=0.0816p as=0.0528p pd=1.16u ps=0.68u
    I_MXI1_I42_I111_XG_MN2 (I1_I42_G15_12n I1_I42_G15_14 VSS VSS) gpdk090_nmos1v w=0.12u l=0.1u ad=0.0468p as=0.0696p pd=0.68u ps=1.16u
    I_MXI1_I42_I111_XG_MN0 (XI1_I42_I111_XG_n1 I1_I42_P15_14 I1_I42_G15_12n VSS) gpdk090_nmos1v w=0.24u l=0.1u ad=0.0528p as=0.0468p pd=0.68u ps=0.68u
    I_MXI1_I42_I111_XG_MN1 (VSS I1_I42_G13_12 XI1_I42_I111_XG_n1 VSS) gpdk090_nmos1v w=0.24u l=0.1u ad=0.0816p as=0.0528p pd=1.16u ps=0.68u
    I_MXI1_I42_I169_XG_MN2 (I1_I42_G18_3n I1_I42_G18_11 VSS VSS) gpdk090_nmos1v w=0.12u l=0.1u ad=0.0468p as=0.0696p pd=0.68u ps=1.16u
    I_MXI1_I42_I169_XG_MN0 (XI1_I42_I169_XG_n1 I1_I42_P18_11 I1_I42_G18_3n VSS) gpdk090_nmos1v w=0.24u l=0.1u ad=0.0528p as=0.0468p pd=0.68u ps=0.68u
    I_MXI1_I42_I169_XG_MN1 (VSS I1_I42_G10_3 XI1_I42_I169_XG_n1 VSS) gpdk090_nmos1v w=0.24u l=0.1u ad=0.0816p as=0.0528p pd=1.16u ps=0.68u
    I_MXI1_I42_I175_XG_MN2 (I1_I42_G24_9n I1_I42_G24_17 VSS VSS) gpdk090_nmos1v w=0.12u l=0.1u ad=0.0468p as=0.0696p pd=0.68u ps=1.16u
    I_MXI1_I42_I175_XG_MN0 (XI1_I42_I175_XG_n1 I1_I42_P24_17 I1_I42_G24_9n VSS) gpdk090_nmos1v w=0.24u l=0.1u ad=0.0528p as=0.0468p pd=0.68u ps=0.68u
    I_MXI1_I42_I175_XG_MN1 (VSS I1_I42_G16_9 XI1_I42_I175_XG_n1 VSS) gpdk090_nmos1v w=0.24u l=0.1u ad=0.0816p as=0.0528p pd=1.16u ps=0.68u
    I_MXI1_I42_I163_XG_MN2 (I1_I42_G12_0n I1_I42_G12_5 VSS VSS) gpdk090_nmos1v w=0.12u l=0.1u ad=0.0468p as=0.0696p pd=0.68u ps=1.16u
    I_MXI1_I42_I163_XG_MN0 (XI1_I42_I163_XG_n1 I1_I42_P12_5 I1_I42_G12_0n VSS) gpdk090_nmos1v w=0.24u l=0.1u ad=0.0528p as=0.0468p pd=0.68u ps=0.68u
    I_MXI1_I42_I163_XG_MN1 (VSS I1_I42_G4_0 XI1_I42_I163_XG_n1 VSS) gpdk090_nmos1v w=0.24u l=0.1u ad=0.0816p as=0.0528p pd=1.16u ps=0.68u
    I_MXI3_I248_MN2 (I3_q13_2 I3_o13_2 VSS VSS) gpdk090_nmos1v w=0.12u l=0.1u ad=0.0468p as=0.0696p pd=0.68u ps=1.16u
    I_MXI3_I248_MN0 (XI3_I248_n1 I3_SEL_AS_b3_2 I3_q13_2 VSS) gpdk090_nmos1v w=0.24u l=0.1u ad=0.0528p as=0.0468p pd=0.68u ps=0.68u
    I_MXI3_I248_MN1 (VSS S_13 XI3_I248_n1 VSS) gpdk090_nmos1v w=0.24u l=0.1u ad=0.0816p as=0.0528p pd=1.16u ps=0.68u
    I_MXI3_I428_MN2 (I3_q28_2 I3_o28_2 VSS VSS) gpdk090_nmos1v w=0.12u l=0.1u ad=0.0468p as=0.0696p pd=0.68u ps=1.16u
    I_MXI3_I428_MN0 (XI3_I428_n1 I3_SEL_AS_b3_5 I3_q28_2 VSS) gpdk090_nmos1v w=0.24u l=0.1u ad=0.0528p as=0.0468p pd=0.68u ps=0.68u
    I_MXI3_I428_MN1 (VSS S_28 XI3_I428_n1 VSS) gpdk090_nmos1v w=0.24u l=0.1u ad=0.0816p as=0.0528p pd=1.16u ps=0.68u
    I_MXI1_I42_I123_XG_MN2 (I1_I42_G27_24n I1_I42_G27_26 VSS VSS) gpdk090_nmos1v w=0.12u l=0.1u ad=0.0468p as=0.0696p pd=0.68u ps=1.16u
    I_MXI1_I42_I123_XG_MN0 (XI1_I42_I123_XG_n1 I1_I42_P27_26 I1_I42_G27_24n VSS) gpdk090_nmos1v w=0.24u l=0.1u ad=0.0528p as=0.0468p pd=0.68u ps=0.68u
    I_MXI1_I42_I123_XG_MN1 (VSS I1_I42_G25_24 XI1_I42_I123_XG_n1 VSS) gpdk090_nmos1v w=0.24u l=0.1u ad=0.0816p as=0.0528p pd=1.16u ps=0.68u
    I_MXI1_I42_I178_XG_MN2 (I1_I42_G27_12n I1_I42_G27_20 VSS VSS) gpdk090_nmos1v w=0.12u l=0.1u ad=0.0468p as=0.0696p pd=0.68u ps=1.16u
    I_MXI1_I42_I178_XG_MN0 (XI1_I42_I178_XG_n1 I1_I42_P27_20 I1_I42_G27_12n VSS) gpdk090_nmos1v w=0.24u l=0.1u ad=0.0528p as=0.0468p pd=0.68u ps=0.68u
    I_MXI1_I42_I178_XG_MN1 (VSS I1_I42_G19_12 XI1_I42_I178_XG_n1 VSS) gpdk090_nmos1v w=0.24u l=0.1u ad=0.0816p as=0.0528p pd=1.16u ps=0.68u
    I_MXI1_I42_I113_XG_MN2 (I1_I42_G17_14n I1_I42_G17_16 VSS VSS) gpdk090_nmos1v w=0.12u l=0.1u ad=0.0468p as=0.0696p pd=0.68u ps=1.16u
    I_MXI1_I42_I113_XG_MN0 (XI1_I42_I113_XG_n1 I1_I42_P17_16 I1_I42_G17_14n VSS) gpdk090_nmos1v w=0.24u l=0.1u ad=0.0528p as=0.0468p pd=0.68u ps=0.68u
    I_MXI1_I42_I113_XG_MN1 (VSS I1_I42_G15_14 XI1_I42_I113_XG_n1 VSS) gpdk090_nmos1v w=0.24u l=0.1u ad=0.0816p as=0.0528p pd=1.16u ps=0.68u
    I_MXI1_I42_I179_XG_MN2 (I1_I42_G28_13n I1_I42_G28_21 VSS VSS) gpdk090_nmos1v w=0.12u l=0.1u ad=0.0468p as=0.0696p pd=0.68u ps=1.16u
    I_MXI1_I42_I179_XG_MN0 (XI1_I42_I179_XG_n1 I1_I42_P28_21 I1_I42_G28_13n VSS) gpdk090_nmos1v w=0.24u l=0.1u ad=0.0528p as=0.0468p pd=0.68u ps=0.68u
    I_MXI1_I42_I179_XG_MN1 (VSS I1_I42_G20_13 XI1_I42_I179_XG_n1 VSS) gpdk090_nmos1v w=0.24u l=0.1u ad=0.0816p as=0.0528p pd=1.16u ps=0.68u
    I_MXI1_I42_I171_XG_MN2 (I1_I42_G20_5n I1_I42_G20_13 VSS VSS) gpdk090_nmos1v w=0.12u l=0.1u ad=0.0468p as=0.0696p pd=0.68u ps=1.16u
    I_MXI1_I42_I171_XG_MN0 (XI1_I42_I171_XG_n1 I1_I42_P20_13 I1_I42_G20_5n VSS) gpdk090_nmos1v w=0.24u l=0.1u ad=0.0528p as=0.0468p pd=0.68u ps=0.68u
    I_MXI1_I42_I171_XG_MN1 (VSS I1_I42_G12_5 XI1_I42_I171_XG_n1 VSS) gpdk090_nmos1v w=0.24u l=0.1u ad=0.0816p as=0.0528p pd=1.16u ps=0.68u
    I_MXI1_I42_I110_XG_MN2 (I1_I42_G14_11n I1_I42_G14_13 VSS VSS) gpdk090_nmos1v w=0.12u l=0.1u ad=0.0468p as=0.0696p pd=0.68u ps=1.16u
    I_MXI1_I42_I110_XG_MN0 (XI1_I42_I110_XG_n1 I1_I42_P14_13 I1_I42_G14_11n VSS) gpdk090_nmos1v w=0.24u l=0.1u ad=0.0528p as=0.0468p pd=0.68u ps=0.68u
    I_MXI1_I42_I110_XG_MN1 (VSS I1_I42_G12_11 XI1_I42_I110_XG_n1 VSS) gpdk090_nmos1v w=0.24u l=0.1u ad=0.0816p as=0.0528p pd=1.16u ps=0.68u
    I_MXI3_I260_MN2 (I3_q14_2 I3_o14_2 VSS VSS) gpdk090_nmos1v w=0.12u l=0.1u ad=0.0468p as=0.0696p pd=0.68u ps=1.16u
    I_MXI3_I260_MN0 (XI3_I260_n1 I3_SEL_AS_b3_2 I3_q14_2 VSS) gpdk090_nmos1v w=0.24u l=0.1u ad=0.0528p as=0.0468p pd=0.68u ps=0.68u
    I_MXI3_I260_MN1 (VSS S_14 XI3_I260_n1 VSS) gpdk090_nmos1v w=0.24u l=0.1u ad=0.0816p as=0.0528p pd=1.16u ps=0.68u
    I_MXI3_I416_MN2 (I3_q27_2 I3_o27_2 VSS VSS) gpdk090_nmos1v w=0.12u l=0.1u ad=0.0468p as=0.0696p pd=0.68u ps=1.16u
    I_MXI3_I416_MN0 (XI3_I416_n1 I3_SEL_AS_b3_5 I3_q27_2 VSS) gpdk090_nmos1v w=0.24u l=0.1u ad=0.0528p as=0.0468p pd=0.68u ps=0.68u
    I_MXI3_I416_MN1 (VSS S_27 XI3_I416_n1 VSS) gpdk090_nmos1v w=0.24u l=0.1u ad=0.0816p as=0.0528p pd=1.16u ps=0.68u
    I_MXI1_I42_I126_XG_MN2 (I1_I42_G30_27n I1_I42_G30_29 VSS VSS) gpdk090_nmos1v w=0.12u l=0.1u ad=0.0468p as=0.0696p pd=0.68u ps=1.16u
    I_MXI1_I42_I126_XG_MN0 (XI1_I42_I126_XG_n1 I1_I42_P30_29 I1_I42_G30_27n VSS) gpdk090_nmos1v w=0.24u l=0.1u ad=0.0528p as=0.0468p pd=0.68u ps=0.68u
    I_MXI1_I42_I126_XG_MN1 (VSS I1_I42_G28_27 XI1_I42_I126_XG_n1 VSS) gpdk090_nmos1v w=0.24u l=0.1u ad=0.0816p as=0.0528p pd=1.16u ps=0.68u
    I_MXI1_I42_I124_XG_MN2 (I1_I42_G28_25n I1_I42_G28_27 VSS VSS) gpdk090_nmos1v w=0.12u l=0.1u ad=0.0468p as=0.0696p pd=0.68u ps=1.16u
    I_MXI1_I42_I124_XG_MN0 (XI1_I42_I124_XG_n1 I1_I42_P28_27 I1_I42_G28_25n VSS) gpdk090_nmos1v w=0.24u l=0.1u ad=0.0528p as=0.0468p pd=0.68u ps=0.68u
    I_MXI1_I42_I124_XG_MN1 (VSS I1_I42_G26_25 XI1_I42_I124_XG_n1 VSS) gpdk090_nmos1v w=0.24u l=0.1u ad=0.0816p as=0.0528p pd=1.16u ps=0.68u
    I_MXI1_I42_I121_XG_MN2 (I1_I42_G25_22n I1_I42_G25_24 VSS VSS) gpdk090_nmos1v w=0.12u l=0.1u ad=0.0468p as=0.0696p pd=0.68u ps=1.16u
    I_MXI1_I42_I121_XG_MN0 (XI1_I42_I121_XG_n1 I1_I42_P25_24 I1_I42_G25_22n VSS) gpdk090_nmos1v w=0.24u l=0.1u ad=0.0528p as=0.0468p pd=0.68u ps=0.68u
    I_MXI1_I42_I121_XG_MN1 (VSS I1_I42_G23_22 XI1_I42_I121_XG_n1 VSS) gpdk090_nmos1v w=0.24u l=0.1u ad=0.0816p as=0.0528p pd=1.16u ps=0.68u
    I_MXI1_I42_I119_XG_MN2 (I1_I42_G23_20n I1_I42_G23_22 VSS VSS) gpdk090_nmos1v w=0.12u l=0.1u ad=0.0468p as=0.0696p pd=0.68u ps=1.16u
    I_MXI1_I42_I119_XG_MN0 (XI1_I42_I119_XG_n1 I1_I42_P23_22 I1_I42_G23_20n VSS) gpdk090_nmos1v w=0.24u l=0.1u ad=0.0528p as=0.0468p pd=0.68u ps=0.68u
    I_MXI1_I42_I119_XG_MN1 (VSS I1_I42_G21_20 XI1_I42_I119_XG_n1 VSS) gpdk090_nmos1v w=0.24u l=0.1u ad=0.0816p as=0.0528p pd=1.16u ps=0.68u
    I_MXI1_I42_I181_XG_MN2 (I1_I42_G30_15n I1_I42_G30_23 VSS VSS) gpdk090_nmos1v w=0.12u l=0.1u ad=0.0468p as=0.0696p pd=0.68u ps=1.16u
    I_MXI1_I42_I181_XG_MN0 (XI1_I42_I181_XG_n1 I1_I42_P30_23 I1_I42_G30_15n VSS) gpdk090_nmos1v w=0.24u l=0.1u ad=0.0528p as=0.0468p pd=0.68u ps=0.68u
    I_MXI1_I42_I181_XG_MN1 (VSS I1_I42_G22_15 XI1_I42_I181_XG_n1 VSS) gpdk090_nmos1v w=0.24u l=0.1u ad=0.0816p as=0.0528p pd=1.16u ps=0.68u
    I_MXI1_I42_I117_XG_MN2 (I1_I42_G21_18n I1_I42_G21_20 VSS VSS) gpdk090_nmos1v w=0.12u l=0.1u ad=0.0468p as=0.0696p pd=0.68u ps=1.16u
    I_MXI1_I42_I117_XG_MN0 (XI1_I42_I117_XG_n1 I1_I42_P21_20 I1_I42_G21_18n VSS) gpdk090_nmos1v w=0.24u l=0.1u ad=0.0528p as=0.0468p pd=0.68u ps=0.68u
    I_MXI1_I42_I117_XG_MN1 (VSS I1_I42_G19_18 XI1_I42_I117_XG_n1 VSS) gpdk090_nmos1v w=0.24u l=0.1u ad=0.0816p as=0.0528p pd=1.16u ps=0.68u
    I_MXI1_I42_I115_XG_MN2 (I1_I42_G19_16n I1_I42_G19_18 VSS VSS) gpdk090_nmos1v w=0.12u l=0.1u ad=0.0468p as=0.0696p pd=0.68u ps=1.16u
    I_MXI1_I42_I115_XG_MN0 (XI1_I42_I115_XG_n1 I1_I42_P19_18 I1_I42_G19_16n VSS) gpdk090_nmos1v w=0.24u l=0.1u ad=0.0528p as=0.0468p pd=0.68u ps=0.68u
    I_MXI1_I42_I115_XG_MN1 (VSS I1_I42_G17_16 XI1_I42_I115_XG_n1 VSS) gpdk090_nmos1v w=0.24u l=0.1u ad=0.0816p as=0.0528p pd=1.16u ps=0.68u
    I_MXI1_I42_I173_XG_MN2 (I1_I42_G22_7n I1_I42_G22_15 VSS VSS) gpdk090_nmos1v w=0.12u l=0.1u ad=0.0468p as=0.0696p pd=0.68u ps=1.16u
    I_MXI1_I42_I173_XG_MN0 (XI1_I42_I173_XG_n1 I1_I42_P22_15 I1_I42_G22_7n VSS) gpdk090_nmos1v w=0.24u l=0.1u ad=0.0528p as=0.0468p pd=0.68u ps=0.68u
    I_MXI1_I42_I173_XG_MN1 (VSS I1_I42_G14_7 XI1_I42_I173_XG_n1 VSS) gpdk090_nmos1v w=0.24u l=0.1u ad=0.0816p as=0.0528p pd=1.16u ps=0.68u
    I_MXI1_I42_I165_XG_MN2 (I1_I42_G14_0n I1_I42_G14_7 VSS VSS) gpdk090_nmos1v w=0.12u l=0.1u ad=0.0468p as=0.0696p pd=0.68u ps=1.16u
    I_MXI1_I42_I165_XG_MN0 (XI1_I42_I165_XG_n1 I1_I42_P14_7 I1_I42_G14_0n VSS) gpdk090_nmos1v w=0.24u l=0.1u ad=0.0528p as=0.0468p pd=0.68u ps=0.68u
    I_MXI1_I42_I165_XG_MN1 (VSS I1_I42_G6_0 XI1_I42_I165_XG_n1 VSS) gpdk090_nmos1v w=0.24u l=0.1u ad=0.0816p as=0.0528p pd=1.16u ps=0.68u
    I_MXI1_I42_I112_XG_MN2 (I1_I42_G16_13n I1_I42_G16_15 VSS VSS) gpdk090_nmos1v w=0.12u l=0.1u ad=0.0468p as=0.0696p pd=0.68u ps=1.16u
    I_MXI1_I42_I112_XG_MN0 (XI1_I42_I112_XG_n1 I1_I42_P16_15 I1_I42_G16_13n VSS) gpdk090_nmos1v w=0.24u l=0.1u ad=0.0528p as=0.0468p pd=0.68u ps=0.68u
    I_MXI1_I42_I112_XG_MN1 (VSS I1_I42_G14_13 XI1_I42_I112_XG_n1 VSS) gpdk090_nmos1v w=0.24u l=0.1u ad=0.0816p as=0.0528p pd=1.16u ps=0.68u
    I_MXI3_I272_MN2 (I3_q15_2 I3_o15_2 VSS VSS) gpdk090_nmos1v w=0.12u l=0.1u ad=0.0468p as=0.0696p pd=0.68u ps=1.16u
    I_MXI3_I272_MN0 (XI3_I272_n1 I3_SEL_AS_b3_2 I3_q15_2 VSS) gpdk090_nmos1v w=0.24u l=0.1u ad=0.0528p as=0.0468p pd=0.68u ps=0.68u
    I_MXI3_I272_MN1 (VSS S_15 XI3_I272_n1 VSS) gpdk090_nmos1v w=0.24u l=0.1u ad=0.0816p as=0.0528p pd=1.16u ps=0.68u
    I_MXI1_I42_I122_XG_MN2 (I1_I42_G26_23n I1_I42_G26_25 VSS VSS) gpdk090_nmos1v w=0.12u l=0.1u ad=0.0468p as=0.0696p pd=0.68u ps=1.16u
    I_MXI1_I42_I122_XG_MN0 (XI1_I42_I122_XG_n1 I1_I42_P26_25 I1_I42_G26_23n VSS) gpdk090_nmos1v w=0.24u l=0.1u ad=0.0528p as=0.0468p pd=0.68u ps=0.68u
    I_MXI1_I42_I122_XG_MN1 (VSS I1_I42_G24_23 XI1_I42_I122_XG_n1 VSS) gpdk090_nmos1v w=0.24u l=0.1u ad=0.0816p as=0.0528p pd=1.16u ps=0.68u
    I_MXI1_I42_I120_XG_MN2 (I1_I42_G24_21n I1_I42_G24_23 VSS VSS) gpdk090_nmos1v w=0.12u l=0.1u ad=0.0468p as=0.0696p pd=0.68u ps=1.16u
    I_MXI1_I42_I120_XG_MN0 (XI1_I42_I120_XG_n1 I1_I42_P24_23 I1_I42_G24_21n VSS) gpdk090_nmos1v w=0.24u l=0.1u ad=0.0528p as=0.0468p pd=0.68u ps=0.68u
    I_MXI1_I42_I120_XG_MN1 (VSS I1_I42_G22_21 XI1_I42_I120_XG_n1 VSS) gpdk090_nmos1v w=0.24u l=0.1u ad=0.0816p as=0.0528p pd=1.16u ps=0.68u
    I_MXI1_I42_I118_XG_MN2 (I1_I42_G22_19n I1_I42_G22_21 VSS VSS) gpdk090_nmos1v w=0.12u l=0.1u ad=0.0468p as=0.0696p pd=0.68u ps=1.16u
    I_MXI1_I42_I118_XG_MN0 (XI1_I42_I118_XG_n1 I1_I42_P22_21 I1_I42_G22_19n VSS) gpdk090_nmos1v w=0.24u l=0.1u ad=0.0528p as=0.0468p pd=0.68u ps=0.68u
    I_MXI1_I42_I118_XG_MN1 (VSS I1_I42_G20_19 XI1_I42_I118_XG_n1 VSS) gpdk090_nmos1v w=0.24u l=0.1u ad=0.0816p as=0.0528p pd=1.16u ps=0.68u
    I_MXI1_I42_I177_XG_MN2 (I1_I42_G26_11n I1_I42_G26_19 VSS VSS) gpdk090_nmos1v w=0.12u l=0.1u ad=0.0468p as=0.0696p pd=0.68u ps=1.16u
    I_MXI1_I42_I177_XG_MN0 (XI1_I42_I177_XG_n1 I1_I42_P26_19 I1_I42_G26_11n VSS) gpdk090_nmos1v w=0.24u l=0.1u ad=0.0528p as=0.0468p pd=0.68u ps=0.68u
    I_MXI1_I42_I177_XG_MN1 (VSS I1_I42_G18_11 XI1_I42_I177_XG_n1 VSS) gpdk090_nmos1v w=0.24u l=0.1u ad=0.0816p as=0.0528p pd=1.16u ps=0.68u
    I_MXI1_I42_I116_XG_MN2 (I1_I42_G20_17n I1_I42_G20_19 VSS VSS) gpdk090_nmos1v w=0.12u l=0.1u ad=0.0468p as=0.0696p pd=0.68u ps=1.16u
    I_MXI1_I42_I116_XG_MN0 (XI1_I42_I116_XG_n1 I1_I42_P20_19 I1_I42_G20_17n VSS) gpdk090_nmos1v w=0.24u l=0.1u ad=0.0528p as=0.0468p pd=0.68u ps=0.68u
    I_MXI1_I42_I116_XG_MN1 (VSS I1_I42_G18_17 XI1_I42_I116_XG_n1 VSS) gpdk090_nmos1v w=0.24u l=0.1u ad=0.0816p as=0.0528p pd=1.16u ps=0.68u
    I_MXI1_I42_I114_XG_MN2 (I1_I42_G18_15n I1_I42_G18_17 VSS VSS) gpdk090_nmos1v w=0.12u l=0.1u ad=0.0468p as=0.0696p pd=0.68u ps=1.16u
    I_MXI1_I42_I114_XG_MN0 (XI1_I42_I114_XG_n1 I1_I42_P18_17 I1_I42_G18_15n VSS) gpdk090_nmos1v w=0.24u l=0.1u ad=0.0528p as=0.0468p pd=0.68u ps=0.68u
    I_MXI1_I42_I114_XG_MN1 (VSS I1_I42_G16_15 XI1_I42_I114_XG_n1 VSS) gpdk090_nmos1v w=0.24u l=0.1u ad=0.0816p as=0.0528p pd=1.16u ps=0.68u
    I_MXI3_I392_MN2 (I3_q25_2 I3_o25_2 VSS VSS) gpdk090_nmos1v w=0.12u l=0.1u ad=0.0468p as=0.0696p pd=0.68u ps=1.16u
    I_MXI3_I392_MN0 (XI3_I392_n1 I3_SEL_AS_b3_4 I3_q25_2 VSS) gpdk090_nmos1v w=0.24u l=0.1u ad=0.0528p as=0.0468p pd=0.68u ps=0.68u
    I_MXI3_I392_MN1 (VSS S_25 XI3_I392_n1 VSS) gpdk090_nmos1v w=0.24u l=0.1u ad=0.0816p as=0.0528p pd=1.16u ps=0.68u
    I_MXI3_I404_MN2 (I3_q26_2 I3_o26_2 VSS VSS) gpdk090_nmos1v w=0.12u l=0.1u ad=0.0468p as=0.0696p pd=0.68u ps=1.16u
    I_MXI3_I404_MN0 (XI3_I404_n1 I3_SEL_AS_b3_4 I3_q26_2 VSS) gpdk090_nmos1v w=0.24u l=0.1u ad=0.0528p as=0.0468p pd=0.68u ps=0.68u
    I_MXI3_I404_MN1 (VSS S_26 XI3_I404_n1 VSS) gpdk090_nmos1v w=0.24u l=0.1u ad=0.0816p as=0.0528p pd=1.16u ps=0.68u
    I_MXI3_I380_MN2 (I3_q24_2 I3_o24_2 VSS VSS) gpdk090_nmos1v w=0.12u l=0.1u ad=0.0468p as=0.0696p pd=0.68u ps=1.16u
    I_MXI3_I380_MN0 (XI3_I380_n1 I3_SEL_AS_b3_4 I3_q24_2 VSS) gpdk090_nmos1v w=0.24u l=0.1u ad=0.0528p as=0.0468p pd=0.68u ps=0.68u
    I_MXI3_I380_MN1 (VSS S_24 XI3_I380_n1 VSS) gpdk090_nmos1v w=0.24u l=0.1u ad=0.0816p as=0.0528p pd=1.16u ps=0.68u
    I_MXI3_I284_MN2 (I3_q16_2 I3_o16_2 VSS VSS) gpdk090_nmos1v w=0.12u l=0.1u ad=0.0468p as=0.0696p pd=0.68u ps=1.16u
    I_MXI3_I284_MN0 (XI3_I284_n1 I3_SEL_AS_b3_3 I3_q16_2 VSS) gpdk090_nmos1v w=0.24u l=0.1u ad=0.0528p as=0.0468p pd=0.68u ps=0.68u
    I_MXI3_I284_MN1 (VSS S_16 XI3_I284_n1 VSS) gpdk090_nmos1v w=0.24u l=0.1u ad=0.0816p as=0.0528p pd=1.16u ps=0.68u
    I_MXI3_I356_MN2 (I3_q22_2 I3_o22_2 VSS VSS) gpdk090_nmos1v w=0.12u l=0.1u ad=0.0468p as=0.0696p pd=0.68u ps=1.16u
    I_MXI3_I356_MN0 (XI3_I356_n1 I3_SEL_AS_b3_4 I3_q22_2 VSS) gpdk090_nmos1v w=0.24u l=0.1u ad=0.0528p as=0.0468p pd=0.68u ps=0.68u
    I_MXI3_I356_MN1 (VSS S_22 XI3_I356_n1 VSS) gpdk090_nmos1v w=0.24u l=0.1u ad=0.0816p as=0.0528p pd=1.16u ps=0.68u
    I_MXI3_I344_MN2 (I3_q21_2 I3_o21_2 VSS VSS) gpdk090_nmos1v w=0.12u l=0.1u ad=0.0468p as=0.0696p pd=0.68u ps=1.16u
    I_MXI3_I344_MN0 (XI3_I344_n1 I3_SEL_AS_b3_3 I3_q21_2 VSS) gpdk090_nmos1v w=0.24u l=0.1u ad=0.0528p as=0.0468p pd=0.68u ps=0.68u
    I_MXI3_I344_MN1 (VSS S_21 XI3_I344_n1 VSS) gpdk090_nmos1v w=0.24u l=0.1u ad=0.0816p as=0.0528p pd=1.16u ps=0.68u
    I_MXI3_I332_MN2 (I3_q20_2 I3_o20_2 VSS VSS) gpdk090_nmos1v w=0.12u l=0.1u ad=0.0468p as=0.0696p pd=0.68u ps=1.16u
    I_MXI3_I332_MN0 (XI3_I332_n1 I3_SEL_AS_b3_3 I3_q20_2 VSS) gpdk090_nmos1v w=0.24u l=0.1u ad=0.0528p as=0.0468p pd=0.68u ps=0.68u
    I_MXI3_I332_MN1 (VSS S_20 XI3_I332_n1 VSS) gpdk090_nmos1v w=0.24u l=0.1u ad=0.0816p as=0.0528p pd=1.16u ps=0.68u
    I_MXI3_I320_MN2 (I3_q19_2 I3_o19_2 VSS VSS) gpdk090_nmos1v w=0.12u l=0.1u ad=0.0468p as=0.0696p pd=0.68u ps=1.16u
    I_MXI3_I320_MN0 (XI3_I320_n1 I3_SEL_AS_b3_3 I3_q19_2 VSS) gpdk090_nmos1v w=0.24u l=0.1u ad=0.0528p as=0.0468p pd=0.68u ps=0.68u
    I_MXI3_I320_MN1 (VSS S_19 XI3_I320_n1 VSS) gpdk090_nmos1v w=0.24u l=0.1u ad=0.0816p as=0.0528p pd=1.16u ps=0.68u
    I_MXI3_I308_MN2 (I3_q18_2 I3_o18_2 VSS VSS) gpdk090_nmos1v w=0.12u l=0.1u ad=0.0468p as=0.0696p pd=0.68u ps=1.16u
    I_MXI3_I308_MN0 (XI3_I308_n1 I3_SEL_AS_b3_3 I3_q18_2 VSS) gpdk090_nmos1v w=0.24u l=0.1u ad=0.0528p as=0.0468p pd=0.68u ps=0.68u
    I_MXI3_I308_MN1 (VSS S_18 XI3_I308_n1 VSS) gpdk090_nmos1v w=0.24u l=0.1u ad=0.0816p as=0.0528p pd=1.16u ps=0.68u
    I_MXI3_I296_MN2 (I3_q17_2 I3_o17_2 VSS VSS) gpdk090_nmos1v w=0.12u l=0.1u ad=0.0468p as=0.0696p pd=0.68u ps=1.16u
    I_MXI3_I296_MN0 (XI3_I296_n1 I3_SEL_AS_b3_3 I3_q17_2 VSS) gpdk090_nmos1v w=0.24u l=0.1u ad=0.0528p as=0.0468p pd=0.68u ps=0.68u
    I_MXI3_I296_MN1 (VSS S_17 XI3_I296_n1 VSS) gpdk090_nmos1v w=0.24u l=0.1u ad=0.0816p as=0.0528p pd=1.16u ps=0.68u
    I_MXI3_I368_MN2 (I3_q23_2 I3_o23_2 VSS VSS) gpdk090_nmos1v w=0.12u l=0.1u ad=0.0468p as=0.0696p pd=0.68u ps=1.16u
    I_MXI3_I368_MN0 (XI3_I368_n1 I3_SEL_AS_b3_4 I3_q23_2 VSS) gpdk090_nmos1v w=0.24u l=0.1u ad=0.0528p as=0.0468p pd=0.68u ps=0.68u
    I_MXI3_I368_MN1 (VSS S_23 XI3_I368_n1 VSS) gpdk090_nmos1v w=0.24u l=0.1u ad=0.0816p as=0.0528p pd=1.16u ps=0.68u
    I_MXI1_I42_I65_XG_MN2 (XI1_I42_I65_XG_n1 I1_I42_gn0 VSS VSS) gpdk090_nmos1v w=0.24u l=0.1u ad=0.0528p as=0.0816p pd=0.68u ps=1.16u
    I_MXI1_I42_I65_XG_MN0 (I1_I42_G0_0 I1_I42_pn0 XI1_I42_I65_XG_n1 VSS) gpdk090_nmos1v w=0.24u l=0.1u ad=0.0528p as=0.0528p pd=0.68u ps=0.68u
    I_MXI1_I42_I65_XG_MN1 (XI1_I42_I65_XG_n1 I1_I42_cinn I1_I42_G0_0 VSS) gpdk090_nmos1v w=0.24u l=0.1u ad=0.0816p as=0.0528p pd=1.16u ps=0.68u
    I_MXI1_I42_I75_XG_MN2 (XI1_I42_I75_XG_n1 I1_I42_gn9 VSS VSS) gpdk090_nmos1v w=0.24u l=0.1u ad=0.0528p as=0.0816p pd=0.68u ps=1.16u
    I_MXI1_I42_I75_XG_MN0 (I1_I42_G9_8 I1_I42_pn9 XI1_I42_I75_XG_n1 VSS) gpdk090_nmos1v w=0.24u l=0.1u ad=0.0528p as=0.0528p pd=0.68u ps=0.68u
    I_MXI1_I42_I75_XG_MN1 (XI1_I42_I75_XG_n1 I1_I42_gn8 I1_I42_G9_8 VSS) gpdk090_nmos1v w=0.24u l=0.1u ad=0.0816p as=0.0528p pd=1.16u ps=0.68u
    I_MXI1_I42_I74_XG_MN2 (XI1_I42_I74_XG_n1 I1_I42_gn8 VSS VSS) gpdk090_nmos1v w=0.24u l=0.1u ad=0.0528p as=0.0816p pd=0.68u ps=1.16u
    I_MXI1_I42_I74_XG_MN0 (I1_I42_G8_7 I1_I42_pn8 XI1_I42_I74_XG_n1 VSS) gpdk090_nmos1v w=0.24u l=0.1u ad=0.0528p as=0.0528p pd=0.68u ps=0.68u
    I_MXI1_I42_I74_XG_MN1 (XI1_I42_I74_XG_n1 I1_I42_gn7 I1_I42_G8_7 VSS) gpdk090_nmos1v w=0.24u l=0.1u ad=0.0816p as=0.0528p pd=1.16u ps=0.68u
    I_MXI1_I42_I73_XG_MN2 (XI1_I42_I73_XG_n1 I1_I42_gn7 VSS VSS) gpdk090_nmos1v w=0.24u l=0.1u ad=0.0528p as=0.0816p pd=0.68u ps=1.16u
    I_MXI1_I42_I73_XG_MN0 (I1_I42_G7_6 I1_I42_pn7 XI1_I42_I73_XG_n1 VSS) gpdk090_nmos1v w=0.24u l=0.1u ad=0.0528p as=0.0528p pd=0.68u ps=0.68u
    I_MXI1_I42_I73_XG_MN1 (XI1_I42_I73_XG_n1 I1_I42_gn6 I1_I42_G7_6 VSS) gpdk090_nmos1v w=0.24u l=0.1u ad=0.0816p as=0.0528p pd=1.16u ps=0.68u
    I_MXI1_I42_I72_XG_MN2 (XI1_I42_I72_XG_n1 I1_I42_gn6 VSS VSS) gpdk090_nmos1v w=0.24u l=0.1u ad=0.0528p as=0.0816p pd=0.68u ps=1.16u
    I_MXI1_I42_I72_XG_MN0 (I1_I42_G6_5 I1_I42_pn6 XI1_I42_I72_XG_n1 VSS) gpdk090_nmos1v w=0.24u l=0.1u ad=0.0528p as=0.0528p pd=0.68u ps=0.68u
    I_MXI1_I42_I72_XG_MN1 (XI1_I42_I72_XG_n1 I1_I42_gn5 I1_I42_G6_5 VSS) gpdk090_nmos1v w=0.24u l=0.1u ad=0.0816p as=0.0528p pd=1.16u ps=0.68u
    I_MXI1_I42_I71_XG_MN2 (XI1_I42_I71_XG_n1 I1_I42_gn5 VSS VSS) gpdk090_nmos1v w=0.24u l=0.1u ad=0.0528p as=0.0816p pd=0.68u ps=1.16u
    I_MXI1_I42_I71_XG_MN0 (I1_I42_G5_4 I1_I42_pn5 XI1_I42_I71_XG_n1 VSS) gpdk090_nmos1v w=0.24u l=0.1u ad=0.0528p as=0.0528p pd=0.68u ps=0.68u
    I_MXI1_I42_I71_XG_MN1 (XI1_I42_I71_XG_n1 I1_I42_gn4 I1_I42_G5_4 VSS) gpdk090_nmos1v w=0.24u l=0.1u ad=0.0816p as=0.0528p pd=1.16u ps=0.68u
    I_MXI1_I42_I70_XG_MN2 (XI1_I42_I70_XG_n1 I1_I42_gn4 VSS VSS) gpdk090_nmos1v w=0.24u l=0.1u ad=0.0528p as=0.0816p pd=0.68u ps=1.16u
    I_MXI1_I42_I70_XG_MN0 (I1_I42_G4_3 I1_I42_pn4 XI1_I42_I70_XG_n1 VSS) gpdk090_nmos1v w=0.24u l=0.1u ad=0.0528p as=0.0528p pd=0.68u ps=0.68u
    I_MXI1_I42_I70_XG_MN1 (XI1_I42_I70_XG_n1 I1_I42_gn3 I1_I42_G4_3 VSS) gpdk090_nmos1v w=0.24u l=0.1u ad=0.0816p as=0.0528p pd=1.16u ps=0.68u
    I_MXI1_I42_I130_XG_MN2 (XI1_I42_I130_XG_n1 I1_I42_G5_2n VSS VSS) gpdk090_nmos1v w=0.24u l=0.1u ad=0.0528p as=0.0816p pd=0.68u ps=1.16u
    I_MXI1_I42_I130_XG_MN0 (I1_I42_G5_0 I1_I42_P5_2n XI1_I42_I130_XG_n1 VSS) gpdk090_nmos1v w=0.24u l=0.1u ad=0.0528p as=0.0528p pd=0.68u ps=0.68u
    I_MXI1_I42_I130_XG_MN1 (XI1_I42_I130_XG_n1 I1_I42_G1_0n I1_I42_G5_0 VSS) gpdk090_nmos1v w=0.24u l=0.1u ad=0.0816p as=0.0528p pd=1.16u ps=0.68u
    I_MXI1_I42_I134_XG_MN2 (XI1_I42_I134_XG_n1 I1_I42_G9_6n VSS VSS) gpdk090_nmos1v w=0.24u l=0.1u ad=0.0528p as=0.0816p pd=0.68u ps=1.16u
    I_MXI1_I42_I134_XG_MN0 (I1_I42_G9_2 I1_I42_P9_6n XI1_I42_I134_XG_n1 VSS) gpdk090_nmos1v w=0.24u l=0.1u ad=0.0528p as=0.0528p pd=0.68u ps=0.68u
    I_MXI1_I42_I134_XG_MN1 (XI1_I42_I134_XG_n1 I1_I42_G5_2n I1_I42_G9_2 VSS) gpdk090_nmos1v w=0.24u l=0.1u ad=0.0816p as=0.0528p pd=1.16u ps=0.68u
    I_MXI1_I42_I76_XG_MN2 (XI1_I42_I76_XG_n1 I1_I42_gn10 VSS VSS) gpdk090_nmos1v w=0.24u l=0.1u ad=0.0528p as=0.0816p pd=0.68u ps=1.16u
    I_MXI1_I42_I76_XG_MN0 (I1_I42_G10_9 I1_I42_pn10 XI1_I42_I76_XG_n1 VSS) gpdk090_nmos1v w=0.24u l=0.1u ad=0.0528p as=0.0528p pd=0.68u ps=0.68u
    I_MXI1_I42_I76_XG_MN1 (XI1_I42_I76_XG_n1 I1_I42_gn9 I1_I42_G10_9 VSS) gpdk090_nmos1v w=0.24u l=0.1u ad=0.0816p as=0.0528p pd=1.16u ps=0.68u
    I_MXI1_I42_I69_XG_MN2 (XI1_I42_I69_XG_n1 I1_I42_gn3 VSS VSS) gpdk090_nmos1v w=0.24u l=0.1u ad=0.0528p as=0.0816p pd=0.68u ps=1.16u
    I_MXI1_I42_I69_XG_MN0 (I1_I42_G3_2 I1_I42_pn3 XI1_I42_I69_XG_n1 VSS) gpdk090_nmos1v w=0.24u l=0.1u ad=0.0528p as=0.0528p pd=0.68u ps=0.68u
    I_MXI1_I42_I69_XG_MN1 (XI1_I42_I69_XG_n1 I1_I42_gn2 I1_I42_G3_2 VSS) gpdk090_nmos1v w=0.24u l=0.1u ad=0.0816p as=0.0528p pd=1.16u ps=0.68u
    I_MXI1_I42_I68_XG_MN2 (XI1_I42_I68_XG_n1 I1_I42_gn2 VSS VSS) gpdk090_nmos1v w=0.24u l=0.1u ad=0.0528p as=0.0816p pd=0.68u ps=1.16u
    I_MXI1_I42_I68_XG_MN0 (I1_I42_G2_1 I1_I42_pn2 XI1_I42_I68_XG_n1 VSS) gpdk090_nmos1v w=0.24u l=0.1u ad=0.0528p as=0.0528p pd=0.68u ps=0.68u
    I_MXI1_I42_I68_XG_MN1 (XI1_I42_I68_XG_n1 I1_I42_gn1 I1_I42_G2_1 VSS) gpdk090_nmos1v w=0.24u l=0.1u ad=0.0816p as=0.0528p pd=1.16u ps=0.68u
    I_MXI1_I42_I67_XG_MN2 (XI1_I42_I67_XG_n1 I1_I42_gn1 VSS VSS) gpdk090_nmos1v w=0.24u l=0.1u ad=0.0528p as=0.0816p pd=0.68u ps=1.16u
    I_MXI1_I42_I67_XG_MN0 (I1_I42_G1_0 I1_I42_pn1 XI1_I42_I67_XG_n1 VSS) gpdk090_nmos1v w=0.24u l=0.1u ad=0.0528p as=0.0528p pd=0.68u ps=0.68u
    I_MXI1_I42_I67_XG_MN1 (XI1_I42_I67_XG_n1 I1_I42_G0_0n I1_I42_G1_0 VSS) gpdk090_nmos1v w=0.24u l=0.1u ad=0.0816p as=0.0528p pd=1.16u ps=0.68u
    I_MXI1_I42_I184_XG_MN2 (XI1_I42_I184_XG_n1 I1_I42_G17_2n VSS VSS) gpdk090_nmos1v w=0.24u l=0.1u ad=0.0528p as=0.0816p pd=0.68u ps=1.16u
    I_MXI1_I42_I184_XG_MN0 (I1_I42_G17_0 I1_I42_P17_2n XI1_I42_I184_XG_n1 VSS) gpdk090_nmos1v w=0.24u l=0.1u ad=0.0528p as=0.0528p pd=0.68u ps=0.68u
    I_MXI1_I42_I184_XG_MN1 (XI1_I42_I184_XG_n1 I1_I42_G1_0n I1_I42_G17_0 VSS) gpdk090_nmos1v w=0.24u l=0.1u ad=0.0816p as=0.0528p pd=1.16u ps=0.68u
    I_MXI1_I42_I132_XG_MN2 (XI1_I42_I132_XG_n1 I1_I42_G7_4n VSS VSS) gpdk090_nmos1v w=0.24u l=0.1u ad=0.0528p as=0.0816p pd=0.68u ps=1.16u
    I_MXI1_I42_I132_XG_MN0 (I1_I42_G7_0 I1_I42_P7_4n XI1_I42_I132_XG_n1 VSS) gpdk090_nmos1v w=0.24u l=0.1u ad=0.0528p as=0.0528p pd=0.68u ps=0.68u
    I_MXI1_I42_I132_XG_MN1 (XI1_I42_I132_XG_n1 I1_I42_G3_0n I1_I42_G7_0 VSS) gpdk090_nmos1v w=0.24u l=0.1u ad=0.0816p as=0.0528p pd=1.16u ps=0.68u
    I_MXI1_I42_I133_XG_MN2 (XI1_I42_I133_XG_n1 I1_I42_G8_5n VSS VSS) gpdk090_nmos1v w=0.24u l=0.1u ad=0.0528p as=0.0816p pd=0.68u ps=1.16u
    I_MXI1_I42_I133_XG_MN0 (I1_I42_G8_1 I1_I42_P8_5n XI1_I42_I133_XG_n1 VSS) gpdk090_nmos1v w=0.24u l=0.1u ad=0.0528p as=0.0528p pd=0.68u ps=0.68u
    I_MXI1_I42_I133_XG_MN1 (XI1_I42_I133_XG_n1 I1_I42_G4_1n I1_I42_G8_1 VSS) gpdk090_nmos1v w=0.24u l=0.1u ad=0.0816p as=0.0528p pd=1.16u ps=0.68u
    I_MXI1_I42_I128_XG_MN2 (XI1_I42_I128_XG_n1 I1_I42_G4_1n VSS VSS) gpdk090_nmos1v w=0.24u l=0.1u ad=0.0528p as=0.0816p pd=0.68u ps=1.16u
    I_MXI1_I42_I128_XG_MN0 (I1_I42_G4_0 I1_I42_P4_1n XI1_I42_I128_XG_n1 VSS) gpdk090_nmos1v w=0.24u l=0.1u ad=0.0528p as=0.0528p pd=0.68u ps=0.68u
    I_MXI1_I42_I128_XG_MN1 (XI1_I42_I128_XG_n1 I1_I42_G0_0n I1_I42_G4_0 VSS) gpdk090_nmos1v w=0.24u l=0.1u ad=0.0816p as=0.0528p pd=1.16u ps=0.68u
    I_MXI1_I42_I200_XG_MN2 (XI1_I42_I200_XG_n1 I1_I42_G29_14n VSS VSS) gpdk090_nmos1v w=0.24u l=0.1u ad=0.0528p as=0.0816p pd=0.68u ps=1.16u
    I_MXI1_I42_I200_XG_MN0 (I1_I42_G29_0 I1_I42_P29_14n XI1_I42_I200_XG_n1 VSS) gpdk090_nmos1v w=0.24u l=0.1u ad=0.0528p as=0.0528p pd=0.68u ps=0.68u
    I_MXI1_I42_I200_XG_MN1 (XI1_I42_I200_XG_n1 I1_I42_G13_0n I1_I42_G29_0 VSS) gpdk090_nmos1v w=0.24u l=0.1u ad=0.0816p as=0.0528p pd=1.16u ps=0.68u
    I_MXI1_I42_I196_XG_MN2 (XI1_I42_I196_XG_n1 I1_I42_G25_10n VSS VSS) gpdk090_nmos1v w=0.24u l=0.1u ad=0.0528p as=0.0816p pd=0.68u ps=1.16u
    I_MXI1_I42_I196_XG_MN0 (I1_I42_G25_0 I1_I42_P25_10n XI1_I42_I196_XG_n1 VSS) gpdk090_nmos1v w=0.24u l=0.1u ad=0.0528p as=0.0528p pd=0.68u ps=0.68u
    I_MXI1_I42_I196_XG_MN1 (XI1_I42_I196_XG_n1 I1_I42_G9_0n I1_I42_G25_0 VSS) gpdk090_nmos1v w=0.24u l=0.1u ad=0.0816p as=0.0528p pd=1.16u ps=0.68u
    I_MXI1_I42_I190_XG_MN2 (XI1_I42_I190_XG_n1 I1_I42_G21_6n VSS VSS) gpdk090_nmos1v w=0.24u l=0.1u ad=0.0528p as=0.0816p pd=0.68u ps=1.16u
    I_MXI1_I42_I190_XG_MN0 (I1_I42_G21_0 I1_I42_P21_6n XI1_I42_I190_XG_n1 VSS) gpdk090_nmos1v w=0.24u l=0.1u ad=0.0528p as=0.0528p pd=0.68u ps=0.68u
    I_MXI1_I42_I190_XG_MN1 (XI1_I42_I190_XG_n1 I1_I42_G5_0n I1_I42_G21_0 VSS) gpdk090_nmos1v w=0.24u l=0.1u ad=0.0816p as=0.0528p pd=1.16u ps=0.68u
    I_MXI1_I42_I138_XG_MN2 (XI1_I42_I138_XG_n1 I1_I42_G13_10n VSS VSS) gpdk090_nmos1v w=0.24u l=0.1u ad=0.0528p as=0.0816p pd=0.68u ps=1.16u
    I_MXI1_I42_I138_XG_MN0 (I1_I42_G13_6 I1_I42_P13_10n XI1_I42_I138_XG_n1 VSS) gpdk090_nmos1v w=0.24u l=0.1u ad=0.0528p as=0.0528p pd=0.68u ps=0.68u
    I_MXI1_I42_I138_XG_MN1 (XI1_I42_I138_XG_n1 I1_I42_G9_6n I1_I42_G13_6 VSS) gpdk090_nmos1v w=0.24u l=0.1u ad=0.0816p as=0.0528p pd=1.16u ps=0.68u
    I_MXI1_I42_I136_XG_MN2 (XI1_I42_I136_XG_n1 I1_I42_G11_8n VSS VSS) gpdk090_nmos1v w=0.24u l=0.1u ad=0.0528p as=0.0816p pd=0.68u ps=1.16u
    I_MXI1_I42_I136_XG_MN0 (I1_I42_G11_4 I1_I42_P11_8n XI1_I42_I136_XG_n1 VSS) gpdk090_nmos1v w=0.24u l=0.1u ad=0.0528p as=0.0528p pd=0.68u ps=0.68u
    I_MXI1_I42_I136_XG_MN1 (XI1_I42_I136_XG_n1 I1_I42_G7_4n I1_I42_G11_4 VSS) gpdk090_nmos1v w=0.24u l=0.1u ad=0.0816p as=0.0528p pd=1.16u ps=0.68u
    I_MXI1_I42_I77_XG_MN2 (XI1_I42_I77_XG_n1 I1_I42_gn11 VSS VSS) gpdk090_nmos1v w=0.24u l=0.1u ad=0.0528p as=0.0816p pd=0.68u ps=1.16u
    I_MXI1_I42_I77_XG_MN0 (I1_I42_G11_10 I1_I42_pn11 XI1_I42_I77_XG_n1 VSS) gpdk090_nmos1v w=0.24u l=0.1u ad=0.0528p as=0.0528p pd=0.68u ps=0.68u
    I_MXI1_I42_I77_XG_MN1 (XI1_I42_I77_XG_n1 I1_I42_gn10 I1_I42_G11_10 VSS) gpdk090_nmos1v w=0.24u l=0.1u ad=0.0816p as=0.0528p pd=1.16u ps=0.68u
    I_MXI1_I42_I131_XG_MN2 (XI1_I42_I131_XG_n1 I1_I42_G6_3n VSS VSS) gpdk090_nmos1v w=0.24u l=0.1u ad=0.0528p as=0.0816p pd=0.68u ps=1.16u
    I_MXI1_I42_I131_XG_MN0 (I1_I42_G6_0 I1_I42_P6_3n XI1_I42_I131_XG_n1 VSS) gpdk090_nmos1v w=0.24u l=0.1u ad=0.0528p as=0.0528p pd=0.68u ps=0.68u
    I_MXI1_I42_I131_XG_MN1 (XI1_I42_I131_XG_n1 I1_I42_G2_0n I1_I42_G6_0 VSS) gpdk090_nmos1v w=0.24u l=0.1u ad=0.0816p as=0.0528p pd=1.16u ps=0.68u
    I_MXI1_I42_I183_XG_MN2 (XI1_I42_I183_XG_n1 I1_I42_G16_1n VSS VSS) gpdk090_nmos1v w=0.24u l=0.1u ad=0.0528p as=0.0816p pd=0.68u ps=1.16u
    I_MXI1_I42_I183_XG_MN0 (I1_I42_G16_0 I1_I42_P16_1n XI1_I42_I183_XG_n1 VSS) gpdk090_nmos1v w=0.24u l=0.1u ad=0.0528p as=0.0528p pd=0.68u ps=0.68u
    I_MXI1_I42_I183_XG_MN1 (XI1_I42_I183_XG_n1 I1_I42_G0_0n I1_I42_G16_0 VSS) gpdk090_nmos1v w=0.24u l=0.1u ad=0.0816p as=0.0528p pd=1.16u ps=0.68u
    I_MXI1_I42_I97_XG_MN2 (XI1_I42_I97_XG_n1 I1_I42_gn31 VSS VSS) gpdk090_nmos1v w=0.24u l=0.1u ad=0.0528p as=0.0816p pd=0.68u ps=1.16u
    I_MXI1_I42_I97_XG_MN0 (I1_I42_G31_30 I1_I42_pn31 XI1_I42_I97_XG_n1 VSS) gpdk090_nmos1v w=0.24u l=0.1u ad=0.0528p as=0.0528p pd=0.68u ps=0.68u
    I_MXI1_I42_I97_XG_MN1 (XI1_I42_I97_XG_n1 I1_I42_gn30 I1_I42_G31_30 VSS) gpdk090_nmos1v w=0.24u l=0.1u ad=0.0816p as=0.0528p pd=1.16u ps=0.68u
    I_MXI1_I42_I150_XG_MN2 (XI1_I42_I150_XG_n1 I1_I42_G25_22n VSS VSS) gpdk090_nmos1v w=0.24u l=0.1u ad=0.0528p as=0.0816p pd=0.68u ps=1.16u
    I_MXI1_I42_I150_XG_MN0 (I1_I42_G25_18 I1_I42_P25_22n XI1_I42_I150_XG_n1 VSS) gpdk090_nmos1v w=0.24u l=0.1u ad=0.0528p as=0.0528p pd=0.68u ps=0.68u
    I_MXI1_I42_I150_XG_MN1 (XI1_I42_I150_XG_n1 I1_I42_G21_18n I1_I42_G25_18 VSS) gpdk090_nmos1v w=0.24u l=0.1u ad=0.0816p as=0.0528p pd=1.16u ps=0.68u
    I_MXI1_I42_I146_XG_MN2 (XI1_I42_I146_XG_n1 I1_I42_G21_18n VSS VSS) gpdk090_nmos1v w=0.24u l=0.1u ad=0.0528p as=0.0816p pd=0.68u ps=1.16u
    I_MXI1_I42_I146_XG_MN0 (I1_I42_G21_14 I1_I42_P21_18n XI1_I42_I146_XG_n1 VSS) gpdk090_nmos1v w=0.24u l=0.1u ad=0.0528p as=0.0528p pd=0.68u ps=0.68u
    I_MXI1_I42_I146_XG_MN1 (XI1_I42_I146_XG_n1 I1_I42_G17_14n I1_I42_G21_14 VSS) gpdk090_nmos1v w=0.24u l=0.1u ad=0.0816p as=0.0528p pd=1.16u ps=0.68u
    I_MXI1_I42_I142_XG_MN2 (XI1_I42_I142_XG_n1 I1_I42_G17_14n VSS VSS) gpdk090_nmos1v w=0.24u l=0.1u ad=0.0528p as=0.0816p pd=0.68u ps=1.16u
    I_MXI1_I42_I142_XG_MN0 (I1_I42_G17_10 I1_I42_P17_14n XI1_I42_I142_XG_n1 VSS) gpdk090_nmos1v w=0.24u l=0.1u ad=0.0528p as=0.0528p pd=0.68u ps=0.68u
    I_MXI1_I42_I142_XG_MN1 (XI1_I42_I142_XG_n1 I1_I42_G13_10n I1_I42_G17_10 VSS) gpdk090_nmos1v w=0.24u l=0.1u ad=0.0816p as=0.0528p pd=1.16u ps=0.68u
    I_MXI1_I42_I135_XG_MN2 (XI1_I42_I135_XG_n1 I1_I42_G10_7n VSS VSS) gpdk090_nmos1v w=0.24u l=0.1u ad=0.0528p as=0.0816p pd=0.68u ps=1.16u
    I_MXI1_I42_I135_XG_MN0 (I1_I42_G10_3 I1_I42_P10_7n XI1_I42_I135_XG_n1 VSS) gpdk090_nmos1v w=0.24u l=0.1u ad=0.0528p as=0.0528p pd=0.68u ps=0.68u
    I_MXI1_I42_I135_XG_MN1 (XI1_I42_I135_XG_n1 I1_I42_G6_3n I1_I42_G10_3 VSS) gpdk090_nmos1v w=0.24u l=0.1u ad=0.0816p as=0.0528p pd=1.16u ps=0.68u
    I_MXI1_I42_I195_XG_MN2 (XI1_I42_I195_XG_n1 I1_I42_G24_9n VSS VSS) gpdk090_nmos1v w=0.24u l=0.1u ad=0.0528p as=0.0816p pd=0.68u ps=1.16u
    I_MXI1_I42_I195_XG_MN0 (I1_I42_G24_0 I1_I42_P24_9n XI1_I42_I195_XG_n1 VSS) gpdk090_nmos1v w=0.24u l=0.1u ad=0.0528p as=0.0528p pd=0.68u ps=0.68u
    I_MXI1_I42_I195_XG_MN1 (XI1_I42_I195_XG_n1 I1_I42_G8_0n I1_I42_G24_0 VSS) gpdk090_nmos1v w=0.24u l=0.1u ad=0.0816p as=0.0528p pd=1.16u ps=0.68u
    I_MXI1_I42_I137_XG_MN2 (XI1_I42_I137_XG_n1 I1_I42_G12_9n VSS VSS) gpdk090_nmos1v w=0.24u l=0.1u ad=0.0528p as=0.0816p pd=0.68u ps=1.16u
    I_MXI1_I42_I137_XG_MN0 (I1_I42_G12_5 I1_I42_P12_9n XI1_I42_I137_XG_n1 VSS) gpdk090_nmos1v w=0.24u l=0.1u ad=0.0528p as=0.0528p pd=0.68u ps=0.68u
    I_MXI1_I42_I137_XG_MN1 (XI1_I42_I137_XG_n1 I1_I42_G8_5n I1_I42_G12_5 VSS) gpdk090_nmos1v w=0.24u l=0.1u ad=0.0816p as=0.0528p pd=1.16u ps=0.68u
    I_MXI1_I42_I78_XG_MN2 (XI1_I42_I78_XG_n1 I1_I42_gn12 VSS VSS) gpdk090_nmos1v w=0.24u l=0.1u ad=0.0528p as=0.0816p pd=0.68u ps=1.16u
    I_MXI1_I42_I78_XG_MN0 (I1_I42_G12_11 I1_I42_pn12 XI1_I42_I78_XG_n1 VSS) gpdk090_nmos1v w=0.24u l=0.1u ad=0.0528p as=0.0528p pd=0.68u ps=0.68u
    I_MXI1_I42_I78_XG_MN1 (XI1_I42_I78_XG_n1 I1_I42_gn11 I1_I42_G12_11 VSS) gpdk090_nmos1v w=0.24u l=0.1u ad=0.0816p as=0.0528p pd=1.16u ps=0.68u
    I_MXI1_I42_I79_XG_MN2 (XI1_I42_I79_XG_n1 I1_I42_gn13 VSS VSS) gpdk090_nmos1v w=0.24u l=0.1u ad=0.0528p as=0.0816p pd=0.68u ps=1.16u
    I_MXI1_I42_I79_XG_MN0 (I1_I42_G13_12 I1_I42_pn13 XI1_I42_I79_XG_n1 VSS) gpdk090_nmos1v w=0.24u l=0.1u ad=0.0528p as=0.0528p pd=0.68u ps=0.68u
    I_MXI1_I42_I79_XG_MN1 (XI1_I42_I79_XG_n1 I1_I42_gn12 I1_I42_G13_12 VSS) gpdk090_nmos1v w=0.24u l=0.1u ad=0.0816p as=0.0528p pd=1.16u ps=0.68u
    I_MXI1_I42_I95_XG_MN2 (XI1_I42_I95_XG_n1 I1_I42_gn29 VSS VSS) gpdk090_nmos1v w=0.24u l=0.1u ad=0.0528p as=0.0816p pd=0.68u ps=1.16u
    I_MXI1_I42_I95_XG_MN0 (I1_I42_G29_28 I1_I42_pn29 XI1_I42_I95_XG_n1 VSS) gpdk090_nmos1v w=0.24u l=0.1u ad=0.0528p as=0.0528p pd=0.68u ps=0.68u
    I_MXI1_I42_I95_XG_MN1 (XI1_I42_I95_XG_n1 I1_I42_gn28 I1_I42_G29_28 VSS) gpdk090_nmos1v w=0.24u l=0.1u ad=0.0816p as=0.0528p pd=1.16u ps=0.68u
    I_MXI1_I42_I96_XG_MN2 (XI1_I42_I96_XG_n1 I1_I42_gn30 VSS VSS) gpdk090_nmos1v w=0.24u l=0.1u ad=0.0528p as=0.0816p pd=0.68u ps=1.16u
    I_MXI1_I42_I96_XG_MN0 (I1_I42_G30_29 I1_I42_pn30 XI1_I42_I96_XG_n1 VSS) gpdk090_nmos1v w=0.24u l=0.1u ad=0.0528p as=0.0528p pd=0.68u ps=0.68u
    I_MXI1_I42_I96_XG_MN1 (XI1_I42_I96_XG_n1 I1_I42_gn29 I1_I42_G30_29 VSS) gpdk090_nmos1v w=0.24u l=0.1u ad=0.0816p as=0.0528p pd=1.16u ps=0.68u
    I_MXI1_I42_I154_XG_MN2 (XI1_I42_I154_XG_n1 I1_I42_G29_26n VSS VSS) gpdk090_nmos1v w=0.24u l=0.1u ad=0.0528p as=0.0816p pd=0.68u ps=1.16u
    I_MXI1_I42_I154_XG_MN0 (I1_I42_G29_22 I1_I42_P29_26n XI1_I42_I154_XG_n1 VSS) gpdk090_nmos1v w=0.24u l=0.1u ad=0.0528p as=0.0528p pd=0.68u ps=0.68u
    I_MXI1_I42_I154_XG_MN1 (XI1_I42_I154_XG_n1 I1_I42_G25_22n I1_I42_G29_22 VSS) gpdk090_nmos1v w=0.24u l=0.1u ad=0.0816p as=0.0528p pd=1.16u ps=0.68u
    I_MXI1_I42_I156_XG_MN2 (XI1_I42_I156_XG_n1 I1_I42_G31_28n VSS VSS) gpdk090_nmos1v w=0.24u l=0.1u ad=0.0528p as=0.0816p pd=0.68u ps=1.16u
    I_MXI1_I42_I156_XG_MN0 (I1_I42_G31_24 I1_I42_P31_28n XI1_I42_I156_XG_n1 VSS) gpdk090_nmos1v w=0.24u l=0.1u ad=0.0528p as=0.0528p pd=0.68u ps=0.68u
    I_MXI1_I42_I156_XG_MN1 (XI1_I42_I156_XG_n1 I1_I42_G27_24n I1_I42_G31_24 VSS) gpdk090_nmos1v w=0.24u l=0.1u ad=0.0816p as=0.0528p pd=1.16u ps=0.68u
    I_MXI1_I42_I202_XG_MN2 (XI1_I42_I202_XG_n1 I1_I42_G31_16n VSS VSS) gpdk090_nmos1v w=0.24u l=0.1u ad=0.0528p as=0.0816p pd=0.68u ps=1.16u
    I_MXI1_I42_I202_XG_MN0 (CO I1_I42_P31_16n XI1_I42_I202_XG_n1 VSS) gpdk090_nmos1v w=0.24u l=0.1u ad=0.0528p as=0.0528p pd=0.68u ps=0.68u
    I_MXI1_I42_I202_XG_MN1 (XI1_I42_I202_XG_n1 I1_I42_G15_0n CO VSS) gpdk090_nmos1v w=0.24u l=0.1u ad=0.0816p as=0.0528p pd=1.16u ps=0.68u
    I_MXI1_I42_I194_XG_MN2 (XI1_I42_I194_XG_n1 I1_I42_G23_8n VSS VSS) gpdk090_nmos1v w=0.24u l=0.1u ad=0.0528p as=0.0816p pd=0.68u ps=1.16u
    I_MXI1_I42_I194_XG_MN0 (I1_I42_G23_0 I1_I42_P23_8n XI1_I42_I194_XG_n1 VSS) gpdk090_nmos1v w=0.24u l=0.1u ad=0.0528p as=0.0528p pd=0.68u ps=0.68u
    I_MXI1_I42_I194_XG_MN1 (XI1_I42_I194_XG_n1 I1_I42_G7_0n I1_I42_G23_0 VSS) gpdk090_nmos1v w=0.24u l=0.1u ad=0.0816p as=0.0528p pd=1.16u ps=0.68u
    I_MXI1_I42_I198_XG_MN2 (XI1_I42_I198_XG_n1 I1_I42_G27_12n VSS VSS) gpdk090_nmos1v w=0.24u l=0.1u ad=0.0528p as=0.0816p pd=0.68u ps=1.16u
    I_MXI1_I42_I198_XG_MN0 (I1_I42_G27_0 I1_I42_P27_12n XI1_I42_I198_XG_n1 VSS) gpdk090_nmos1v w=0.24u l=0.1u ad=0.0528p as=0.0528p pd=0.68u ps=0.68u
    I_MXI1_I42_I198_XG_MN1 (XI1_I42_I198_XG_n1 I1_I42_G11_0n I1_I42_G27_0 VSS) gpdk090_nmos1v w=0.24u l=0.1u ad=0.0816p as=0.0528p pd=1.16u ps=0.68u
    I_MXI1_I42_I140_XG_MN2 (XI1_I42_I140_XG_n1 I1_I42_G15_12n VSS VSS) gpdk090_nmos1v w=0.24u l=0.1u ad=0.0528p as=0.0816p pd=0.68u ps=1.16u
    I_MXI1_I42_I140_XG_MN0 (I1_I42_G15_8 I1_I42_P15_12n XI1_I42_I140_XG_n1 VSS) gpdk090_nmos1v w=0.24u l=0.1u ad=0.0528p as=0.0528p pd=0.68u ps=0.68u
    I_MXI1_I42_I140_XG_MN1 (XI1_I42_I140_XG_n1 I1_I42_G11_8n I1_I42_G15_8 VSS) gpdk090_nmos1v w=0.24u l=0.1u ad=0.0816p as=0.0528p pd=1.16u ps=0.68u
    I_MXI1_I42_I186_XG_MN2 (XI1_I42_I186_XG_n1 I1_I42_G19_4n VSS VSS) gpdk090_nmos1v w=0.24u l=0.1u ad=0.0528p as=0.0816p pd=0.68u ps=1.16u
    I_MXI1_I42_I186_XG_MN0 (I1_I42_G19_0 I1_I42_P19_4n XI1_I42_I186_XG_n1 VSS) gpdk090_nmos1v w=0.24u l=0.1u ad=0.0528p as=0.0528p pd=0.68u ps=0.68u
    I_MXI1_I42_I186_XG_MN1 (XI1_I42_I186_XG_n1 I1_I42_G3_0n I1_I42_G19_0 VSS) gpdk090_nmos1v w=0.24u l=0.1u ad=0.0816p as=0.0528p pd=1.16u ps=0.68u
    I_MXI1_I42_I199_XG_MN2 (XI1_I42_I199_XG_n1 I1_I42_G28_13n VSS VSS) gpdk090_nmos1v w=0.24u l=0.1u ad=0.0528p as=0.0816p pd=0.68u ps=1.16u
    I_MXI1_I42_I199_XG_MN0 (I1_I42_G28_0 I1_I42_P28_13n XI1_I42_I199_XG_n1 VSS) gpdk090_nmos1v w=0.24u l=0.1u ad=0.0528p as=0.0528p pd=0.68u ps=0.68u
    I_MXI1_I42_I199_XG_MN1 (XI1_I42_I199_XG_n1 I1_I42_G12_0n I1_I42_G28_0 VSS) gpdk090_nmos1v w=0.24u l=0.1u ad=0.0816p as=0.0528p pd=1.16u ps=0.68u
    I_MXI1_I42_I185_XG_MN2 (XI1_I42_I185_XG_n1 I1_I42_G18_3n VSS VSS) gpdk090_nmos1v w=0.24u l=0.1u ad=0.0528p as=0.0816p pd=0.68u ps=1.16u
    I_MXI1_I42_I185_XG_MN0 (I1_I42_G18_0 I1_I42_P18_3n XI1_I42_I185_XG_n1 VSS) gpdk090_nmos1v w=0.24u l=0.1u ad=0.0528p as=0.0528p pd=0.68u ps=0.68u
    I_MXI1_I42_I185_XG_MN1 (XI1_I42_I185_XG_n1 I1_I42_G2_0n I1_I42_G18_0 VSS) gpdk090_nmos1v w=0.24u l=0.1u ad=0.0816p as=0.0528p pd=1.16u ps=0.68u
    I_MXI1_I42_I141_XG_MN2 (XI1_I42_I141_XG_n1 I1_I42_G16_13n VSS VSS) gpdk090_nmos1v w=0.24u l=0.1u ad=0.0528p as=0.0816p pd=0.68u ps=1.16u
    I_MXI1_I42_I141_XG_MN0 (I1_I42_G16_9 I1_I42_P16_13n XI1_I42_I141_XG_n1 VSS) gpdk090_nmos1v w=0.24u l=0.1u ad=0.0528p as=0.0528p pd=0.68u ps=0.68u
    I_MXI1_I42_I141_XG_MN1 (XI1_I42_I141_XG_n1 I1_I42_G12_9n I1_I42_G16_9 VSS) gpdk090_nmos1v w=0.24u l=0.1u ad=0.0816p as=0.0528p pd=1.16u ps=0.68u
    I_MXI1_I42_I152_XG_MN2 (XI1_I42_I152_XG_n1 I1_I42_G27_24n VSS VSS) gpdk090_nmos1v w=0.24u l=0.1u ad=0.0528p as=0.0816p pd=0.68u ps=1.16u
    I_MXI1_I42_I152_XG_MN0 (I1_I42_G27_20 I1_I42_P27_24n XI1_I42_I152_XG_n1 VSS) gpdk090_nmos1v w=0.24u l=0.1u ad=0.0528p as=0.0528p pd=0.68u ps=0.68u
    I_MXI1_I42_I152_XG_MN1 (XI1_I42_I152_XG_n1 I1_I42_G23_20n I1_I42_G27_20 VSS) gpdk090_nmos1v w=0.24u l=0.1u ad=0.0816p as=0.0528p pd=1.16u ps=0.68u
    I_MXI1_I42_I148_XG_MN2 (XI1_I42_I148_XG_n1 I1_I42_G23_20n VSS VSS) gpdk090_nmos1v w=0.24u l=0.1u ad=0.0528p as=0.0816p pd=0.68u ps=1.16u
    I_MXI1_I42_I148_XG_MN0 (I1_I42_G23_16 I1_I42_P23_20n XI1_I42_I148_XG_n1 VSS) gpdk090_nmos1v w=0.24u l=0.1u ad=0.0528p as=0.0528p pd=0.68u ps=0.68u
    I_MXI1_I42_I148_XG_MN1 (XI1_I42_I148_XG_n1 I1_I42_G19_16n I1_I42_G23_16 VSS) gpdk090_nmos1v w=0.24u l=0.1u ad=0.0816p as=0.0528p pd=1.16u ps=0.68u
    I_MXI1_I42_I144_XG_MN2 (XI1_I42_I144_XG_n1 I1_I42_G19_16n VSS VSS) gpdk090_nmos1v w=0.24u l=0.1u ad=0.0528p as=0.0816p pd=0.68u ps=1.16u
    I_MXI1_I42_I144_XG_MN0 (I1_I42_G19_12 I1_I42_P19_16n XI1_I42_I144_XG_n1 VSS) gpdk090_nmos1v w=0.24u l=0.1u ad=0.0528p as=0.0528p pd=0.68u ps=0.68u
    I_MXI1_I42_I144_XG_MN1 (XI1_I42_I144_XG_n1 I1_I42_G15_12n I1_I42_G19_12 VSS) gpdk090_nmos1v w=0.24u l=0.1u ad=0.0816p as=0.0528p pd=1.16u ps=0.68u
    I_MXI1_I42_I139_XG_MN2 (XI1_I42_I139_XG_n1 I1_I42_G14_11n VSS VSS) gpdk090_nmos1v w=0.24u l=0.1u ad=0.0528p as=0.0816p pd=0.68u ps=1.16u
    I_MXI1_I42_I139_XG_MN0 (I1_I42_G14_7 I1_I42_P14_11n XI1_I42_I139_XG_n1 VSS) gpdk090_nmos1v w=0.24u l=0.1u ad=0.0528p as=0.0528p pd=0.68u ps=0.68u
    I_MXI1_I42_I139_XG_MN1 (XI1_I42_I139_XG_n1 I1_I42_G10_7n I1_I42_G14_7 VSS) gpdk090_nmos1v w=0.24u l=0.1u ad=0.0816p as=0.0528p pd=1.16u ps=0.68u
    I_MXI1_I42_I188_XG_MN2 (XI1_I42_I188_XG_n1 I1_I42_G20_5n VSS VSS) gpdk090_nmos1v w=0.24u l=0.1u ad=0.0528p as=0.0816p pd=0.68u ps=1.16u
    I_MXI1_I42_I188_XG_MN0 (I1_I42_G20_0 I1_I42_P20_5n XI1_I42_I188_XG_n1 VSS) gpdk090_nmos1v w=0.24u l=0.1u ad=0.0528p as=0.0528p pd=0.68u ps=0.68u
    I_MXI1_I42_I188_XG_MN1 (XI1_I42_I188_XG_n1 I1_I42_G4_0n I1_I42_G20_0 VSS) gpdk090_nmos1v w=0.24u l=0.1u ad=0.0816p as=0.0528p pd=1.16u ps=0.68u
    I_MXI1_I42_I80_XG_MN2 (XI1_I42_I80_XG_n1 I1_I42_gn14 VSS VSS) gpdk090_nmos1v w=0.24u l=0.1u ad=0.0528p as=0.0816p pd=0.68u ps=1.16u
    I_MXI1_I42_I80_XG_MN0 (I1_I42_G14_13 I1_I42_pn14 XI1_I42_I80_XG_n1 VSS) gpdk090_nmos1v w=0.24u l=0.1u ad=0.0528p as=0.0528p pd=0.68u ps=0.68u
    I_MXI1_I42_I80_XG_MN1 (XI1_I42_I80_XG_n1 I1_I42_gn13 I1_I42_G14_13 VSS) gpdk090_nmos1v w=0.24u l=0.1u ad=0.0816p as=0.0528p pd=1.16u ps=0.68u
    I_MXI1_I42_I94_XG_MN2 (XI1_I42_I94_XG_n1 I1_I42_gn28 VSS VSS) gpdk090_nmos1v w=0.24u l=0.1u ad=0.0528p as=0.0816p pd=0.68u ps=1.16u
    I_MXI1_I42_I94_XG_MN0 (I1_I42_G28_27 I1_I42_pn28 XI1_I42_I94_XG_n1 VSS) gpdk090_nmos1v w=0.24u l=0.1u ad=0.0528p as=0.0528p pd=0.68u ps=0.68u
    I_MXI1_I42_I94_XG_MN1 (XI1_I42_I94_XG_n1 I1_I42_gn27 I1_I42_G28_27 VSS) gpdk090_nmos1v w=0.24u l=0.1u ad=0.0816p as=0.0528p pd=1.16u ps=0.68u
    I_MXI1_I42_I155_XG_MN2 (XI1_I42_I155_XG_n1 I1_I42_G30_27n VSS VSS) gpdk090_nmos1v w=0.24u l=0.1u ad=0.0528p as=0.0816p pd=0.68u ps=1.16u
    I_MXI1_I42_I155_XG_MN0 (I1_I42_G30_23 I1_I42_P30_27n XI1_I42_I155_XG_n1 VSS) gpdk090_nmos1v w=0.24u l=0.1u ad=0.0528p as=0.0528p pd=0.68u ps=0.68u
    I_MXI1_I42_I155_XG_MN1 (XI1_I42_I155_XG_n1 I1_I42_G26_23n I1_I42_G30_23 VSS) gpdk090_nmos1v w=0.24u l=0.1u ad=0.0816p as=0.0528p pd=1.16u ps=0.68u
    I_MXI1_I42_I201_XG_MN2 (XI1_I42_I201_XG_n1 I1_I42_G30_15n VSS VSS) gpdk090_nmos1v w=0.24u l=0.1u ad=0.0528p as=0.0816p pd=0.68u ps=1.16u
    I_MXI1_I42_I201_XG_MN0 (CM I1_I42_P30_15n XI1_I42_I201_XG_n1 VSS) gpdk090_nmos1v w=0.24u l=0.1u ad=0.0528p as=0.0528p pd=0.68u ps=0.68u
    I_MXI1_I42_I201_XG_MN1 (XI1_I42_I201_XG_n1 I1_I42_G14_0n CM VSS) gpdk090_nmos1v w=0.24u l=0.1u ad=0.0816p as=0.0528p pd=1.16u ps=0.68u
    I_MXI1_I42_I153_XG_MN2 (XI1_I42_I153_XG_n1 I1_I42_G28_25n VSS VSS) gpdk090_nmos1v w=0.24u l=0.1u ad=0.0528p as=0.0816p pd=0.68u ps=1.16u
    I_MXI1_I42_I153_XG_MN0 (I1_I42_G28_21 I1_I42_P28_25n XI1_I42_I153_XG_n1 VSS) gpdk090_nmos1v w=0.24u l=0.1u ad=0.0528p as=0.0528p pd=0.68u ps=0.68u
    I_MXI1_I42_I153_XG_MN1 (XI1_I42_I153_XG_n1 I1_I42_G24_21n I1_I42_G28_21 VSS) gpdk090_nmos1v w=0.24u l=0.1u ad=0.0816p as=0.0528p pd=1.16u ps=0.68u
    I_MXI1_I42_I192_XG_MN2 (XI1_I42_I192_XG_n1 I1_I42_G22_7n VSS VSS) gpdk090_nmos1v w=0.24u l=0.1u ad=0.0528p as=0.0816p pd=0.68u ps=1.16u
    I_MXI1_I42_I192_XG_MN0 (I1_I42_G22_0 I1_I42_P22_7n XI1_I42_I192_XG_n1 VSS) gpdk090_nmos1v w=0.24u l=0.1u ad=0.0528p as=0.0528p pd=0.68u ps=0.68u
    I_MXI1_I42_I192_XG_MN1 (XI1_I42_I192_XG_n1 I1_I42_G6_0n I1_I42_G22_0 VSS) gpdk090_nmos1v w=0.24u l=0.1u ad=0.0816p as=0.0528p pd=1.16u ps=0.68u
    I_MXI1_I42_I197_XG_MN2 (XI1_I42_I197_XG_n1 I1_I42_G26_11n VSS VSS) gpdk090_nmos1v w=0.24u l=0.1u ad=0.0528p as=0.0816p pd=0.68u ps=1.16u
    I_MXI1_I42_I197_XG_MN0 (I1_I42_G26_0 I1_I42_P26_11n XI1_I42_I197_XG_n1 VSS) gpdk090_nmos1v w=0.24u l=0.1u ad=0.0528p as=0.0528p pd=0.68u ps=0.68u
    I_MXI1_I42_I197_XG_MN1 (XI1_I42_I197_XG_n1 I1_I42_G10_0n I1_I42_G26_0 VSS) gpdk090_nmos1v w=0.24u l=0.1u ad=0.0816p as=0.0528p pd=1.16u ps=0.68u
    I_MXI1_I42_I143_XG_MN2 (XI1_I42_I143_XG_n1 I1_I42_G18_15n VSS VSS) gpdk090_nmos1v w=0.24u l=0.1u ad=0.0528p as=0.0816p pd=0.68u ps=1.16u
    I_MXI1_I42_I143_XG_MN0 (I1_I42_G18_11 I1_I42_P18_15n XI1_I42_I143_XG_n1 VSS) gpdk090_nmos1v w=0.24u l=0.1u ad=0.0528p as=0.0528p pd=0.68u ps=0.68u
    I_MXI1_I42_I143_XG_MN1 (XI1_I42_I143_XG_n1 I1_I42_G14_11n I1_I42_G18_11 VSS) gpdk090_nmos1v w=0.24u l=0.1u ad=0.0816p as=0.0528p pd=1.16u ps=0.68u
    I_MXI1_I42_I149_XG_MN2 (XI1_I42_I149_XG_n1 I1_I42_G24_21n VSS VSS) gpdk090_nmos1v w=0.24u l=0.1u ad=0.0528p as=0.0816p pd=0.68u ps=1.16u
    I_MXI1_I42_I149_XG_MN0 (I1_I42_G24_17 I1_I42_P24_21n XI1_I42_I149_XG_n1 VSS) gpdk090_nmos1v w=0.24u l=0.1u ad=0.0528p as=0.0528p pd=0.68u ps=0.68u
    I_MXI1_I42_I149_XG_MN1 (XI1_I42_I149_XG_n1 I1_I42_G20_17n I1_I42_G24_17 VSS) gpdk090_nmos1v w=0.24u l=0.1u ad=0.0816p as=0.0528p pd=1.16u ps=0.68u
    I_MXI1_I42_I145_XG_MN2 (XI1_I42_I145_XG_n1 I1_I42_G20_17n VSS VSS) gpdk090_nmos1v w=0.24u l=0.1u ad=0.0528p as=0.0816p pd=0.68u ps=1.16u
    I_MXI1_I42_I145_XG_MN0 (I1_I42_G20_13 I1_I42_P20_17n XI1_I42_I145_XG_n1 VSS) gpdk090_nmos1v w=0.24u l=0.1u ad=0.0528p as=0.0528p pd=0.68u ps=0.68u
    I_MXI1_I42_I145_XG_MN1 (XI1_I42_I145_XG_n1 I1_I42_G16_13n I1_I42_G20_13 VSS) gpdk090_nmos1v w=0.24u l=0.1u ad=0.0816p as=0.0528p pd=1.16u ps=0.68u
    I_MXI1_I42_I81_XG_MN2 (XI1_I42_I81_XG_n1 I1_I42_gn15 VSS VSS) gpdk090_nmos1v w=0.24u l=0.1u ad=0.0528p as=0.0816p pd=0.68u ps=1.16u
    I_MXI1_I42_I81_XG_MN0 (I1_I42_G15_14 I1_I42_pn15 XI1_I42_I81_XG_n1 VSS) gpdk090_nmos1v w=0.24u l=0.1u ad=0.0528p as=0.0528p pd=0.68u ps=0.68u
    I_MXI1_I42_I81_XG_MN1 (XI1_I42_I81_XG_n1 I1_I42_gn14 I1_I42_G15_14 VSS) gpdk090_nmos1v w=0.24u l=0.1u ad=0.0816p as=0.0528p pd=1.16u ps=0.68u
    I_MXI1_I42_I93_XG_MN2 (XI1_I42_I93_XG_n1 I1_I42_gn27 VSS VSS) gpdk090_nmos1v w=0.24u l=0.1u ad=0.0528p as=0.0816p pd=0.68u ps=1.16u
    I_MXI1_I42_I93_XG_MN0 (I1_I42_G27_26 I1_I42_pn27 XI1_I42_I93_XG_n1 VSS) gpdk090_nmos1v w=0.24u l=0.1u ad=0.0528p as=0.0528p pd=0.68u ps=0.68u
    I_MXI1_I42_I93_XG_MN1 (XI1_I42_I93_XG_n1 I1_I42_gn26 I1_I42_G27_26 VSS) gpdk090_nmos1v w=0.24u l=0.1u ad=0.0816p as=0.0528p pd=1.16u ps=0.68u
    I_MXI1_I42_I151_XG_MN2 (XI1_I42_I151_XG_n1 I1_I42_G26_23n VSS VSS) gpdk090_nmos1v w=0.24u l=0.1u ad=0.0528p as=0.0816p pd=0.68u ps=1.16u
    I_MXI1_I42_I151_XG_MN0 (I1_I42_G26_19 I1_I42_P26_23n XI1_I42_I151_XG_n1 VSS) gpdk090_nmos1v w=0.24u l=0.1u ad=0.0528p as=0.0528p pd=0.68u ps=0.68u
    I_MXI1_I42_I151_XG_MN1 (XI1_I42_I151_XG_n1 I1_I42_G22_19n I1_I42_G26_19 VSS) gpdk090_nmos1v w=0.24u l=0.1u ad=0.0816p as=0.0528p pd=1.16u ps=0.68u
    I_MXI1_I42_I147_XG_MN2 (XI1_I42_I147_XG_n1 I1_I42_G22_19n VSS VSS) gpdk090_nmos1v w=0.24u l=0.1u ad=0.0528p as=0.0816p pd=0.68u ps=1.16u
    I_MXI1_I42_I147_XG_MN0 (I1_I42_G22_15 I1_I42_P22_19n XI1_I42_I147_XG_n1 VSS) gpdk090_nmos1v w=0.24u l=0.1u ad=0.0528p as=0.0528p pd=0.68u ps=0.68u
    I_MXI1_I42_I147_XG_MN1 (XI1_I42_I147_XG_n1 I1_I42_G18_15n I1_I42_G22_15 VSS) gpdk090_nmos1v w=0.24u l=0.1u ad=0.0816p as=0.0528p pd=1.16u ps=0.68u
    I_MXI1_I42_I83_XG_MN2 (XI1_I42_I83_XG_n1 I1_I42_gn17 VSS VSS) gpdk090_nmos1v w=0.24u l=0.1u ad=0.0528p as=0.0816p pd=0.68u ps=1.16u
    I_MXI1_I42_I83_XG_MN0 (I1_I42_G17_16 I1_I42_pn17 XI1_I42_I83_XG_n1 VSS) gpdk090_nmos1v w=0.24u l=0.1u ad=0.0528p as=0.0528p pd=0.68u ps=0.68u
    I_MXI1_I42_I83_XG_MN1 (XI1_I42_I83_XG_n1 I1_I42_gn16 I1_I42_G17_16 VSS) gpdk090_nmos1v w=0.24u l=0.1u ad=0.0816p as=0.0528p pd=1.16u ps=0.68u
    I_MXI1_I42_I82_XG_MN2 (XI1_I42_I82_XG_n1 I1_I42_gn16 VSS VSS) gpdk090_nmos1v w=0.24u l=0.1u ad=0.0528p as=0.0816p pd=0.68u ps=1.16u
    I_MXI1_I42_I82_XG_MN0 (I1_I42_G16_15 I1_I42_pn16 XI1_I42_I82_XG_n1 VSS) gpdk090_nmos1v w=0.24u l=0.1u ad=0.0528p as=0.0528p pd=0.68u ps=0.68u
    I_MXI1_I42_I82_XG_MN1 (XI1_I42_I82_XG_n1 I1_I42_gn15 I1_I42_G16_15 VSS) gpdk090_nmos1v w=0.24u l=0.1u ad=0.0816p as=0.0528p pd=1.16u ps=0.68u
    I_MXI1_I42_I92_XG_MN2 (XI1_I42_I92_XG_n1 I1_I42_gn26 VSS VSS) gpdk090_nmos1v w=0.24u l=0.1u ad=0.0528p as=0.0816p pd=0.68u ps=1.16u
    I_MXI1_I42_I92_XG_MN0 (I1_I42_G26_25 I1_I42_pn26 XI1_I42_I92_XG_n1 VSS) gpdk090_nmos1v w=0.24u l=0.1u ad=0.0528p as=0.0528p pd=0.68u ps=0.68u
    I_MXI1_I42_I92_XG_MN1 (XI1_I42_I92_XG_n1 I1_I42_gn25 I1_I42_G26_25 VSS) gpdk090_nmos1v w=0.24u l=0.1u ad=0.0816p as=0.0528p pd=1.16u ps=0.68u
    I_MXI1_I42_I91_XG_MN2 (XI1_I42_I91_XG_n1 I1_I42_gn25 VSS VSS) gpdk090_nmos1v w=0.24u l=0.1u ad=0.0528p as=0.0816p pd=0.68u ps=1.16u
    I_MXI1_I42_I91_XG_MN0 (I1_I42_G25_24 I1_I42_pn25 XI1_I42_I91_XG_n1 VSS) gpdk090_nmos1v w=0.24u l=0.1u ad=0.0528p as=0.0528p pd=0.68u ps=0.68u
    I_MXI1_I42_I91_XG_MN1 (XI1_I42_I91_XG_n1 I1_I42_gn24 I1_I42_G25_24 VSS) gpdk090_nmos1v w=0.24u l=0.1u ad=0.0816p as=0.0528p pd=1.16u ps=0.68u
    I_MXI1_I42_I90_XG_MN2 (XI1_I42_I90_XG_n1 I1_I42_gn24 VSS VSS) gpdk090_nmos1v w=0.24u l=0.1u ad=0.0528p as=0.0816p pd=0.68u ps=1.16u
    I_MXI1_I42_I90_XG_MN0 (I1_I42_G24_23 I1_I42_pn24 XI1_I42_I90_XG_n1 VSS) gpdk090_nmos1v w=0.24u l=0.1u ad=0.0528p as=0.0528p pd=0.68u ps=0.68u
    I_MXI1_I42_I90_XG_MN1 (XI1_I42_I90_XG_n1 I1_I42_gn23 I1_I42_G24_23 VSS) gpdk090_nmos1v w=0.24u l=0.1u ad=0.0816p as=0.0528p pd=1.16u ps=0.68u
    I_MXI1_I42_I89_XG_MN2 (XI1_I42_I89_XG_n1 I1_I42_gn23 VSS VSS) gpdk090_nmos1v w=0.24u l=0.1u ad=0.0528p as=0.0816p pd=0.68u ps=1.16u
    I_MXI1_I42_I89_XG_MN0 (I1_I42_G23_22 I1_I42_pn23 XI1_I42_I89_XG_n1 VSS) gpdk090_nmos1v w=0.24u l=0.1u ad=0.0528p as=0.0528p pd=0.68u ps=0.68u
    I_MXI1_I42_I89_XG_MN1 (XI1_I42_I89_XG_n1 I1_I42_gn22 I1_I42_G23_22 VSS) gpdk090_nmos1v w=0.24u l=0.1u ad=0.0816p as=0.0528p pd=1.16u ps=0.68u
    I_MXI1_I42_I88_XG_MN2 (XI1_I42_I88_XG_n1 I1_I42_gn22 VSS VSS) gpdk090_nmos1v w=0.24u l=0.1u ad=0.0528p as=0.0816p pd=0.68u ps=1.16u
    I_MXI1_I42_I88_XG_MN0 (I1_I42_G22_21 I1_I42_pn22 XI1_I42_I88_XG_n1 VSS) gpdk090_nmos1v w=0.24u l=0.1u ad=0.0528p as=0.0528p pd=0.68u ps=0.68u
    I_MXI1_I42_I88_XG_MN1 (XI1_I42_I88_XG_n1 I1_I42_gn21 I1_I42_G22_21 VSS) gpdk090_nmos1v w=0.24u l=0.1u ad=0.0816p as=0.0528p pd=1.16u ps=0.68u
    I_MXI1_I42_I87_XG_MN2 (XI1_I42_I87_XG_n1 I1_I42_gn21 VSS VSS) gpdk090_nmos1v w=0.24u l=0.1u ad=0.0528p as=0.0816p pd=0.68u ps=1.16u
    I_MXI1_I42_I87_XG_MN0 (I1_I42_G21_20 I1_I42_pn21 XI1_I42_I87_XG_n1 VSS) gpdk090_nmos1v w=0.24u l=0.1u ad=0.0528p as=0.0528p pd=0.68u ps=0.68u
    I_MXI1_I42_I87_XG_MN1 (XI1_I42_I87_XG_n1 I1_I42_gn20 I1_I42_G21_20 VSS) gpdk090_nmos1v w=0.24u l=0.1u ad=0.0816p as=0.0528p pd=1.16u ps=0.68u
    I_MXI1_I42_I86_XG_MN2 (XI1_I42_I86_XG_n1 I1_I42_gn20 VSS VSS) gpdk090_nmos1v w=0.24u l=0.1u ad=0.0528p as=0.0816p pd=0.68u ps=1.16u
    I_MXI1_I42_I86_XG_MN0 (I1_I42_G20_19 I1_I42_pn20 XI1_I42_I86_XG_n1 VSS) gpdk090_nmos1v w=0.24u l=0.1u ad=0.0528p as=0.0528p pd=0.68u ps=0.68u
    I_MXI1_I42_I86_XG_MN1 (XI1_I42_I86_XG_n1 I1_I42_gn19 I1_I42_G20_19 VSS) gpdk090_nmos1v w=0.24u l=0.1u ad=0.0816p as=0.0528p pd=1.16u ps=0.68u
    I_MXI1_I42_I85_XG_MN2 (XI1_I42_I85_XG_n1 I1_I42_gn19 VSS VSS) gpdk090_nmos1v w=0.24u l=0.1u ad=0.0528p as=0.0816p pd=0.68u ps=1.16u
    I_MXI1_I42_I85_XG_MN0 (I1_I42_G19_18 I1_I42_pn19 XI1_I42_I85_XG_n1 VSS) gpdk090_nmos1v w=0.24u l=0.1u ad=0.0528p as=0.0528p pd=0.68u ps=0.68u
    I_MXI1_I42_I85_XG_MN1 (XI1_I42_I85_XG_n1 I1_I42_gn18 I1_I42_G19_18 VSS) gpdk090_nmos1v w=0.24u l=0.1u ad=0.0816p as=0.0528p pd=1.16u ps=0.68u
    I_MXI1_I42_I84_XG_MN2 (XI1_I42_I84_XG_n1 I1_I42_gn18 VSS VSS) gpdk090_nmos1v w=0.24u l=0.1u ad=0.0528p as=0.0816p pd=0.68u ps=1.16u
    I_MXI1_I42_I84_XG_MN0 (I1_I42_G18_17 I1_I42_pn18 XI1_I42_I84_XG_n1 VSS) gpdk090_nmos1v w=0.24u l=0.1u ad=0.0528p as=0.0528p pd=0.68u ps=0.68u
    I_MXI1_I42_I84_XG_MN1 (XI1_I42_I84_XG_n1 I1_I42_gn17 I1_I42_G18_17 VSS) gpdk090_nmos1v w=0.24u l=0.1u ad=0.0816p as=0.0528p pd=1.16u ps=0.68u
    I_MXI3_I533_MN1 (XI3_I533_n1 DIVR_22 VSS VSS) gpdk090_nmos1v w=0.24u l=0.1u ad=0.0528p as=0.0816p pd=0.68u ps=1.16u
    I_MXI3_I533_MN0 (I3_hd54 I3_SEL_DIV_b3_9 XI3_I533_n1 VSS) gpdk090_nmos1v w=0.24u l=0.1u ad=0.0816p as=0.0528p pd=1.16u ps=0.68u
    I_MXI3_I541_MN1 (XI3_I541_n1 MULP_57 VSS VSS) gpdk090_nmos1v w=0.24u l=0.1u ad=0.0528p as=0.0816p pd=0.68u ps=1.16u
    I_MXI3_I541_MN0 (I3_hm57 I3_SEL_MUL_b3_9 XI3_I541_n1 VSS) gpdk090_nmos1v w=0.24u l=0.1u ad=0.0816p as=0.0528p pd=1.16u ps=0.68u
    I_MXI3_I545_MN1 (XI3_I545_n1 DIVR_26 VSS VSS) gpdk090_nmos1v w=0.24u l=0.1u ad=0.0528p as=0.0816p pd=0.68u ps=1.16u
    I_MXI3_I545_MN0 (I3_hd58 I3_SEL_DIV_b3_9 XI3_I545_n1 VSS) gpdk090_nmos1v w=0.24u l=0.1u ad=0.0816p as=0.0528p pd=1.16u ps=0.68u
    I_MXI3_I546_MN1 (XI3_I546_n1 I3_hd58 VSS VSS) gpdk090_nmos1v w=0.24u l=0.1u ad=0.0528p as=0.0816p pd=0.68u ps=1.16u
    I_MXI3_I546_MN0 (Y_58 I3_hm58 XI3_I546_n1 VSS) gpdk090_nmos1v w=0.24u l=0.1u ad=0.0816p as=0.0528p pd=1.16u ps=0.68u
    I_MXI3_I544_MN1 (XI3_I544_n1 MULP_58 VSS VSS) gpdk090_nmos1v w=0.24u l=0.1u ad=0.0528p as=0.0816p pd=0.68u ps=1.16u
    I_MXI3_I544_MN0 (I3_hm58 I3_SEL_MUL_b3_9 XI3_I544_n1 VSS) gpdk090_nmos1v w=0.24u l=0.1u ad=0.0816p as=0.0528p pd=1.16u ps=0.68u
    I_MXI3_I549_MN1 (XI3_I549_n1 I3_hd59 VSS VSS) gpdk090_nmos1v w=0.24u l=0.1u ad=0.0528p as=0.0816p pd=0.68u ps=1.16u
    I_MXI3_I549_MN0 (Y_59 I3_hm59 XI3_I549_n1 VSS) gpdk090_nmos1v w=0.24u l=0.1u ad=0.0816p as=0.0528p pd=1.16u ps=0.68u
    I_MXI3_I548_MN1 (XI3_I548_n1 DIVR_27 VSS VSS) gpdk090_nmos1v w=0.24u l=0.1u ad=0.0528p as=0.0816p pd=0.68u ps=1.16u
    I_MXI3_I548_MN0 (I3_hd59 I3_SEL_DIV_b3_10 XI3_I548_n1 VSS) gpdk090_nmos1v w=0.24u l=0.1u ad=0.0816p as=0.0528p pd=1.16u ps=0.68u
    I_MXI3_I557_MN1 (XI3_I557_n1 DIVR_30 VSS VSS) gpdk090_nmos1v w=0.24u l=0.1u ad=0.0528p as=0.0816p pd=0.68u ps=1.16u
    I_MXI3_I557_MN0 (I3_hd62 I3_SEL_DIV_b3_10 XI3_I557_n1 VSS) gpdk090_nmos1v w=0.24u l=0.1u ad=0.0816p as=0.0528p pd=1.16u ps=0.68u
    I_MXI3_I552_MN1 (XI3_I552_n1 I3_hd60 VSS VSS) gpdk090_nmos1v w=0.24u l=0.1u ad=0.0528p as=0.0816p pd=0.68u ps=1.16u
    I_MXI3_I552_MN0 (Y_60 I3_hm60 XI3_I552_n1 VSS) gpdk090_nmos1v w=0.24u l=0.1u ad=0.0816p as=0.0528p pd=1.16u ps=0.68u
    I_MXI3_I551_MN1 (XI3_I551_n1 DIVR_28 VSS VSS) gpdk090_nmos1v w=0.24u l=0.1u ad=0.0528p as=0.0816p pd=0.68u ps=1.16u
    I_MXI3_I551_MN0 (I3_hd60 I3_SEL_DIV_b3_10 XI3_I551_n1 VSS) gpdk090_nmos1v w=0.24u l=0.1u ad=0.0816p as=0.0528p pd=1.16u ps=0.68u
    I_MXI3_I550_MN1 (XI3_I550_n1 MULP_60 VSS VSS) gpdk090_nmos1v w=0.24u l=0.1u ad=0.0528p as=0.0816p pd=0.68u ps=1.16u
    I_MXI3_I550_MN0 (I3_hm60 I3_SEL_MUL_b3_10 XI3_I550_n1 VSS) gpdk090_nmos1v w=0.24u l=0.1u ad=0.0816p as=0.0528p pd=1.16u ps=0.68u
    I_MXI4_I70_MN1 (XI4_I70_n1 DIVDZ VSS VSS) gpdk090_nmos1v w=0.24u l=0.1u ad=0.0528p as=0.0816p pd=0.68u ps=1.16u
    I_MXI4_I70_MN0 (I4_dzn SEL_DIV XI4_I70_n1 VSS) gpdk090_nmos1v w=0.24u l=0.1u ad=0.0816p as=0.0528p pd=1.16u ps=0.68u
    I_MXI3_I206_MN1 (XI3_I206_n1 MULP_10 VSS VSS) gpdk090_nmos1v w=0.24u l=0.1u ad=0.0528p as=0.0816p pd=0.68u ps=1.16u
    I_MXI3_I206_MN0 (I3_n10_4 I3_SEL_MUL_b3_1 XI3_I206_n1 VSS) gpdk090_nmos1v w=0.24u l=0.1u ad=0.0816p as=0.0528p pd=1.16u ps=0.68u
    I_MXI3_I210_MN1 (XI3_I210_n1 I3_n10_5 VSS VSS) gpdk090_nmos1v w=0.24u l=0.1u ad=0.0528p as=0.0816p pd=0.68u ps=1.16u
    I_MXI3_I210_MN0 (I3_o10_2 I3_n10_4 XI3_I210_n1 VSS) gpdk090_nmos1v w=0.24u l=0.1u ad=0.0816p as=0.0528p pd=1.16u ps=0.68u
    I_MXI3_I207_MN1 (XI3_I207_n1 DIVQ_10 VSS VSS) gpdk090_nmos1v w=0.24u l=0.1u ad=0.0528p as=0.0816p pd=0.68u ps=1.16u
    I_MXI3_I207_MN0 (I3_n10_5 I3_SEL_DIV_b3_1 XI3_I207_n1 VSS) gpdk090_nmos1v w=0.24u l=0.1u ad=0.0816p as=0.0528p pd=1.16u ps=0.68u
    I_MXI3_I195_MN1 (XI3_I195_n1 DIVQ_9 VSS VSS) gpdk090_nmos1v w=0.24u l=0.1u ad=0.0528p as=0.0816p pd=0.68u ps=1.16u
    I_MXI3_I195_MN0 (I3_n9_5 I3_SEL_DIV_b3_1 XI3_I195_n1 VSS) gpdk090_nmos1v w=0.24u l=0.1u ad=0.0816p as=0.0528p pd=1.16u ps=0.68u
    I_MXI3_I171_MN1 (XI3_I171_n1 DIVQ_7 VSS VSS) gpdk090_nmos1v w=0.24u l=0.1u ad=0.0528p as=0.0816p pd=0.68u ps=1.16u
    I_MXI3_I171_MN0 (I3_n7_5 I3_SEL_DIV_b3_1 XI3_I171_n1 VSS) gpdk090_nmos1v w=0.24u l=0.1u ad=0.0816p as=0.0528p pd=1.16u ps=0.68u
    I_MXI3_I158_MN1 (XI3_I158_n1 MULP_6 VSS VSS) gpdk090_nmos1v w=0.24u l=0.1u ad=0.0528p as=0.0816p pd=0.68u ps=1.16u
    I_MXI3_I158_MN0 (I3_n6_4 I3_SEL_MUL_b3_1 XI3_I158_n1 VSS) gpdk090_nmos1v w=0.24u l=0.1u ad=0.0816p as=0.0528p pd=1.16u ps=0.68u
    I_MXI3_I190_MN1 (XI3_I190_n1 AND_9 VSS VSS) gpdk090_nmos1v w=0.24u l=0.1u ad=0.0528p as=0.0816p pd=0.68u ps=1.16u
    I_MXI3_I190_MN0 (I3_n9_0 I3_SEL_AND_b3_1 XI3_I190_n1 VSS) gpdk090_nmos1v w=0.24u l=0.1u ad=0.0816p as=0.0528p pd=1.16u ps=0.68u
    I_MXI3_I154_MN1 (XI3_I154_n1 AND_6 VSS VSS) gpdk090_nmos1v w=0.24u l=0.1u ad=0.0528p as=0.0816p pd=0.68u ps=1.16u
    I_MXI3_I154_MN0 (I3_n6_0 I3_SEL_AND_b3_1 XI3_I154_n1 VSS) gpdk090_nmos1v w=0.24u l=0.1u ad=0.0816p as=0.0528p pd=1.16u ps=0.68u
    I_MXI4_I33_MN1 (XI4_I33_n1 I4_z0_3 VSS VSS) gpdk090_nmos1v w=0.24u l=0.1u ad=0.0528p as=0.0816p pd=0.68u ps=1.16u
    I_MXI4_I33_MN0 (I4_z1_1 I4_z0_2 XI4_I33_n1 VSS) gpdk090_nmos1v w=0.24u l=0.1u ad=0.0816p as=0.0528p pd=1.16u ps=0.68u
    I_MXI2_I0_MN1 (XI2_I0_n1 B_0 VSS VSS) gpdk090_nmos1v w=0.24u l=0.1u ad=0.0528p as=0.0816p pd=0.68u ps=1.16u
    I_MXI2_I0_MN0 (I2_nand0 A_0 XI2_I0_n1 VSS) gpdk090_nmos1v w=0.24u l=0.1u ad=0.0816p as=0.0528p pd=1.16u ps=0.68u
    I_MXI3_I83_MN1 (XI3_I83_n1 OR_0 VSS VSS) gpdk090_nmos1v w=0.24u l=0.1u ad=0.0528p as=0.0816p pd=0.68u ps=1.16u
    I_MXI3_I83_MN0 (I3_n0_1 I3_SEL_OR_b3_0 XI3_I83_n1 VSS) gpdk090_nmos1v w=0.24u l=0.1u ad=0.0816p as=0.0528p pd=1.16u ps=0.68u
    I_MXI3_I141_MN1 (XI3_I141_n1 I3_q4_2 VSS VSS) gpdk090_nmos1v w=0.24u l=0.1u ad=0.0528p as=0.0816p pd=0.68u ps=1.16u
    I_MXI3_I141_MN0 (Y_4 I3_q4_1 XI3_I141_n1 VSS) gpdk090_nmos1v w=0.24u l=0.1u ad=0.0816p as=0.0528p pd=1.16u ps=0.68u
    I_MXI2_I6_MN1 (XI2_I6_n1 B_1 VSS VSS) gpdk090_nmos1v w=0.24u l=0.1u ad=0.0528p as=0.0816p pd=0.68u ps=1.16u
    I_MXI2_I6_MN0 (I2_nand1 A_1 XI2_I6_n1 VSS) gpdk090_nmos1v w=0.24u l=0.1u ad=0.0816p as=0.0528p pd=1.16u ps=0.68u
    I_MXI3_I136_MN1 (XI3_I136_n1 I3_n4_1 VSS VSS) gpdk090_nmos1v w=0.24u l=0.1u ad=0.0528p as=0.0816p pd=0.68u ps=1.16u
    I_MXI3_I136_MN0 (I3_o4_0 I3_n4_0 XI3_I136_n1 VSS) gpdk090_nmos1v w=0.24u l=0.1u ad=0.0816p as=0.0528p pd=1.16u ps=0.68u
    I_MXI3_I131_MN1 (XI3_I131_n1 OR_4 VSS VSS) gpdk090_nmos1v w=0.24u l=0.1u ad=0.0528p as=0.0816p pd=0.68u ps=1.16u
    I_MXI3_I131_MN0 (I3_n4_1 I3_SEL_OR_b3_0 XI3_I131_n1 VSS) gpdk090_nmos1v w=0.24u l=0.1u ad=0.0816p as=0.0528p pd=1.16u ps=0.68u
    I_MXI3_I532_MN1 (XI3_I532_n1 MULP_54 VSS VSS) gpdk090_nmos1v w=0.24u l=0.1u ad=0.0528p as=0.0816p pd=0.68u ps=1.16u
    I_MXI3_I532_MN0 (I3_hm54 I3_SEL_MUL_b3_9 XI3_I532_n1 VSS) gpdk090_nmos1v w=0.24u l=0.1u ad=0.0816p as=0.0528p pd=1.16u ps=0.68u
    I_MXI3_I534_MN1 (XI3_I534_n1 I3_hd54 VSS VSS) gpdk090_nmos1v w=0.24u l=0.1u ad=0.0528p as=0.0816p pd=0.68u ps=1.16u
    I_MXI3_I534_MN0 (Y_54 I3_hm54 XI3_I534_n1 VSS) gpdk090_nmos1v w=0.24u l=0.1u ad=0.0816p as=0.0528p pd=1.16u ps=0.68u
    I_MXI3_I535_MN1 (XI3_I535_n1 MULP_55 VSS VSS) gpdk090_nmos1v w=0.24u l=0.1u ad=0.0528p as=0.0816p pd=0.68u ps=1.16u
    I_MXI3_I535_MN0 (I3_hm55 I3_SEL_MUL_b3_9 XI3_I535_n1 VSS) gpdk090_nmos1v w=0.24u l=0.1u ad=0.0816p as=0.0528p pd=1.16u ps=0.68u
    I_MXI3_I542_MN1 (XI3_I542_n1 DIVR_25 VSS VSS) gpdk090_nmos1v w=0.24u l=0.1u ad=0.0528p as=0.0816p pd=0.68u ps=1.16u
    I_MXI3_I542_MN0 (I3_hd57 I3_SEL_DIV_b3_9 XI3_I542_n1 VSS) gpdk090_nmos1v w=0.24u l=0.1u ad=0.0816p as=0.0528p pd=1.16u ps=0.68u
    I_MXI3_I537_MN1 (XI3_I537_n1 I3_hd55 VSS VSS) gpdk090_nmos1v w=0.24u l=0.1u ad=0.0528p as=0.0816p pd=0.68u ps=1.16u
    I_MXI3_I537_MN0 (Y_55 I3_hm55 XI3_I537_n1 VSS) gpdk090_nmos1v w=0.24u l=0.1u ad=0.0816p as=0.0528p pd=1.16u ps=0.68u
    I_MXI3_I543_MN1 (XI3_I543_n1 I3_hd57 VSS VSS) gpdk090_nmos1v w=0.24u l=0.1u ad=0.0528p as=0.0816p pd=0.68u ps=1.16u
    I_MXI3_I543_MN0 (Y_57 I3_hm57 XI3_I543_n1 VSS) gpdk090_nmos1v w=0.24u l=0.1u ad=0.0816p as=0.0528p pd=1.16u ps=0.68u
    I_MXI3_I536_MN1 (XI3_I536_n1 DIVR_23 VSS VSS) gpdk090_nmos1v w=0.24u l=0.1u ad=0.0528p as=0.0816p pd=0.68u ps=1.16u
    I_MXI3_I536_MN0 (I3_hd55 I3_SEL_DIV_b3_9 XI3_I536_n1 VSS) gpdk090_nmos1v w=0.24u l=0.1u ad=0.0816p as=0.0528p pd=1.16u ps=0.68u
    I_MXI3_I539_MN1 (XI3_I539_n1 DIVR_24 VSS VSS) gpdk090_nmos1v w=0.24u l=0.1u ad=0.0528p as=0.0816p pd=0.68u ps=1.16u
    I_MXI3_I539_MN0 (I3_hd56 I3_SEL_DIV_b3_9 XI3_I539_n1 VSS) gpdk090_nmos1v w=0.24u l=0.1u ad=0.0816p as=0.0528p pd=1.16u ps=0.68u
    I_MXI3_I538_MN1 (XI3_I538_n1 MULP_56 VSS VSS) gpdk090_nmos1v w=0.24u l=0.1u ad=0.0528p as=0.0816p pd=0.68u ps=1.16u
    I_MXI3_I538_MN0 (I3_hm56 I3_SEL_MUL_b3_9 XI3_I538_n1 VSS) gpdk090_nmos1v w=0.24u l=0.1u ad=0.0816p as=0.0528p pd=1.16u ps=0.68u
    I_MXI3_I540_MN1 (XI3_I540_n1 I3_hd56 VSS VSS) gpdk090_nmos1v w=0.24u l=0.1u ad=0.0528p as=0.0816p pd=0.68u ps=1.16u
    I_MXI3_I540_MN0 (Y_56 I3_hm56 XI3_I540_n1 VSS) gpdk090_nmos1v w=0.24u l=0.1u ad=0.0816p as=0.0528p pd=1.16u ps=0.68u
    I_MXI4_I46_MN1 (XI4_I46_n1 I4_z0_29 VSS VSS) gpdk090_nmos1v w=0.24u l=0.1u ad=0.0528p as=0.0816p pd=0.68u ps=1.16u
    I_MXI4_I46_MN0 (I4_z1_14 I4_z0_28 XI4_I46_n1 VSS) gpdk090_nmos1v w=0.24u l=0.1u ad=0.0816p as=0.0528p pd=1.16u ps=0.68u
    I_MXI4_I47_MN1 (XI4_I47_n1 I4_z0_31 VSS VSS) gpdk090_nmos1v w=0.24u l=0.1u ad=0.0528p as=0.0816p pd=0.68u ps=1.16u
    I_MXI4_I47_MN0 (I4_z1_15 I4_z0_30 XI4_I47_n1 VSS) gpdk090_nmos1v w=0.24u l=0.1u ad=0.0816p as=0.0528p pd=1.16u ps=0.68u
    I_MXI3_I547_MN1 (XI3_I547_n1 MULP_59 VSS VSS) gpdk090_nmos1v w=0.24u l=0.1u ad=0.0528p as=0.0816p pd=0.68u ps=1.16u
    I_MXI3_I547_MN0 (I3_hm59 I3_SEL_MUL_b3_10 XI3_I547_n1 VSS) gpdk090_nmos1v w=0.24u l=0.1u ad=0.0816p as=0.0528p pd=1.16u ps=0.68u
    I_MXI3_I558_MN1 (XI3_I558_n1 I3_hd62 VSS VSS) gpdk090_nmos1v w=0.24u l=0.1u ad=0.0528p as=0.0816p pd=0.68u ps=1.16u
    I_MXI3_I558_MN0 (Y_62 I3_hm62 XI3_I558_n1 VSS) gpdk090_nmos1v w=0.24u l=0.1u ad=0.0816p as=0.0528p pd=1.16u ps=0.68u
    I_MXI3_I505_MN1 (XI3_I505_n1 MULP_45 VSS VSS) gpdk090_nmos1v w=0.24u l=0.1u ad=0.0528p as=0.0816p pd=0.68u ps=1.16u
    I_MXI3_I505_MN0 (I3_hm45 I3_SEL_MUL_b3_7 XI3_I505_n1 VSS) gpdk090_nmos1v w=0.24u l=0.1u ad=0.0816p as=0.0528p pd=1.16u ps=0.68u
    I_MXI3_I556_MN1 (XI3_I556_n1 MULP_62 VSS VSS) gpdk090_nmos1v w=0.24u l=0.1u ad=0.0528p as=0.0816p pd=0.68u ps=1.16u
    I_MXI3_I556_MN0 (I3_hm62 I3_SEL_MUL_b3_10 XI3_I556_n1 VSS) gpdk090_nmos1v w=0.24u l=0.1u ad=0.0816p as=0.0528p pd=1.16u ps=0.68u
    I_MXI3_I561_MN1 (XI3_I561_n1 I3_hd63 VSS VSS) gpdk090_nmos1v w=0.24u l=0.1u ad=0.0528p as=0.0816p pd=0.68u ps=1.16u
    I_MXI3_I561_MN0 (Y_63 I3_hm63 XI3_I561_n1 VSS) gpdk090_nmos1v w=0.24u l=0.1u ad=0.0816p as=0.0528p pd=1.16u ps=0.68u
    I_MXI3_I559_MN1 (XI3_I559_n1 MULP_63 VSS VSS) gpdk090_nmos1v w=0.24u l=0.1u ad=0.0528p as=0.0816p pd=0.68u ps=1.16u
    I_MXI3_I559_MN0 (I3_hm63 I3_SEL_MUL_b3_10 XI3_I559_n1 VSS) gpdk090_nmos1v w=0.24u l=0.1u ad=0.0816p as=0.0528p pd=1.16u ps=0.68u
    I_MXI3_I496_MN1 (XI3_I496_n1 MULP_42 VSS VSS) gpdk090_nmos1v w=0.24u l=0.1u ad=0.0528p as=0.0816p pd=0.68u ps=1.16u
    I_MXI3_I496_MN0 (I3_hm42 I3_SEL_MUL_b3_7 XI3_I496_n1 VSS) gpdk090_nmos1v w=0.24u l=0.1u ad=0.0816p as=0.0528p pd=1.16u ps=0.68u
    I_MXI3_I560_MN1 (XI3_I560_n1 DIVR_31 VSS VSS) gpdk090_nmos1v w=0.24u l=0.1u ad=0.0528p as=0.0816p pd=0.68u ps=1.16u
    I_MXI3_I560_MN0 (I3_hd63 I3_SEL_DIV_b3_10 XI3_I560_n1 VSS) gpdk090_nmos1v w=0.24u l=0.1u ad=0.0816p as=0.0528p pd=1.16u ps=0.68u
    I_MXI3_I555_MN1 (XI3_I555_n1 I3_hd61 VSS VSS) gpdk090_nmos1v w=0.24u l=0.1u ad=0.0528p as=0.0816p pd=0.68u ps=1.16u
    I_MXI3_I555_MN0 (Y_61 I3_hm61 XI3_I555_n1 VSS) gpdk090_nmos1v w=0.24u l=0.1u ad=0.0816p as=0.0528p pd=1.16u ps=0.68u
    I_MXI3_I554_MN1 (XI3_I554_n1 DIVR_29 VSS VSS) gpdk090_nmos1v w=0.24u l=0.1u ad=0.0528p as=0.0816p pd=0.68u ps=1.16u
    I_MXI3_I554_MN0 (I3_hd61 I3_SEL_DIV_b3_10 XI3_I554_n1 VSS) gpdk090_nmos1v w=0.24u l=0.1u ad=0.0816p as=0.0528p pd=1.16u ps=0.68u
    I_MXI3_I553_MN1 (XI3_I553_n1 MULP_61 VSS VSS) gpdk090_nmos1v w=0.24u l=0.1u ad=0.0528p as=0.0816p pd=0.68u ps=1.16u
    I_MXI3_I553_MN0 (I3_hm61 I3_SEL_MUL_b3_10 XI3_I553_n1 VSS) gpdk090_nmos1v w=0.24u l=0.1u ad=0.0816p as=0.0528p pd=1.16u ps=0.68u
    I_MXI3_I179_MN1 (XI3_I179_n1 OR_8 VSS VSS) gpdk090_nmos1v w=0.24u l=0.1u ad=0.0528p as=0.0816p pd=0.68u ps=1.16u
    I_MXI3_I179_MN0 (I3_n8_1 I3_SEL_OR_b3_1 XI3_I179_n1 VSS) gpdk090_nmos1v w=0.24u l=0.1u ad=0.0816p as=0.0528p pd=1.16u ps=0.68u
    I_MXI2_I48_MN1 (XI2_I48_n1 B_8 VSS VSS) gpdk090_nmos1v w=0.24u l=0.1u ad=0.0528p as=0.0816p pd=0.68u ps=1.16u
    I_MXI2_I48_MN0 (I2_nand8 A_8 XI2_I48_n1 VSS) gpdk090_nmos1v w=0.24u l=0.1u ad=0.0816p as=0.0528p pd=1.16u ps=0.68u
    I_MXI3_I182_MN1 (XI3_I182_n1 MULP_8 VSS VSS) gpdk090_nmos1v w=0.24u l=0.1u ad=0.0528p as=0.0816p pd=0.68u ps=1.16u
    I_MXI3_I182_MN0 (I3_n8_4 I3_SEL_MUL_b3_1 XI3_I182_n1 VSS) gpdk090_nmos1v w=0.24u l=0.1u ad=0.0816p as=0.0528p pd=1.16u ps=0.68u
    I_MXI3_I183_MN1 (XI3_I183_n1 DIVQ_8 VSS VSS) gpdk090_nmos1v w=0.24u l=0.1u ad=0.0528p as=0.0816p pd=0.68u ps=1.16u
    I_MXI3_I183_MN0 (I3_n8_5 I3_SEL_DIV_b3_1 XI3_I183_n1 VSS) gpdk090_nmos1v w=0.24u l=0.1u ad=0.0816p as=0.0528p pd=1.16u ps=0.68u
    I_MXI3_I186_MN1 (XI3_I186_n1 I3_n8_5 VSS VSS) gpdk090_nmos1v w=0.24u l=0.1u ad=0.0528p as=0.0816p pd=0.68u ps=1.16u
    I_MXI3_I186_MN0 (I3_o8_2 I3_n8_4 XI3_I186_n1 VSS) gpdk090_nmos1v w=0.24u l=0.1u ad=0.0816p as=0.0528p pd=1.16u ps=0.68u
    I_MXI3_I198_MN1 (XI3_I198_n1 I3_n9_5 VSS VSS) gpdk090_nmos1v w=0.24u l=0.1u ad=0.0528p as=0.0816p pd=0.68u ps=1.16u
    I_MXI3_I198_MN0 (I3_o9_2 I3_n9_4 XI3_I198_n1 VSS) gpdk090_nmos1v w=0.24u l=0.1u ad=0.0816p as=0.0528p pd=1.16u ps=0.68u
    I_MXI3_I159_MN1 (XI3_I159_n1 DIVQ_6 VSS VSS) gpdk090_nmos1v w=0.24u l=0.1u ad=0.0528p as=0.0816p pd=0.68u ps=1.16u
    I_MXI3_I159_MN0 (I3_n6_5 I3_SEL_DIV_b3_1 XI3_I159_n1 VSS) gpdk090_nmos1v w=0.24u l=0.1u ad=0.0816p as=0.0528p pd=1.16u ps=0.68u
    I_MXI3_I194_MN1 (XI3_I194_n1 MULP_9 VSS VSS) gpdk090_nmos1v w=0.24u l=0.1u ad=0.0528p as=0.0816p pd=0.68u ps=1.16u
    I_MXI3_I194_MN0 (I3_n9_4 I3_SEL_MUL_b3_1 XI3_I194_n1 VSS) gpdk090_nmos1v w=0.24u l=0.1u ad=0.0816p as=0.0528p pd=1.16u ps=0.68u
    I_MXI3_I170_MN1 (XI3_I170_n1 MULP_7 VSS VSS) gpdk090_nmos1v w=0.24u l=0.1u ad=0.0528p as=0.0816p pd=0.68u ps=1.16u
    I_MXI3_I170_MN0 (I3_n7_4 I3_SEL_MUL_b3_1 XI3_I170_n1 VSS) gpdk090_nmos1v w=0.24u l=0.1u ad=0.0816p as=0.0528p pd=1.16u ps=0.68u
    I_MXI3_I162_MN1 (XI3_I162_n1 I3_n6_5 VSS VSS) gpdk090_nmos1v w=0.24u l=0.1u ad=0.0528p as=0.0816p pd=0.68u ps=1.16u
    I_MXI3_I162_MN0 (I3_o6_2 I3_n6_4 XI3_I162_n1 VSS) gpdk090_nmos1v w=0.24u l=0.1u ad=0.0816p as=0.0528p pd=1.16u ps=0.68u
    I_MXI3_I174_MN1 (XI3_I174_n1 I3_n7_5 VSS VSS) gpdk090_nmos1v w=0.24u l=0.1u ad=0.0528p as=0.0816p pd=0.68u ps=1.16u
    I_MXI3_I174_MN0 (I3_o7_2 I3_n7_4 XI3_I174_n1 VSS) gpdk090_nmos1v w=0.24u l=0.1u ad=0.0816p as=0.0528p pd=1.16u ps=0.68u
    I_MXI2_I54_MN1 (XI2_I54_n1 B_9 VSS VSS) gpdk090_nmos1v w=0.24u l=0.1u ad=0.0528p as=0.0816p pd=0.68u ps=1.16u
    I_MXI2_I54_MN0 (I2_nand9 A_9 XI2_I54_n1 VSS) gpdk090_nmos1v w=0.24u l=0.1u ad=0.0816p as=0.0528p pd=1.16u ps=0.68u
    I_MXI3_I196_MN1 (XI3_I196_n1 I3_n9_1 VSS VSS) gpdk090_nmos1v w=0.24u l=0.1u ad=0.0528p as=0.0816p pd=0.68u ps=1.16u
    I_MXI3_I196_MN0 (I3_o9_0 I3_n9_0 XI3_I196_n1 VSS) gpdk090_nmos1v w=0.24u l=0.1u ad=0.0816p as=0.0528p pd=1.16u ps=0.68u
    I_MXI3_I191_MN1 (XI3_I191_n1 OR_9 VSS VSS) gpdk090_nmos1v w=0.24u l=0.1u ad=0.0528p as=0.0816p pd=0.68u ps=1.16u
    I_MXI3_I191_MN0 (I3_n9_1 I3_SEL_OR_b3_1 XI3_I191_n1 VSS) gpdk090_nmos1v w=0.24u l=0.1u ad=0.0816p as=0.0528p pd=1.16u ps=0.68u
    I_MXI3_I165_MN1 (XI3_I165_n1 I3_q6_2 VSS VSS) gpdk090_nmos1v w=0.24u l=0.1u ad=0.0528p as=0.0816p pd=0.68u ps=1.16u
    I_MXI3_I165_MN0 (Y_6 I3_q6_1 XI3_I165_n1 VSS) gpdk090_nmos1v w=0.24u l=0.1u ad=0.0816p as=0.0528p pd=1.16u ps=0.68u
    I_MXI3_I161_MN1 (XI3_I161_n1 I3_n6_3 VSS VSS) gpdk090_nmos1v w=0.24u l=0.1u ad=0.0528p as=0.0816p pd=0.68u ps=1.16u
    I_MXI3_I161_MN0 (I3_o6_1 I3_n6_2 XI3_I161_n1 VSS) gpdk090_nmos1v w=0.24u l=0.1u ad=0.0816p as=0.0528p pd=1.16u ps=0.68u
    I_MXI3_I160_MN1 (XI3_I160_n1 I3_n6_1 VSS VSS) gpdk090_nmos1v w=0.24u l=0.1u ad=0.0528p as=0.0816p pd=0.68u ps=1.16u
    I_MXI3_I160_MN0 (I3_o6_0 I3_n6_0 XI3_I160_n1 VSS) gpdk090_nmos1v w=0.24u l=0.1u ad=0.0816p as=0.0528p pd=1.16u ps=0.68u
    I_MXI3_I155_MN1 (XI3_I155_n1 OR_6 VSS VSS) gpdk090_nmos1v w=0.24u l=0.1u ad=0.0528p as=0.0816p pd=0.68u ps=1.16u
    I_MXI3_I155_MN0 (I3_n6_1 I3_SEL_OR_b3_1 XI3_I155_n1 VSS) gpdk090_nmos1v w=0.24u l=0.1u ad=0.0816p as=0.0528p pd=1.16u ps=0.68u
    I_MXI2_I36_MN1 (XI2_I36_n1 B_6 VSS VSS) gpdk090_nmos1v w=0.24u l=0.1u ad=0.0528p as=0.0816p pd=0.68u ps=1.16u
    I_MXI2_I36_MN0 (I2_nand6 A_6 XI2_I36_n1 VSS) gpdk090_nmos1v w=0.24u l=0.1u ad=0.0816p as=0.0528p pd=1.16u ps=0.68u
    I_MXI3_I84_MN1 (XI3_I84_n1 XOR_0 VSS VSS) gpdk090_nmos1v w=0.24u l=0.1u ad=0.0528p as=0.0816p pd=0.68u ps=1.16u
    I_MXI3_I84_MN0 (I3_n0_2 I3_SEL_XOR_b3_0 XI3_I84_n1 VSS) gpdk090_nmos1v w=0.24u l=0.1u ad=0.0816p as=0.0528p pd=1.16u ps=0.68u
    I_MXI3_I85_MN1 (XI3_I85_n1 NOT_0 VSS VSS) gpdk090_nmos1v w=0.24u l=0.1u ad=0.0528p as=0.0816p pd=0.68u ps=1.16u
    I_MXI3_I85_MN0 (I3_n0_3 I3_SEL_NOT_b3_0 XI3_I85_n1 VSS) gpdk090_nmos1v w=0.24u l=0.1u ad=0.0816p as=0.0528p pd=1.16u ps=0.68u
    I_MXI3_I82_MN1 (XI3_I82_n1 AND_0 VSS VSS) gpdk090_nmos1v w=0.24u l=0.1u ad=0.0528p as=0.0816p pd=0.68u ps=1.16u
    I_MXI3_I82_MN0 (I3_n0_0 I3_SEL_AND_b3_0 XI3_I82_n1 VSS) gpdk090_nmos1v w=0.24u l=0.1u ad=0.0816p as=0.0528p pd=1.16u ps=0.68u
    I_MXI3_I89_MN1 (XI3_I89_n1 I3_n0_3 VSS VSS) gpdk090_nmos1v w=0.24u l=0.1u ad=0.0528p as=0.0816p pd=0.68u ps=1.16u
    I_MXI3_I89_MN0 (I3_o0_1 I3_n0_2 XI3_I89_n1 VSS) gpdk090_nmos1v w=0.24u l=0.1u ad=0.0816p as=0.0528p pd=1.16u ps=0.68u
    I_MXI3_I88_MN1 (XI3_I88_n1 I3_n0_1 VSS VSS) gpdk090_nmos1v w=0.24u l=0.1u ad=0.0528p as=0.0816p pd=0.68u ps=1.16u
    I_MXI3_I88_MN0 (I3_o0_0 I3_n0_0 XI3_I88_n1 VSS) gpdk090_nmos1v w=0.24u l=0.1u ad=0.0816p as=0.0528p pd=1.16u ps=0.68u
    I_MXI4_I32_MN1 (XI4_I32_n1 I4_z0_1 VSS VSS) gpdk090_nmos1v w=0.24u l=0.1u ad=0.0528p as=0.0816p pd=0.68u ps=1.16u
    I_MXI4_I32_MN0 (I4_z1_0 I4_z0_0 XI4_I32_n1 VSS) gpdk090_nmos1v w=0.24u l=0.1u ad=0.0816p as=0.0528p pd=1.16u ps=0.68u
    I_MXI3_I94_MN1 (XI3_I94_n1 AND_1 VSS VSS) gpdk090_nmos1v w=0.24u l=0.1u ad=0.0528p as=0.0816p pd=0.68u ps=1.16u
    I_MXI3_I94_MN0 (I3_n1_0 I3_SEL_AND_b3_0 XI3_I94_n1 VSS) gpdk090_nmos1v w=0.24u l=0.1u ad=0.0816p as=0.0528p pd=1.16u ps=0.68u
    I_MXI3_I105_MN1 (XI3_I105_n1 I3_q1_2 VSS VSS) gpdk090_nmos1v w=0.24u l=0.1u ad=0.0528p as=0.0816p pd=0.68u ps=1.16u
    I_MXI3_I105_MN0 (Y_1 I3_q1_1 XI3_I105_n1 VSS) gpdk090_nmos1v w=0.24u l=0.1u ad=0.0816p as=0.0528p pd=1.16u ps=0.68u
    I_MXI3_I100_MN1 (XI3_I100_n1 I3_n1_1 VSS VSS) gpdk090_nmos1v w=0.24u l=0.1u ad=0.0528p as=0.0816p pd=0.68u ps=1.16u
    I_MXI3_I100_MN0 (I3_o1_0 I3_n1_0 XI3_I100_n1 VSS) gpdk090_nmos1v w=0.24u l=0.1u ad=0.0816p as=0.0528p pd=1.16u ps=0.68u
    I_MXI3_I95_MN1 (XI3_I95_n1 OR_1 VSS VSS) gpdk090_nmos1v w=0.24u l=0.1u ad=0.0528p as=0.0816p pd=0.68u ps=1.16u
    I_MXI3_I95_MN0 (I3_n1_1 I3_SEL_OR_b3_0 XI3_I95_n1 VSS) gpdk090_nmos1v w=0.24u l=0.1u ad=0.0816p as=0.0528p pd=1.16u ps=0.68u
    I_MXI3_I132_MN1 (XI3_I132_n1 XOR_4 VSS VSS) gpdk090_nmos1v w=0.24u l=0.1u ad=0.0528p as=0.0816p pd=0.68u ps=1.16u
    I_MXI3_I132_MN0 (I3_n4_2 I3_SEL_XOR_b3_0 XI3_I132_n1 VSS) gpdk090_nmos1v w=0.24u l=0.1u ad=0.0816p as=0.0528p pd=1.16u ps=0.68u
    I_MXI3_I137_MN1 (XI3_I137_n1 I3_n4_3 VSS VSS) gpdk090_nmos1v w=0.24u l=0.1u ad=0.0528p as=0.0816p pd=0.68u ps=1.16u
    I_MXI3_I137_MN0 (I3_o4_1 I3_n4_2 XI3_I137_n1 VSS) gpdk090_nmos1v w=0.24u l=0.1u ad=0.0816p as=0.0528p pd=1.16u ps=0.68u
    I_MXI3_I130_MN1 (XI3_I130_n1 AND_4 VSS VSS) gpdk090_nmos1v w=0.24u l=0.1u ad=0.0528p as=0.0816p pd=0.68u ps=1.16u
    I_MXI3_I130_MN0 (I3_n4_0 I3_SEL_AND_b3_0 XI3_I130_n1 VSS) gpdk090_nmos1v w=0.24u l=0.1u ad=0.0816p as=0.0528p pd=1.16u ps=0.68u
    I_MXI2_I24_MN1 (XI2_I24_n1 B_4 VSS VSS) gpdk090_nmos1v w=0.24u l=0.1u ad=0.0528p as=0.0816p pd=0.68u ps=1.16u
    I_MXI2_I24_MN0 (I2_nand4 A_4 XI2_I24_n1 VSS) gpdk090_nmos1v w=0.24u l=0.1u ad=0.0816p as=0.0528p pd=1.16u ps=0.68u
    I_MXI3_I530_MN1 (XI3_I530_n1 DIVR_21 VSS VSS) gpdk090_nmos1v w=0.24u l=0.1u ad=0.0528p as=0.0816p pd=0.68u ps=1.16u
    I_MXI3_I530_MN0 (I3_hd53 I3_SEL_DIV_b3_9 XI3_I530_n1 VSS) gpdk090_nmos1v w=0.24u l=0.1u ad=0.0816p as=0.0528p pd=1.16u ps=0.68u
    I_MXI3_I529_MN1 (XI3_I529_n1 MULP_53 VSS VSS) gpdk090_nmos1v w=0.24u l=0.1u ad=0.0528p as=0.0816p pd=0.68u ps=1.16u
    I_MXI3_I529_MN0 (I3_hm53 I3_SEL_MUL_b3_9 XI3_I529_n1 VSS) gpdk090_nmos1v w=0.24u l=0.1u ad=0.0816p as=0.0528p pd=1.16u ps=0.68u
    I_MXI3_I528_MN1 (XI3_I528_n1 I3_hd52 VSS VSS) gpdk090_nmos1v w=0.24u l=0.1u ad=0.0528p as=0.0816p pd=0.68u ps=1.16u
    I_MXI3_I528_MN0 (Y_52 I3_hm52 XI3_I528_n1 VSS) gpdk090_nmos1v w=0.24u l=0.1u ad=0.0816p as=0.0528p pd=1.16u ps=0.68u
    I_MXI3_I531_MN1 (XI3_I531_n1 I3_hd53 VSS VSS) gpdk090_nmos1v w=0.24u l=0.1u ad=0.0528p as=0.0816p pd=0.68u ps=1.16u
    I_MXI3_I531_MN0 (Y_53 I3_hm53 XI3_I531_n1 VSS) gpdk090_nmos1v w=0.24u l=0.1u ad=0.0816p as=0.0528p pd=1.16u ps=0.68u
    I_MXI3_I512_MN1 (XI3_I512_n1 DIVR_15 VSS VSS) gpdk090_nmos1v w=0.24u l=0.1u ad=0.0528p as=0.0816p pd=0.68u ps=1.16u
    I_MXI3_I512_MN0 (I3_hd47 I3_SEL_DIV_b3_8 XI3_I512_n1 VSS) gpdk090_nmos1v w=0.24u l=0.1u ad=0.0816p as=0.0528p pd=1.16u ps=0.68u
    I_MXI4_I45_MN1 (XI4_I45_n1 I4_z0_27 VSS VSS) gpdk090_nmos1v w=0.24u l=0.1u ad=0.0528p as=0.0816p pd=0.68u ps=1.16u
    I_MXI4_I45_MN0 (I4_z1_13 I4_z0_26 XI4_I45_n1 VSS) gpdk090_nmos1v w=0.24u l=0.1u ad=0.0816p as=0.0528p pd=1.16u ps=0.68u
    I_MXI4_I59_MN1 (XI4_I59_n1 I4_z2_7 VSS VSS) gpdk090_nmos1v w=0.24u l=0.1u ad=0.0528p as=0.0816p pd=0.68u ps=1.16u
    I_MXI4_I59_MN0 (I4_z3_3 I4_z2_6 XI4_I59_n1 VSS) gpdk090_nmos1v w=0.24u l=0.1u ad=0.0816p as=0.0528p pd=1.16u ps=0.68u
    I_MXI3_I508_MN1 (XI3_I508_n1 MULP_46 VSS VSS) gpdk090_nmos1v w=0.24u l=0.1u ad=0.0528p as=0.0816p pd=0.68u ps=1.16u
    I_MXI3_I508_MN0 (I3_hm46 I3_SEL_MUL_b3_7 XI3_I508_n1 VSS) gpdk090_nmos1v w=0.24u l=0.1u ad=0.0816p as=0.0528p pd=1.16u ps=0.68u
    I_MXI3_I509_MN1 (XI3_I509_n1 DIVR_14 VSS VSS) gpdk090_nmos1v w=0.24u l=0.1u ad=0.0528p as=0.0816p pd=0.68u ps=1.16u
    I_MXI3_I509_MN0 (I3_hd46 I3_SEL_DIV_b3_7 XI3_I509_n1 VSS) gpdk090_nmos1v w=0.24u l=0.1u ad=0.0816p as=0.0528p pd=1.16u ps=0.68u
    I_MXI3_I507_MN1 (XI3_I507_n1 I3_hd45 VSS VSS) gpdk090_nmos1v w=0.24u l=0.1u ad=0.0528p as=0.0816p pd=0.68u ps=1.16u
    I_MXI3_I507_MN0 (Y_45 I3_hm45 XI3_I507_n1 VSS) gpdk090_nmos1v w=0.24u l=0.1u ad=0.0816p as=0.0528p pd=1.16u ps=0.68u
    I_MXI3_I506_MN1 (XI3_I506_n1 DIVR_13 VSS VSS) gpdk090_nmos1v w=0.24u l=0.1u ad=0.0528p as=0.0816p pd=0.68u ps=1.16u
    I_MXI3_I506_MN0 (I3_hd45 I3_SEL_DIV_b3_7 XI3_I506_n1 VSS) gpdk090_nmos1v w=0.24u l=0.1u ad=0.0816p as=0.0528p pd=1.16u ps=0.68u
    I_MXI3_I504_MN1 (XI3_I504_n1 I3_hd44 VSS VSS) gpdk090_nmos1v w=0.24u l=0.1u ad=0.0528p as=0.0816p pd=0.68u ps=1.16u
    I_MXI3_I504_MN0 (Y_44 I3_hm44 XI3_I504_n1 VSS) gpdk090_nmos1v w=0.24u l=0.1u ad=0.0816p as=0.0528p pd=1.16u ps=0.68u
    I_MXI3_I498_MN1 (XI3_I498_n1 I3_hd42 VSS VSS) gpdk090_nmos1v w=0.24u l=0.1u ad=0.0528p as=0.0816p pd=0.68u ps=1.16u
    I_MXI3_I498_MN0 (Y_42 I3_hm42 XI3_I498_n1 VSS) gpdk090_nmos1v w=0.24u l=0.1u ad=0.0816p as=0.0528p pd=1.16u ps=0.68u
    I_MXI3_I503_MN1 (XI3_I503_n1 DIVR_12 VSS VSS) gpdk090_nmos1v w=0.24u l=0.1u ad=0.0528p as=0.0816p pd=0.68u ps=1.16u
    I_MXI3_I503_MN0 (I3_hd44 I3_SEL_DIV_b3_7 XI3_I503_n1 VSS) gpdk090_nmos1v w=0.24u l=0.1u ad=0.0816p as=0.0528p pd=1.16u ps=0.68u
    I_MXI3_I497_MN1 (XI3_I497_n1 DIVR_10 VSS VSS) gpdk090_nmos1v w=0.24u l=0.1u ad=0.0528p as=0.0816p pd=0.68u ps=1.16u
    I_MXI3_I497_MN0 (I3_hd42 I3_SEL_DIV_b3_7 XI3_I497_n1 VSS) gpdk090_nmos1v w=0.24u l=0.1u ad=0.0816p as=0.0528p pd=1.16u ps=0.68u
    I_MXI4_I62_MN1 (XI4_I62_n1 I4_z4_1 VSS VSS) gpdk090_nmos1v w=0.24u l=0.1u ad=0.0528p as=0.0816p pd=0.68u ps=1.16u
    I_MXI4_I62_MN0 (I4_z5_0 I4_z4_0 XI4_I62_n1 VSS) gpdk090_nmos1v w=0.24u l=0.1u ad=0.0816p as=0.0528p pd=1.16u ps=0.68u
    I_MXI3_I502_MN1 (XI3_I502_n1 MULP_44 VSS VSS) gpdk090_nmos1v w=0.24u l=0.1u ad=0.0528p as=0.0816p pd=0.68u ps=1.16u
    I_MXI3_I502_MN0 (I3_hm44 I3_SEL_MUL_b3_7 XI3_I502_n1 VSS) gpdk090_nmos1v w=0.24u l=0.1u ad=0.0816p as=0.0528p pd=1.16u ps=0.68u
    I_MXI3_I180_MN1 (XI3_I180_n1 XOR_8 VSS VSS) gpdk090_nmos1v w=0.24u l=0.1u ad=0.0528p as=0.0816p pd=0.68u ps=1.16u
    I_MXI3_I180_MN0 (I3_n8_2 I3_SEL_XOR_b3_1 XI3_I180_n1 VSS) gpdk090_nmos1v w=0.24u l=0.1u ad=0.0816p as=0.0528p pd=1.16u ps=0.68u
    I_MXI3_I184_MN1 (XI3_I184_n1 I3_n8_1 VSS VSS) gpdk090_nmos1v w=0.24u l=0.1u ad=0.0528p as=0.0816p pd=0.68u ps=1.16u
    I_MXI3_I184_MN0 (I3_o8_0 I3_n8_0 XI3_I184_n1 VSS) gpdk090_nmos1v w=0.24u l=0.1u ad=0.0816p as=0.0528p pd=1.16u ps=0.68u
    I_MXI3_I185_MN1 (XI3_I185_n1 I3_n8_3 VSS VSS) gpdk090_nmos1v w=0.24u l=0.1u ad=0.0528p as=0.0816p pd=0.68u ps=1.16u
    I_MXI3_I185_MN0 (I3_o8_1 I3_n8_2 XI3_I185_n1 VSS) gpdk090_nmos1v w=0.24u l=0.1u ad=0.0816p as=0.0528p pd=1.16u ps=0.68u
    I_MXI3_I181_MN1 (XI3_I181_n1 NOT_8 VSS VSS) gpdk090_nmos1v w=0.24u l=0.1u ad=0.0528p as=0.0816p pd=0.68u ps=1.16u
    I_MXI3_I181_MN0 (I3_n8_3 I3_SEL_NOT_b3_1 XI3_I181_n1 VSS) gpdk090_nmos1v w=0.24u l=0.1u ad=0.0816p as=0.0528p pd=1.16u ps=0.68u
    I_MXI3_I178_MN1 (XI3_I178_n1 AND_8 VSS VSS) gpdk090_nmos1v w=0.24u l=0.1u ad=0.0528p as=0.0816p pd=0.68u ps=1.16u
    I_MXI3_I178_MN0 (I3_n8_0 I3_SEL_AND_b3_1 XI3_I178_n1 VSS) gpdk090_nmos1v w=0.24u l=0.1u ad=0.0816p as=0.0528p pd=1.16u ps=0.68u
    I_MXI3_I189_MN1 (XI3_I189_n1 I3_q8_2 VSS VSS) gpdk090_nmos1v w=0.24u l=0.1u ad=0.0528p as=0.0816p pd=0.68u ps=1.16u
    I_MXI3_I189_MN0 (Y_8 I3_q8_1 XI3_I189_n1 VSS) gpdk090_nmos1v w=0.24u l=0.1u ad=0.0816p as=0.0528p pd=1.16u ps=0.68u
    I_MXI3_I201_MN1 (XI3_I201_n1 I3_q9_2 VSS VSS) gpdk090_nmos1v w=0.24u l=0.1u ad=0.0528p as=0.0816p pd=0.68u ps=1.16u
    I_MXI3_I201_MN0 (Y_9 I3_q9_1 XI3_I201_n1 VSS) gpdk090_nmos1v w=0.24u l=0.1u ad=0.0816p as=0.0528p pd=1.16u ps=0.68u
    I_MXI3_I197_MN1 (XI3_I197_n1 I3_n9_3 VSS VSS) gpdk090_nmos1v w=0.24u l=0.1u ad=0.0528p as=0.0816p pd=0.68u ps=1.16u
    I_MXI3_I197_MN0 (I3_o9_1 I3_n9_2 XI3_I197_n1 VSS) gpdk090_nmos1v w=0.24u l=0.1u ad=0.0816p as=0.0528p pd=1.16u ps=0.68u
    I_MXI3_I219_MN1 (XI3_I219_n1 DIVQ_11 VSS VSS) gpdk090_nmos1v w=0.24u l=0.1u ad=0.0528p as=0.0816p pd=0.68u ps=1.16u
    I_MXI3_I219_MN0 (I3_n11_5 I3_SEL_DIV_b3_1 XI3_I219_n1 VSS) gpdk090_nmos1v w=0.24u l=0.1u ad=0.0816p as=0.0528p pd=1.16u ps=0.68u
    I_MXI3_I192_MN1 (XI3_I192_n1 XOR_9 VSS VSS) gpdk090_nmos1v w=0.24u l=0.1u ad=0.0528p as=0.0816p pd=0.68u ps=1.16u
    I_MXI3_I192_MN0 (I3_n9_2 I3_SEL_XOR_b3_1 XI3_I192_n1 VSS) gpdk090_nmos1v w=0.24u l=0.1u ad=0.0816p as=0.0528p pd=1.16u ps=0.68u
    I_MXI3_I177_MN1 (XI3_I177_n1 I3_q7_2 VSS VSS) gpdk090_nmos1v w=0.24u l=0.1u ad=0.0528p as=0.0816p pd=0.68u ps=1.16u
    I_MXI3_I177_MN0 (Y_7 I3_q7_1 XI3_I177_n1 VSS) gpdk090_nmos1v w=0.24u l=0.1u ad=0.0816p as=0.0528p pd=1.16u ps=0.68u
    I_MXI3_I156_MN1 (XI3_I156_n1 XOR_6 VSS VSS) gpdk090_nmos1v w=0.24u l=0.1u ad=0.0528p as=0.0816p pd=0.68u ps=1.16u
    I_MXI3_I156_MN0 (I3_n6_2 I3_SEL_XOR_b3_1 XI3_I156_n1 VSS) gpdk090_nmos1v w=0.24u l=0.1u ad=0.0816p as=0.0528p pd=1.16u ps=0.68u
    I_MXI3_I166_MN1 (XI3_I166_n1 AND_7 VSS VSS) gpdk090_nmos1v w=0.24u l=0.1u ad=0.0528p as=0.0816p pd=0.68u ps=1.16u
    I_MXI3_I166_MN0 (I3_n7_0 I3_SEL_AND_b3_1 XI3_I166_n1 VSS) gpdk090_nmos1v w=0.24u l=0.1u ad=0.0816p as=0.0528p pd=1.16u ps=0.68u
    I_MXI3_I157_MN1 (XI3_I157_n1 NOT_6 VSS VSS) gpdk090_nmos1v w=0.24u l=0.1u ad=0.0528p as=0.0816p pd=0.68u ps=1.16u
    I_MXI3_I157_MN0 (I3_n6_3 I3_SEL_NOT_b3_1 XI3_I157_n1 VSS) gpdk090_nmos1v w=0.24u l=0.1u ad=0.0816p as=0.0528p pd=1.16u ps=0.68u
    I_MXI2_I42_MN1 (XI2_I42_n1 B_7 VSS VSS) gpdk090_nmos1v w=0.24u l=0.1u ad=0.0528p as=0.0816p pd=0.68u ps=1.16u
    I_MXI2_I42_MN0 (I2_nand7 A_7 XI2_I42_n1 VSS) gpdk090_nmos1v w=0.24u l=0.1u ad=0.0816p as=0.0528p pd=1.16u ps=0.68u
    I_MXI1_I42_I0_MN1 (XI1_I42_I0_n1 I1_bx0 VSS VSS) gpdk090_nmos1v w=0.24u l=0.1u ad=0.0528p as=0.0816p pd=0.68u ps=1.16u
    I_MXI1_I42_I0_MN0 (I1_I42_gn0 A_0 XI1_I42_I0_n1 VSS) gpdk090_nmos1v w=0.24u l=0.1u ad=0.0816p as=0.0528p pd=1.16u ps=0.68u
    I_MXI3_I145_MN1 (XI3_I145_n1 NOT_5 VSS VSS) gpdk090_nmos1v w=0.24u l=0.1u ad=0.0528p as=0.0816p pd=0.68u ps=1.16u
    I_MXI3_I145_MN0 (I3_n5_3 I3_SEL_NOT_b3_0 XI3_I145_n1 VSS) gpdk090_nmos1v w=0.24u l=0.1u ad=0.0816p as=0.0528p pd=1.16u ps=0.68u
    I_MXI3_I93_MN1 (XI3_I93_n1 I3_q0_2 VSS VSS) gpdk090_nmos1v w=0.24u l=0.1u ad=0.0528p as=0.0816p pd=0.68u ps=1.16u
    I_MXI3_I93_MN0 (Y_0 I3_q0_1 XI3_I93_n1 VSS) gpdk090_nmos1v w=0.24u l=0.1u ad=0.0816p as=0.0528p pd=1.16u ps=0.68u
    I_MXI1_I42_I1_MN1 (XI1_I42_I1_n1 I1_bx1 VSS VSS) gpdk090_nmos1v w=0.24u l=0.1u ad=0.0528p as=0.0816p pd=0.68u ps=1.16u
    I_MXI1_I42_I1_MN0 (I1_I42_gn1 A_1 XI1_I42_I1_n1 VSS) gpdk090_nmos1v w=0.24u l=0.1u ad=0.0816p as=0.0528p pd=1.16u ps=0.68u
    I_MXI3_I101_MN1 (XI3_I101_n1 I3_n1_3 VSS VSS) gpdk090_nmos1v w=0.24u l=0.1u ad=0.0528p as=0.0816p pd=0.68u ps=1.16u
    I_MXI3_I101_MN0 (I3_o1_1 I3_n1_2 XI3_I101_n1 VSS) gpdk090_nmos1v w=0.24u l=0.1u ad=0.0816p as=0.0528p pd=1.16u ps=0.68u
    I_MXI3_I97_MN1 (XI3_I97_n1 NOT_1 VSS VSS) gpdk090_nmos1v w=0.24u l=0.1u ad=0.0528p as=0.0816p pd=0.68u ps=1.16u
    I_MXI3_I97_MN0 (I3_n1_3 I3_SEL_NOT_b3_0 XI3_I97_n1 VSS) gpdk090_nmos1v w=0.24u l=0.1u ad=0.0816p as=0.0528p pd=1.16u ps=0.68u
    I_MXI3_I96_MN1 (XI3_I96_n1 XOR_1 VSS VSS) gpdk090_nmos1v w=0.24u l=0.1u ad=0.0528p as=0.0816p pd=0.68u ps=1.16u
    I_MXI3_I96_MN0 (I3_n1_2 I3_SEL_XOR_b3_0 XI3_I96_n1 VSS) gpdk090_nmos1v w=0.24u l=0.1u ad=0.0816p as=0.0528p pd=1.16u ps=0.68u
    I_MXI3_I133_MN1 (XI3_I133_n1 NOT_4 VSS VSS) gpdk090_nmos1v w=0.24u l=0.1u ad=0.0528p as=0.0816p pd=0.68u ps=1.16u
    I_MXI3_I133_MN0 (I3_n4_3 I3_SEL_NOT_b3_0 XI3_I133_n1 VSS) gpdk090_nmos1v w=0.24u l=0.1u ad=0.0816p as=0.0528p pd=1.16u ps=0.68u
    I_MXI3_I107_MN1 (XI3_I107_n1 OR_2 VSS VSS) gpdk090_nmos1v w=0.24u l=0.1u ad=0.0528p as=0.0816p pd=0.68u ps=1.16u
    I_MXI3_I107_MN0 (I3_n2_1 I3_SEL_OR_b3_0 XI3_I107_n1 VSS) gpdk090_nmos1v w=0.24u l=0.1u ad=0.0816p as=0.0528p pd=1.16u ps=0.68u
    I_MXI3_I112_MN1 (XI3_I112_n1 I3_n2_1 VSS VSS) gpdk090_nmos1v w=0.24u l=0.1u ad=0.0528p as=0.0816p pd=0.68u ps=1.16u
    I_MXI3_I112_MN0 (I3_o2_0 I3_n2_0 XI3_I112_n1 VSS) gpdk090_nmos1v w=0.24u l=0.1u ad=0.0816p as=0.0528p pd=1.16u ps=0.68u
    I_MXI2_I12_MN1 (XI2_I12_n1 B_2 VSS VSS) gpdk090_nmos1v w=0.24u l=0.1u ad=0.0528p as=0.0816p pd=0.68u ps=1.16u
    I_MXI2_I12_MN0 (I2_nand2 A_2 XI2_I12_n1 VSS) gpdk090_nmos1v w=0.24u l=0.1u ad=0.0816p as=0.0528p pd=1.16u ps=0.68u
    I_MXI3_I106_MN1 (XI3_I106_n1 AND_2 VSS VSS) gpdk090_nmos1v w=0.24u l=0.1u ad=0.0528p as=0.0816p pd=0.68u ps=1.16u
    I_MXI3_I106_MN0 (I3_n2_0 I3_SEL_AND_b3_0 XI3_I106_n1 VSS) gpdk090_nmos1v w=0.24u l=0.1u ad=0.0816p as=0.0528p pd=1.16u ps=0.68u
    I_MXI3_I527_MN1 (XI3_I527_n1 DIVR_20 VSS VSS) gpdk090_nmos1v w=0.24u l=0.1u ad=0.0528p as=0.0816p pd=0.68u ps=1.16u
    I_MXI3_I527_MN0 (I3_hd52 I3_SEL_DIV_b3_8 XI3_I527_n1 VSS) gpdk090_nmos1v w=0.24u l=0.1u ad=0.0816p as=0.0528p pd=1.16u ps=0.68u
    I_MXI3_I516_MN1 (XI3_I516_n1 I3_hd48 VSS VSS) gpdk090_nmos1v w=0.24u l=0.1u ad=0.0528p as=0.0816p pd=0.68u ps=1.16u
    I_MXI3_I516_MN0 (Y_48 I3_hm48 XI3_I516_n1 VSS) gpdk090_nmos1v w=0.24u l=0.1u ad=0.0816p as=0.0528p pd=1.16u ps=0.68u
    I_MXI3_I511_MN1 (XI3_I511_n1 MULP_47 VSS VSS) gpdk090_nmos1v w=0.24u l=0.1u ad=0.0528p as=0.0816p pd=0.68u ps=1.16u
    I_MXI3_I511_MN0 (I3_hm47 I3_SEL_MUL_b3_8 XI3_I511_n1 VSS) gpdk090_nmos1v w=0.24u l=0.1u ad=0.0816p as=0.0528p pd=1.16u ps=0.68u
    I_MXI3_I526_MN1 (XI3_I526_n1 MULP_52 VSS VSS) gpdk090_nmos1v w=0.24u l=0.1u ad=0.0528p as=0.0816p pd=0.68u ps=1.16u
    I_MXI3_I526_MN0 (I3_hm52 I3_SEL_MUL_b3_8 XI3_I526_n1 VSS) gpdk090_nmos1v w=0.24u l=0.1u ad=0.0816p as=0.0528p pd=1.16u ps=0.68u
    I_MXI3_I520_MN1 (XI3_I520_n1 MULP_50 VSS VSS) gpdk090_nmos1v w=0.24u l=0.1u ad=0.0528p as=0.0816p pd=0.68u ps=1.16u
    I_MXI3_I520_MN0 (I3_hm50 I3_SEL_MUL_b3_8 XI3_I520_n1 VSS) gpdk090_nmos1v w=0.24u l=0.1u ad=0.0816p as=0.0528p pd=1.16u ps=0.68u
    I_MXI3_I513_MN1 (XI3_I513_n1 I3_hd47 VSS VSS) gpdk090_nmos1v w=0.24u l=0.1u ad=0.0528p as=0.0816p pd=0.68u ps=1.16u
    I_MXI3_I513_MN0 (Y_47 I3_hm47 XI3_I513_n1 VSS) gpdk090_nmos1v w=0.24u l=0.1u ad=0.0816p as=0.0528p pd=1.16u ps=0.68u
    I_MXI4_I44_MN1 (XI4_I44_n1 I4_z0_25 VSS VSS) gpdk090_nmos1v w=0.24u l=0.1u ad=0.0528p as=0.0816p pd=0.68u ps=1.16u
    I_MXI4_I44_MN0 (I4_z1_12 I4_z0_24 XI4_I44_n1 VSS) gpdk090_nmos1v w=0.24u l=0.1u ad=0.0816p as=0.0528p pd=1.16u ps=0.68u
    I_MXI3_I522_MN1 (XI3_I522_n1 I3_hd50 VSS VSS) gpdk090_nmos1v w=0.24u l=0.1u ad=0.0528p as=0.0816p pd=0.68u ps=1.16u
    I_MXI3_I522_MN0 (Y_50 I3_hm50 XI3_I522_n1 VSS) gpdk090_nmos1v w=0.24u l=0.1u ad=0.0816p as=0.0528p pd=1.16u ps=0.68u
    I_MXI4_I58_MN1 (XI4_I58_n1 I4_z2_5 VSS VSS) gpdk090_nmos1v w=0.24u l=0.1u ad=0.0528p as=0.0816p pd=0.68u ps=1.16u
    I_MXI4_I58_MN0 (I4_z3_2 I4_z2_4 XI4_I58_n1 VSS) gpdk090_nmos1v w=0.24u l=0.1u ad=0.0816p as=0.0528p pd=1.16u ps=0.68u
    I_MXI3_I510_MN1 (XI3_I510_n1 I3_hd46 VSS VSS) gpdk090_nmos1v w=0.24u l=0.1u ad=0.0528p as=0.0816p pd=0.68u ps=1.16u
    I_MXI3_I510_MN0 (Y_46 I3_hm46 XI3_I510_n1 VSS) gpdk090_nmos1v w=0.24u l=0.1u ad=0.0816p as=0.0528p pd=1.16u ps=0.68u
    I_MXI4_I43_MN1 (XI4_I43_n1 I4_z0_23 VSS VSS) gpdk090_nmos1v w=0.24u l=0.1u ad=0.0528p as=0.0816p pd=0.68u ps=1.16u
    I_MXI4_I43_MN0 (I4_z1_11 I4_z0_22 XI4_I43_n1 VSS) gpdk090_nmos1v w=0.24u l=0.1u ad=0.0816p as=0.0528p pd=1.16u ps=0.68u
    I_MXI4_I42_MN1 (XI4_I42_n1 I4_z0_21 VSS VSS) gpdk090_nmos1v w=0.24u l=0.1u ad=0.0528p as=0.0816p pd=0.68u ps=1.16u
    I_MXI4_I42_MN0 (I4_z1_10 I4_z0_20 XI4_I42_n1 VSS) gpdk090_nmos1v w=0.24u l=0.1u ad=0.0816p as=0.0528p pd=1.16u ps=0.68u
    I_MXI3_I501_MN1 (XI3_I501_n1 I3_hd43 VSS VSS) gpdk090_nmos1v w=0.24u l=0.1u ad=0.0528p as=0.0816p pd=0.68u ps=1.16u
    I_MXI3_I501_MN0 (Y_43 I3_hm43 XI3_I501_n1 VSS) gpdk090_nmos1v w=0.24u l=0.1u ad=0.0816p as=0.0528p pd=1.16u ps=0.68u
    I_MXI3_I499_MN1 (XI3_I499_n1 MULP_43 VSS VSS) gpdk090_nmos1v w=0.24u l=0.1u ad=0.0528p as=0.0816p pd=0.68u ps=1.16u
    I_MXI3_I499_MN0 (I3_hm43 I3_SEL_MUL_b3_7 XI3_I499_n1 VSS) gpdk090_nmos1v w=0.24u l=0.1u ad=0.0816p as=0.0528p pd=1.16u ps=0.68u
    I_MXI3_I500_MN1 (XI3_I500_n1 DIVR_11 VSS VSS) gpdk090_nmos1v w=0.24u l=0.1u ad=0.0528p as=0.0816p pd=0.68u ps=1.16u
    I_MXI3_I500_MN0 (I3_hd43 I3_SEL_DIV_b3_7 XI3_I500_n1 VSS) gpdk090_nmos1v w=0.24u l=0.1u ad=0.0816p as=0.0528p pd=1.16u ps=0.68u
    I_MXI3_I204_MN1 (XI3_I204_n1 XOR_10 VSS VSS) gpdk090_nmos1v w=0.24u l=0.1u ad=0.0528p as=0.0816p pd=0.68u ps=1.16u
    I_MXI3_I204_MN0 (I3_n10_2 I3_SEL_XOR_b3_1 XI3_I204_n1 VSS) gpdk090_nmos1v w=0.24u l=0.1u ad=0.0816p as=0.0528p pd=1.16u ps=0.68u
    I_MXI3_I209_MN1 (XI3_I209_n1 I3_n10_3 VSS VSS) gpdk090_nmos1v w=0.24u l=0.1u ad=0.0528p as=0.0816p pd=0.68u ps=1.16u
    I_MXI3_I209_MN0 (I3_o10_1 I3_n10_2 XI3_I209_n1 VSS) gpdk090_nmos1v w=0.24u l=0.1u ad=0.0816p as=0.0528p pd=1.16u ps=0.68u
    I_MXI3_I205_MN1 (XI3_I205_n1 NOT_10 VSS VSS) gpdk090_nmos1v w=0.24u l=0.1u ad=0.0528p as=0.0816p pd=0.68u ps=1.16u
    I_MXI3_I205_MN0 (I3_n10_3 I3_SEL_NOT_b3_1 XI3_I205_n1 VSS) gpdk090_nmos1v w=0.24u l=0.1u ad=0.0816p as=0.0528p pd=1.16u ps=0.68u
    I_MXI3_I213_MN1 (XI3_I213_n1 I3_q10_2 VSS VSS) gpdk090_nmos1v w=0.24u l=0.1u ad=0.0528p as=0.0816p pd=0.68u ps=1.16u
    I_MXI3_I213_MN0 (Y_10 I3_q10_1 XI3_I213_n1 VSS) gpdk090_nmos1v w=0.24u l=0.1u ad=0.0816p as=0.0528p pd=1.16u ps=0.68u
    I_MXI3_I218_MN1 (XI3_I218_n1 MULP_11 VSS VSS) gpdk090_nmos1v w=0.24u l=0.1u ad=0.0528p as=0.0816p pd=0.68u ps=1.16u
    I_MXI3_I218_MN0 (I3_n11_4 I3_SEL_MUL_b3_1 XI3_I218_n1 VSS) gpdk090_nmos1v w=0.24u l=0.1u ad=0.0816p as=0.0528p pd=1.16u ps=0.68u
    I_MXI3_I222_MN1 (XI3_I222_n1 I3_n11_5 VSS VSS) gpdk090_nmos1v w=0.24u l=0.1u ad=0.0528p as=0.0816p pd=0.68u ps=1.16u
    I_MXI3_I222_MN0 (I3_o11_2 I3_n11_4 XI3_I222_n1 VSS) gpdk090_nmos1v w=0.24u l=0.1u ad=0.0816p as=0.0528p pd=1.16u ps=0.68u
    I_MXI3_I193_MN1 (XI3_I193_n1 NOT_9 VSS VSS) gpdk090_nmos1v w=0.24u l=0.1u ad=0.0528p as=0.0816p pd=0.68u ps=1.16u
    I_MXI3_I193_MN0 (I3_n9_3 I3_SEL_NOT_b3_1 XI3_I193_n1 VSS) gpdk090_nmos1v w=0.24u l=0.1u ad=0.0816p as=0.0528p pd=1.16u ps=0.68u
    I_MXI4_I34_MN1 (XI4_I34_n1 I4_z0_5 VSS VSS) gpdk090_nmos1v w=0.24u l=0.1u ad=0.0528p as=0.0816p pd=0.68u ps=1.16u
    I_MXI4_I34_MN0 (I4_z1_2 I4_z0_4 XI4_I34_n1 VSS) gpdk090_nmos1v w=0.24u l=0.1u ad=0.0816p as=0.0528p pd=1.16u ps=0.68u
    I_MXI3_I169_MN1 (XI3_I169_n1 NOT_7 VSS VSS) gpdk090_nmos1v w=0.24u l=0.1u ad=0.0528p as=0.0816p pd=0.68u ps=1.16u
    I_MXI3_I169_MN0 (I3_n7_3 I3_SEL_NOT_b3_1 XI3_I169_n1 VSS) gpdk090_nmos1v w=0.24u l=0.1u ad=0.0816p as=0.0528p pd=1.16u ps=0.68u
    I_MXI3_I173_MN1 (XI3_I173_n1 I3_n7_3 VSS VSS) gpdk090_nmos1v w=0.24u l=0.1u ad=0.0528p as=0.0816p pd=0.68u ps=1.16u
    I_MXI3_I173_MN0 (I3_o7_1 I3_n7_2 XI3_I173_n1 VSS) gpdk090_nmos1v w=0.24u l=0.1u ad=0.0816p as=0.0528p pd=1.16u ps=0.68u
    I_MXI3_I168_MN1 (XI3_I168_n1 XOR_7 VSS VSS) gpdk090_nmos1v w=0.24u l=0.1u ad=0.0528p as=0.0816p pd=0.68u ps=1.16u
    I_MXI3_I168_MN0 (I3_n7_2 I3_SEL_XOR_b3_1 XI3_I168_n1 VSS) gpdk090_nmos1v w=0.24u l=0.1u ad=0.0816p as=0.0528p pd=1.16u ps=0.68u
    I_MXI3_I172_MN1 (XI3_I172_n1 I3_n7_1 VSS VSS) gpdk090_nmos1v w=0.24u l=0.1u ad=0.0528p as=0.0816p pd=0.68u ps=1.16u
    I_MXI3_I172_MN0 (I3_o7_0 I3_n7_0 XI3_I172_n1 VSS) gpdk090_nmos1v w=0.24u l=0.1u ad=0.0816p as=0.0528p pd=1.16u ps=0.68u
    I_MXI3_I167_MN1 (XI3_I167_n1 OR_7 VSS VSS) gpdk090_nmos1v w=0.24u l=0.1u ad=0.0528p as=0.0816p pd=0.68u ps=1.16u
    I_MXI3_I167_MN0 (I3_n7_1 I3_SEL_OR_b3_1 XI3_I167_n1 VSS) gpdk090_nmos1v w=0.24u l=0.1u ad=0.0816p as=0.0528p pd=1.16u ps=0.68u
    I_MXI4_I56_MN1 (XI4_I56_n1 I4_z2_1 VSS VSS) gpdk090_nmos1v w=0.24u l=0.1u ad=0.0528p as=0.0816p pd=0.68u ps=1.16u
    I_MXI4_I56_MN0 (I4_z3_0 I4_z2_0 XI4_I56_n1 VSS) gpdk090_nmos1v w=0.24u l=0.1u ad=0.0816p as=0.0528p pd=1.16u ps=0.68u
    I_MXI3_I144_MN1 (XI3_I144_n1 XOR_5 VSS VSS) gpdk090_nmos1v w=0.24u l=0.1u ad=0.0528p as=0.0816p pd=0.68u ps=1.16u
    I_MXI3_I144_MN0 (I3_n5_2 I3_SEL_XOR_b3_0 XI3_I144_n1 VSS) gpdk090_nmos1v w=0.24u l=0.1u ad=0.0816p as=0.0528p pd=1.16u ps=0.68u
    I_MXI3_I153_MN1 (XI3_I153_n1 I3_q5_2 VSS VSS) gpdk090_nmos1v w=0.24u l=0.1u ad=0.0528p as=0.0816p pd=0.68u ps=1.16u
    I_MXI3_I153_MN0 (Y_5 I3_q5_1 XI3_I153_n1 VSS) gpdk090_nmos1v w=0.24u l=0.1u ad=0.0816p as=0.0528p pd=1.16u ps=0.68u
    I_MXI3_I149_MN1 (XI3_I149_n1 I3_n5_3 VSS VSS) gpdk090_nmos1v w=0.24u l=0.1u ad=0.0528p as=0.0816p pd=0.68u ps=1.16u
    I_MXI3_I149_MN0 (I3_o5_1 I3_n5_2 XI3_I149_n1 VSS) gpdk090_nmos1v w=0.24u l=0.1u ad=0.0816p as=0.0528p pd=1.16u ps=0.68u
    I_MXI3_I90_MN1 (XI3_I90_n1 I3_n0_5 VSS VSS) gpdk090_nmos1v w=0.24u l=0.1u ad=0.0528p as=0.0816p pd=0.68u ps=1.16u
    I_MXI3_I90_MN0 (I3_o0_2 I3_n0_4 XI3_I90_n1 VSS) gpdk090_nmos1v w=0.24u l=0.1u ad=0.0816p as=0.0528p pd=1.16u ps=0.68u
    I_MXI3_I87_MN1 (XI3_I87_n1 DIVQ_0 VSS VSS) gpdk090_nmos1v w=0.24u l=0.1u ad=0.0528p as=0.0816p pd=0.68u ps=1.16u
    I_MXI3_I87_MN0 (I3_n0_5 I3_SEL_DIV_b3_0 XI3_I87_n1 VSS) gpdk090_nmos1v w=0.24u l=0.1u ad=0.0816p as=0.0528p pd=1.16u ps=0.68u
    I_MXI3_I86_MN1 (XI3_I86_n1 MULP_0 VSS VSS) gpdk090_nmos1v w=0.24u l=0.1u ad=0.0528p as=0.0816p pd=0.68u ps=1.16u
    I_MXI3_I86_MN0 (I3_n0_4 I3_SEL_MUL_b3_0 XI3_I86_n1 VSS) gpdk090_nmos1v w=0.24u l=0.1u ad=0.0816p as=0.0528p pd=1.16u ps=0.68u
    I_MXI1_I42_I4_MN1 (XI1_I42_I4_n1 I1_bx4 VSS VSS) gpdk090_nmos1v w=0.24u l=0.1u ad=0.0528p as=0.0816p pd=0.68u ps=1.16u
    I_MXI1_I42_I4_MN0 (I1_I42_gn4 A_4 XI1_I42_I4_n1 VSS) gpdk090_nmos1v w=0.24u l=0.1u ad=0.0816p as=0.0528p pd=1.16u ps=0.68u
    I_MXI3_I102_MN1 (XI3_I102_n1 I3_n1_5 VSS VSS) gpdk090_nmos1v w=0.24u l=0.1u ad=0.0528p as=0.0816p pd=0.68u ps=1.16u
    I_MXI3_I102_MN0 (I3_o1_2 I3_n1_4 XI3_I102_n1 VSS) gpdk090_nmos1v w=0.24u l=0.1u ad=0.0816p as=0.0528p pd=1.16u ps=0.68u
    I_MXI3_I109_MN1 (XI3_I109_n1 NOT_2 VSS VSS) gpdk090_nmos1v w=0.24u l=0.1u ad=0.0528p as=0.0816p pd=0.68u ps=1.16u
    I_MXI3_I109_MN0 (I3_n2_3 I3_SEL_NOT_b3_0 XI3_I109_n1 VSS) gpdk090_nmos1v w=0.24u l=0.1u ad=0.0816p as=0.0528p pd=1.16u ps=0.68u
    I_MXI3_I99_MN1 (XI3_I99_n1 DIVQ_1 VSS VSS) gpdk090_nmos1v w=0.24u l=0.1u ad=0.0528p as=0.0816p pd=0.68u ps=1.16u
    I_MXI3_I99_MN0 (I3_n1_5 I3_SEL_DIV_b3_0 XI3_I99_n1 VSS) gpdk090_nmos1v w=0.24u l=0.1u ad=0.0816p as=0.0528p pd=1.16u ps=0.68u
    I_MXI3_I113_MN1 (XI3_I113_n1 I3_n2_3 VSS VSS) gpdk090_nmos1v w=0.24u l=0.1u ad=0.0528p as=0.0816p pd=0.68u ps=1.16u
    I_MXI3_I113_MN0 (I3_o2_1 I3_n2_2 XI3_I113_n1 VSS) gpdk090_nmos1v w=0.24u l=0.1u ad=0.0816p as=0.0528p pd=1.16u ps=0.68u
    I_MXI3_I98_MN1 (XI3_I98_n1 MULP_1 VSS VSS) gpdk090_nmos1v w=0.24u l=0.1u ad=0.0528p as=0.0816p pd=0.68u ps=1.16u
    I_MXI3_I98_MN0 (I3_n1_4 I3_SEL_MUL_b3_0 XI3_I98_n1 VSS) gpdk090_nmos1v w=0.24u l=0.1u ad=0.0816p as=0.0528p pd=1.16u ps=0.68u
    I_MXI3_I117_MN1 (XI3_I117_n1 I3_q2_2 VSS VSS) gpdk090_nmos1v w=0.24u l=0.1u ad=0.0528p as=0.0816p pd=0.68u ps=1.16u
    I_MXI3_I117_MN0 (Y_2 I3_q2_1 XI3_I117_n1 VSS) gpdk090_nmos1v w=0.24u l=0.1u ad=0.0816p as=0.0528p pd=1.16u ps=0.68u
    I_MXI3_I108_MN1 (XI3_I108_n1 XOR_2 VSS VSS) gpdk090_nmos1v w=0.24u l=0.1u ad=0.0528p as=0.0816p pd=0.68u ps=1.16u
    I_MXI3_I108_MN0 (I3_n2_2 I3_SEL_XOR_b3_0 XI3_I108_n1 VSS) gpdk090_nmos1v w=0.24u l=0.1u ad=0.0816p as=0.0528p pd=1.16u ps=0.68u
    I_MXI3_I515_MN1 (XI3_I515_n1 DIVR_16 VSS VSS) gpdk090_nmos1v w=0.24u l=0.1u ad=0.0528p as=0.0816p pd=0.68u ps=1.16u
    I_MXI3_I515_MN0 (I3_hd48 I3_SEL_DIV_b3_8 XI3_I515_n1 VSS) gpdk090_nmos1v w=0.24u l=0.1u ad=0.0816p as=0.0528p pd=1.16u ps=0.68u
    I_MXI3_I488_MN1 (XI3_I488_n1 DIVR_7 VSS VSS) gpdk090_nmos1v w=0.24u l=0.1u ad=0.0528p as=0.0816p pd=0.68u ps=1.16u
    I_MXI3_I488_MN0 (I3_hd39 I3_SEL_DIV_b3_6 XI3_I488_n1 VSS) gpdk090_nmos1v w=0.24u l=0.1u ad=0.0816p as=0.0528p pd=1.16u ps=0.68u
    I_MXI3_I517_MN1 (XI3_I517_n1 MULP_49 VSS VSS) gpdk090_nmos1v w=0.24u l=0.1u ad=0.0528p as=0.0816p pd=0.68u ps=1.16u
    I_MXI3_I517_MN0 (I3_hm49 I3_SEL_MUL_b3_8 XI3_I517_n1 VSS) gpdk090_nmos1v w=0.24u l=0.1u ad=0.0816p as=0.0528p pd=1.16u ps=0.68u
    I_MXI3_I514_MN1 (XI3_I514_n1 MULP_48 VSS VSS) gpdk090_nmos1v w=0.24u l=0.1u ad=0.0528p as=0.0816p pd=0.68u ps=1.16u
    I_MXI3_I514_MN0 (I3_hm48 I3_SEL_MUL_b3_8 XI3_I514_n1 VSS) gpdk090_nmos1v w=0.24u l=0.1u ad=0.0816p as=0.0528p pd=1.16u ps=0.68u
    I_MXI3_I492_MN1 (XI3_I492_n1 I3_hd40 VSS VSS) gpdk090_nmos1v w=0.24u l=0.1u ad=0.0528p as=0.0816p pd=0.68u ps=1.16u
    I_MXI3_I492_MN0 (Y_40 I3_hm40 XI3_I492_n1 VSS) gpdk090_nmos1v w=0.24u l=0.1u ad=0.0816p as=0.0528p pd=1.16u ps=0.68u
    I_MXI3_I519_MN1 (XI3_I519_n1 I3_hd49 VSS VSS) gpdk090_nmos1v w=0.24u l=0.1u ad=0.0528p as=0.0816p pd=0.68u ps=1.16u
    I_MXI3_I519_MN0 (Y_49 I3_hm49 XI3_I519_n1 VSS) gpdk090_nmos1v w=0.24u l=0.1u ad=0.0816p as=0.0528p pd=1.16u ps=0.68u
    I_MXI3_I523_MN1 (XI3_I523_n1 MULP_51 VSS VSS) gpdk090_nmos1v w=0.24u l=0.1u ad=0.0528p as=0.0816p pd=0.68u ps=1.16u
    I_MXI3_I523_MN0 (I3_hm51 I3_SEL_MUL_b3_8 XI3_I523_n1 VSS) gpdk090_nmos1v w=0.24u l=0.1u ad=0.0816p as=0.0528p pd=1.16u ps=0.68u
    I_MXI3_I518_MN1 (XI3_I518_n1 DIVR_17 VSS VSS) gpdk090_nmos1v w=0.24u l=0.1u ad=0.0528p as=0.0816p pd=0.68u ps=1.16u
    I_MXI3_I518_MN0 (I3_hd49 I3_SEL_DIV_b3_8 XI3_I518_n1 VSS) gpdk090_nmos1v w=0.24u l=0.1u ad=0.0816p as=0.0528p pd=1.16u ps=0.68u
    I_MXI3_I521_MN1 (XI3_I521_n1 DIVR_18 VSS VSS) gpdk090_nmos1v w=0.24u l=0.1u ad=0.0528p as=0.0816p pd=0.68u ps=1.16u
    I_MXI3_I521_MN0 (I3_hd50 I3_SEL_DIV_b3_8 XI3_I521_n1 VSS) gpdk090_nmos1v w=0.24u l=0.1u ad=0.0816p as=0.0528p pd=1.16u ps=0.68u
    I_MXI3_I525_MN1 (XI3_I525_n1 I3_hd51 VSS VSS) gpdk090_nmos1v w=0.24u l=0.1u ad=0.0528p as=0.0816p pd=0.68u ps=1.16u
    I_MXI3_I525_MN0 (Y_51 I3_hm51 XI3_I525_n1 VSS) gpdk090_nmos1v w=0.24u l=0.1u ad=0.0816p as=0.0528p pd=1.16u ps=0.68u
    I_MXI3_I524_MN1 (XI3_I524_n1 DIVR_19 VSS VSS) gpdk090_nmos1v w=0.24u l=0.1u ad=0.0528p as=0.0816p pd=0.68u ps=1.16u
    I_MXI3_I524_MN0 (I3_hd51 I3_SEL_DIV_b3_8 XI3_I524_n1 VSS) gpdk090_nmos1v w=0.24u l=0.1u ad=0.0816p as=0.0528p pd=1.16u ps=0.68u
    I_MXI3_I493_MN1 (XI3_I493_n1 MULP_41 VSS VSS) gpdk090_nmos1v w=0.24u l=0.1u ad=0.0528p as=0.0816p pd=0.68u ps=1.16u
    I_MXI3_I493_MN0 (I3_hm41 I3_SEL_MUL_b3_7 XI3_I493_n1 VSS) gpdk090_nmos1v w=0.24u l=0.1u ad=0.0816p as=0.0528p pd=1.16u ps=0.68u
    I_MXI3_I494_MN1 (XI3_I494_n1 DIVR_9 VSS VSS) gpdk090_nmos1v w=0.24u l=0.1u ad=0.0528p as=0.0816p pd=0.68u ps=1.16u
    I_MXI3_I494_MN0 (I3_hd41 I3_SEL_DIV_b3_7 XI3_I494_n1 VSS) gpdk090_nmos1v w=0.24u l=0.1u ad=0.0816p as=0.0528p pd=1.16u ps=0.68u
    I_MXI3_I495_MN1 (XI3_I495_n1 I3_hd41 VSS VSS) gpdk090_nmos1v w=0.24u l=0.1u ad=0.0528p as=0.0816p pd=0.68u ps=1.16u
    I_MXI3_I495_MN0 (Y_41 I3_hm41 XI3_I495_n1 VSS) gpdk090_nmos1v w=0.24u l=0.1u ad=0.0816p as=0.0528p pd=1.16u ps=0.68u
    I_MXI3_I202_MN1 (XI3_I202_n1 AND_10 VSS VSS) gpdk090_nmos1v w=0.24u l=0.1u ad=0.0528p as=0.0816p pd=0.68u ps=1.16u
    I_MXI3_I202_MN0 (I3_n10_0 I3_SEL_AND_b3_1 XI3_I202_n1 VSS) gpdk090_nmos1v w=0.24u l=0.1u ad=0.0816p as=0.0528p pd=1.16u ps=0.68u
    I_MXI3_I203_MN1 (XI3_I203_n1 OR_10 VSS VSS) gpdk090_nmos1v w=0.24u l=0.1u ad=0.0528p as=0.0816p pd=0.68u ps=1.16u
    I_MXI3_I203_MN0 (I3_n10_1 I3_SEL_OR_b3_1 XI3_I203_n1 VSS) gpdk090_nmos1v w=0.24u l=0.1u ad=0.0816p as=0.0528p pd=1.16u ps=0.68u
    I_MXI3_I208_MN1 (XI3_I208_n1 I3_n10_1 VSS VSS) gpdk090_nmos1v w=0.24u l=0.1u ad=0.0528p as=0.0816p pd=0.68u ps=1.16u
    I_MXI3_I208_MN0 (I3_o10_0 I3_n10_0 XI3_I208_n1 VSS) gpdk090_nmos1v w=0.24u l=0.1u ad=0.0816p as=0.0528p pd=1.16u ps=0.68u
    I_MXI1_I42_I8_MN1 (XI1_I42_I8_n1 I1_bx8 VSS VSS) gpdk090_nmos1v w=0.24u l=0.1u ad=0.0528p as=0.0816p pd=0.68u ps=1.16u
    I_MXI1_I42_I8_MN0 (I1_I42_gn8 A_8 XI1_I42_I8_n1 VSS) gpdk090_nmos1v w=0.24u l=0.1u ad=0.0816p as=0.0528p pd=1.16u ps=0.68u
    I_MXI1_I42_I9_MN1 (XI1_I42_I9_n1 I1_bx9 VSS VSS) gpdk090_nmos1v w=0.24u l=0.1u ad=0.0528p as=0.0816p pd=0.68u ps=1.16u
    I_MXI1_I42_I9_MN0 (I1_I42_gn9 A_9 XI1_I42_I9_n1 VSS) gpdk090_nmos1v w=0.24u l=0.1u ad=0.0816p as=0.0528p pd=1.16u ps=0.68u
    I_MXI1_I42_I7_MN1 (XI1_I42_I7_n1 I1_bx7 VSS VSS) gpdk090_nmos1v w=0.24u l=0.1u ad=0.0528p as=0.0816p pd=0.68u ps=1.16u
    I_MXI1_I42_I7_MN0 (I1_I42_gn7 A_7 XI1_I42_I7_n1 VSS) gpdk090_nmos1v w=0.24u l=0.1u ad=0.0816p as=0.0528p pd=1.16u ps=0.68u
    I_MXI1_I42_I6_MN1 (XI1_I42_I6_n1 I1_bx6 VSS VSS) gpdk090_nmos1v w=0.24u l=0.1u ad=0.0528p as=0.0816p pd=0.68u ps=1.16u
    I_MXI1_I42_I6_MN0 (I1_I42_gn6 A_6 XI1_I42_I6_n1 VSS) gpdk090_nmos1v w=0.24u l=0.1u ad=0.0816p as=0.0528p pd=1.16u ps=0.68u
    I_MXI2_I30_MN1 (XI2_I30_n1 B_5 VSS VSS) gpdk090_nmos1v w=0.24u l=0.1u ad=0.0528p as=0.0816p pd=0.68u ps=1.16u
    I_MXI2_I30_MN0 (I2_nand5 A_5 XI2_I30_n1 VSS) gpdk090_nmos1v w=0.24u l=0.1u ad=0.0816p as=0.0528p pd=1.16u ps=0.68u
    I_MXI3_I143_MN1 (XI3_I143_n1 OR_5 VSS VSS) gpdk090_nmos1v w=0.24u l=0.1u ad=0.0528p as=0.0816p pd=0.68u ps=1.16u
    I_MXI3_I143_MN0 (I3_n5_1 I3_SEL_OR_b3_0 XI3_I143_n1 VSS) gpdk090_nmos1v w=0.24u l=0.1u ad=0.0816p as=0.0528p pd=1.16u ps=0.68u
    I_MXI3_I142_MN1 (XI3_I142_n1 AND_5 VSS VSS) gpdk090_nmos1v w=0.24u l=0.1u ad=0.0528p as=0.0816p pd=0.68u ps=1.16u
    I_MXI3_I142_MN0 (I3_n5_0 I3_SEL_AND_b3_0 XI3_I142_n1 VSS) gpdk090_nmos1v w=0.24u l=0.1u ad=0.0816p as=0.0528p pd=1.16u ps=0.68u
    I_MXI3_I148_MN1 (XI3_I148_n1 I3_n5_1 VSS VSS) gpdk090_nmos1v w=0.24u l=0.1u ad=0.0528p as=0.0816p pd=0.68u ps=1.16u
    I_MXI3_I148_MN0 (I3_o5_0 I3_n5_0 XI3_I148_n1 VSS) gpdk090_nmos1v w=0.24u l=0.1u ad=0.0816p as=0.0528p pd=1.16u ps=0.68u
    I_MXI3_I146_MN1 (XI3_I146_n1 MULP_5 VSS VSS) gpdk090_nmos1v w=0.24u l=0.1u ad=0.0528p as=0.0816p pd=0.68u ps=1.16u
    I_MXI3_I146_MN0 (I3_n5_4 I3_SEL_MUL_b3_0 XI3_I146_n1 VSS) gpdk090_nmos1v w=0.24u l=0.1u ad=0.0816p as=0.0528p pd=1.16u ps=0.68u
    I_MXI3_I114_MN1 (XI3_I114_n1 I3_n2_5 VSS VSS) gpdk090_nmos1v w=0.24u l=0.1u ad=0.0528p as=0.0816p pd=0.68u ps=1.16u
    I_MXI3_I114_MN0 (I3_o2_2 I3_n2_4 XI3_I114_n1 VSS) gpdk090_nmos1v w=0.24u l=0.1u ad=0.0816p as=0.0528p pd=1.16u ps=0.68u
    I_MXI3_I126_MN1 (XI3_I126_n1 I3_n3_5 VSS VSS) gpdk090_nmos1v w=0.24u l=0.1u ad=0.0528p as=0.0816p pd=0.68u ps=1.16u
    I_MXI3_I126_MN0 (I3_o3_2 I3_n3_4 XI3_I126_n1 VSS) gpdk090_nmos1v w=0.24u l=0.1u ad=0.0816p as=0.0528p pd=1.16u ps=0.68u
    I_MXI3_I110_MN1 (XI3_I110_n1 MULP_2 VSS VSS) gpdk090_nmos1v w=0.24u l=0.1u ad=0.0528p as=0.0816p pd=0.68u ps=1.16u
    I_MXI3_I110_MN0 (I3_n2_4 I3_SEL_MUL_b3_0 XI3_I110_n1 VSS) gpdk090_nmos1v w=0.24u l=0.1u ad=0.0816p as=0.0528p pd=1.16u ps=0.68u
    I_MXI3_I122_MN1 (XI3_I122_n1 MULP_3 VSS VSS) gpdk090_nmos1v w=0.24u l=0.1u ad=0.0528p as=0.0816p pd=0.68u ps=1.16u
    I_MXI3_I122_MN0 (I3_n3_4 I3_SEL_MUL_b3_0 XI3_I122_n1 VSS) gpdk090_nmos1v w=0.24u l=0.1u ad=0.0816p as=0.0528p pd=1.16u ps=0.68u
    I_MXI3_I111_MN1 (XI3_I111_n1 DIVQ_2 VSS VSS) gpdk090_nmos1v w=0.24u l=0.1u ad=0.0528p as=0.0816p pd=0.68u ps=1.16u
    I_MXI3_I111_MN0 (I3_n2_5 I3_SEL_DIV_b3_0 XI3_I111_n1 VSS) gpdk090_nmos1v w=0.24u l=0.1u ad=0.0816p as=0.0528p pd=1.16u ps=0.68u
    I_MXI3_I123_MN1 (XI3_I123_n1 DIVQ_3 VSS VSS) gpdk090_nmos1v w=0.24u l=0.1u ad=0.0528p as=0.0816p pd=0.68u ps=1.16u
    I_MXI3_I123_MN0 (I3_n3_5 I3_SEL_DIV_b3_0 XI3_I123_n1 VSS) gpdk090_nmos1v w=0.24u l=0.1u ad=0.0816p as=0.0528p pd=1.16u ps=0.68u
    I_MXI3_I121_MN1 (XI3_I121_n1 NOT_3 VSS VSS) gpdk090_nmos1v w=0.24u l=0.1u ad=0.0528p as=0.0816p pd=0.68u ps=1.16u
    I_MXI3_I121_MN0 (I3_n3_3 I3_SEL_NOT_b3_0 XI3_I121_n1 VSS) gpdk090_nmos1v w=0.24u l=0.1u ad=0.0816p as=0.0528p pd=1.16u ps=0.68u
    I_MXI3_I129_MN1 (XI3_I129_n1 I3_q3_2 VSS VSS) gpdk090_nmos1v w=0.24u l=0.1u ad=0.0528p as=0.0816p pd=0.68u ps=1.16u
    I_MXI3_I129_MN0 (Y_3 I3_q3_1 XI3_I129_n1 VSS) gpdk090_nmos1v w=0.24u l=0.1u ad=0.0816p as=0.0528p pd=1.16u ps=0.68u
    I_MXI3_I125_MN1 (XI3_I125_n1 I3_n3_3 VSS VSS) gpdk090_nmos1v w=0.24u l=0.1u ad=0.0528p as=0.0816p pd=0.68u ps=1.16u
    I_MXI3_I125_MN0 (I3_o3_1 I3_n3_2 XI3_I125_n1 VSS) gpdk090_nmos1v w=0.24u l=0.1u ad=0.0816p as=0.0528p pd=1.16u ps=0.68u
    I_MXI3_I120_MN1 (XI3_I120_n1 XOR_3 VSS VSS) gpdk090_nmos1v w=0.24u l=0.1u ad=0.0528p as=0.0816p pd=0.68u ps=1.16u
    I_MXI3_I120_MN0 (I3_n3_2 I3_SEL_XOR_b3_0 XI3_I120_n1 VSS) gpdk090_nmos1v w=0.24u l=0.1u ad=0.0816p as=0.0528p pd=1.16u ps=0.68u
    I_MXI3_I487_MN1 (XI3_I487_n1 MULP_39 VSS VSS) gpdk090_nmos1v w=0.24u l=0.1u ad=0.0528p as=0.0816p pd=0.68u ps=1.16u
    I_MXI3_I487_MN0 (I3_hm39 I3_SEL_MUL_b3_6 XI3_I487_n1 VSS) gpdk090_nmos1v w=0.24u l=0.1u ad=0.0816p as=0.0528p pd=1.16u ps=0.68u
    I_MXI3_I489_MN1 (XI3_I489_n1 I3_hd39 VSS VSS) gpdk090_nmos1v w=0.24u l=0.1u ad=0.0528p as=0.0816p pd=0.68u ps=1.16u
    I_MXI3_I489_MN0 (Y_39 I3_hm39 XI3_I489_n1 VSS) gpdk090_nmos1v w=0.24u l=0.1u ad=0.0816p as=0.0528p pd=1.16u ps=0.68u
    I_MXI3_I478_MN1 (XI3_I478_n1 MULP_36 VSS VSS) gpdk090_nmos1v w=0.24u l=0.1u ad=0.0528p as=0.0816p pd=0.68u ps=1.16u
    I_MXI3_I478_MN0 (I3_hm36 I3_SEL_MUL_b3_6 XI3_I478_n1 VSS) gpdk090_nmos1v w=0.24u l=0.1u ad=0.0816p as=0.0528p pd=1.16u ps=0.68u
    I_MXI3_I491_MN1 (XI3_I491_n1 DIVR_8 VSS VSS) gpdk090_nmos1v w=0.24u l=0.1u ad=0.0528p as=0.0816p pd=0.68u ps=1.16u
    I_MXI3_I491_MN0 (I3_hd40 I3_SEL_DIV_b3_6 XI3_I491_n1 VSS) gpdk090_nmos1v w=0.24u l=0.1u ad=0.0816p as=0.0528p pd=1.16u ps=0.68u
    I_MXI3_I482_MN1 (XI3_I482_n1 DIVR_5 VSS VSS) gpdk090_nmos1v w=0.24u l=0.1u ad=0.0528p as=0.0816p pd=0.68u ps=1.16u
    I_MXI3_I482_MN0 (I3_hd37 I3_SEL_DIV_b3_6 XI3_I482_n1 VSS) gpdk090_nmos1v w=0.24u l=0.1u ad=0.0816p as=0.0528p pd=1.16u ps=0.68u
    I_MXI3_I484_MN1 (XI3_I484_n1 MULP_38 VSS VSS) gpdk090_nmos1v w=0.24u l=0.1u ad=0.0528p as=0.0816p pd=0.68u ps=1.16u
    I_MXI3_I484_MN0 (I3_hm38 I3_SEL_MUL_b3_6 XI3_I484_n1 VSS) gpdk090_nmos1v w=0.24u l=0.1u ad=0.0816p as=0.0528p pd=1.16u ps=0.68u
    I_MXI3_I490_MN1 (XI3_I490_n1 MULP_40 VSS VSS) gpdk090_nmos1v w=0.24u l=0.1u ad=0.0528p as=0.0816p pd=0.68u ps=1.16u
    I_MXI3_I490_MN0 (I3_hm40 I3_SEL_MUL_b3_6 XI3_I490_n1 VSS) gpdk090_nmos1v w=0.24u l=0.1u ad=0.0816p as=0.0528p pd=1.16u ps=0.68u
    I_MXI3_I485_MN1 (XI3_I485_n1 DIVR_6 VSS VSS) gpdk090_nmos1v w=0.24u l=0.1u ad=0.0528p as=0.0816p pd=0.68u ps=1.16u
    I_MXI3_I485_MN0 (I3_hd38 I3_SEL_DIV_b3_6 XI3_I485_n1 VSS) gpdk090_nmos1v w=0.24u l=0.1u ad=0.0816p as=0.0528p pd=1.16u ps=0.68u
    I_MXI3_I486_MN1 (XI3_I486_n1 I3_hd38 VSS VSS) gpdk090_nmos1v w=0.24u l=0.1u ad=0.0528p as=0.0816p pd=0.68u ps=1.16u
    I_MXI3_I486_MN0 (Y_38 I3_hm38 XI3_I486_n1 VSS) gpdk090_nmos1v w=0.24u l=0.1u ad=0.0816p as=0.0528p pd=1.16u ps=0.68u
    I_MXI3_I475_MN1 (XI3_I475_n1 MULP_35 VSS VSS) gpdk090_nmos1v w=0.24u l=0.1u ad=0.0528p as=0.0816p pd=0.68u ps=1.16u
    I_MXI3_I475_MN0 (I3_hm35 I3_SEL_MUL_b3_6 XI3_I475_n1 VSS) gpdk090_nmos1v w=0.24u l=0.1u ad=0.0816p as=0.0528p pd=1.16u ps=0.68u
    I_MXI4_I41_MN1 (XI4_I41_n1 I4_z0_19 VSS VSS) gpdk090_nmos1v w=0.24u l=0.1u ad=0.0528p as=0.0816p pd=0.68u ps=1.16u
    I_MXI4_I41_MN0 (I4_z1_9 I4_z0_18 XI4_I41_n1 VSS) gpdk090_nmos1v w=0.24u l=0.1u ad=0.0816p as=0.0528p pd=1.16u ps=0.68u
    I_MXI0_I6_MN1 (XI0_I6_n1 I0_opn2 VSS VSS) gpdk090_nmos1v w=0.24u l=0.1u ad=0.0528p as=0.0816p pd=0.68u ps=1.16u
    I_MXI0_I6_MN0 (I0_h10 OP_3 XI0_I6_n1 VSS) gpdk090_nmos1v w=0.24u l=0.1u ad=0.0816p as=0.0528p pd=1.16u ps=0.68u
    I_MXI0_I4_MN1 (XI0_I4_n1 I0_opn2 VSS VSS) gpdk090_nmos1v w=0.24u l=0.1u ad=0.0528p as=0.0816p pd=0.68u ps=1.16u
    I_MXI0_I4_MN0 (I0_h00 I0_opn3 XI0_I4_n1 VSS) gpdk090_nmos1v w=0.24u l=0.1u ad=0.0816p as=0.0528p pd=1.16u ps=0.68u
    I_MXI0_I5_MN1 (XI0_I5_n1 OP_2 VSS VSS) gpdk090_nmos1v w=0.24u l=0.1u ad=0.0528p as=0.0816p pd=0.68u ps=1.16u
    I_MXI0_I5_MN0 (I0_h01 I0_opn3 XI0_I5_n1 VSS) gpdk090_nmos1v w=0.24u l=0.1u ad=0.0816p as=0.0528p pd=1.16u ps=0.68u
    I_MXI0_I8_MN1 (XI0_I8_n1 OP_0 VSS VSS) gpdk090_nmos1v w=0.24u l=0.1u ad=0.0528p as=0.0816p pd=0.68u ps=1.16u
    I_MXI0_I8_MN0 (I0_l01 I0_opn1 XI0_I8_n1 VSS) gpdk090_nmos1v w=0.24u l=0.1u ad=0.0816p as=0.0528p pd=1.16u ps=0.68u
    I_MXI2_I60_MN1 (XI2_I60_n1 B_10 VSS VSS) gpdk090_nmos1v w=0.24u l=0.1u ad=0.0528p as=0.0816p pd=0.68u ps=1.16u
    I_MXI2_I60_MN0 (I2_nand10 A_10 XI2_I60_n1 VSS) gpdk090_nmos1v w=0.24u l=0.1u ad=0.0816p as=0.0528p pd=1.16u ps=0.68u
    I_MXI1_I42_I10_MN1 (XI1_I42_I10_n1 I1_bx10 VSS VSS) gpdk090_nmos1v w=0.24u l=0.1u ad=0.0528p as=0.0816p pd=0.68u ps=1.16u
    I_MXI1_I42_I10_MN0 (I1_I42_gn10 A_10 XI1_I42_I10_n1 VSS) gpdk090_nmos1v w=0.24u l=0.1u ad=0.0816p as=0.0528p pd=1.16u ps=0.68u
    I_MXI1_I42_I5_MN1 (XI1_I42_I5_n1 I1_bx5 VSS VSS) gpdk090_nmos1v w=0.24u l=0.1u ad=0.0528p as=0.0816p pd=0.68u ps=1.16u
    I_MXI1_I42_I5_MN0 (I1_I42_gn5 A_5 XI1_I42_I5_n1 VSS) gpdk090_nmos1v w=0.24u l=0.1u ad=0.0816p as=0.0528p pd=1.16u ps=0.68u
    I_MXI3_I150_MN1 (XI3_I150_n1 I3_n5_5 VSS VSS) gpdk090_nmos1v w=0.24u l=0.1u ad=0.0528p as=0.0816p pd=0.68u ps=1.16u
    I_MXI3_I150_MN0 (I3_o5_2 I3_n5_4 XI3_I150_n1 VSS) gpdk090_nmos1v w=0.24u l=0.1u ad=0.0816p as=0.0528p pd=1.16u ps=0.68u
    I_MXI1_I42_I2_MN1 (XI1_I42_I2_n1 I1_bx2 VSS VSS) gpdk090_nmos1v w=0.24u l=0.1u ad=0.0528p as=0.0816p pd=0.68u ps=1.16u
    I_MXI1_I42_I2_MN0 (I1_I42_gn2 A_2 XI1_I42_I2_n1 VSS) gpdk090_nmos1v w=0.24u l=0.1u ad=0.0816p as=0.0528p pd=1.16u ps=0.68u
    I_MXI3_I147_MN1 (XI3_I147_n1 DIVQ_5 VSS VSS) gpdk090_nmos1v w=0.24u l=0.1u ad=0.0528p as=0.0816p pd=0.68u ps=1.16u
    I_MXI3_I147_MN0 (I3_n5_5 I3_SEL_DIV_b3_0 XI3_I147_n1 VSS) gpdk090_nmos1v w=0.24u l=0.1u ad=0.0816p as=0.0528p pd=1.16u ps=0.68u
    I_MXI3_I138_MN1 (XI3_I138_n1 I3_n4_5 VSS VSS) gpdk090_nmos1v w=0.24u l=0.1u ad=0.0528p as=0.0816p pd=0.68u ps=1.16u
    I_MXI3_I138_MN0 (I3_o4_2 I3_n4_4 XI3_I138_n1 VSS) gpdk090_nmos1v w=0.24u l=0.1u ad=0.0816p as=0.0528p pd=1.16u ps=0.68u
    I_MXI3_I134_MN1 (XI3_I134_n1 MULP_4 VSS VSS) gpdk090_nmos1v w=0.24u l=0.1u ad=0.0528p as=0.0816p pd=0.68u ps=1.16u
    I_MXI3_I134_MN0 (I3_n4_4 I3_SEL_MUL_b3_0 XI3_I134_n1 VSS) gpdk090_nmos1v w=0.24u l=0.1u ad=0.0816p as=0.0528p pd=1.16u ps=0.68u
    I_MXI3_I135_MN1 (XI3_I135_n1 DIVQ_4 VSS VSS) gpdk090_nmos1v w=0.24u l=0.1u ad=0.0528p as=0.0816p pd=0.68u ps=1.16u
    I_MXI3_I135_MN0 (I3_n4_5 I3_SEL_DIV_b3_0 XI3_I135_n1 VSS) gpdk090_nmos1v w=0.24u l=0.1u ad=0.0816p as=0.0528p pd=1.16u ps=0.68u
    I_MXI3_I119_MN1 (XI3_I119_n1 OR_3 VSS VSS) gpdk090_nmos1v w=0.24u l=0.1u ad=0.0528p as=0.0816p pd=0.68u ps=1.16u
    I_MXI3_I119_MN0 (I3_n3_1 I3_SEL_OR_b3_0 XI3_I119_n1 VSS) gpdk090_nmos1v w=0.24u l=0.1u ad=0.0816p as=0.0528p pd=1.16u ps=0.68u
    I_MXI3_I124_MN1 (XI3_I124_n1 I3_n3_1 VSS VSS) gpdk090_nmos1v w=0.24u l=0.1u ad=0.0528p as=0.0816p pd=0.68u ps=1.16u
    I_MXI3_I124_MN0 (I3_o3_0 I3_n3_0 XI3_I124_n1 VSS) gpdk090_nmos1v w=0.24u l=0.1u ad=0.0816p as=0.0528p pd=1.16u ps=0.68u
    I_MXI3_I118_MN1 (XI3_I118_n1 AND_3 VSS VSS) gpdk090_nmos1v w=0.24u l=0.1u ad=0.0528p as=0.0816p pd=0.68u ps=1.16u
    I_MXI3_I118_MN0 (I3_n3_0 I3_SEL_AND_b3_0 XI3_I118_n1 VSS) gpdk090_nmos1v w=0.24u l=0.1u ad=0.0816p as=0.0528p pd=1.16u ps=0.68u
    I_MXI3_I479_MN1 (XI3_I479_n1 DIVR_4 VSS VSS) gpdk090_nmos1v w=0.24u l=0.1u ad=0.0528p as=0.0816p pd=0.68u ps=1.16u
    I_MXI3_I479_MN0 (I3_hd36 I3_SEL_DIV_b3_6 XI3_I479_n1 VSS) gpdk090_nmos1v w=0.24u l=0.1u ad=0.0816p as=0.0528p pd=1.16u ps=0.68u
    I_MXI3_I474_MN1 (XI3_I474_n1 I3_hd34 VSS VSS) gpdk090_nmos1v w=0.24u l=0.1u ad=0.0528p as=0.0816p pd=0.68u ps=1.16u
    I_MXI3_I474_MN0 (Y_34 I3_hm34 XI3_I474_n1 VSS) gpdk090_nmos1v w=0.24u l=0.1u ad=0.0816p as=0.0528p pd=1.16u ps=0.68u
    I_MXI3_I480_MN1 (XI3_I480_n1 I3_hd36 VSS VSS) gpdk090_nmos1v w=0.24u l=0.1u ad=0.0528p as=0.0816p pd=0.68u ps=1.16u
    I_MXI3_I480_MN0 (Y_36 I3_hm36 XI3_I480_n1 VSS) gpdk090_nmos1v w=0.24u l=0.1u ad=0.0816p as=0.0528p pd=1.16u ps=0.68u
    I_MXI3_I481_MN1 (XI3_I481_n1 MULP_37 VSS VSS) gpdk090_nmos1v w=0.24u l=0.1u ad=0.0528p as=0.0816p pd=0.68u ps=1.16u
    I_MXI3_I481_MN0 (I3_hm37 I3_SEL_MUL_b3_6 XI3_I481_n1 VSS) gpdk090_nmos1v w=0.24u l=0.1u ad=0.0816p as=0.0528p pd=1.16u ps=0.68u
    I_MXI3_I469_MN1 (XI3_I469_n1 MULP_33 VSS VSS) gpdk090_nmos1v w=0.24u l=0.1u ad=0.0528p as=0.0816p pd=0.68u ps=1.16u
    I_MXI3_I469_MN0 (I3_hm33 I3_SEL_MUL_b3_5 XI3_I469_n1 VSS) gpdk090_nmos1v w=0.24u l=0.1u ad=0.0816p as=0.0528p pd=1.16u ps=0.68u
    I_MXI3_I483_MN1 (XI3_I483_n1 I3_hd37 VSS VSS) gpdk090_nmos1v w=0.24u l=0.1u ad=0.0528p as=0.0816p pd=0.68u ps=1.16u
    I_MXI3_I483_MN0 (Y_37 I3_hm37 XI3_I483_n1 VSS) gpdk090_nmos1v w=0.24u l=0.1u ad=0.0816p as=0.0528p pd=1.16u ps=0.68u
    I_MXI3_I476_MN1 (XI3_I476_n1 DIVR_3 VSS VSS) gpdk090_nmos1v w=0.24u l=0.1u ad=0.0528p as=0.0816p pd=0.68u ps=1.16u
    I_MXI3_I476_MN0 (I3_hd35 I3_SEL_DIV_b3_6 XI3_I476_n1 VSS) gpdk090_nmos1v w=0.24u l=0.1u ad=0.0816p as=0.0528p pd=1.16u ps=0.68u
    I_MXI3_I471_MN1 (XI3_I471_n1 I3_hd33 VSS VSS) gpdk090_nmos1v w=0.24u l=0.1u ad=0.0528p as=0.0816p pd=0.68u ps=1.16u
    I_MXI3_I471_MN0 (Y_33 I3_hm33 XI3_I471_n1 VSS) gpdk090_nmos1v w=0.24u l=0.1u ad=0.0816p as=0.0528p pd=1.16u ps=0.68u
    I_MXI3_I466_MN1 (XI3_I466_n1 MULP_32 VSS VSS) gpdk090_nmos1v w=0.24u l=0.1u ad=0.0528p as=0.0816p pd=0.68u ps=1.16u
    I_MXI3_I466_MN0 (I3_hm32 I3_SEL_MUL_b3_5 XI3_I466_n1 VSS) gpdk090_nmos1v w=0.24u l=0.1u ad=0.0816p as=0.0528p pd=1.16u ps=0.68u
    I_MXI3_I477_MN1 (XI3_I477_n1 I3_hd35 VSS VSS) gpdk090_nmos1v w=0.24u l=0.1u ad=0.0528p as=0.0816p pd=0.68u ps=1.16u
    I_MXI3_I477_MN0 (Y_35 I3_hm35 XI3_I477_n1 VSS) gpdk090_nmos1v w=0.24u l=0.1u ad=0.0816p as=0.0528p pd=1.16u ps=0.68u
    I_MXI3_I468_MN1 (XI3_I468_n1 I3_hd32 VSS VSS) gpdk090_nmos1v w=0.24u l=0.1u ad=0.0528p as=0.0816p pd=0.68u ps=1.16u
    I_MXI3_I468_MN0 (Y_32 I3_hm32 XI3_I468_n1 VSS) gpdk090_nmos1v w=0.24u l=0.1u ad=0.0816p as=0.0528p pd=1.16u ps=0.68u
    I_MXI4_I40_MN1 (XI4_I40_n1 I4_z0_17 VSS VSS) gpdk090_nmos1v w=0.24u l=0.1u ad=0.0528p as=0.0816p pd=0.68u ps=1.16u
    I_MXI4_I40_MN0 (I4_z1_8 I4_z0_16 XI4_I40_n1 VSS) gpdk090_nmos1v w=0.24u l=0.1u ad=0.0816p as=0.0528p pd=1.16u ps=0.68u
    I_MXI4_I68_MN1 (XI4_I68_n1 DIVV VSS VSS) gpdk090_nmos1v w=0.24u l=0.1u ad=0.0528p as=0.0816p pd=0.68u ps=1.16u
    I_MXI4_I68_MN0 (I4_v2 SEL_DIV XI4_I68_n1 VSS) gpdk090_nmos1v w=0.24u l=0.1u ad=0.0816p as=0.0528p pd=1.16u ps=0.68u
    I_MXI0_I10_MN1 (XI0_I10_n1 OP_0 VSS VSS) gpdk090_nmos1v w=0.24u l=0.1u ad=0.0528p as=0.0816p pd=0.68u ps=1.16u
    I_MXI0_I10_MN0 (I0_l11 OP_1 XI0_I10_n1 VSS) gpdk090_nmos1v w=0.24u l=0.1u ad=0.0816p as=0.0528p pd=1.16u ps=0.68u
    I_MXI0_I7_MN1 (XI0_I7_n1 I0_opn0 VSS VSS) gpdk090_nmos1v w=0.24u l=0.1u ad=0.0528p as=0.0816p pd=0.68u ps=1.16u
    I_MXI0_I7_MN0 (I0_l00 I0_opn1 XI0_I7_n1 VSS) gpdk090_nmos1v w=0.24u l=0.1u ad=0.0816p as=0.0528p pd=1.16u ps=0.68u
    I_MXI0_I9_MN1 (XI0_I9_n1 I0_opn0 VSS VSS) gpdk090_nmos1v w=0.24u l=0.1u ad=0.0528p as=0.0816p pd=0.68u ps=1.16u
    I_MXI0_I9_MN0 (I0_l10 OP_1 XI0_I9_n1 VSS) gpdk090_nmos1v w=0.24u l=0.1u ad=0.0816p as=0.0528p pd=1.16u ps=0.68u
    I_MXI1_I42_I105_XP_MN1 (XI1_I42_I105_XP_n1 I1_I42_P7_6 VSS VSS) gpdk090_nmos1v w=0.24u l=0.1u ad=0.0528p as=0.0816p pd=0.68u ps=1.16u
    I_MXI1_I42_I105_XP_MN0 (I1_I42_P9_6n I1_I42_P9_8 XI1_I42_I105_XP_n1 VSS) gpdk090_nmos1v w=0.24u l=0.1u ad=0.0816p as=0.0528p pd=1.16u ps=0.68u
    I_MXI1_I42_I103_XP_MN1 (XI1_I42_I103_XP_n1 I1_I42_P5_4 VSS VSS) gpdk090_nmos1v w=0.24u l=0.1u ad=0.0528p as=0.0816p pd=0.68u ps=1.16u
    I_MXI1_I42_I103_XP_MN0 (I1_I42_P7_4n I1_I42_P7_6 XI1_I42_I103_XP_n1 VSS) gpdk090_nmos1v w=0.24u l=0.1u ad=0.0816p as=0.0528p pd=1.16u ps=0.68u
    I_MXI1_I42_I101_XP_MN1 (XI1_I42_I101_XP_n1 I1_I42_P3_2 VSS VSS) gpdk090_nmos1v w=0.24u l=0.1u ad=0.0528p as=0.0816p pd=0.68u ps=1.16u
    I_MXI1_I42_I101_XP_MN0 (I1_I42_P5_2n I1_I42_P5_4 XI1_I42_I101_XP_n1 VSS) gpdk090_nmos1v w=0.24u l=0.1u ad=0.0816p as=0.0528p pd=1.16u ps=0.68u
    I_MXI1_I42_I3_MN1 (XI1_I42_I3_n1 I1_bx3 VSS VSS) gpdk090_nmos1v w=0.24u l=0.1u ad=0.0528p as=0.0816p pd=0.68u ps=1.16u
    I_MXI1_I42_I3_MN0 (I1_I42_gn3 A_3 XI1_I42_I3_n1 VSS) gpdk090_nmos1v w=0.24u l=0.1u ad=0.0816p as=0.0528p pd=1.16u ps=0.68u
    I_MXI3_I216_MN1 (XI3_I216_n1 XOR_11 VSS VSS) gpdk090_nmos1v w=0.24u l=0.1u ad=0.0528p as=0.0816p pd=0.68u ps=1.16u
    I_MXI3_I216_MN0 (I3_n11_2 I3_SEL_XOR_b3_2 XI3_I216_n1 VSS) gpdk090_nmos1v w=0.24u l=0.1u ad=0.0816p as=0.0528p pd=1.16u ps=0.68u
    I_MXI2_I18_MN1 (XI2_I18_n1 B_3 VSS VSS) gpdk090_nmos1v w=0.24u l=0.1u ad=0.0528p as=0.0816p pd=0.68u ps=1.16u
    I_MXI2_I18_MN0 (I2_nand3 A_3 XI2_I18_n1 VSS) gpdk090_nmos1v w=0.24u l=0.1u ad=0.0816p as=0.0528p pd=1.16u ps=0.68u
    I_MXI3_I473_MN1 (XI3_I473_n1 DIVR_2 VSS VSS) gpdk090_nmos1v w=0.24u l=0.1u ad=0.0528p as=0.0816p pd=0.68u ps=1.16u
    I_MXI3_I473_MN0 (I3_hd34 I3_SEL_DIV_b3_5 XI3_I473_n1 VSS) gpdk090_nmos1v w=0.24u l=0.1u ad=0.0816p as=0.0528p pd=1.16u ps=0.68u
    I_MXI3_I472_MN1 (XI3_I472_n1 MULP_34 VSS VSS) gpdk090_nmos1v w=0.24u l=0.1u ad=0.0528p as=0.0816p pd=0.68u ps=1.16u
    I_MXI3_I472_MN0 (I3_hm34 I3_SEL_MUL_b3_5 XI3_I472_n1 VSS) gpdk090_nmos1v w=0.24u l=0.1u ad=0.0816p as=0.0528p pd=1.16u ps=0.68u
    I_MXI3_I447_MN1 (XI3_I447_n1 DIVQ_30 VSS VSS) gpdk090_nmos1v w=0.24u l=0.1u ad=0.0528p as=0.0816p pd=0.68u ps=1.16u
    I_MXI3_I447_MN0 (I3_n30_5 I3_SEL_DIV_b3_5 XI3_I447_n1 VSS) gpdk090_nmos1v w=0.24u l=0.1u ad=0.0816p as=0.0528p pd=1.16u ps=0.68u
    I_MXI3_I446_MN1 (XI3_I446_n1 MULP_30 VSS VSS) gpdk090_nmos1v w=0.24u l=0.1u ad=0.0528p as=0.0816p pd=0.68u ps=1.16u
    I_MXI3_I446_MN0 (I3_n30_4 I3_SEL_MUL_b3_5 XI3_I446_n1 VSS) gpdk090_nmos1v w=0.24u l=0.1u ad=0.0816p as=0.0528p pd=1.16u ps=0.68u
    I_MXI3_I450_MN1 (XI3_I450_n1 I3_n30_5 VSS VSS) gpdk090_nmos1v w=0.24u l=0.1u ad=0.0528p as=0.0816p pd=0.68u ps=1.16u
    I_MXI3_I450_MN0 (I3_o30_2 I3_n30_4 XI3_I450_n1 VSS) gpdk090_nmos1v w=0.24u l=0.1u ad=0.0816p as=0.0528p pd=1.16u ps=0.68u
    I_MXI3_I458_MN1 (XI3_I458_n1 MULP_31 VSS VSS) gpdk090_nmos1v w=0.24u l=0.1u ad=0.0528p as=0.0816p pd=0.68u ps=1.16u
    I_MXI3_I458_MN0 (I3_n31_4 I3_SEL_MUL_b3_5 XI3_I458_n1 VSS) gpdk090_nmos1v w=0.24u l=0.1u ad=0.0816p as=0.0528p pd=1.16u ps=0.68u
    I_MXI3_I470_MN1 (XI3_I470_n1 DIVR_1 VSS VSS) gpdk090_nmos1v w=0.24u l=0.1u ad=0.0528p as=0.0816p pd=0.68u ps=1.16u
    I_MXI3_I470_MN0 (I3_hd33 I3_SEL_DIV_b3_5 XI3_I470_n1 VSS) gpdk090_nmos1v w=0.24u l=0.1u ad=0.0816p as=0.0528p pd=1.16u ps=0.68u
    I_MXI3_I459_MN1 (XI3_I459_n1 DIVQ_31 VSS VSS) gpdk090_nmos1v w=0.24u l=0.1u ad=0.0528p as=0.0816p pd=0.68u ps=1.16u
    I_MXI3_I459_MN0 (I3_n31_5 I3_SEL_DIV_b3_5 XI3_I459_n1 VSS) gpdk090_nmos1v w=0.24u l=0.1u ad=0.0816p as=0.0528p pd=1.16u ps=0.68u
    I_MXI3_I462_MN1 (XI3_I462_n1 I3_n31_5 VSS VSS) gpdk090_nmos1v w=0.24u l=0.1u ad=0.0528p as=0.0816p pd=0.68u ps=1.16u
    I_MXI3_I462_MN0 (I3_o31_2 I3_n31_4 XI3_I462_n1 VSS) gpdk090_nmos1v w=0.24u l=0.1u ad=0.0816p as=0.0528p pd=1.16u ps=0.68u
    I_MXI3_I467_MN1 (XI3_I467_n1 DIVR_0 VSS VSS) gpdk090_nmos1v w=0.24u l=0.1u ad=0.0528p as=0.0816p pd=0.68u ps=1.16u
    I_MXI3_I467_MN0 (I3_hd32 I3_SEL_DIV_b3_5 XI3_I467_n1 VSS) gpdk090_nmos1v w=0.24u l=0.1u ad=0.0816p as=0.0528p pd=1.16u ps=0.68u
    I_MXI3_I444_MN1 (XI3_I444_n1 XOR_30 VSS VSS) gpdk090_nmos1v w=0.24u l=0.1u ad=0.0528p as=0.0816p pd=0.68u ps=1.16u
    I_MXI3_I444_MN0 (I3_n30_2 I3_SEL_XOR_b3_5 XI3_I444_n1 VSS) gpdk090_nmos1v w=0.24u l=0.1u ad=0.0816p as=0.0528p pd=1.16u ps=0.68u
    I_MXI4_I69_MN1 (XI4_I69_n1 I4_v2 VSS VSS) gpdk090_nmos1v w=0.24u l=0.1u ad=0.0528p as=0.0816p pd=0.68u ps=1.16u
    I_MXI4_I69_MN0 (V I4_v1 XI4_I69_n1 VSS) gpdk090_nmos1v w=0.24u l=0.1u ad=0.0816p as=0.0528p pd=1.16u ps=0.68u
    I_MXI4_I64_MN1 (XI4_I64_n1 SEL_AS VSS VSS) gpdk090_nmos1v w=0.24u l=0.1u ad=0.0528p as=0.0816p pd=0.68u ps=1.16u
    I_MXI4_I64_MN0 (I4_cn CO XI4_I64_n1 VSS) gpdk090_nmos1v w=0.24u l=0.1u ad=0.0816p as=0.0528p pd=1.16u ps=0.68u
    I_MXI4_I67_MN1 (XI4_I67_n1 I4_ovf VSS VSS) gpdk090_nmos1v w=0.24u l=0.1u ad=0.0528p as=0.0816p pd=0.68u ps=1.16u
    I_MXI4_I67_MN0 (I4_v1 SEL_AS XI4_I67_n1 VSS) gpdk090_nmos1v w=0.24u l=0.1u ad=0.0816p as=0.0528p pd=1.16u ps=0.68u
    I_MXI1_I42_I168_XP_MN1 (XI1_I42_I168_XP_n1 I1_I42_P9_2 VSS VSS) gpdk090_nmos1v w=0.24u l=0.1u ad=0.0528p as=0.0816p pd=0.68u ps=1.16u
    I_MXI1_I42_I168_XP_MN0 (I1_I42_P17_2n I1_I42_P17_10 XI1_I42_I168_XP_n1 VSS) gpdk090_nmos1v w=0.24u l=0.1u ad=0.0816p as=0.0528p pd=1.16u ps=0.68u
    I_MXI1_I42_I107_XP_MN1 (XI1_I42_I107_XP_n1 I1_I42_P9_8 VSS VSS) gpdk090_nmos1v w=0.24u l=0.1u ad=0.0528p as=0.0816p pd=0.68u ps=1.16u
    I_MXI1_I42_I107_XP_MN0 (I1_I42_P11_8n I1_I42_P11_10 XI1_I42_I107_XP_n1 VSS) gpdk090_nmos1v w=0.24u l=0.1u ad=0.0816p as=0.0528p pd=1.16u ps=0.68u
    I_MXI3_I225_MN1 (XI3_I225_n1 I3_q11_2 VSS VSS) gpdk090_nmos1v w=0.24u l=0.1u ad=0.0528p as=0.0816p pd=0.68u ps=1.16u
    I_MXI3_I225_MN0 (Y_11 I3_q11_1 XI3_I225_n1 VSS) gpdk090_nmos1v w=0.24u l=0.1u ad=0.0816p as=0.0528p pd=1.16u ps=0.68u
    I_MXI1_I42_I106_XP_MN1 (XI1_I42_I106_XP_n1 I1_I42_P8_7 VSS VSS) gpdk090_nmos1v w=0.24u l=0.1u ad=0.0528p as=0.0816p pd=0.68u ps=1.16u
    I_MXI1_I42_I106_XP_MN0 (I1_I42_P10_7n I1_I42_P10_9 XI1_I42_I106_XP_n1 VSS) gpdk090_nmos1v w=0.24u l=0.1u ad=0.0816p as=0.0528p pd=1.16u ps=0.68u
    I_MXI1_I42_I104_XP_MN1 (XI1_I42_I104_XP_n1 I1_I42_P6_5 VSS VSS) gpdk090_nmos1v w=0.24u l=0.1u ad=0.0528p as=0.0816p pd=0.68u ps=1.16u
    I_MXI1_I42_I104_XP_MN0 (I1_I42_P8_5n I1_I42_P8_7 XI1_I42_I104_XP_n1 VSS) gpdk090_nmos1v w=0.24u l=0.1u ad=0.0816p as=0.0528p pd=1.16u ps=0.68u
    I_MXI1_I42_I102_XP_MN1 (XI1_I42_I102_XP_n1 I1_I42_P4_3 VSS VSS) gpdk090_nmos1v w=0.24u l=0.1u ad=0.0528p as=0.0816p pd=0.68u ps=1.16u
    I_MXI1_I42_I102_XP_MN0 (I1_I42_P6_3n I1_I42_P6_5 XI1_I42_I102_XP_n1 VSS) gpdk090_nmos1v w=0.24u l=0.1u ad=0.0816p as=0.0528p pd=1.16u ps=0.68u
    I_MXI1_I42_I100_XP_MN1 (XI1_I42_I100_XP_n1 I1_I42_P2_1 VSS VSS) gpdk090_nmos1v w=0.24u l=0.1u ad=0.0528p as=0.0816p pd=0.68u ps=1.16u
    I_MXI1_I42_I100_XP_MN0 (I1_I42_P4_1n I1_I42_P4_3 XI1_I42_I100_XP_n1 VSS) gpdk090_nmos1v w=0.24u l=0.1u ad=0.0816p as=0.0528p pd=1.16u ps=0.68u
    I_MXI3_I214_MN1 (XI3_I214_n1 AND_11 VSS VSS) gpdk090_nmos1v w=0.24u l=0.1u ad=0.0528p as=0.0816p pd=0.68u ps=1.16u
    I_MXI3_I214_MN0 (I3_n11_0 I3_SEL_AND_b3_2 XI3_I214_n1 VSS) gpdk090_nmos1v w=0.24u l=0.1u ad=0.0816p as=0.0528p pd=1.16u ps=0.68u
    I_MXI3_I220_MN1 (XI3_I220_n1 I3_n11_1 VSS VSS) gpdk090_nmos1v w=0.24u l=0.1u ad=0.0528p as=0.0816p pd=0.68u ps=1.16u
    I_MXI3_I220_MN0 (I3_o11_0 I3_n11_0 XI3_I220_n1 VSS) gpdk090_nmos1v w=0.24u l=0.1u ad=0.0816p as=0.0528p pd=1.16u ps=0.68u
    I_MXI2_I66_MN1 (XI2_I66_n1 B_11 VSS VSS) gpdk090_nmos1v w=0.24u l=0.1u ad=0.0528p as=0.0816p pd=0.68u ps=1.16u
    I_MXI2_I66_MN0 (I2_nand11 A_11 XI2_I66_n1 VSS) gpdk090_nmos1v w=0.24u l=0.1u ad=0.0816p as=0.0528p pd=1.16u ps=0.68u
    I_MXI3_I215_MN1 (XI3_I215_n1 OR_11 VSS VSS) gpdk090_nmos1v w=0.24u l=0.1u ad=0.0528p as=0.0816p pd=0.68u ps=1.16u
    I_MXI3_I215_MN0 (I3_n11_1 I3_SEL_OR_b3_2 XI3_I215_n1 VSS) gpdk090_nmos1v w=0.24u l=0.1u ad=0.0816p as=0.0528p pd=1.16u ps=0.68u
    I_MXI3_I217_MN1 (XI3_I217_n1 NOT_11 VSS VSS) gpdk090_nmos1v w=0.24u l=0.1u ad=0.0528p as=0.0816p pd=0.68u ps=1.16u
    I_MXI3_I217_MN0 (I3_n11_3 I3_SEL_NOT_b3_2 XI3_I217_n1 VSS) gpdk090_nmos1v w=0.24u l=0.1u ad=0.0816p as=0.0528p pd=1.16u ps=0.68u
    I_MXI3_I221_MN1 (XI3_I221_n1 I3_n11_3 VSS VSS) gpdk090_nmos1v w=0.24u l=0.1u ad=0.0528p as=0.0816p pd=0.68u ps=1.16u
    I_MXI3_I221_MN0 (I3_o11_1 I3_n11_2 XI3_I221_n1 VSS) gpdk090_nmos1v w=0.24u l=0.1u ad=0.0816p as=0.0528p pd=1.16u ps=0.68u
    I_MXI3_I227_MN1 (XI3_I227_n1 OR_12 VSS VSS) gpdk090_nmos1v w=0.24u l=0.1u ad=0.0528p as=0.0816p pd=0.68u ps=1.16u
    I_MXI3_I227_MN0 (I3_n12_1 I3_SEL_OR_b3_2 XI3_I227_n1 VSS) gpdk090_nmos1v w=0.24u l=0.1u ad=0.0816p as=0.0528p pd=1.16u ps=0.68u
    I_MXI2_I180_MN1 (XI2_I180_n1 B_30 VSS VSS) gpdk090_nmos1v w=0.24u l=0.1u ad=0.0528p as=0.0816p pd=0.68u ps=1.16u
    I_MXI2_I180_MN0 (I2_nand30 A_30 XI2_I180_n1 VSS) gpdk090_nmos1v w=0.24u l=0.1u ad=0.0816p as=0.0528p pd=1.16u ps=0.68u
    I_MXI3_I443_MN1 (XI3_I443_n1 OR_30 VSS VSS) gpdk090_nmos1v w=0.24u l=0.1u ad=0.0528p as=0.0816p pd=0.68u ps=1.16u
    I_MXI3_I443_MN0 (I3_n30_1 I3_SEL_OR_b3_5 XI3_I443_n1 VSS) gpdk090_nmos1v w=0.24u l=0.1u ad=0.0816p as=0.0528p pd=1.16u ps=0.68u
    I_MXI3_I453_MN1 (XI3_I453_n1 I3_q30_2 VSS VSS) gpdk090_nmos1v w=0.24u l=0.1u ad=0.0528p as=0.0816p pd=0.68u ps=1.16u
    I_MXI3_I453_MN0 (Y_30 I3_q30_1 XI3_I453_n1 VSS) gpdk090_nmos1v w=0.24u l=0.1u ad=0.0816p as=0.0528p pd=1.16u ps=0.68u
    I_MXI3_I465_MN1 (XI3_I465_n1 I3_q31_2 VSS VSS) gpdk090_nmos1v w=0.24u l=0.1u ad=0.0528p as=0.0816p pd=0.68u ps=1.16u
    I_MXI3_I465_MN0 (Y_31 I3_q31_1 XI3_I465_n1 VSS) gpdk090_nmos1v w=0.24u l=0.1u ad=0.0816p as=0.0528p pd=1.16u ps=0.68u
    I_MXI3_I449_MN1 (XI3_I449_n1 I3_n30_3 VSS VSS) gpdk090_nmos1v w=0.24u l=0.1u ad=0.0528p as=0.0816p pd=0.68u ps=1.16u
    I_MXI3_I449_MN0 (I3_o30_1 I3_n30_2 XI3_I449_n1 VSS) gpdk090_nmos1v w=0.24u l=0.1u ad=0.0816p as=0.0528p pd=1.16u ps=0.68u
    I_MXI3_I445_MN1 (XI3_I445_n1 NOT_30 VSS VSS) gpdk090_nmos1v w=0.24u l=0.1u ad=0.0528p as=0.0816p pd=0.68u ps=1.16u
    I_MXI3_I445_MN0 (I3_n30_3 I3_SEL_NOT_b3_5 XI3_I445_n1 VSS) gpdk090_nmos1v w=0.24u l=0.1u ad=0.0816p as=0.0528p pd=1.16u ps=0.68u
    I_MXI3_I461_MN1 (XI3_I461_n1 I3_n31_3 VSS VSS) gpdk090_nmos1v w=0.24u l=0.1u ad=0.0528p as=0.0816p pd=0.68u ps=1.16u
    I_MXI3_I461_MN0 (I3_o31_1 I3_n31_2 XI3_I461_n1 VSS) gpdk090_nmos1v w=0.24u l=0.1u ad=0.0816p as=0.0528p pd=1.16u ps=0.68u
    I_MXI3_I457_MN1 (XI3_I457_n1 NOT_31 VSS VSS) gpdk090_nmos1v w=0.24u l=0.1u ad=0.0528p as=0.0816p pd=0.68u ps=1.16u
    I_MXI3_I457_MN0 (I3_n31_3 I3_SEL_NOT_b3_5 XI3_I457_n1 VSS) gpdk090_nmos1v w=0.24u l=0.1u ad=0.0816p as=0.0528p pd=1.16u ps=0.68u
    I_MXI3_I456_MN1 (XI3_I456_n1 XOR_31 VSS VSS) gpdk090_nmos1v w=0.24u l=0.1u ad=0.0528p as=0.0816p pd=0.68u ps=1.16u
    I_MXI3_I456_MN0 (I3_n31_2 I3_SEL_XOR_b3_5 XI3_I456_n1 VSS) gpdk090_nmos1v w=0.24u l=0.1u ad=0.0816p as=0.0528p pd=1.16u ps=0.68u
    I_MXI1_I42_I30_MN1 (XI1_I42_I30_n1 I1_bx30 VSS VSS) gpdk090_nmos1v w=0.24u l=0.1u ad=0.0528p as=0.0816p pd=0.68u ps=1.16u
    I_MXI1_I42_I30_MN0 (I1_I42_gn30 A_30 XI1_I42_I30_n1 VSS) gpdk090_nmos1v w=0.24u l=0.1u ad=0.0816p as=0.0528p pd=1.16u ps=0.68u
    I_MXI1_I42_I176_XP_MN1 (XI1_I42_I176_XP_n1 I1_I42_P17_10 VSS VSS) gpdk090_nmos1v w=0.24u l=0.1u ad=0.0528p as=0.0816p pd=0.68u ps=1.16u
    I_MXI1_I42_I176_XP_MN0 (I1_I42_P25_10n I1_I42_P25_18 XI1_I42_I176_XP_n1 VSS) gpdk090_nmos1v w=0.24u l=0.1u ad=0.0816p as=0.0528p pd=1.16u ps=0.68u
    I_MXI1_I42_I172_XP_MN1 (XI1_I42_I172_XP_n1 I1_I42_P13_6 VSS VSS) gpdk090_nmos1v w=0.24u l=0.1u ad=0.0528p as=0.0816p pd=0.68u ps=1.16u
    I_MXI1_I42_I172_XP_MN0 (I1_I42_P21_6n I1_I42_P21_14 XI1_I42_I172_XP_n1 VSS) gpdk090_nmos1v w=0.24u l=0.1u ad=0.0816p as=0.0528p pd=1.16u ps=0.68u
    I_MXI1_I42_I109_XP_MN1 (XI1_I42_I109_XP_n1 I1_I42_P11_10 VSS VSS) gpdk090_nmos1v w=0.24u l=0.1u ad=0.0528p as=0.0816p pd=0.68u ps=1.16u
    I_MXI1_I42_I109_XP_MN0 (I1_I42_P13_10n I1_I42_P13_12 XI1_I42_I109_XP_n1 VSS) gpdk090_nmos1v w=0.24u l=0.1u ad=0.0816p as=0.0528p pd=1.16u ps=0.68u
    I_MXI1_I42_I108_XP_MN1 (XI1_I42_I108_XP_n1 I1_I42_P10_9 VSS VSS) gpdk090_nmos1v w=0.24u l=0.1u ad=0.0528p as=0.0816p pd=0.68u ps=1.16u
    I_MXI1_I42_I108_XP_MN0 (I1_I42_P12_9n I1_I42_P12_11 XI1_I42_I108_XP_n1 VSS) gpdk090_nmos1v w=0.24u l=0.1u ad=0.0816p as=0.0528p pd=1.16u ps=0.68u
    I_MXI1_I42_I167_XP_MN1 (XI1_I42_I167_XP_n1 I1_I42_P8_1 VSS VSS) gpdk090_nmos1v w=0.24u l=0.1u ad=0.0528p as=0.0816p pd=0.68u ps=1.16u
    I_MXI1_I42_I167_XP_MN0 (I1_I42_P16_1n I1_I42_P16_9 XI1_I42_I167_XP_n1 VSS) gpdk090_nmos1v w=0.24u l=0.1u ad=0.0816p as=0.0528p pd=1.16u ps=0.68u
    I_MXI1_I42_I11_MN1 (XI1_I42_I11_n1 I1_bx11 VSS VSS) gpdk090_nmos1v w=0.24u l=0.1u ad=0.0528p as=0.0816p pd=0.68u ps=1.16u
    I_MXI1_I42_I11_MN0 (I1_I42_gn11 A_11 XI1_I42_I11_n1 VSS) gpdk090_nmos1v w=0.24u l=0.1u ad=0.0816p as=0.0528p pd=1.16u ps=0.68u
    I_MXI3_I228_MN1 (XI3_I228_n1 XOR_12 VSS VSS) gpdk090_nmos1v w=0.24u l=0.1u ad=0.0528p as=0.0816p pd=0.68u ps=1.16u
    I_MXI3_I228_MN0 (I3_n12_2 I3_SEL_XOR_b3_2 XI3_I228_n1 VSS) gpdk090_nmos1v w=0.24u l=0.1u ad=0.0816p as=0.0528p pd=1.16u ps=0.68u
    I_MXI3_I226_MN1 (XI3_I226_n1 AND_12 VSS VSS) gpdk090_nmos1v w=0.24u l=0.1u ad=0.0528p as=0.0816p pd=0.68u ps=1.16u
    I_MXI3_I226_MN0 (I3_n12_0 I3_SEL_AND_b3_2 XI3_I226_n1 VSS) gpdk090_nmos1v w=0.24u l=0.1u ad=0.0816p as=0.0528p pd=1.16u ps=0.68u
    I_MXI3_I232_MN1 (XI3_I232_n1 I3_n12_1 VSS VSS) gpdk090_nmos1v w=0.24u l=0.1u ad=0.0528p as=0.0816p pd=0.68u ps=1.16u
    I_MXI3_I232_MN0 (I3_o12_0 I3_n12_0 XI3_I232_n1 VSS) gpdk090_nmos1v w=0.24u l=0.1u ad=0.0816p as=0.0528p pd=1.16u ps=0.68u
    I_MXI2_I72_MN1 (XI2_I72_n1 B_12 VSS VSS) gpdk090_nmos1v w=0.24u l=0.1u ad=0.0528p as=0.0816p pd=0.68u ps=1.16u
    I_MXI2_I72_MN0 (I2_nand12 A_12 XI2_I72_n1 VSS) gpdk090_nmos1v w=0.24u l=0.1u ad=0.0816p as=0.0528p pd=1.16u ps=0.68u
    I_MXI3_I442_MN1 (XI3_I442_n1 AND_30 VSS VSS) gpdk090_nmos1v w=0.24u l=0.1u ad=0.0528p as=0.0816p pd=0.68u ps=1.16u
    I_MXI3_I442_MN0 (I3_n30_0 I3_SEL_AND_b3_5 XI3_I442_n1 VSS) gpdk090_nmos1v w=0.24u l=0.1u ad=0.0816p as=0.0528p pd=1.16u ps=0.68u
    I_MXI3_I430_MN1 (XI3_I430_n1 AND_29 VSS VSS) gpdk090_nmos1v w=0.24u l=0.1u ad=0.0528p as=0.0816p pd=0.68u ps=1.16u
    I_MXI3_I430_MN0 (I3_n29_0 I3_SEL_AND_b3_5 XI3_I430_n1 VSS) gpdk090_nmos1v w=0.24u l=0.1u ad=0.0816p as=0.0528p pd=1.16u ps=0.68u
    I_MXI3_I448_MN1 (XI3_I448_n1 I3_n30_1 VSS VSS) gpdk090_nmos1v w=0.24u l=0.1u ad=0.0528p as=0.0816p pd=0.68u ps=1.16u
    I_MXI3_I448_MN0 (I3_o30_0 I3_n30_0 XI3_I448_n1 VSS) gpdk090_nmos1v w=0.24u l=0.1u ad=0.0816p as=0.0528p pd=1.16u ps=0.68u
    I_MXI3_I431_MN1 (XI3_I431_n1 OR_29 VSS VSS) gpdk090_nmos1v w=0.24u l=0.1u ad=0.0528p as=0.0816p pd=0.68u ps=1.16u
    I_MXI3_I431_MN0 (I3_n29_1 I3_SEL_OR_b3_5 XI3_I431_n1 VSS) gpdk090_nmos1v w=0.24u l=0.1u ad=0.0816p as=0.0528p pd=1.16u ps=0.68u
    I_MXI3_I454_MN1 (XI3_I454_n1 AND_31 VSS VSS) gpdk090_nmos1v w=0.24u l=0.1u ad=0.0528p as=0.0816p pd=0.68u ps=1.16u
    I_MXI3_I454_MN0 (I3_n31_0 I3_SEL_AND_b3_5 XI3_I454_n1 VSS) gpdk090_nmos1v w=0.24u l=0.1u ad=0.0816p as=0.0528p pd=1.16u ps=0.68u
    I_MXI3_I455_MN1 (XI3_I455_n1 OR_31 VSS VSS) gpdk090_nmos1v w=0.24u l=0.1u ad=0.0528p as=0.0816p pd=0.68u ps=1.16u
    I_MXI3_I455_MN0 (I3_n31_1 I3_SEL_OR_b3_5 XI3_I455_n1 VSS) gpdk090_nmos1v w=0.24u l=0.1u ad=0.0816p as=0.0528p pd=1.16u ps=0.68u
    I_MXI3_I460_MN1 (XI3_I460_n1 I3_n31_1 VSS VSS) gpdk090_nmos1v w=0.24u l=0.1u ad=0.0528p as=0.0816p pd=0.68u ps=1.16u
    I_MXI3_I460_MN0 (I3_o31_0 I3_n31_0 XI3_I460_n1 VSS) gpdk090_nmos1v w=0.24u l=0.1u ad=0.0816p as=0.0528p pd=1.16u ps=0.68u
    I_MXI2_I186_MN1 (XI2_I186_n1 B_31 VSS VSS) gpdk090_nmos1v w=0.24u l=0.1u ad=0.0528p as=0.0816p pd=0.68u ps=1.16u
    I_MXI2_I186_MN0 (I2_nand31 A_31 XI2_I186_n1 VSS) gpdk090_nmos1v w=0.24u l=0.1u ad=0.0816p as=0.0528p pd=1.16u ps=0.68u
    I_MXI1_I42_I31_MN1 (XI1_I42_I31_n1 I1_bx31 VSS VSS) gpdk090_nmos1v w=0.24u l=0.1u ad=0.0528p as=0.0816p pd=0.68u ps=1.16u
    I_MXI1_I42_I31_MN0 (I1_I42_gn31 A_31 XI1_I42_I31_n1 VSS) gpdk090_nmos1v w=0.24u l=0.1u ad=0.0816p as=0.0528p pd=1.16u ps=0.68u
    I_MXI1_I42_I180_XP_MN1 (XI1_I42_I180_XP_n1 I1_I42_P21_14 VSS VSS) gpdk090_nmos1v w=0.24u l=0.1u ad=0.0528p as=0.0816p pd=0.68u ps=1.16u
    I_MXI1_I42_I180_XP_MN0 (I1_I42_P29_14n I1_I42_P29_22 XI1_I42_I180_XP_n1 VSS) gpdk090_nmos1v w=0.24u l=0.1u ad=0.0816p as=0.0528p pd=1.16u ps=0.68u
    I_MXI1_I42_I111_XP_MN1 (XI1_I42_I111_XP_n1 I1_I42_P13_12 VSS VSS) gpdk090_nmos1v w=0.24u l=0.1u ad=0.0528p as=0.0816p pd=0.68u ps=1.16u
    I_MXI1_I42_I111_XP_MN0 (I1_I42_P15_12n I1_I42_P15_14 XI1_I42_I111_XP_n1 VSS) gpdk090_nmos1v w=0.24u l=0.1u ad=0.0816p as=0.0528p pd=1.16u ps=0.68u
    I_MXI1_I42_I170_XP_MN1 (XI1_I42_I170_XP_n1 I1_I42_P11_4 VSS VSS) gpdk090_nmos1v w=0.24u l=0.1u ad=0.0528p as=0.0816p pd=0.68u ps=1.16u
    I_MXI1_I42_I170_XP_MN0 (I1_I42_P19_4n I1_I42_P19_12 XI1_I42_I170_XP_n1 VSS) gpdk090_nmos1v w=0.24u l=0.1u ad=0.0816p as=0.0528p pd=1.16u ps=0.68u
    I_MXI1_I42_I175_XP_MN1 (XI1_I42_I175_XP_n1 I1_I42_P16_9 VSS VSS) gpdk090_nmos1v w=0.24u l=0.1u ad=0.0528p as=0.0816p pd=0.68u ps=1.16u
    I_MXI1_I42_I175_XP_MN0 (I1_I42_P24_9n I1_I42_P24_17 XI1_I42_I175_XP_n1 VSS) gpdk090_nmos1v w=0.24u l=0.1u ad=0.0816p as=0.0528p pd=1.16u ps=0.68u
    I_MXI1_I42_I13_MN1 (XI1_I42_I13_n1 I1_bx13 VSS VSS) gpdk090_nmos1v w=0.24u l=0.1u ad=0.0528p as=0.0816p pd=0.68u ps=1.16u
    I_MXI1_I42_I13_MN0 (I1_I42_gn13 A_13 XI1_I42_I13_n1 VSS) gpdk090_nmos1v w=0.24u l=0.1u ad=0.0816p as=0.0528p pd=1.16u ps=0.68u
    I_MXI1_I42_I12_MN1 (XI1_I42_I12_n1 I1_bx12 VSS VSS) gpdk090_nmos1v w=0.24u l=0.1u ad=0.0528p as=0.0816p pd=0.68u ps=1.16u
    I_MXI1_I42_I12_MN0 (I1_I42_gn12 A_12 XI1_I42_I12_n1 VSS) gpdk090_nmos1v w=0.24u l=0.1u ad=0.0816p as=0.0528p pd=1.16u ps=0.68u
    I_MXI3_I241_MN1 (XI3_I241_n1 NOT_13 VSS VSS) gpdk090_nmos1v w=0.24u l=0.1u ad=0.0528p as=0.0816p pd=0.68u ps=1.16u
    I_MXI3_I241_MN0 (I3_n13_3 I3_SEL_NOT_b3_2 XI3_I241_n1 VSS) gpdk090_nmos1v w=0.24u l=0.1u ad=0.0816p as=0.0528p pd=1.16u ps=0.68u
    I_MXI3_I229_MN1 (XI3_I229_n1 NOT_12 VSS VSS) gpdk090_nmos1v w=0.24u l=0.1u ad=0.0528p as=0.0816p pd=0.68u ps=1.16u
    I_MXI3_I229_MN0 (I3_n12_3 I3_SEL_NOT_b3_2 XI3_I229_n1 VSS) gpdk090_nmos1v w=0.24u l=0.1u ad=0.0816p as=0.0528p pd=1.16u ps=0.68u
    I_MXI3_I233_MN1 (XI3_I233_n1 I3_n12_3 VSS VSS) gpdk090_nmos1v w=0.24u l=0.1u ad=0.0528p as=0.0816p pd=0.68u ps=1.16u
    I_MXI3_I233_MN0 (I3_o12_1 I3_n12_2 XI3_I233_n1 VSS) gpdk090_nmos1v w=0.24u l=0.1u ad=0.0816p as=0.0528p pd=1.16u ps=0.68u
    I_MXI3_I239_MN1 (XI3_I239_n1 OR_13 VSS VSS) gpdk090_nmos1v w=0.24u l=0.1u ad=0.0528p as=0.0816p pd=0.68u ps=1.16u
    I_MXI3_I239_MN0 (I3_n13_1 I3_SEL_OR_b3_2 XI3_I239_n1 VSS) gpdk090_nmos1v w=0.24u l=0.1u ad=0.0816p as=0.0528p pd=1.16u ps=0.68u
    I_MXI3_I237_MN1 (XI3_I237_n1 I3_q12_2 VSS VSS) gpdk090_nmos1v w=0.24u l=0.1u ad=0.0528p as=0.0816p pd=0.68u ps=1.16u
    I_MXI3_I237_MN0 (Y_12 I3_q12_1 XI3_I237_n1 VSS) gpdk090_nmos1v w=0.24u l=0.1u ad=0.0816p as=0.0528p pd=1.16u ps=0.68u
    I_MXI4_I35_MN1 (XI4_I35_n1 I4_z0_7 VSS VSS) gpdk090_nmos1v w=0.24u l=0.1u ad=0.0528p as=0.0816p pd=0.68u ps=1.16u
    I_MXI4_I35_MN0 (I4_z1_3 I4_z0_6 XI4_I35_n1 VSS) gpdk090_nmos1v w=0.24u l=0.1u ad=0.0816p as=0.0528p pd=1.16u ps=0.68u
    I_MXI3_I435_MN1 (XI3_I435_n1 DIVQ_29 VSS VSS) gpdk090_nmos1v w=0.24u l=0.1u ad=0.0528p as=0.0816p pd=0.68u ps=1.16u
    I_MXI3_I435_MN0 (I3_n29_5 I3_SEL_DIV_b3_4 XI3_I435_n1 VSS) gpdk090_nmos1v w=0.24u l=0.1u ad=0.0816p as=0.0528p pd=1.16u ps=0.68u
    I_MXI3_I434_MN1 (XI3_I434_n1 MULP_29 VSS VSS) gpdk090_nmos1v w=0.24u l=0.1u ad=0.0528p as=0.0816p pd=0.68u ps=1.16u
    I_MXI3_I434_MN0 (I3_n29_4 I3_SEL_MUL_b3_4 XI3_I434_n1 VSS) gpdk090_nmos1v w=0.24u l=0.1u ad=0.0816p as=0.0528p pd=1.16u ps=0.68u
    I_MXI3_I438_MN1 (XI3_I438_n1 I3_n29_5 VSS VSS) gpdk090_nmos1v w=0.24u l=0.1u ad=0.0528p as=0.0816p pd=0.68u ps=1.16u
    I_MXI3_I438_MN0 (I3_o29_2 I3_n29_4 XI3_I438_n1 VSS) gpdk090_nmos1v w=0.24u l=0.1u ad=0.0816p as=0.0528p pd=1.16u ps=0.68u
    I_MXI3_I436_MN1 (XI3_I436_n1 I3_n29_1 VSS VSS) gpdk090_nmos1v w=0.24u l=0.1u ad=0.0528p as=0.0816p pd=0.68u ps=1.16u
    I_MXI3_I436_MN0 (I3_o29_0 I3_n29_0 XI3_I436_n1 VSS) gpdk090_nmos1v w=0.24u l=0.1u ad=0.0816p as=0.0528p pd=1.16u ps=0.68u
    I_MXI4_I39_MN1 (XI4_I39_n1 I4_z0_15 VSS VSS) gpdk090_nmos1v w=0.24u l=0.1u ad=0.0528p as=0.0816p pd=0.68u ps=1.16u
    I_MXI4_I39_MN0 (I4_z1_7 I4_z0_14 XI4_I39_n1 VSS) gpdk090_nmos1v w=0.24u l=0.1u ad=0.0816p as=0.0528p pd=1.16u ps=0.68u
    I_MXI2_I174_MN1 (XI2_I174_n1 B_29 VSS VSS) gpdk090_nmos1v w=0.24u l=0.1u ad=0.0528p as=0.0816p pd=0.68u ps=1.16u
    I_MXI2_I174_MN0 (I2_nand29 A_29 XI2_I174_n1 VSS) gpdk090_nmos1v w=0.24u l=0.1u ad=0.0816p as=0.0528p pd=1.16u ps=0.68u
    I_MXI3_I441_MN1 (XI3_I441_n1 I3_q29_2 VSS VSS) gpdk090_nmos1v w=0.24u l=0.1u ad=0.0528p as=0.0816p pd=0.68u ps=1.16u
    I_MXI3_I441_MN0 (Y_29 I3_q29_1 XI3_I441_n1 VSS) gpdk090_nmos1v w=0.24u l=0.1u ad=0.0816p as=0.0528p pd=1.16u ps=0.68u
    I_MXI3_I437_MN1 (XI3_I437_n1 I3_n29_3 VSS VSS) gpdk090_nmos1v w=0.24u l=0.1u ad=0.0528p as=0.0816p pd=0.68u ps=1.16u
    I_MXI3_I437_MN0 (I3_o29_1 I3_n29_2 XI3_I437_n1 VSS) gpdk090_nmos1v w=0.24u l=0.1u ad=0.0816p as=0.0528p pd=1.16u ps=0.68u
    I_MXI3_I433_MN1 (XI3_I433_n1 NOT_29 VSS VSS) gpdk090_nmos1v w=0.24u l=0.1u ad=0.0528p as=0.0816p pd=0.68u ps=1.16u
    I_MXI3_I433_MN0 (I3_n29_3 I3_SEL_NOT_b3_5 XI3_I433_n1 VSS) gpdk090_nmos1v w=0.24u l=0.1u ad=0.0816p as=0.0528p pd=1.16u ps=0.68u
    I_MXI3_I432_MN1 (XI3_I432_n1 XOR_29 VSS VSS) gpdk090_nmos1v w=0.24u l=0.1u ad=0.0528p as=0.0816p pd=0.68u ps=1.16u
    I_MXI3_I432_MN0 (I3_n29_2 I3_SEL_XOR_b3_5 XI3_I432_n1 VSS) gpdk090_nmos1v w=0.24u l=0.1u ad=0.0816p as=0.0528p pd=1.16u ps=0.68u
    I_MXI1_I42_I29_MN1 (XI1_I42_I29_n1 I1_bx29 VSS VSS) gpdk090_nmos1v w=0.24u l=0.1u ad=0.0528p as=0.0816p pd=0.68u ps=1.16u
    I_MXI1_I42_I29_MN0 (I1_I42_gn29 A_29 XI1_I42_I29_n1 VSS) gpdk090_nmos1v w=0.24u l=0.1u ad=0.0816p as=0.0528p pd=1.16u ps=0.68u
    I_MXI1_I42_I127_XP_MN1 (XI1_I42_I127_XP_n1 I1_I42_P29_28 VSS VSS) gpdk090_nmos1v w=0.24u l=0.1u ad=0.0528p as=0.0816p pd=0.68u ps=1.16u
    I_MXI1_I42_I127_XP_MN0 (I1_I42_P31_28n I1_I42_P31_30 XI1_I42_I127_XP_n1 VSS) gpdk090_nmos1v w=0.24u l=0.1u ad=0.0816p as=0.0528p pd=1.16u ps=0.68u
    I_MXI1_I42_I182_XP_MN1 (XI1_I42_I182_XP_n1 I1_I42_P23_16 VSS VSS) gpdk090_nmos1v w=0.24u l=0.1u ad=0.0528p as=0.0816p pd=0.68u ps=1.16u
    I_MXI1_I42_I182_XP_MN0 (I1_I42_P31_16n I1_I42_P31_24 XI1_I42_I182_XP_n1 VSS) gpdk090_nmos1v w=0.24u l=0.1u ad=0.0816p as=0.0528p pd=1.16u ps=0.68u
    I_MXI1_I42_I174_XP_MN1 (XI1_I42_I174_XP_n1 I1_I42_P15_8 VSS VSS) gpdk090_nmos1v w=0.24u l=0.1u ad=0.0528p as=0.0816p pd=0.68u ps=1.16u
    I_MXI1_I42_I174_XP_MN0 (I1_I42_P23_8n I1_I42_P23_16 XI1_I42_I174_XP_n1 VSS) gpdk090_nmos1v w=0.24u l=0.1u ad=0.0816p as=0.0528p pd=1.16u ps=0.68u
    I_MXI1_I42_I178_XP_MN1 (XI1_I42_I178_XP_n1 I1_I42_P19_12 VSS VSS) gpdk090_nmos1v w=0.24u l=0.1u ad=0.0528p as=0.0816p pd=0.68u ps=1.16u
    I_MXI1_I42_I178_XP_MN0 (I1_I42_P27_12n I1_I42_P27_20 XI1_I42_I178_XP_n1 VSS) gpdk090_nmos1v w=0.24u l=0.1u ad=0.0816p as=0.0528p pd=1.16u ps=0.68u
    I_MXI1_I42_I113_XP_MN1 (XI1_I42_I113_XP_n1 I1_I42_P15_14 VSS VSS) gpdk090_nmos1v w=0.24u l=0.1u ad=0.0528p as=0.0816p pd=0.68u ps=1.16u
    I_MXI1_I42_I113_XP_MN0 (I1_I42_P17_14n I1_I42_P17_16 XI1_I42_I113_XP_n1 VSS) gpdk090_nmos1v w=0.24u l=0.1u ad=0.0816p as=0.0528p pd=1.16u ps=0.68u
    I_MXI1_I42_I169_XP_MN1 (XI1_I42_I169_XP_n1 I1_I42_P10_3 VSS VSS) gpdk090_nmos1v w=0.24u l=0.1u ad=0.0528p as=0.0816p pd=0.68u ps=1.16u
    I_MXI1_I42_I169_XP_MN0 (I1_I42_P18_3n I1_I42_P18_11 XI1_I42_I169_XP_n1 VSS) gpdk090_nmos1v w=0.24u l=0.1u ad=0.0816p as=0.0528p pd=1.16u ps=0.68u
    I_MXI3_I240_MN1 (XI3_I240_n1 XOR_13 VSS VSS) gpdk090_nmos1v w=0.24u l=0.1u ad=0.0528p as=0.0816p pd=0.68u ps=1.16u
    I_MXI3_I240_MN0 (I3_n13_2 I3_SEL_XOR_b3_2 XI3_I240_n1 VSS) gpdk090_nmos1v w=0.24u l=0.1u ad=0.0816p as=0.0528p pd=1.16u ps=0.68u
    I_MXI3_I245_MN1 (XI3_I245_n1 I3_n13_3 VSS VSS) gpdk090_nmos1v w=0.24u l=0.1u ad=0.0528p as=0.0816p pd=0.68u ps=1.16u
    I_MXI3_I245_MN0 (I3_o13_1 I3_n13_2 XI3_I245_n1 VSS) gpdk090_nmos1v w=0.24u l=0.1u ad=0.0816p as=0.0528p pd=1.16u ps=0.68u
    I_MXI2_I78_MN1 (XI2_I78_n1 B_13 VSS VSS) gpdk090_nmos1v w=0.24u l=0.1u ad=0.0528p as=0.0816p pd=0.68u ps=1.16u
    I_MXI2_I78_MN0 (I2_nand13 A_13 XI2_I78_n1 VSS) gpdk090_nmos1v w=0.24u l=0.1u ad=0.0816p as=0.0528p pd=1.16u ps=0.68u
    I_MXI3_I249_MN1 (XI3_I249_n1 I3_q13_2 VSS VSS) gpdk090_nmos1v w=0.24u l=0.1u ad=0.0528p as=0.0816p pd=0.68u ps=1.16u
    I_MXI3_I249_MN0 (Y_13 I3_q13_1 XI3_I249_n1 VSS) gpdk090_nmos1v w=0.24u l=0.1u ad=0.0816p as=0.0528p pd=1.16u ps=0.68u
    I_MXI3_I244_MN1 (XI3_I244_n1 I3_n13_1 VSS VSS) gpdk090_nmos1v w=0.24u l=0.1u ad=0.0528p as=0.0816p pd=0.68u ps=1.16u
    I_MXI3_I244_MN0 (I3_o13_0 I3_n13_0 XI3_I244_n1 VSS) gpdk090_nmos1v w=0.24u l=0.1u ad=0.0816p as=0.0528p pd=1.16u ps=0.68u
    I_MXI3_I246_MN1 (XI3_I246_n1 I3_n13_5 VSS VSS) gpdk090_nmos1v w=0.24u l=0.1u ad=0.0528p as=0.0816p pd=0.68u ps=1.16u
    I_MXI3_I246_MN0 (I3_o13_2 I3_n13_4 XI3_I246_n1 VSS) gpdk090_nmos1v w=0.24u l=0.1u ad=0.0816p as=0.0528p pd=1.16u ps=0.68u
    I_MXI3_I234_MN1 (XI3_I234_n1 I3_n12_5 VSS VSS) gpdk090_nmos1v w=0.24u l=0.1u ad=0.0528p as=0.0816p pd=0.68u ps=1.16u
    I_MXI3_I234_MN0 (I3_o12_2 I3_n12_4 XI3_I234_n1 VSS) gpdk090_nmos1v w=0.24u l=0.1u ad=0.0816p as=0.0528p pd=1.16u ps=0.68u
    I_MXI3_I238_MN1 (XI3_I238_n1 AND_13 VSS VSS) gpdk090_nmos1v w=0.24u l=0.1u ad=0.0528p as=0.0816p pd=0.68u ps=1.16u
    I_MXI3_I238_MN0 (I3_n13_0 I3_SEL_AND_b3_2 XI3_I238_n1 VSS) gpdk090_nmos1v w=0.24u l=0.1u ad=0.0816p as=0.0528p pd=1.16u ps=0.68u
    I_MXI3_I231_MN1 (XI3_I231_n1 DIVQ_12 VSS VSS) gpdk090_nmos1v w=0.24u l=0.1u ad=0.0528p as=0.0816p pd=0.68u ps=1.16u
    I_MXI3_I231_MN0 (I3_n12_5 I3_SEL_DIV_b3_2 XI3_I231_n1 VSS) gpdk090_nmos1v w=0.24u l=0.1u ad=0.0816p as=0.0528p pd=1.16u ps=0.68u
    I_MXI3_I230_MN1 (XI3_I230_n1 MULP_12 VSS VSS) gpdk090_nmos1v w=0.24u l=0.1u ad=0.0528p as=0.0816p pd=0.68u ps=1.16u
    I_MXI3_I230_MN0 (I3_n12_4 I3_SEL_MUL_b3_2 XI3_I230_n1 VSS) gpdk090_nmos1v w=0.24u l=0.1u ad=0.0816p as=0.0528p pd=1.16u ps=0.68u
    I_MXI3_I423_MN1 (XI3_I423_n1 DIVQ_28 VSS VSS) gpdk090_nmos1v w=0.24u l=0.1u ad=0.0528p as=0.0816p pd=0.68u ps=1.16u
    I_MXI3_I423_MN0 (I3_n28_5 I3_SEL_DIV_b3_4 XI3_I423_n1 VSS) gpdk090_nmos1v w=0.24u l=0.1u ad=0.0816p as=0.0528p pd=1.16u ps=0.68u
    I_MXI3_I422_MN1 (XI3_I422_n1 MULP_28 VSS VSS) gpdk090_nmos1v w=0.24u l=0.1u ad=0.0528p as=0.0816p pd=0.68u ps=1.16u
    I_MXI3_I422_MN0 (I3_n28_4 I3_SEL_MUL_b3_4 XI3_I422_n1 VSS) gpdk090_nmos1v w=0.24u l=0.1u ad=0.0816p as=0.0528p pd=1.16u ps=0.68u
    I_MXI3_I418_MN1 (XI3_I418_n1 AND_28 VSS VSS) gpdk090_nmos1v w=0.24u l=0.1u ad=0.0528p as=0.0816p pd=0.68u ps=1.16u
    I_MXI3_I418_MN0 (I3_n28_0 I3_SEL_AND_b3_5 XI3_I418_n1 VSS) gpdk090_nmos1v w=0.24u l=0.1u ad=0.0816p as=0.0528p pd=1.16u ps=0.68u
    I_MXI3_I426_MN1 (XI3_I426_n1 I3_n28_5 VSS VSS) gpdk090_nmos1v w=0.24u l=0.1u ad=0.0528p as=0.0816p pd=0.68u ps=1.16u
    I_MXI3_I426_MN0 (I3_o28_2 I3_n28_4 XI3_I426_n1 VSS) gpdk090_nmos1v w=0.24u l=0.1u ad=0.0816p as=0.0528p pd=1.16u ps=0.68u
    I_MXI3_I419_MN1 (XI3_I419_n1 OR_28 VSS VSS) gpdk090_nmos1v w=0.24u l=0.1u ad=0.0528p as=0.0816p pd=0.68u ps=1.16u
    I_MXI3_I419_MN0 (I3_n28_1 I3_SEL_OR_b3_5 XI3_I419_n1 VSS) gpdk090_nmos1v w=0.24u l=0.1u ad=0.0816p as=0.0528p pd=1.16u ps=0.68u
    I_MXI3_I429_MN1 (XI3_I429_n1 I3_q28_2 VSS VSS) gpdk090_nmos1v w=0.24u l=0.1u ad=0.0528p as=0.0816p pd=0.68u ps=1.16u
    I_MXI3_I429_MN0 (Y_28 I3_q28_1 XI3_I429_n1 VSS) gpdk090_nmos1v w=0.24u l=0.1u ad=0.0816p as=0.0528p pd=1.16u ps=0.68u
    I_MXI3_I424_MN1 (XI3_I424_n1 I3_n28_1 VSS VSS) gpdk090_nmos1v w=0.24u l=0.1u ad=0.0528p as=0.0816p pd=0.68u ps=1.16u
    I_MXI3_I424_MN0 (I3_o28_0 I3_n28_0 XI3_I424_n1 VSS) gpdk090_nmos1v w=0.24u l=0.1u ad=0.0816p as=0.0528p pd=1.16u ps=0.68u
    I_MXI3_I407_MN1 (XI3_I407_n1 OR_27 VSS VSS) gpdk090_nmos1v w=0.24u l=0.1u ad=0.0528p as=0.0816p pd=0.68u ps=1.16u
    I_MXI3_I407_MN0 (I3_n27_1 I3_SEL_OR_b3_5 XI3_I407_n1 VSS) gpdk090_nmos1v w=0.24u l=0.1u ad=0.0816p as=0.0528p pd=1.16u ps=0.68u
    I_MXI3_I421_MN1 (XI3_I421_n1 NOT_28 VSS VSS) gpdk090_nmos1v w=0.24u l=0.1u ad=0.0528p as=0.0816p pd=0.68u ps=1.16u
    I_MXI3_I421_MN0 (I3_n28_3 I3_SEL_NOT_b3_5 XI3_I421_n1 VSS) gpdk090_nmos1v w=0.24u l=0.1u ad=0.0816p as=0.0528p pd=1.16u ps=0.68u
    I_MXI3_I425_MN1 (XI3_I425_n1 I3_n28_3 VSS VSS) gpdk090_nmos1v w=0.24u l=0.1u ad=0.0528p as=0.0816p pd=0.68u ps=1.16u
    I_MXI3_I425_MN0 (I3_o28_1 I3_n28_2 XI3_I425_n1 VSS) gpdk090_nmos1v w=0.24u l=0.1u ad=0.0816p as=0.0528p pd=1.16u ps=0.68u
    I_MXI3_I420_MN1 (XI3_I420_n1 XOR_28 VSS VSS) gpdk090_nmos1v w=0.24u l=0.1u ad=0.0528p as=0.0816p pd=0.68u ps=1.16u
    I_MXI3_I420_MN0 (I3_n28_2 I3_SEL_XOR_b3_5 XI3_I420_n1 VSS) gpdk090_nmos1v w=0.24u l=0.1u ad=0.0816p as=0.0528p pd=1.16u ps=0.68u
    I_MXI1_I42_I28_MN1 (XI1_I42_I28_n1 I1_bx28 VSS VSS) gpdk090_nmos1v w=0.24u l=0.1u ad=0.0528p as=0.0816p pd=0.68u ps=1.16u
    I_MXI1_I42_I28_MN0 (I1_I42_gn28 A_28 XI1_I42_I28_n1 VSS) gpdk090_nmos1v w=0.24u l=0.1u ad=0.0816p as=0.0528p pd=1.16u ps=0.68u
    I_MXI1_I42_I125_XP_MN1 (XI1_I42_I125_XP_n1 I1_I42_P27_26 VSS VSS) gpdk090_nmos1v w=0.24u l=0.1u ad=0.0528p as=0.0816p pd=0.68u ps=1.16u
    I_MXI1_I42_I125_XP_MN0 (I1_I42_P29_26n I1_I42_P29_28 XI1_I42_I125_XP_n1 VSS) gpdk090_nmos1v w=0.24u l=0.1u ad=0.0816p as=0.0528p pd=1.16u ps=0.68u
    I_MXI1_I42_I123_XP_MN1 (XI1_I42_I123_XP_n1 I1_I42_P25_24 VSS VSS) gpdk090_nmos1v w=0.24u l=0.1u ad=0.0528p as=0.0816p pd=0.68u ps=1.16u
    I_MXI1_I42_I123_XP_MN0 (I1_I42_P27_24n I1_I42_P27_26 XI1_I42_I123_XP_n1 VSS) gpdk090_nmos1v w=0.24u l=0.1u ad=0.0816p as=0.0528p pd=1.16u ps=0.68u
    I_MXI1_I42_I121_XP_MN1 (XI1_I42_I121_XP_n1 I1_I42_P23_22 VSS VSS) gpdk090_nmos1v w=0.24u l=0.1u ad=0.0528p as=0.0816p pd=0.68u ps=1.16u
    I_MXI1_I42_I121_XP_MN0 (I1_I42_P25_22n I1_I42_P25_24 XI1_I42_I121_XP_n1 VSS) gpdk090_nmos1v w=0.24u l=0.1u ad=0.0816p as=0.0528p pd=1.16u ps=0.68u
    I_MXI1_I42_I119_XP_MN1 (XI1_I42_I119_XP_n1 I1_I42_P21_20 VSS VSS) gpdk090_nmos1v w=0.24u l=0.1u ad=0.0528p as=0.0816p pd=0.68u ps=1.16u
    I_MXI1_I42_I119_XP_MN0 (I1_I42_P23_20n I1_I42_P23_22 XI1_I42_I119_XP_n1 VSS) gpdk090_nmos1v w=0.24u l=0.1u ad=0.0816p as=0.0528p pd=1.16u ps=0.68u
    I_MXI1_I42_I117_XP_MN1 (XI1_I42_I117_XP_n1 I1_I42_P19_18 VSS VSS) gpdk090_nmos1v w=0.24u l=0.1u ad=0.0528p as=0.0816p pd=0.68u ps=1.16u
    I_MXI1_I42_I117_XP_MN0 (I1_I42_P21_18n I1_I42_P21_20 XI1_I42_I117_XP_n1 VSS) gpdk090_nmos1v w=0.24u l=0.1u ad=0.0816p as=0.0528p pd=1.16u ps=0.68u
    I_MXI1_I42_I115_XP_MN1 (XI1_I42_I115_XP_n1 I1_I42_P17_16 VSS VSS) gpdk090_nmos1v w=0.24u l=0.1u ad=0.0528p as=0.0816p pd=0.68u ps=1.16u
    I_MXI1_I42_I115_XP_MN0 (I1_I42_P19_16n I1_I42_P19_18 XI1_I42_I115_XP_n1 VSS) gpdk090_nmos1v w=0.24u l=0.1u ad=0.0816p as=0.0528p pd=1.16u ps=0.68u
    I_MXI1_I42_I179_XP_MN1 (XI1_I42_I179_XP_n1 I1_I42_P20_13 VSS VSS) gpdk090_nmos1v w=0.24u l=0.1u ad=0.0528p as=0.0816p pd=0.68u ps=1.16u
    I_MXI1_I42_I179_XP_MN0 (I1_I42_P28_13n I1_I42_P28_21 XI1_I42_I179_XP_n1 VSS) gpdk090_nmos1v w=0.24u l=0.1u ad=0.0816p as=0.0528p pd=1.16u ps=0.68u
    I_MXI1_I42_I171_XP_MN1 (XI1_I42_I171_XP_n1 I1_I42_P12_5 VSS VSS) gpdk090_nmos1v w=0.24u l=0.1u ad=0.0528p as=0.0816p pd=0.68u ps=1.16u
    I_MXI1_I42_I171_XP_MN0 (I1_I42_P20_5n I1_I42_P20_13 XI1_I42_I171_XP_n1 VSS) gpdk090_nmos1v w=0.24u l=0.1u ad=0.0816p as=0.0528p pd=1.16u ps=0.68u
    I_MXI1_I42_I110_XP_MN1 (XI1_I42_I110_XP_n1 I1_I42_P12_11 VSS VSS) gpdk090_nmos1v w=0.24u l=0.1u ad=0.0528p as=0.0816p pd=0.68u ps=1.16u
    I_MXI1_I42_I110_XP_MN0 (I1_I42_P14_11n I1_I42_P14_13 XI1_I42_I110_XP_n1 VSS) gpdk090_nmos1v w=0.24u l=0.1u ad=0.0816p as=0.0528p pd=1.16u ps=0.68u
    I_MXI1_I42_I112_XP_MN1 (XI1_I42_I112_XP_n1 I1_I42_P14_13 VSS VSS) gpdk090_nmos1v w=0.24u l=0.1u ad=0.0528p as=0.0816p pd=0.68u ps=1.16u
    I_MXI1_I42_I112_XP_MN0 (I1_I42_P16_13n I1_I42_P16_15 XI1_I42_I112_XP_n1 VSS) gpdk090_nmos1v w=0.24u l=0.1u ad=0.0816p as=0.0528p pd=1.16u ps=0.68u
    I_MXI3_I252_MN1 (XI3_I252_n1 XOR_14 VSS VSS) gpdk090_nmos1v w=0.24u l=0.1u ad=0.0528p as=0.0816p pd=0.68u ps=1.16u
    I_MXI3_I252_MN0 (I3_n14_2 I3_SEL_XOR_b3_2 XI3_I252_n1 VSS) gpdk090_nmos1v w=0.24u l=0.1u ad=0.0816p as=0.0528p pd=1.16u ps=0.68u
    I_MXI3_I253_MN1 (XI3_I253_n1 NOT_14 VSS VSS) gpdk090_nmos1v w=0.24u l=0.1u ad=0.0528p as=0.0816p pd=0.68u ps=1.16u
    I_MXI3_I253_MN0 (I3_n14_3 I3_SEL_NOT_b3_2 XI3_I253_n1 VSS) gpdk090_nmos1v w=0.24u l=0.1u ad=0.0816p as=0.0528p pd=1.16u ps=0.68u
    I_MXI3_I257_MN1 (XI3_I257_n1 I3_n14_3 VSS VSS) gpdk090_nmos1v w=0.24u l=0.1u ad=0.0528p as=0.0816p pd=0.68u ps=1.16u
    I_MXI3_I257_MN0 (I3_o14_1 I3_n14_2 XI3_I257_n1 VSS) gpdk090_nmos1v w=0.24u l=0.1u ad=0.0816p as=0.0528p pd=1.16u ps=0.68u
    I_MXI2_I84_MN1 (XI2_I84_n1 B_14 VSS VSS) gpdk090_nmos1v w=0.24u l=0.1u ad=0.0528p as=0.0816p pd=0.68u ps=1.16u
    I_MXI2_I84_MN0 (I2_nand14 A_14 XI2_I84_n1 VSS) gpdk090_nmos1v w=0.24u l=0.1u ad=0.0816p as=0.0528p pd=1.16u ps=0.68u
    I_MXI3_I261_MN1 (XI3_I261_n1 I3_q14_2 VSS VSS) gpdk090_nmos1v w=0.24u l=0.1u ad=0.0528p as=0.0816p pd=0.68u ps=1.16u
    I_MXI3_I261_MN0 (Y_14 I3_q14_1 XI3_I261_n1 VSS) gpdk090_nmos1v w=0.24u l=0.1u ad=0.0816p as=0.0528p pd=1.16u ps=0.68u
    I_MXI3_I256_MN1 (XI3_I256_n1 I3_n14_1 VSS VSS) gpdk090_nmos1v w=0.24u l=0.1u ad=0.0528p as=0.0816p pd=0.68u ps=1.16u
    I_MXI3_I256_MN0 (I3_o14_0 I3_n14_0 XI3_I256_n1 VSS) gpdk090_nmos1v w=0.24u l=0.1u ad=0.0816p as=0.0528p pd=1.16u ps=0.68u
    I_MXI3_I243_MN1 (XI3_I243_n1 DIVQ_13 VSS VSS) gpdk090_nmos1v w=0.24u l=0.1u ad=0.0528p as=0.0816p pd=0.68u ps=1.16u
    I_MXI3_I243_MN0 (I3_n13_5 I3_SEL_DIV_b3_2 XI3_I243_n1 VSS) gpdk090_nmos1v w=0.24u l=0.1u ad=0.0816p as=0.0528p pd=1.16u ps=0.68u
    I_MXI3_I250_MN1 (XI3_I250_n1 AND_14 VSS VSS) gpdk090_nmos1v w=0.24u l=0.1u ad=0.0528p as=0.0816p pd=0.68u ps=1.16u
    I_MXI3_I250_MN0 (I3_n14_0 I3_SEL_AND_b3_2 XI3_I250_n1 VSS) gpdk090_nmos1v w=0.24u l=0.1u ad=0.0816p as=0.0528p pd=1.16u ps=0.68u
    I_MXI3_I242_MN1 (XI3_I242_n1 MULP_13 VSS VSS) gpdk090_nmos1v w=0.24u l=0.1u ad=0.0528p as=0.0816p pd=0.68u ps=1.16u
    I_MXI3_I242_MN0 (I3_n13_4 I3_SEL_MUL_b3_2 XI3_I242_n1 VSS) gpdk090_nmos1v w=0.24u l=0.1u ad=0.0816p as=0.0528p pd=1.16u ps=0.68u
    I_MXI2_I168_MN1 (XI2_I168_n1 B_28 VSS VSS) gpdk090_nmos1v w=0.24u l=0.1u ad=0.0528p as=0.0816p pd=0.68u ps=1.16u
    I_MXI2_I168_MN0 (I2_nand28 A_28 XI2_I168_n1 VSS) gpdk090_nmos1v w=0.24u l=0.1u ad=0.0816p as=0.0528p pd=1.16u ps=0.68u
    I_MXI3_I411_MN1 (XI3_I411_n1 DIVQ_27 VSS VSS) gpdk090_nmos1v w=0.24u l=0.1u ad=0.0528p as=0.0816p pd=0.68u ps=1.16u
    I_MXI3_I411_MN0 (I3_n27_5 I3_SEL_DIV_b3_4 XI3_I411_n1 VSS) gpdk090_nmos1v w=0.24u l=0.1u ad=0.0816p as=0.0528p pd=1.16u ps=0.68u
    I_MXI3_I410_MN1 (XI3_I410_n1 MULP_27 VSS VSS) gpdk090_nmos1v w=0.24u l=0.1u ad=0.0528p as=0.0816p pd=0.68u ps=1.16u
    I_MXI3_I410_MN0 (I3_n27_4 I3_SEL_MUL_b3_4 XI3_I410_n1 VSS) gpdk090_nmos1v w=0.24u l=0.1u ad=0.0816p as=0.0528p pd=1.16u ps=0.68u
    I_MXI3_I414_MN1 (XI3_I414_n1 I3_n27_5 VSS VSS) gpdk090_nmos1v w=0.24u l=0.1u ad=0.0528p as=0.0816p pd=0.68u ps=1.16u
    I_MXI3_I414_MN0 (I3_o27_2 I3_n27_4 XI3_I414_n1 VSS) gpdk090_nmos1v w=0.24u l=0.1u ad=0.0816p as=0.0528p pd=1.16u ps=0.68u
    I_MXI3_I417_MN1 (XI3_I417_n1 I3_q27_2 VSS VSS) gpdk090_nmos1v w=0.24u l=0.1u ad=0.0528p as=0.0816p pd=0.68u ps=1.16u
    I_MXI3_I417_MN0 (Y_27 I3_q27_1 XI3_I417_n1 VSS) gpdk090_nmos1v w=0.24u l=0.1u ad=0.0816p as=0.0528p pd=1.16u ps=0.68u
    I_MXI3_I412_MN1 (XI3_I412_n1 I3_n27_1 VSS VSS) gpdk090_nmos1v w=0.24u l=0.1u ad=0.0528p as=0.0816p pd=0.68u ps=1.16u
    I_MXI3_I412_MN0 (I3_o27_0 I3_n27_0 XI3_I412_n1 VSS) gpdk090_nmos1v w=0.24u l=0.1u ad=0.0816p as=0.0528p pd=1.16u ps=0.68u
    I_MXI3_I406_MN1 (XI3_I406_n1 AND_27 VSS VSS) gpdk090_nmos1v w=0.24u l=0.1u ad=0.0528p as=0.0816p pd=0.68u ps=1.16u
    I_MXI3_I406_MN0 (I3_n27_0 I3_SEL_AND_b3_5 XI3_I406_n1 VSS) gpdk090_nmos1v w=0.24u l=0.1u ad=0.0816p as=0.0528p pd=1.16u ps=0.68u
    I_MXI3_I413_MN1 (XI3_I413_n1 I3_n27_3 VSS VSS) gpdk090_nmos1v w=0.24u l=0.1u ad=0.0528p as=0.0816p pd=0.68u ps=1.16u
    I_MXI3_I413_MN0 (I3_o27_1 I3_n27_2 XI3_I413_n1 VSS) gpdk090_nmos1v w=0.24u l=0.1u ad=0.0816p as=0.0528p pd=1.16u ps=0.68u
    I_MXI3_I409_MN1 (XI3_I409_n1 NOT_27 VSS VSS) gpdk090_nmos1v w=0.24u l=0.1u ad=0.0528p as=0.0816p pd=0.68u ps=1.16u
    I_MXI3_I409_MN0 (I3_n27_3 I3_SEL_NOT_b3_5 XI3_I409_n1 VSS) gpdk090_nmos1v w=0.24u l=0.1u ad=0.0816p as=0.0528p pd=1.16u ps=0.68u
    I_MXI4_I57_MN1 (XI4_I57_n1 I4_z2_3 VSS VSS) gpdk090_nmos1v w=0.24u l=0.1u ad=0.0528p as=0.0816p pd=0.68u ps=1.16u
    I_MXI4_I57_MN0 (I4_z3_1 I4_z2_2 XI4_I57_n1 VSS) gpdk090_nmos1v w=0.24u l=0.1u ad=0.0816p as=0.0528p pd=1.16u ps=0.68u
    I_MXI1_I42_I126_XP_MN1 (XI1_I42_I126_XP_n1 I1_I42_P28_27 VSS VSS) gpdk090_nmos1v w=0.24u l=0.1u ad=0.0528p as=0.0816p pd=0.68u ps=1.16u
    I_MXI1_I42_I126_XP_MN0 (I1_I42_P30_27n I1_I42_P30_29 XI1_I42_I126_XP_n1 VSS) gpdk090_nmos1v w=0.24u l=0.1u ad=0.0816p as=0.0528p pd=1.16u ps=0.68u
    I_MXI1_I42_I124_XP_MN1 (XI1_I42_I124_XP_n1 I1_I42_P26_25 VSS VSS) gpdk090_nmos1v w=0.24u l=0.1u ad=0.0528p as=0.0816p pd=0.68u ps=1.16u
    I_MXI1_I42_I124_XP_MN0 (I1_I42_P28_25n I1_I42_P28_27 XI1_I42_I124_XP_n1 VSS) gpdk090_nmos1v w=0.24u l=0.1u ad=0.0816p as=0.0528p pd=1.16u ps=0.68u
    I_MXI1_I42_I181_XP_MN1 (XI1_I42_I181_XP_n1 I1_I42_P22_15 VSS VSS) gpdk090_nmos1v w=0.24u l=0.1u ad=0.0528p as=0.0816p pd=0.68u ps=1.16u
    I_MXI1_I42_I181_XP_MN0 (I1_I42_P30_15n I1_I42_P30_23 XI1_I42_I181_XP_n1 VSS) gpdk090_nmos1v w=0.24u l=0.1u ad=0.0816p as=0.0528p pd=1.16u ps=0.68u
    I_MXI1_I42_I173_XP_MN1 (XI1_I42_I173_XP_n1 I1_I42_P14_7 VSS VSS) gpdk090_nmos1v w=0.24u l=0.1u ad=0.0528p as=0.0816p pd=0.68u ps=1.16u
    I_MXI1_I42_I173_XP_MN0 (I1_I42_P22_7n I1_I42_P22_15 XI1_I42_I173_XP_n1 VSS) gpdk090_nmos1v w=0.24u l=0.1u ad=0.0816p as=0.0528p pd=1.16u ps=0.68u
    I_MXI1_I42_I177_XP_MN1 (XI1_I42_I177_XP_n1 I1_I42_P18_11 VSS VSS) gpdk090_nmos1v w=0.24u l=0.1u ad=0.0528p as=0.0816p pd=0.68u ps=1.16u
    I_MXI1_I42_I177_XP_MN0 (I1_I42_P26_11n I1_I42_P26_19 XI1_I42_I177_XP_n1 VSS) gpdk090_nmos1v w=0.24u l=0.1u ad=0.0816p as=0.0528p pd=1.16u ps=0.68u
    I_MXI1_I42_I114_XP_MN1 (XI1_I42_I114_XP_n1 I1_I42_P16_15 VSS VSS) gpdk090_nmos1v w=0.24u l=0.1u ad=0.0528p as=0.0816p pd=0.68u ps=1.16u
    I_MXI1_I42_I114_XP_MN0 (I1_I42_P18_15n I1_I42_P18_17 XI1_I42_I114_XP_n1 VSS) gpdk090_nmos1v w=0.24u l=0.1u ad=0.0816p as=0.0528p pd=1.16u ps=0.68u
    I_MXI1_I42_I14_MN1 (XI1_I42_I14_n1 I1_bx14 VSS VSS) gpdk090_nmos1v w=0.24u l=0.1u ad=0.0528p as=0.0816p pd=0.68u ps=1.16u
    I_MXI1_I42_I14_MN0 (I1_I42_gn14 A_14 XI1_I42_I14_n1 VSS) gpdk090_nmos1v w=0.24u l=0.1u ad=0.0816p as=0.0528p pd=1.16u ps=0.68u
    I_MXI3_I265_MN1 (XI3_I265_n1 NOT_15 VSS VSS) gpdk090_nmos1v w=0.24u l=0.1u ad=0.0528p as=0.0816p pd=0.68u ps=1.16u
    I_MXI3_I265_MN0 (I3_n15_3 I3_SEL_NOT_b3_2 XI3_I265_n1 VSS) gpdk090_nmos1v w=0.24u l=0.1u ad=0.0816p as=0.0528p pd=1.16u ps=0.68u
    I_MXI3_I269_MN1 (XI3_I269_n1 I3_n15_3 VSS VSS) gpdk090_nmos1v w=0.24u l=0.1u ad=0.0528p as=0.0816p pd=0.68u ps=1.16u
    I_MXI3_I269_MN0 (I3_o15_1 I3_n15_2 XI3_I269_n1 VSS) gpdk090_nmos1v w=0.24u l=0.1u ad=0.0816p as=0.0528p pd=1.16u ps=0.68u
    I_MXI3_I251_MN1 (XI3_I251_n1 OR_14 VSS VSS) gpdk090_nmos1v w=0.24u l=0.1u ad=0.0528p as=0.0816p pd=0.68u ps=1.16u
    I_MXI3_I251_MN0 (I3_n14_1 I3_SEL_OR_b3_2 XI3_I251_n1 VSS) gpdk090_nmos1v w=0.24u l=0.1u ad=0.0816p as=0.0528p pd=1.16u ps=0.68u
    I_MXI3_I273_MN1 (XI3_I273_n1 I3_q15_2 VSS VSS) gpdk090_nmos1v w=0.24u l=0.1u ad=0.0528p as=0.0816p pd=0.68u ps=1.16u
    I_MXI3_I273_MN0 (Y_15 I3_q15_1 XI3_I273_n1 VSS) gpdk090_nmos1v w=0.24u l=0.1u ad=0.0816p as=0.0528p pd=1.16u ps=0.68u
    I_MXI3_I258_MN1 (XI3_I258_n1 I3_n14_5 VSS VSS) gpdk090_nmos1v w=0.24u l=0.1u ad=0.0528p as=0.0816p pd=0.68u ps=1.16u
    I_MXI3_I258_MN0 (I3_o14_2 I3_n14_4 XI3_I258_n1 VSS) gpdk090_nmos1v w=0.24u l=0.1u ad=0.0816p as=0.0528p pd=1.16u ps=0.68u
    I_MXI3_I255_MN1 (XI3_I255_n1 DIVQ_14 VSS VSS) gpdk090_nmos1v w=0.24u l=0.1u ad=0.0528p as=0.0816p pd=0.68u ps=1.16u
    I_MXI3_I255_MN0 (I3_n14_5 I3_SEL_DIV_b3_2 XI3_I255_n1 VSS) gpdk090_nmos1v w=0.24u l=0.1u ad=0.0816p as=0.0528p pd=1.16u ps=0.68u
    I_MXI3_I270_MN1 (XI3_I270_n1 I3_n15_5 VSS VSS) gpdk090_nmos1v w=0.24u l=0.1u ad=0.0528p as=0.0816p pd=0.68u ps=1.16u
    I_MXI3_I270_MN0 (I3_o15_2 I3_n15_4 XI3_I270_n1 VSS) gpdk090_nmos1v w=0.24u l=0.1u ad=0.0816p as=0.0528p pd=1.16u ps=0.68u
    I_MXI3_I254_MN1 (XI3_I254_n1 MULP_14 VSS VSS) gpdk090_nmos1v w=0.24u l=0.1u ad=0.0528p as=0.0816p pd=0.68u ps=1.16u
    I_MXI3_I254_MN0 (I3_n14_4 I3_SEL_MUL_b3_2 XI3_I254_n1 VSS) gpdk090_nmos1v w=0.24u l=0.1u ad=0.0816p as=0.0528p pd=1.16u ps=0.68u
    I_MXI3_I387_MN1 (XI3_I387_n1 DIVQ_25 VSS VSS) gpdk090_nmos1v w=0.24u l=0.1u ad=0.0528p as=0.0816p pd=0.68u ps=1.16u
    I_MXI3_I387_MN0 (I3_n25_5 I3_SEL_DIV_b3_4 XI3_I387_n1 VSS) gpdk090_nmos1v w=0.24u l=0.1u ad=0.0816p as=0.0528p pd=1.16u ps=0.68u
    I_MXI3_I398_MN1 (XI3_I398_n1 MULP_26 VSS VSS) gpdk090_nmos1v w=0.24u l=0.1u ad=0.0528p as=0.0816p pd=0.68u ps=1.16u
    I_MXI3_I398_MN0 (I3_n26_4 I3_SEL_MUL_b3_4 XI3_I398_n1 VSS) gpdk090_nmos1v w=0.24u l=0.1u ad=0.0816p as=0.0528p pd=1.16u ps=0.68u
    I_MXI3_I375_MN1 (XI3_I375_n1 DIVQ_24 VSS VSS) gpdk090_nmos1v w=0.24u l=0.1u ad=0.0528p as=0.0816p pd=0.68u ps=1.16u
    I_MXI3_I375_MN0 (I3_n24_5 I3_SEL_DIV_b3_4 XI3_I375_n1 VSS) gpdk090_nmos1v w=0.24u l=0.1u ad=0.0816p as=0.0528p pd=1.16u ps=0.68u
    I_MXI3_I399_MN1 (XI3_I399_n1 DIVQ_26 VSS VSS) gpdk090_nmos1v w=0.24u l=0.1u ad=0.0528p as=0.0816p pd=0.68u ps=1.16u
    I_MXI3_I399_MN0 (I3_n26_5 I3_SEL_DIV_b3_4 XI3_I399_n1 VSS) gpdk090_nmos1v w=0.24u l=0.1u ad=0.0816p as=0.0528p pd=1.16u ps=0.68u
    I_MXI3_I402_MN1 (XI3_I402_n1 I3_n26_5 VSS VSS) gpdk090_nmos1v w=0.24u l=0.1u ad=0.0528p as=0.0816p pd=0.68u ps=1.16u
    I_MXI3_I402_MN0 (I3_o26_2 I3_n26_4 XI3_I402_n1 VSS) gpdk090_nmos1v w=0.24u l=0.1u ad=0.0816p as=0.0528p pd=1.16u ps=0.68u
    I_MXI2_I162_MN1 (XI2_I162_n1 B_27 VSS VSS) gpdk090_nmos1v w=0.24u l=0.1u ad=0.0528p as=0.0816p pd=0.68u ps=1.16u
    I_MXI2_I162_MN0 (I2_nand27 A_27 XI2_I162_n1 VSS) gpdk090_nmos1v w=0.24u l=0.1u ad=0.0816p as=0.0528p pd=1.16u ps=0.68u
    I_MXI3_I408_MN1 (XI3_I408_n1 XOR_27 VSS VSS) gpdk090_nmos1v w=0.24u l=0.1u ad=0.0528p as=0.0816p pd=0.68u ps=1.16u
    I_MXI3_I408_MN0 (I3_n27_2 I3_SEL_XOR_b3_5 XI3_I408_n1 VSS) gpdk090_nmos1v w=0.24u l=0.1u ad=0.0816p as=0.0528p pd=1.16u ps=0.68u
    I_MXI1_I42_I27_MN1 (XI1_I42_I27_n1 I1_bx27 VSS VSS) gpdk090_nmos1v w=0.24u l=0.1u ad=0.0528p as=0.0816p pd=0.68u ps=1.16u
    I_MXI1_I42_I27_MN0 (I1_I42_gn27 A_27 XI1_I42_I27_n1 VSS) gpdk090_nmos1v w=0.24u l=0.1u ad=0.0816p as=0.0528p pd=1.16u ps=0.68u
    I_MXI1_I42_I122_XP_MN1 (XI1_I42_I122_XP_n1 I1_I42_P24_23 VSS VSS) gpdk090_nmos1v w=0.24u l=0.1u ad=0.0528p as=0.0816p pd=0.68u ps=1.16u
    I_MXI1_I42_I122_XP_MN0 (I1_I42_P26_23n I1_I42_P26_25 XI1_I42_I122_XP_n1 VSS) gpdk090_nmos1v w=0.24u l=0.1u ad=0.0816p as=0.0528p pd=1.16u ps=0.68u
    I_MXI1_I42_I120_XP_MN1 (XI1_I42_I120_XP_n1 I1_I42_P22_21 VSS VSS) gpdk090_nmos1v w=0.24u l=0.1u ad=0.0528p as=0.0816p pd=0.68u ps=1.16u
    I_MXI1_I42_I120_XP_MN0 (I1_I42_P24_21n I1_I42_P24_23 XI1_I42_I120_XP_n1 VSS) gpdk090_nmos1v w=0.24u l=0.1u ad=0.0816p as=0.0528p pd=1.16u ps=0.68u
    I_MXI1_I42_I118_XP_MN1 (XI1_I42_I118_XP_n1 I1_I42_P20_19 VSS VSS) gpdk090_nmos1v w=0.24u l=0.1u ad=0.0528p as=0.0816p pd=0.68u ps=1.16u
    I_MXI1_I42_I118_XP_MN0 (I1_I42_P22_19n I1_I42_P22_21 XI1_I42_I118_XP_n1 VSS) gpdk090_nmos1v w=0.24u l=0.1u ad=0.0816p as=0.0528p pd=1.16u ps=0.68u
    I_MXI1_I42_I116_XP_MN1 (XI1_I42_I116_XP_n1 I1_I42_P18_17 VSS VSS) gpdk090_nmos1v w=0.24u l=0.1u ad=0.0528p as=0.0816p pd=0.68u ps=1.16u
    I_MXI1_I42_I116_XP_MN0 (I1_I42_P20_17n I1_I42_P20_19 XI1_I42_I116_XP_n1 VSS) gpdk090_nmos1v w=0.24u l=0.1u ad=0.0816p as=0.0528p pd=1.16u ps=0.68u
    I_MXI1_I42_I15_MN1 (XI1_I42_I15_n1 I1_bx15 VSS VSS) gpdk090_nmos1v w=0.24u l=0.1u ad=0.0528p as=0.0816p pd=0.68u ps=1.16u
    I_MXI1_I42_I15_MN0 (I1_I42_gn15 A_15 XI1_I42_I15_n1 VSS) gpdk090_nmos1v w=0.24u l=0.1u ad=0.0816p as=0.0528p pd=1.16u ps=0.68u
    I_MXI3_I264_MN1 (XI3_I264_n1 XOR_15 VSS VSS) gpdk090_nmos1v w=0.24u l=0.1u ad=0.0528p as=0.0816p pd=0.68u ps=1.16u
    I_MXI3_I264_MN0 (I3_n15_2 I3_SEL_XOR_b3_2 XI3_I264_n1 VSS) gpdk090_nmos1v w=0.24u l=0.1u ad=0.0816p as=0.0528p pd=1.16u ps=0.68u
    I_MXI3_I263_MN1 (XI3_I263_n1 OR_15 VSS VSS) gpdk090_nmos1v w=0.24u l=0.1u ad=0.0528p as=0.0816p pd=0.68u ps=1.16u
    I_MXI3_I263_MN0 (I3_n15_1 I3_SEL_OR_b3_2 XI3_I263_n1 VSS) gpdk090_nmos1v w=0.24u l=0.1u ad=0.0816p as=0.0528p pd=1.16u ps=0.68u
    I_MXI3_I268_MN1 (XI3_I268_n1 I3_n15_1 VSS VSS) gpdk090_nmos1v w=0.24u l=0.1u ad=0.0528p as=0.0816p pd=0.68u ps=1.16u
    I_MXI3_I268_MN0 (I3_o15_0 I3_n15_0 XI3_I268_n1 VSS) gpdk090_nmos1v w=0.24u l=0.1u ad=0.0816p as=0.0528p pd=1.16u ps=0.68u
    I_MXI2_I90_MN1 (XI2_I90_n1 B_15 VSS VSS) gpdk090_nmos1v w=0.24u l=0.1u ad=0.0528p as=0.0816p pd=0.68u ps=1.16u
    I_MXI2_I90_MN0 (I2_nand15 A_15 XI2_I90_n1 VSS) gpdk090_nmos1v w=0.24u l=0.1u ad=0.0816p as=0.0528p pd=1.16u ps=0.68u
    I_MXI3_I266_MN1 (XI3_I266_n1 MULP_15 VSS VSS) gpdk090_nmos1v w=0.24u l=0.1u ad=0.0528p as=0.0816p pd=0.68u ps=1.16u
    I_MXI3_I266_MN0 (I3_n15_4 I3_SEL_MUL_b3_2 XI3_I266_n1 VSS) gpdk090_nmos1v w=0.24u l=0.1u ad=0.0816p as=0.0528p pd=1.16u ps=0.68u
    I_MXI3_I262_MN1 (XI3_I262_n1 AND_15 VSS VSS) gpdk090_nmos1v w=0.24u l=0.1u ad=0.0528p as=0.0816p pd=0.68u ps=1.16u
    I_MXI3_I262_MN0 (I3_n15_0 I3_SEL_AND_b3_2 XI3_I262_n1 VSS) gpdk090_nmos1v w=0.24u l=0.1u ad=0.0816p as=0.0528p pd=1.16u ps=0.68u
    I_MXI3_I267_MN1 (XI3_I267_n1 DIVQ_15 VSS VSS) gpdk090_nmos1v w=0.24u l=0.1u ad=0.0528p as=0.0816p pd=0.68u ps=1.16u
    I_MXI3_I267_MN0 (I3_n15_5 I3_SEL_DIV_b3_2 XI3_I267_n1 VSS) gpdk090_nmos1v w=0.24u l=0.1u ad=0.0816p as=0.0528p pd=1.16u ps=0.68u
    I_MXI3_I386_MN1 (XI3_I386_n1 MULP_25 VSS VSS) gpdk090_nmos1v w=0.24u l=0.1u ad=0.0528p as=0.0816p pd=0.68u ps=1.16u
    I_MXI3_I386_MN0 (I3_n25_4 I3_SEL_MUL_b3_4 XI3_I386_n1 VSS) gpdk090_nmos1v w=0.24u l=0.1u ad=0.0816p as=0.0528p pd=1.16u ps=0.68u
    I_MXI3_I390_MN1 (XI3_I390_n1 I3_n25_5 VSS VSS) gpdk090_nmos1v w=0.24u l=0.1u ad=0.0528p as=0.0816p pd=0.68u ps=1.16u
    I_MXI3_I390_MN0 (I3_o25_2 I3_n25_4 XI3_I390_n1 VSS) gpdk090_nmos1v w=0.24u l=0.1u ad=0.0816p as=0.0528p pd=1.16u ps=0.68u
    I_MXI4_I38_MN1 (XI4_I38_n1 I4_z0_13 VSS VSS) gpdk090_nmos1v w=0.24u l=0.1u ad=0.0528p as=0.0816p pd=0.68u ps=1.16u
    I_MXI4_I38_MN0 (I4_z1_6 I4_z0_12 XI4_I38_n1 VSS) gpdk090_nmos1v w=0.24u l=0.1u ad=0.0816p as=0.0528p pd=1.16u ps=0.68u
    I_MXI3_I374_MN1 (XI3_I374_n1 MULP_24 VSS VSS) gpdk090_nmos1v w=0.24u l=0.1u ad=0.0528p as=0.0816p pd=0.68u ps=1.16u
    I_MXI3_I374_MN0 (I3_n24_4 I3_SEL_MUL_b3_4 XI3_I374_n1 VSS) gpdk090_nmos1v w=0.24u l=0.1u ad=0.0816p as=0.0528p pd=1.16u ps=0.68u
    I_MXI3_I378_MN1 (XI3_I378_n1 I3_n24_5 VSS VSS) gpdk090_nmos1v w=0.24u l=0.1u ad=0.0528p as=0.0816p pd=0.68u ps=1.16u
    I_MXI3_I378_MN0 (I3_o24_2 I3_n24_4 XI3_I378_n1 VSS) gpdk090_nmos1v w=0.24u l=0.1u ad=0.0816p as=0.0528p pd=1.16u ps=0.68u
    I_MXI3_I405_MN1 (XI3_I405_n1 I3_q26_2 VSS VSS) gpdk090_nmos1v w=0.24u l=0.1u ad=0.0528p as=0.0816p pd=0.68u ps=1.16u
    I_MXI3_I405_MN0 (Y_26 I3_q26_1 XI3_I405_n1 VSS) gpdk090_nmos1v w=0.24u l=0.1u ad=0.0816p as=0.0528p pd=1.16u ps=0.68u
    I_MXI1_I42_I26_MN1 (XI1_I42_I26_n1 I1_bx26 VSS VSS) gpdk090_nmos1v w=0.24u l=0.1u ad=0.0528p as=0.0816p pd=0.68u ps=1.16u
    I_MXI1_I42_I26_MN0 (I1_I42_gn26 A_26 XI1_I42_I26_n1 VSS) gpdk090_nmos1v w=0.24u l=0.1u ad=0.0816p as=0.0528p pd=1.16u ps=0.68u
    I_MXI1_I42_I25_MN1 (XI1_I42_I25_n1 I1_bx25 VSS VSS) gpdk090_nmos1v w=0.24u l=0.1u ad=0.0528p as=0.0816p pd=0.68u ps=1.16u
    I_MXI1_I42_I25_MN0 (I1_I42_gn25 A_25 XI1_I42_I25_n1 VSS) gpdk090_nmos1v w=0.24u l=0.1u ad=0.0816p as=0.0528p pd=1.16u ps=0.68u
    I_MXI1_I42_I23_MN1 (XI1_I42_I23_n1 I1_bx23 VSS VSS) gpdk090_nmos1v w=0.24u l=0.1u ad=0.0528p as=0.0816p pd=0.68u ps=1.16u
    I_MXI1_I42_I23_MN0 (I1_I42_gn23 A_23 XI1_I42_I23_n1 VSS) gpdk090_nmos1v w=0.24u l=0.1u ad=0.0816p as=0.0528p pd=1.16u ps=0.68u
    I_MXI1_I42_I20_MN1 (XI1_I42_I20_n1 I1_bx20 VSS VSS) gpdk090_nmos1v w=0.24u l=0.1u ad=0.0528p as=0.0816p pd=0.68u ps=1.16u
    I_MXI1_I42_I20_MN0 (I1_I42_gn20 A_20 XI1_I42_I20_n1 VSS) gpdk090_nmos1v w=0.24u l=0.1u ad=0.0816p as=0.0528p pd=1.16u ps=0.68u
    I_MXI1_I42_I19_MN1 (XI1_I42_I19_n1 I1_bx19 VSS VSS) gpdk090_nmos1v w=0.24u l=0.1u ad=0.0528p as=0.0816p pd=0.68u ps=1.16u
    I_MXI1_I42_I19_MN0 (I1_I42_gn19 A_19 XI1_I42_I19_n1 VSS) gpdk090_nmos1v w=0.24u l=0.1u ad=0.0816p as=0.0528p pd=1.16u ps=0.68u
    I_MXI1_I42_I17_MN1 (XI1_I42_I17_n1 I1_bx17 VSS VSS) gpdk090_nmos1v w=0.24u l=0.1u ad=0.0528p as=0.0816p pd=0.68u ps=1.16u
    I_MXI1_I42_I17_MN0 (I1_I42_gn17 A_17 XI1_I42_I17_n1 VSS) gpdk090_nmos1v w=0.24u l=0.1u ad=0.0816p as=0.0528p pd=1.16u ps=0.68u
    I_MXI1_I42_I16_MN1 (XI1_I42_I16_n1 I1_bx16 VSS VSS) gpdk090_nmos1v w=0.24u l=0.1u ad=0.0528p as=0.0816p pd=0.68u ps=1.16u
    I_MXI1_I42_I16_MN0 (I1_I42_gn16 A_16 XI1_I42_I16_n1 VSS) gpdk090_nmos1v w=0.24u l=0.1u ad=0.0816p as=0.0528p pd=1.16u ps=0.68u
    I_MXI3_I282_MN1 (XI3_I282_n1 I3_n16_5 VSS VSS) gpdk090_nmos1v w=0.24u l=0.1u ad=0.0528p as=0.0816p pd=0.68u ps=1.16u
    I_MXI3_I282_MN0 (I3_o16_2 I3_n16_4 XI3_I282_n1 VSS) gpdk090_nmos1v w=0.24u l=0.1u ad=0.0816p as=0.0528p pd=1.16u ps=0.68u
    I_MXI3_I279_MN1 (XI3_I279_n1 DIVQ_16 VSS VSS) gpdk090_nmos1v w=0.24u l=0.1u ad=0.0528p as=0.0816p pd=0.68u ps=1.16u
    I_MXI3_I279_MN0 (I3_n16_5 I3_SEL_DIV_b3_2 XI3_I279_n1 VSS) gpdk090_nmos1v w=0.24u l=0.1u ad=0.0816p as=0.0528p pd=1.16u ps=0.68u
    I_MXI3_I278_MN1 (XI3_I278_n1 MULP_16 VSS VSS) gpdk090_nmos1v w=0.24u l=0.1u ad=0.0528p as=0.0816p pd=0.68u ps=1.16u
    I_MXI3_I278_MN0 (I3_n16_4 I3_SEL_MUL_b3_2 XI3_I278_n1 VSS) gpdk090_nmos1v w=0.24u l=0.1u ad=0.0816p as=0.0528p pd=1.16u ps=0.68u
    I_MXI3_I291_MN1 (XI3_I291_n1 DIVQ_17 VSS VSS) gpdk090_nmos1v w=0.24u l=0.1u ad=0.0528p as=0.0816p pd=0.68u ps=1.16u
    I_MXI3_I291_MN0 (I3_n17_5 I3_SEL_DIV_b3_2 XI3_I291_n1 VSS) gpdk090_nmos1v w=0.24u l=0.1u ad=0.0816p as=0.0528p pd=1.16u ps=0.68u
    I_MXI3_I290_MN1 (XI3_I290_n1 MULP_17 VSS VSS) gpdk090_nmos1v w=0.24u l=0.1u ad=0.0528p as=0.0816p pd=0.68u ps=1.16u
    I_MXI3_I290_MN0 (I3_n17_4 I3_SEL_MUL_b3_2 XI3_I290_n1 VSS) gpdk090_nmos1v w=0.24u l=0.1u ad=0.0816p as=0.0528p pd=1.16u ps=0.68u
    I_MXI3_I394_MN1 (XI3_I394_n1 AND_26 VSS VSS) gpdk090_nmos1v w=0.24u l=0.1u ad=0.0528p as=0.0816p pd=0.68u ps=1.16u
    I_MXI3_I394_MN0 (I3_n26_0 I3_SEL_AND_b3_4 XI3_I394_n1 VSS) gpdk090_nmos1v w=0.24u l=0.1u ad=0.0816p as=0.0528p pd=1.16u ps=0.68u
    I_MXI2_I156_MN1 (XI2_I156_n1 B_26 VSS VSS) gpdk090_nmos1v w=0.24u l=0.1u ad=0.0528p as=0.0816p pd=0.68u ps=1.16u
    I_MXI2_I156_MN0 (I2_nand26 A_26 XI2_I156_n1 VSS) gpdk090_nmos1v w=0.24u l=0.1u ad=0.0816p as=0.0528p pd=1.16u ps=0.68u
    I_MXI3_I400_MN1 (XI3_I400_n1 I3_n26_1 VSS VSS) gpdk090_nmos1v w=0.24u l=0.1u ad=0.0528p as=0.0816p pd=0.68u ps=1.16u
    I_MXI3_I400_MN0 (I3_o26_0 I3_n26_0 XI3_I400_n1 VSS) gpdk090_nmos1v w=0.24u l=0.1u ad=0.0816p as=0.0528p pd=1.16u ps=0.68u
    I_MXI3_I393_MN1 (XI3_I393_n1 I3_q25_2 VSS VSS) gpdk090_nmos1v w=0.24u l=0.1u ad=0.0528p as=0.0816p pd=0.68u ps=1.16u
    I_MXI3_I393_MN0 (Y_25 I3_q25_1 XI3_I393_n1 VSS) gpdk090_nmos1v w=0.24u l=0.1u ad=0.0816p as=0.0528p pd=1.16u ps=0.68u
    I_MXI3_I401_MN1 (XI3_I401_n1 I3_n26_3 VSS VSS) gpdk090_nmos1v w=0.24u l=0.1u ad=0.0528p as=0.0816p pd=0.68u ps=1.16u
    I_MXI3_I401_MN0 (I3_o26_1 I3_n26_2 XI3_I401_n1 VSS) gpdk090_nmos1v w=0.24u l=0.1u ad=0.0816p as=0.0528p pd=1.16u ps=0.68u
    I_MXI3_I396_MN1 (XI3_I396_n1 XOR_26 VSS VSS) gpdk090_nmos1v w=0.24u l=0.1u ad=0.0528p as=0.0816p pd=0.68u ps=1.16u
    I_MXI3_I396_MN0 (I3_n26_2 I3_SEL_XOR_b3_4 XI3_I396_n1 VSS) gpdk090_nmos1v w=0.24u l=0.1u ad=0.0816p as=0.0528p pd=1.16u ps=0.68u
    I_MXI3_I373_MN1 (XI3_I373_n1 NOT_24 VSS VSS) gpdk090_nmos1v w=0.24u l=0.1u ad=0.0528p as=0.0816p pd=0.68u ps=1.16u
    I_MXI3_I373_MN0 (I3_n24_3 I3_SEL_NOT_b3_4 XI3_I373_n1 VSS) gpdk090_nmos1v w=0.24u l=0.1u ad=0.0816p as=0.0528p pd=1.16u ps=0.68u
    I_MXI1_I42_I24_MN1 (XI1_I42_I24_n1 I1_bx24 VSS VSS) gpdk090_nmos1v w=0.24u l=0.1u ad=0.0528p as=0.0816p pd=0.68u ps=1.16u
    I_MXI1_I42_I24_MN0 (I1_I42_gn24 A_24 XI1_I42_I24_n1 VSS) gpdk090_nmos1v w=0.24u l=0.1u ad=0.0816p as=0.0528p pd=1.16u ps=0.68u
    I_MXI1_I42_I22_MN1 (XI1_I42_I22_n1 I1_bx22 VSS VSS) gpdk090_nmos1v w=0.24u l=0.1u ad=0.0528p as=0.0816p pd=0.68u ps=1.16u
    I_MXI1_I42_I22_MN0 (I1_I42_gn22 A_22 XI1_I42_I22_n1 VSS) gpdk090_nmos1v w=0.24u l=0.1u ad=0.0816p as=0.0528p pd=1.16u ps=0.68u
    I_MXI1_I42_I21_MN1 (XI1_I42_I21_n1 I1_bx21 VSS VSS) gpdk090_nmos1v w=0.24u l=0.1u ad=0.0528p as=0.0816p pd=0.68u ps=1.16u
    I_MXI1_I42_I21_MN0 (I1_I42_gn21 A_21 XI1_I42_I21_n1 VSS) gpdk090_nmos1v w=0.24u l=0.1u ad=0.0816p as=0.0528p pd=1.16u ps=0.68u
    I_MXI3_I354_MN1 (XI3_I354_n1 I3_n22_5 VSS VSS) gpdk090_nmos1v w=0.24u l=0.1u ad=0.0528p as=0.0816p pd=0.68u ps=1.16u
    I_MXI3_I354_MN0 (I3_o22_2 I3_n22_4 XI3_I354_n1 VSS) gpdk090_nmos1v w=0.24u l=0.1u ad=0.0816p as=0.0528p pd=1.16u ps=0.68u
    I_MXI3_I324_MN1 (XI3_I324_n1 XOR_20 VSS VSS) gpdk090_nmos1v w=0.24u l=0.1u ad=0.0528p as=0.0816p pd=0.68u ps=1.16u
    I_MXI3_I324_MN0 (I3_n20_2 I3_SEL_XOR_b3_3 XI3_I324_n1 VSS) gpdk090_nmos1v w=0.24u l=0.1u ad=0.0816p as=0.0528p pd=1.16u ps=0.68u
    I_MXI3_I306_MN1 (XI3_I306_n1 I3_n18_5 VSS VSS) gpdk090_nmos1v w=0.24u l=0.1u ad=0.0528p as=0.0816p pd=0.68u ps=1.16u
    I_MXI3_I306_MN0 (I3_o18_2 I3_n18_4 XI3_I306_n1 VSS) gpdk090_nmos1v w=0.24u l=0.1u ad=0.0816p as=0.0528p pd=1.16u ps=0.68u
    I_MXI1_I42_I18_MN1 (XI1_I42_I18_n1 I1_bx18 VSS VSS) gpdk090_nmos1v w=0.24u l=0.1u ad=0.0528p as=0.0816p pd=0.68u ps=1.16u
    I_MXI1_I42_I18_MN0 (I1_I42_gn18 A_18 XI1_I42_I18_n1 VSS) gpdk090_nmos1v w=0.24u l=0.1u ad=0.0816p as=0.0528p pd=1.16u ps=0.68u
    I_MXI3_I277_MN1 (XI3_I277_n1 NOT_16 VSS VSS) gpdk090_nmos1v w=0.24u l=0.1u ad=0.0528p as=0.0816p pd=0.68u ps=1.16u
    I_MXI3_I277_MN0 (I3_n16_3 I3_SEL_NOT_b3_3 XI3_I277_n1 VSS) gpdk090_nmos1v w=0.24u l=0.1u ad=0.0816p as=0.0528p pd=1.16u ps=0.68u
    I_MXI3_I281_MN1 (XI3_I281_n1 I3_n16_3 VSS VSS) gpdk090_nmos1v w=0.24u l=0.1u ad=0.0528p as=0.0816p pd=0.68u ps=1.16u
    I_MXI3_I281_MN0 (I3_o16_1 I3_n16_2 XI3_I281_n1 VSS) gpdk090_nmos1v w=0.24u l=0.1u ad=0.0816p as=0.0528p pd=1.16u ps=0.68u
    I_MXI3_I276_MN1 (XI3_I276_n1 XOR_16 VSS VSS) gpdk090_nmos1v w=0.24u l=0.1u ad=0.0528p as=0.0816p pd=0.68u ps=1.16u
    I_MXI3_I276_MN0 (I3_n16_2 I3_SEL_XOR_b3_3 XI3_I276_n1 VSS) gpdk090_nmos1v w=0.24u l=0.1u ad=0.0816p as=0.0528p pd=1.16u ps=0.68u
    I_MXI2_I96_MN1 (XI2_I96_n1 B_16 VSS VSS) gpdk090_nmos1v w=0.24u l=0.1u ad=0.0528p as=0.0816p pd=0.68u ps=1.16u
    I_MXI2_I96_MN0 (I2_nand16 A_16 XI2_I96_n1 VSS) gpdk090_nmos1v w=0.24u l=0.1u ad=0.0816p as=0.0528p pd=1.16u ps=0.68u
    I_MXI3_I294_MN1 (XI3_I294_n1 I3_n17_5 VSS VSS) gpdk090_nmos1v w=0.24u l=0.1u ad=0.0528p as=0.0816p pd=0.68u ps=1.16u
    I_MXI3_I294_MN0 (I3_o17_2 I3_n17_4 XI3_I294_n1 VSS) gpdk090_nmos1v w=0.24u l=0.1u ad=0.0816p as=0.0528p pd=1.16u ps=0.68u
    I_MXI3_I388_MN1 (XI3_I388_n1 I3_n25_1 VSS VSS) gpdk090_nmos1v w=0.24u l=0.1u ad=0.0528p as=0.0816p pd=0.68u ps=1.16u
    I_MXI3_I388_MN0 (I3_o25_0 I3_n25_0 XI3_I388_n1 VSS) gpdk090_nmos1v w=0.24u l=0.1u ad=0.0816p as=0.0528p pd=1.16u ps=0.68u
    I_MXI3_I395_MN1 (XI3_I395_n1 OR_26 VSS VSS) gpdk090_nmos1v w=0.24u l=0.1u ad=0.0528p as=0.0816p pd=0.68u ps=1.16u
    I_MXI3_I395_MN0 (I3_n26_1 I3_SEL_OR_b3_4 XI3_I395_n1 VSS) gpdk090_nmos1v w=0.24u l=0.1u ad=0.0816p as=0.0528p pd=1.16u ps=0.68u
    I_MXI3_I389_MN1 (XI3_I389_n1 I3_n25_3 VSS VSS) gpdk090_nmos1v w=0.24u l=0.1u ad=0.0528p as=0.0816p pd=0.68u ps=1.16u
    I_MXI3_I389_MN0 (I3_o25_1 I3_n25_2 XI3_I389_n1 VSS) gpdk090_nmos1v w=0.24u l=0.1u ad=0.0816p as=0.0528p pd=1.16u ps=0.68u
    I_MXI3_I385_MN1 (XI3_I385_n1 NOT_25 VSS VSS) gpdk090_nmos1v w=0.24u l=0.1u ad=0.0528p as=0.0816p pd=0.68u ps=1.16u
    I_MXI3_I385_MN0 (I3_n25_3 I3_SEL_NOT_b3_4 XI3_I385_n1 VSS) gpdk090_nmos1v w=0.24u l=0.1u ad=0.0816p as=0.0528p pd=1.16u ps=0.68u
    I_MXI3_I397_MN1 (XI3_I397_n1 NOT_26 VSS VSS) gpdk090_nmos1v w=0.24u l=0.1u ad=0.0528p as=0.0816p pd=0.68u ps=1.16u
    I_MXI3_I397_MN0 (I3_n26_3 I3_SEL_NOT_b3_4 XI3_I397_n1 VSS) gpdk090_nmos1v w=0.24u l=0.1u ad=0.0816p as=0.0528p pd=1.16u ps=0.68u
    I_MXI3_I384_MN1 (XI3_I384_n1 XOR_25 VSS VSS) gpdk090_nmos1v w=0.24u l=0.1u ad=0.0528p as=0.0816p pd=0.68u ps=1.16u
    I_MXI3_I384_MN0 (I3_n25_2 I3_SEL_XOR_b3_4 XI3_I384_n1 VSS) gpdk090_nmos1v w=0.24u l=0.1u ad=0.0816p as=0.0528p pd=1.16u ps=0.68u
    I_MXI3_I381_MN1 (XI3_I381_n1 I3_q24_2 VSS VSS) gpdk090_nmos1v w=0.24u l=0.1u ad=0.0528p as=0.0816p pd=0.68u ps=1.16u
    I_MXI3_I381_MN0 (Y_24 I3_q24_1 XI3_I381_n1 VSS) gpdk090_nmos1v w=0.24u l=0.1u ad=0.0816p as=0.0528p pd=1.16u ps=0.68u
    I_MXI3_I376_MN1 (XI3_I376_n1 I3_n24_1 VSS VSS) gpdk090_nmos1v w=0.24u l=0.1u ad=0.0528p as=0.0816p pd=0.68u ps=1.16u
    I_MXI3_I376_MN0 (I3_o24_0 I3_n24_0 XI3_I376_n1 VSS) gpdk090_nmos1v w=0.24u l=0.1u ad=0.0816p as=0.0528p pd=1.16u ps=0.68u
    I_MXI3_I377_MN1 (XI3_I377_n1 I3_n24_3 VSS VSS) gpdk090_nmos1v w=0.24u l=0.1u ad=0.0528p as=0.0816p pd=0.68u ps=1.16u
    I_MXI3_I377_MN0 (I3_o24_1 I3_n24_2 XI3_I377_n1 VSS) gpdk090_nmos1v w=0.24u l=0.1u ad=0.0816p as=0.0528p pd=1.16u ps=0.68u
    I_MXI3_I372_MN1 (XI3_I372_n1 XOR_24 VSS VSS) gpdk090_nmos1v w=0.24u l=0.1u ad=0.0528p as=0.0816p pd=0.68u ps=1.16u
    I_MXI3_I372_MN0 (I3_n24_2 I3_SEL_XOR_b3_4 XI3_I372_n1 VSS) gpdk090_nmos1v w=0.24u l=0.1u ad=0.0816p as=0.0528p pd=1.16u ps=0.68u
    I_MXI3_I360_MN1 (XI3_I360_n1 XOR_23 VSS VSS) gpdk090_nmos1v w=0.24u l=0.1u ad=0.0528p as=0.0816p pd=0.68u ps=1.16u
    I_MXI3_I360_MN0 (I3_n23_2 I3_SEL_XOR_b3_4 XI3_I360_n1 VSS) gpdk090_nmos1v w=0.24u l=0.1u ad=0.0816p as=0.0528p pd=1.16u ps=0.68u
    I_MXI3_I364_MN1 (XI3_I364_n1 I3_n23_1 VSS VSS) gpdk090_nmos1v w=0.24u l=0.1u ad=0.0528p as=0.0816p pd=0.68u ps=1.16u
    I_MXI3_I364_MN0 (I3_o23_0 I3_n23_0 XI3_I364_n1 VSS) gpdk090_nmos1v w=0.24u l=0.1u ad=0.0816p as=0.0528p pd=1.16u ps=0.68u
    I_MXI3_I365_MN1 (XI3_I365_n1 I3_n23_3 VSS VSS) gpdk090_nmos1v w=0.24u l=0.1u ad=0.0528p as=0.0816p pd=0.68u ps=1.16u
    I_MXI3_I365_MN0 (I3_o23_1 I3_n23_2 XI3_I365_n1 VSS) gpdk090_nmos1v w=0.24u l=0.1u ad=0.0816p as=0.0528p pd=1.16u ps=0.68u
    I_MXI3_I361_MN1 (XI3_I361_n1 NOT_23 VSS VSS) gpdk090_nmos1v w=0.24u l=0.1u ad=0.0528p as=0.0816p pd=0.68u ps=1.16u
    I_MXI3_I361_MN0 (I3_n23_3 I3_SEL_NOT_b3_4 XI3_I361_n1 VSS) gpdk090_nmos1v w=0.24u l=0.1u ad=0.0816p as=0.0528p pd=1.16u ps=0.68u
    I_MXI3_I349_MN1 (XI3_I349_n1 NOT_22 VSS VSS) gpdk090_nmos1v w=0.24u l=0.1u ad=0.0528p as=0.0816p pd=0.68u ps=1.16u
    I_MXI3_I349_MN0 (I3_n22_3 I3_SEL_NOT_b3_4 XI3_I349_n1 VSS) gpdk090_nmos1v w=0.24u l=0.1u ad=0.0816p as=0.0528p pd=1.16u ps=0.68u
    I_MXI3_I353_MN1 (XI3_I353_n1 I3_n22_3 VSS VSS) gpdk090_nmos1v w=0.24u l=0.1u ad=0.0528p as=0.0816p pd=0.68u ps=1.16u
    I_MXI3_I353_MN0 (I3_o22_1 I3_n22_2 XI3_I353_n1 VSS) gpdk090_nmos1v w=0.24u l=0.1u ad=0.0816p as=0.0528p pd=1.16u ps=0.68u
    I_MXI3_I348_MN1 (XI3_I348_n1 XOR_22 VSS VSS) gpdk090_nmos1v w=0.24u l=0.1u ad=0.0528p as=0.0816p pd=0.68u ps=1.16u
    I_MXI3_I348_MN0 (I3_n22_2 I3_SEL_XOR_b3_4 XI3_I348_n1 VSS) gpdk090_nmos1v w=0.24u l=0.1u ad=0.0816p as=0.0528p pd=1.16u ps=0.68u
    I_MXI3_I369_MN1 (XI3_I369_n1 I3_q23_2 VSS VSS) gpdk090_nmos1v w=0.24u l=0.1u ad=0.0528p as=0.0816p pd=0.68u ps=1.16u
    I_MXI3_I369_MN0 (Y_23 I3_q23_1 XI3_I369_n1 VSS) gpdk090_nmos1v w=0.24u l=0.1u ad=0.0816p as=0.0528p pd=1.16u ps=0.68u
    I_MXI3_I335_MN1 (XI3_I335_n1 OR_21 VSS VSS) gpdk090_nmos1v w=0.24u l=0.1u ad=0.0528p as=0.0816p pd=0.68u ps=1.16u
    I_MXI3_I335_MN0 (I3_n21_1 I3_SEL_OR_b3_3 XI3_I335_n1 VSS) gpdk090_nmos1v w=0.24u l=0.1u ad=0.0816p as=0.0528p pd=1.16u ps=0.68u
    I_MXI3_I337_MN1 (XI3_I337_n1 NOT_21 VSS VSS) gpdk090_nmos1v w=0.24u l=0.1u ad=0.0528p as=0.0816p pd=0.68u ps=1.16u
    I_MXI3_I337_MN0 (I3_n21_3 I3_SEL_NOT_b3_3 XI3_I337_n1 VSS) gpdk090_nmos1v w=0.24u l=0.1u ad=0.0816p as=0.0528p pd=1.16u ps=0.68u
    I_MXI3_I341_MN1 (XI3_I341_n1 I3_n21_3 VSS VSS) gpdk090_nmos1v w=0.24u l=0.1u ad=0.0528p as=0.0816p pd=0.68u ps=1.16u
    I_MXI3_I341_MN0 (I3_o21_1 I3_n21_2 XI3_I341_n1 VSS) gpdk090_nmos1v w=0.24u l=0.1u ad=0.0816p as=0.0528p pd=1.16u ps=0.68u
    I_MXI3_I351_MN1 (XI3_I351_n1 DIVQ_22 VSS VSS) gpdk090_nmos1v w=0.24u l=0.1u ad=0.0528p as=0.0816p pd=0.68u ps=1.16u
    I_MXI3_I351_MN0 (I3_n22_5 I3_SEL_DIV_b3_3 XI3_I351_n1 VSS) gpdk090_nmos1v w=0.24u l=0.1u ad=0.0816p as=0.0528p pd=1.16u ps=0.68u
    I_MXI3_I366_MN1 (XI3_I366_n1 I3_n23_5 VSS VSS) gpdk090_nmos1v w=0.24u l=0.1u ad=0.0528p as=0.0816p pd=0.68u ps=1.16u
    I_MXI3_I366_MN0 (I3_o23_2 I3_n23_4 XI3_I366_n1 VSS) gpdk090_nmos1v w=0.24u l=0.1u ad=0.0816p as=0.0528p pd=1.16u ps=0.68u
    I_MXI3_I362_MN1 (XI3_I362_n1 MULP_23 VSS VSS) gpdk090_nmos1v w=0.24u l=0.1u ad=0.0528p as=0.0816p pd=0.68u ps=1.16u
    I_MXI3_I362_MN0 (I3_n23_4 I3_SEL_MUL_b3_3 XI3_I362_n1 VSS) gpdk090_nmos1v w=0.24u l=0.1u ad=0.0816p as=0.0528p pd=1.16u ps=0.68u
    I_MXI3_I350_MN1 (XI3_I350_n1 MULP_22 VSS VSS) gpdk090_nmos1v w=0.24u l=0.1u ad=0.0528p as=0.0816p pd=0.68u ps=1.16u
    I_MXI3_I350_MN0 (I3_n22_4 I3_SEL_MUL_b3_3 XI3_I350_n1 VSS) gpdk090_nmos1v w=0.24u l=0.1u ad=0.0816p as=0.0528p pd=1.16u ps=0.68u
    I_MXI3_I338_MN1 (XI3_I338_n1 MULP_21 VSS VSS) gpdk090_nmos1v w=0.24u l=0.1u ad=0.0528p as=0.0816p pd=0.68u ps=1.16u
    I_MXI3_I338_MN0 (I3_n21_4 I3_SEL_MUL_b3_3 XI3_I338_n1 VSS) gpdk090_nmos1v w=0.24u l=0.1u ad=0.0816p as=0.0528p pd=1.16u ps=0.68u
    I_MXI3_I342_MN1 (XI3_I342_n1 I3_n21_5 VSS VSS) gpdk090_nmos1v w=0.24u l=0.1u ad=0.0528p as=0.0816p pd=0.68u ps=1.16u
    I_MXI3_I342_MN0 (I3_o21_2 I3_n21_4 XI3_I342_n1 VSS) gpdk090_nmos1v w=0.24u l=0.1u ad=0.0816p as=0.0528p pd=1.16u ps=0.68u
    I_MXI3_I339_MN1 (XI3_I339_n1 DIVQ_21 VSS VSS) gpdk090_nmos1v w=0.24u l=0.1u ad=0.0528p as=0.0816p pd=0.68u ps=1.16u
    I_MXI3_I339_MN0 (I3_n21_5 I3_SEL_DIV_b3_3 XI3_I339_n1 VSS) gpdk090_nmos1v w=0.24u l=0.1u ad=0.0816p as=0.0528p pd=1.16u ps=0.68u
    I_MXI3_I330_MN1 (XI3_I330_n1 I3_n20_5 VSS VSS) gpdk090_nmos1v w=0.24u l=0.1u ad=0.0528p as=0.0816p pd=0.68u ps=1.16u
    I_MXI3_I330_MN0 (I3_o20_2 I3_n20_4 XI3_I330_n1 VSS) gpdk090_nmos1v w=0.24u l=0.1u ad=0.0816p as=0.0528p pd=1.16u ps=0.68u
    I_MXI3_I327_MN1 (XI3_I327_n1 DIVQ_20 VSS VSS) gpdk090_nmos1v w=0.24u l=0.1u ad=0.0528p as=0.0816p pd=0.68u ps=1.16u
    I_MXI3_I327_MN0 (I3_n20_5 I3_SEL_DIV_b3_3 XI3_I327_n1 VSS) gpdk090_nmos1v w=0.24u l=0.1u ad=0.0816p as=0.0528p pd=1.16u ps=0.68u
    I_MXI3_I326_MN1 (XI3_I326_n1 MULP_20 VSS VSS) gpdk090_nmos1v w=0.24u l=0.1u ad=0.0528p as=0.0816p pd=0.68u ps=1.16u
    I_MXI3_I326_MN0 (I3_n20_4 I3_SEL_MUL_b3_3 XI3_I326_n1 VSS) gpdk090_nmos1v w=0.24u l=0.1u ad=0.0816p as=0.0528p pd=1.16u ps=0.68u
    I_MXI3_I329_MN1 (XI3_I329_n1 I3_n20_3 VSS VSS) gpdk090_nmos1v w=0.24u l=0.1u ad=0.0528p as=0.0816p pd=0.68u ps=1.16u
    I_MXI3_I329_MN0 (I3_o20_1 I3_n20_2 XI3_I329_n1 VSS) gpdk090_nmos1v w=0.24u l=0.1u ad=0.0816p as=0.0528p pd=1.16u ps=0.68u
    I_MXI3_I325_MN1 (XI3_I325_n1 NOT_20 VSS VSS) gpdk090_nmos1v w=0.24u l=0.1u ad=0.0528p as=0.0816p pd=0.68u ps=1.16u
    I_MXI3_I325_MN0 (I3_n20_3 I3_SEL_NOT_b3_3 XI3_I325_n1 VSS) gpdk090_nmos1v w=0.24u l=0.1u ad=0.0816p as=0.0528p pd=1.16u ps=0.68u
    I_MXI3_I318_MN1 (XI3_I318_n1 I3_n19_5 VSS VSS) gpdk090_nmos1v w=0.24u l=0.1u ad=0.0528p as=0.0816p pd=0.68u ps=1.16u
    I_MXI3_I318_MN0 (I3_o19_2 I3_n19_4 XI3_I318_n1 VSS) gpdk090_nmos1v w=0.24u l=0.1u ad=0.0816p as=0.0528p pd=1.16u ps=0.68u
    I_MXI3_I314_MN1 (XI3_I314_n1 MULP_19 VSS VSS) gpdk090_nmos1v w=0.24u l=0.1u ad=0.0528p as=0.0816p pd=0.68u ps=1.16u
    I_MXI3_I314_MN0 (I3_n19_4 I3_SEL_MUL_b3_3 XI3_I314_n1 VSS) gpdk090_nmos1v w=0.24u l=0.1u ad=0.0816p as=0.0528p pd=1.16u ps=0.68u
    I_MXI3_I303_MN1 (XI3_I303_n1 DIVQ_18 VSS VSS) gpdk090_nmos1v w=0.24u l=0.1u ad=0.0528p as=0.0816p pd=0.68u ps=1.16u
    I_MXI3_I303_MN0 (I3_n18_5 I3_SEL_DIV_b3_3 XI3_I303_n1 VSS) gpdk090_nmos1v w=0.24u l=0.1u ad=0.0816p as=0.0528p pd=1.16u ps=0.68u
    I_MXI3_I321_MN1 (XI3_I321_n1 I3_q19_2 VSS VSS) gpdk090_nmos1v w=0.24u l=0.1u ad=0.0528p as=0.0816p pd=0.68u ps=1.16u
    I_MXI3_I321_MN0 (Y_19 I3_q19_1 XI3_I321_n1 VSS) gpdk090_nmos1v w=0.24u l=0.1u ad=0.0816p as=0.0528p pd=1.16u ps=0.68u
    I_MXI3_I302_MN1 (XI3_I302_n1 MULP_18 VSS VSS) gpdk090_nmos1v w=0.24u l=0.1u ad=0.0528p as=0.0816p pd=0.68u ps=1.16u
    I_MXI3_I302_MN0 (I3_n18_4 I3_SEL_MUL_b3_3 XI3_I302_n1 VSS) gpdk090_nmos1v w=0.24u l=0.1u ad=0.0816p as=0.0528p pd=1.16u ps=0.68u
    I_MXI3_I317_MN1 (XI3_I317_n1 I3_n19_3 VSS VSS) gpdk090_nmos1v w=0.24u l=0.1u ad=0.0528p as=0.0816p pd=0.68u ps=1.16u
    I_MXI3_I317_MN0 (I3_o19_1 I3_n19_2 XI3_I317_n1 VSS) gpdk090_nmos1v w=0.24u l=0.1u ad=0.0816p as=0.0528p pd=1.16u ps=0.68u
    I_MXI3_I313_MN1 (XI3_I313_n1 NOT_19 VSS VSS) gpdk090_nmos1v w=0.24u l=0.1u ad=0.0528p as=0.0816p pd=0.68u ps=1.16u
    I_MXI3_I313_MN0 (I3_n19_3 I3_SEL_NOT_b3_3 XI3_I313_n1 VSS) gpdk090_nmos1v w=0.24u l=0.1u ad=0.0816p as=0.0528p pd=1.16u ps=0.68u
    I_MXI3_I312_MN1 (XI3_I312_n1 XOR_19 VSS VSS) gpdk090_nmos1v w=0.24u l=0.1u ad=0.0528p as=0.0816p pd=0.68u ps=1.16u
    I_MXI3_I312_MN0 (I3_n19_2 I3_SEL_XOR_b3_3 XI3_I312_n1 VSS) gpdk090_nmos1v w=0.24u l=0.1u ad=0.0816p as=0.0528p pd=1.16u ps=0.68u
    I_MXI3_I309_MN1 (XI3_I309_n1 I3_q18_2 VSS VSS) gpdk090_nmos1v w=0.24u l=0.1u ad=0.0528p as=0.0816p pd=0.68u ps=1.16u
    I_MXI3_I309_MN0 (Y_18 I3_q18_1 XI3_I309_n1 VSS) gpdk090_nmos1v w=0.24u l=0.1u ad=0.0816p as=0.0528p pd=1.16u ps=0.68u
    I_MXI3_I301_MN1 (XI3_I301_n1 NOT_18 VSS VSS) gpdk090_nmos1v w=0.24u l=0.1u ad=0.0528p as=0.0816p pd=0.68u ps=1.16u
    I_MXI3_I301_MN0 (I3_n18_3 I3_SEL_NOT_b3_3 XI3_I301_n1 VSS) gpdk090_nmos1v w=0.24u l=0.1u ad=0.0816p as=0.0528p pd=1.16u ps=0.68u
    I_MXI2_I108_MN1 (XI2_I108_n1 B_18 VSS VSS) gpdk090_nmos1v w=0.24u l=0.1u ad=0.0528p as=0.0816p pd=0.68u ps=1.16u
    I_MXI2_I108_MN0 (I2_nand18 A_18 XI2_I108_n1 VSS) gpdk090_nmos1v w=0.24u l=0.1u ad=0.0816p as=0.0528p pd=1.16u ps=0.68u
    I_MXI3_I305_MN1 (XI3_I305_n1 I3_n18_3 VSS VSS) gpdk090_nmos1v w=0.24u l=0.1u ad=0.0528p as=0.0816p pd=0.68u ps=1.16u
    I_MXI3_I305_MN0 (I3_o18_1 I3_n18_2 XI3_I305_n1 VSS) gpdk090_nmos1v w=0.24u l=0.1u ad=0.0816p as=0.0528p pd=1.16u ps=0.68u
    I_MXI3_I300_MN1 (XI3_I300_n1 XOR_18 VSS VSS) gpdk090_nmos1v w=0.24u l=0.1u ad=0.0528p as=0.0816p pd=0.68u ps=1.16u
    I_MXI3_I300_MN0 (I3_n18_2 I3_SEL_XOR_b3_3 XI3_I300_n1 VSS) gpdk090_nmos1v w=0.24u l=0.1u ad=0.0816p as=0.0528p pd=1.16u ps=0.68u
    I_MXI3_I297_MN1 (XI3_I297_n1 I3_q17_2 VSS VSS) gpdk090_nmos1v w=0.24u l=0.1u ad=0.0528p as=0.0816p pd=0.68u ps=1.16u
    I_MXI3_I297_MN0 (Y_17 I3_q17_1 XI3_I297_n1 VSS) gpdk090_nmos1v w=0.24u l=0.1u ad=0.0816p as=0.0528p pd=1.16u ps=0.68u
    I_MXI3_I289_MN1 (XI3_I289_n1 NOT_17 VSS VSS) gpdk090_nmos1v w=0.24u l=0.1u ad=0.0528p as=0.0816p pd=0.68u ps=1.16u
    I_MXI3_I289_MN0 (I3_n17_3 I3_SEL_NOT_b3_3 XI3_I289_n1 VSS) gpdk090_nmos1v w=0.24u l=0.1u ad=0.0816p as=0.0528p pd=1.16u ps=0.68u
    I_MXI3_I285_MN1 (XI3_I285_n1 I3_q16_2 VSS VSS) gpdk090_nmos1v w=0.24u l=0.1u ad=0.0528p as=0.0816p pd=0.68u ps=1.16u
    I_MXI3_I285_MN0 (Y_16 I3_q16_1 XI3_I285_n1 VSS) gpdk090_nmos1v w=0.24u l=0.1u ad=0.0816p as=0.0528p pd=1.16u ps=0.68u
    I_MXI3_I293_MN1 (XI3_I293_n1 I3_n17_3 VSS VSS) gpdk090_nmos1v w=0.24u l=0.1u ad=0.0528p as=0.0816p pd=0.68u ps=1.16u
    I_MXI3_I293_MN0 (I3_o17_1 I3_n17_2 XI3_I293_n1 VSS) gpdk090_nmos1v w=0.24u l=0.1u ad=0.0816p as=0.0528p pd=1.16u ps=0.68u
    I_MXI3_I274_MN1 (XI3_I274_n1 AND_16 VSS VSS) gpdk090_nmos1v w=0.24u l=0.1u ad=0.0528p as=0.0816p pd=0.68u ps=1.16u
    I_MXI3_I274_MN0 (I3_n16_0 I3_SEL_AND_b3_3 XI3_I274_n1 VSS) gpdk090_nmos1v w=0.24u l=0.1u ad=0.0816p as=0.0528p pd=1.16u ps=0.68u
    I_MXI3_I292_MN1 (XI3_I292_n1 I3_n17_1 VSS VSS) gpdk090_nmos1v w=0.24u l=0.1u ad=0.0528p as=0.0816p pd=0.68u ps=1.16u
    I_MXI3_I292_MN0 (I3_o17_0 I3_n17_0 XI3_I292_n1 VSS) gpdk090_nmos1v w=0.24u l=0.1u ad=0.0816p as=0.0528p pd=1.16u ps=0.68u
    I_MXI3_I280_MN1 (XI3_I280_n1 I3_n16_1 VSS VSS) gpdk090_nmos1v w=0.24u l=0.1u ad=0.0528p as=0.0816p pd=0.68u ps=1.16u
    I_MXI3_I280_MN0 (I3_o16_0 I3_n16_0 XI3_I280_n1 VSS) gpdk090_nmos1v w=0.24u l=0.1u ad=0.0816p as=0.0528p pd=1.16u ps=0.68u
    I_MXI3_I287_MN1 (XI3_I287_n1 OR_17 VSS VSS) gpdk090_nmos1v w=0.24u l=0.1u ad=0.0528p as=0.0816p pd=0.68u ps=1.16u
    I_MXI3_I287_MN0 (I3_n17_1 I3_SEL_OR_b3_3 XI3_I287_n1 VSS) gpdk090_nmos1v w=0.24u l=0.1u ad=0.0816p as=0.0528p pd=1.16u ps=0.68u
    I_MXI3_I275_MN1 (XI3_I275_n1 OR_16 VSS VSS) gpdk090_nmos1v w=0.24u l=0.1u ad=0.0528p as=0.0816p pd=0.68u ps=1.16u
    I_MXI3_I275_MN0 (I3_n16_1 I3_SEL_OR_b3_3 XI3_I275_n1 VSS) gpdk090_nmos1v w=0.24u l=0.1u ad=0.0816p as=0.0528p pd=1.16u ps=0.68u
    I_MXI3_I383_MN1 (XI3_I383_n1 OR_25 VSS VSS) gpdk090_nmos1v w=0.24u l=0.1u ad=0.0528p as=0.0816p pd=0.68u ps=1.16u
    I_MXI3_I383_MN0 (I3_n25_1 I3_SEL_OR_b3_4 XI3_I383_n1 VSS) gpdk090_nmos1v w=0.24u l=0.1u ad=0.0816p as=0.0528p pd=1.16u ps=0.68u
    I_MXI3_I382_MN1 (XI3_I382_n1 AND_25 VSS VSS) gpdk090_nmos1v w=0.24u l=0.1u ad=0.0528p as=0.0816p pd=0.68u ps=1.16u
    I_MXI3_I382_MN0 (I3_n25_0 I3_SEL_AND_b3_4 XI3_I382_n1 VSS) gpdk090_nmos1v w=0.24u l=0.1u ad=0.0816p as=0.0528p pd=1.16u ps=0.68u
    I_MXI2_I150_MN1 (XI2_I150_n1 B_25 VSS VSS) gpdk090_nmos1v w=0.24u l=0.1u ad=0.0528p as=0.0816p pd=0.68u ps=1.16u
    I_MXI2_I150_MN0 (I2_nand25 A_25 XI2_I150_n1 VSS) gpdk090_nmos1v w=0.24u l=0.1u ad=0.0816p as=0.0528p pd=1.16u ps=0.68u
    I_MXI3_I370_MN1 (XI3_I370_n1 AND_24 VSS VSS) gpdk090_nmos1v w=0.24u l=0.1u ad=0.0528p as=0.0816p pd=0.68u ps=1.16u
    I_MXI3_I370_MN0 (I3_n24_0 I3_SEL_AND_b3_4 XI3_I370_n1 VSS) gpdk090_nmos1v w=0.24u l=0.1u ad=0.0816p as=0.0528p pd=1.16u ps=0.68u
    I_MXI3_I371_MN1 (XI3_I371_n1 OR_24 VSS VSS) gpdk090_nmos1v w=0.24u l=0.1u ad=0.0528p as=0.0816p pd=0.68u ps=1.16u
    I_MXI3_I371_MN0 (I3_n24_1 I3_SEL_OR_b3_4 XI3_I371_n1 VSS) gpdk090_nmos1v w=0.24u l=0.1u ad=0.0816p as=0.0528p pd=1.16u ps=0.68u
    I_MXI2_I144_MN1 (XI2_I144_n1 B_24 VSS VSS) gpdk090_nmos1v w=0.24u l=0.1u ad=0.0528p as=0.0816p pd=0.68u ps=1.16u
    I_MXI2_I144_MN0 (I2_nand24 A_24 XI2_I144_n1 VSS) gpdk090_nmos1v w=0.24u l=0.1u ad=0.0816p as=0.0528p pd=1.16u ps=0.68u
    I_MXI3_I359_MN1 (XI3_I359_n1 OR_23 VSS VSS) gpdk090_nmos1v w=0.24u l=0.1u ad=0.0528p as=0.0816p pd=0.68u ps=1.16u
    I_MXI3_I359_MN0 (I3_n23_1 I3_SEL_OR_b3_4 XI3_I359_n1 VSS) gpdk090_nmos1v w=0.24u l=0.1u ad=0.0816p as=0.0528p pd=1.16u ps=0.68u
    I_MXI3_I358_MN1 (XI3_I358_n1 AND_23 VSS VSS) gpdk090_nmos1v w=0.24u l=0.1u ad=0.0528p as=0.0816p pd=0.68u ps=1.16u
    I_MXI3_I358_MN0 (I3_n23_0 I3_SEL_AND_b3_4 XI3_I358_n1 VSS) gpdk090_nmos1v w=0.24u l=0.1u ad=0.0816p as=0.0528p pd=1.16u ps=0.68u
    I_MXI3_I347_MN1 (XI3_I347_n1 OR_22 VSS VSS) gpdk090_nmos1v w=0.24u l=0.1u ad=0.0528p as=0.0816p pd=0.68u ps=1.16u
    I_MXI3_I347_MN0 (I3_n22_1 I3_SEL_OR_b3_4 XI3_I347_n1 VSS) gpdk090_nmos1v w=0.24u l=0.1u ad=0.0816p as=0.0528p pd=1.16u ps=0.68u
    I_MXI2_I138_MN1 (XI2_I138_n1 B_23 VSS VSS) gpdk090_nmos1v w=0.24u l=0.1u ad=0.0528p as=0.0816p pd=0.68u ps=1.16u
    I_MXI2_I138_MN0 (I2_nand23 A_23 XI2_I138_n1 VSS) gpdk090_nmos1v w=0.24u l=0.1u ad=0.0816p as=0.0528p pd=1.16u ps=0.68u
    I_MXI3_I352_MN1 (XI3_I352_n1 I3_n22_1 VSS VSS) gpdk090_nmos1v w=0.24u l=0.1u ad=0.0528p as=0.0816p pd=0.68u ps=1.16u
    I_MXI3_I352_MN0 (I3_o22_0 I3_n22_0 XI3_I352_n1 VSS) gpdk090_nmos1v w=0.24u l=0.1u ad=0.0816p as=0.0528p pd=1.16u ps=0.68u
    I_MXI3_I346_MN1 (XI3_I346_n1 AND_22 VSS VSS) gpdk090_nmos1v w=0.24u l=0.1u ad=0.0528p as=0.0816p pd=0.68u ps=1.16u
    I_MXI3_I346_MN0 (I3_n22_0 I3_SEL_AND_b3_4 XI3_I346_n1 VSS) gpdk090_nmos1v w=0.24u l=0.1u ad=0.0816p as=0.0528p pd=1.16u ps=0.68u
    I_MXI2_I132_MN1 (XI2_I132_n1 B_22 VSS VSS) gpdk090_nmos1v w=0.24u l=0.1u ad=0.0528p as=0.0816p pd=0.68u ps=1.16u
    I_MXI2_I132_MN0 (I2_nand22 A_22 XI2_I132_n1 VSS) gpdk090_nmos1v w=0.24u l=0.1u ad=0.0816p as=0.0528p pd=1.16u ps=0.68u
    I_MXI3_I357_MN1 (XI3_I357_n1 I3_q22_2 VSS VSS) gpdk090_nmos1v w=0.24u l=0.1u ad=0.0528p as=0.0816p pd=0.68u ps=1.16u
    I_MXI3_I357_MN0 (Y_22 I3_q22_1 XI3_I357_n1 VSS) gpdk090_nmos1v w=0.24u l=0.1u ad=0.0816p as=0.0528p pd=1.16u ps=0.68u
    I_MXI4_I37_MN1 (XI4_I37_n1 I4_z0_11 VSS VSS) gpdk090_nmos1v w=0.24u l=0.1u ad=0.0528p as=0.0816p pd=0.68u ps=1.16u
    I_MXI4_I37_MN0 (I4_z1_5 I4_z0_10 XI4_I37_n1 VSS) gpdk090_nmos1v w=0.24u l=0.1u ad=0.0816p as=0.0528p pd=1.16u ps=0.68u
    I_MXI3_I334_MN1 (XI3_I334_n1 AND_21 VSS VSS) gpdk090_nmos1v w=0.24u l=0.1u ad=0.0528p as=0.0816p pd=0.68u ps=1.16u
    I_MXI3_I334_MN0 (I3_n21_0 I3_SEL_AND_b3_3 XI3_I334_n1 VSS) gpdk090_nmos1v w=0.24u l=0.1u ad=0.0816p as=0.0528p pd=1.16u ps=0.68u
    I_MXI3_I340_MN1 (XI3_I340_n1 I3_n21_1 VSS VSS) gpdk090_nmos1v w=0.24u l=0.1u ad=0.0528p as=0.0816p pd=0.68u ps=1.16u
    I_MXI3_I340_MN0 (I3_o21_0 I3_n21_0 XI3_I340_n1 VSS) gpdk090_nmos1v w=0.24u l=0.1u ad=0.0816p as=0.0528p pd=1.16u ps=0.68u
    I_MXI2_I126_MN1 (XI2_I126_n1 B_21 VSS VSS) gpdk090_nmos1v w=0.24u l=0.1u ad=0.0528p as=0.0816p pd=0.68u ps=1.16u
    I_MXI2_I126_MN0 (I2_nand21 A_21 XI2_I126_n1 VSS) gpdk090_nmos1v w=0.24u l=0.1u ad=0.0816p as=0.0528p pd=1.16u ps=0.68u
    I_MXI3_I336_MN1 (XI3_I336_n1 XOR_21 VSS VSS) gpdk090_nmos1v w=0.24u l=0.1u ad=0.0528p as=0.0816p pd=0.68u ps=1.16u
    I_MXI3_I336_MN0 (I3_n21_2 I3_SEL_XOR_b3_3 XI3_I336_n1 VSS) gpdk090_nmos1v w=0.24u l=0.1u ad=0.0816p as=0.0528p pd=1.16u ps=0.68u
    I_MXI3_I363_MN1 (XI3_I363_n1 DIVQ_23 VSS VSS) gpdk090_nmos1v w=0.24u l=0.1u ad=0.0528p as=0.0816p pd=0.68u ps=1.16u
    I_MXI3_I363_MN0 (I3_n23_5 I3_SEL_DIV_b3_3 XI3_I363_n1 VSS) gpdk090_nmos1v w=0.24u l=0.1u ad=0.0816p as=0.0528p pd=1.16u ps=0.68u
    I_MXI3_I345_MN1 (XI3_I345_n1 I3_q21_2 VSS VSS) gpdk090_nmos1v w=0.24u l=0.1u ad=0.0528p as=0.0816p pd=0.68u ps=1.16u
    I_MXI3_I345_MN0 (Y_21 I3_q21_1 XI3_I345_n1 VSS) gpdk090_nmos1v w=0.24u l=0.1u ad=0.0816p as=0.0528p pd=1.16u ps=0.68u
    I_MXI3_I333_MN1 (XI3_I333_n1 I3_q20_2 VSS VSS) gpdk090_nmos1v w=0.24u l=0.1u ad=0.0528p as=0.0816p pd=0.68u ps=1.16u
    I_MXI3_I333_MN0 (Y_20 I3_q20_1 XI3_I333_n1 VSS) gpdk090_nmos1v w=0.24u l=0.1u ad=0.0816p as=0.0528p pd=1.16u ps=0.68u
    I_MXI3_I322_MN1 (XI3_I322_n1 AND_20 VSS VSS) gpdk090_nmos1v w=0.24u l=0.1u ad=0.0528p as=0.0816p pd=0.68u ps=1.16u
    I_MXI3_I322_MN0 (I3_n20_0 I3_SEL_AND_b3_3 XI3_I322_n1 VSS) gpdk090_nmos1v w=0.24u l=0.1u ad=0.0816p as=0.0528p pd=1.16u ps=0.68u
    I_MXI2_I120_MN1 (XI2_I120_n1 B_20 VSS VSS) gpdk090_nmos1v w=0.24u l=0.1u ad=0.0528p as=0.0816p pd=0.68u ps=1.16u
    I_MXI2_I120_MN0 (I2_nand20 A_20 XI2_I120_n1 VSS) gpdk090_nmos1v w=0.24u l=0.1u ad=0.0816p as=0.0528p pd=1.16u ps=0.68u
    I_MXI3_I328_MN1 (XI3_I328_n1 I3_n20_1 VSS VSS) gpdk090_nmos1v w=0.24u l=0.1u ad=0.0528p as=0.0816p pd=0.68u ps=1.16u
    I_MXI3_I328_MN0 (I3_o20_0 I3_n20_0 XI3_I328_n1 VSS) gpdk090_nmos1v w=0.24u l=0.1u ad=0.0816p as=0.0528p pd=1.16u ps=0.68u
    I_MXI3_I323_MN1 (XI3_I323_n1 OR_20 VSS VSS) gpdk090_nmos1v w=0.24u l=0.1u ad=0.0528p as=0.0816p pd=0.68u ps=1.16u
    I_MXI3_I323_MN0 (I3_n20_1 I3_SEL_OR_b3_3 XI3_I323_n1 VSS) gpdk090_nmos1v w=0.24u l=0.1u ad=0.0816p as=0.0528p pd=1.16u ps=0.68u
    I_MXI2_I114_MN1 (XI2_I114_n1 B_19 VSS VSS) gpdk090_nmos1v w=0.24u l=0.1u ad=0.0528p as=0.0816p pd=0.68u ps=1.16u
    I_MXI2_I114_MN0 (I2_nand19 A_19 XI2_I114_n1 VSS) gpdk090_nmos1v w=0.24u l=0.1u ad=0.0816p as=0.0528p pd=1.16u ps=0.68u
    I_MXI3_I315_MN1 (XI3_I315_n1 DIVQ_19 VSS VSS) gpdk090_nmos1v w=0.24u l=0.1u ad=0.0528p as=0.0816p pd=0.68u ps=1.16u
    I_MXI3_I315_MN0 (I3_n19_5 I3_SEL_DIV_b3_3 XI3_I315_n1 VSS) gpdk090_nmos1v w=0.24u l=0.1u ad=0.0816p as=0.0528p pd=1.16u ps=0.68u
    I_MXI3_I310_MN1 (XI3_I310_n1 AND_19 VSS VSS) gpdk090_nmos1v w=0.24u l=0.1u ad=0.0528p as=0.0816p pd=0.68u ps=1.16u
    I_MXI3_I310_MN0 (I3_n19_0 I3_SEL_AND_b3_3 XI3_I310_n1 VSS) gpdk090_nmos1v w=0.24u l=0.1u ad=0.0816p as=0.0528p pd=1.16u ps=0.68u
    I_MXI3_I311_MN1 (XI3_I311_n1 OR_19 VSS VSS) gpdk090_nmos1v w=0.24u l=0.1u ad=0.0528p as=0.0816p pd=0.68u ps=1.16u
    I_MXI3_I311_MN0 (I3_n19_1 I3_SEL_OR_b3_3 XI3_I311_n1 VSS) gpdk090_nmos1v w=0.24u l=0.1u ad=0.0816p as=0.0528p pd=1.16u ps=0.68u
    I_MXI3_I316_MN1 (XI3_I316_n1 I3_n19_1 VSS VSS) gpdk090_nmos1v w=0.24u l=0.1u ad=0.0528p as=0.0816p pd=0.68u ps=1.16u
    I_MXI3_I316_MN0 (I3_o19_0 I3_n19_0 XI3_I316_n1 VSS) gpdk090_nmos1v w=0.24u l=0.1u ad=0.0816p as=0.0528p pd=1.16u ps=0.68u
    I_MXI4_I36_MN1 (XI4_I36_n1 I4_z0_9 VSS VSS) gpdk090_nmos1v w=0.24u l=0.1u ad=0.0528p as=0.0816p pd=0.68u ps=1.16u
    I_MXI4_I36_MN0 (I4_z1_4 I4_z0_8 XI4_I36_n1 VSS) gpdk090_nmos1v w=0.24u l=0.1u ad=0.0816p as=0.0528p pd=1.16u ps=0.68u
    I_MXI3_I304_MN1 (XI3_I304_n1 I3_n18_1 VSS VSS) gpdk090_nmos1v w=0.24u l=0.1u ad=0.0528p as=0.0816p pd=0.68u ps=1.16u
    I_MXI3_I304_MN0 (I3_o18_0 I3_n18_0 XI3_I304_n1 VSS) gpdk090_nmos1v w=0.24u l=0.1u ad=0.0816p as=0.0528p pd=1.16u ps=0.68u
    I_MXI3_I298_MN1 (XI3_I298_n1 AND_18 VSS VSS) gpdk090_nmos1v w=0.24u l=0.1u ad=0.0528p as=0.0816p pd=0.68u ps=1.16u
    I_MXI3_I298_MN0 (I3_n18_0 I3_SEL_AND_b3_3 XI3_I298_n1 VSS) gpdk090_nmos1v w=0.24u l=0.1u ad=0.0816p as=0.0528p pd=1.16u ps=0.68u
    I_MXI3_I299_MN1 (XI3_I299_n1 OR_18 VSS VSS) gpdk090_nmos1v w=0.24u l=0.1u ad=0.0528p as=0.0816p pd=0.68u ps=1.16u
    I_MXI3_I299_MN0 (I3_n18_1 I3_SEL_OR_b3_3 XI3_I299_n1 VSS) gpdk090_nmos1v w=0.24u l=0.1u ad=0.0816p as=0.0528p pd=1.16u ps=0.68u
    I_MXI3_I288_MN1 (XI3_I288_n1 XOR_17 VSS VSS) gpdk090_nmos1v w=0.24u l=0.1u ad=0.0528p as=0.0816p pd=0.68u ps=1.16u
    I_MXI3_I288_MN0 (I3_n17_2 I3_SEL_XOR_b3_3 XI3_I288_n1 VSS) gpdk090_nmos1v w=0.24u l=0.1u ad=0.0816p as=0.0528p pd=1.16u ps=0.68u
    I_MXI2_I102_MN1 (XI2_I102_n1 B_17 VSS VSS) gpdk090_nmos1v w=0.24u l=0.1u ad=0.0528p as=0.0816p pd=0.68u ps=1.16u
    I_MXI2_I102_MN0 (I2_nand17 A_17 XI2_I102_n1 VSS) gpdk090_nmos1v w=0.24u l=0.1u ad=0.0816p as=0.0528p pd=1.16u ps=0.68u
    I_MXI3_I286_MN1 (XI3_I286_n1 AND_17 VSS VSS) gpdk090_nmos1v w=0.24u l=0.1u ad=0.0528p as=0.0816p pd=0.68u ps=1.16u
    I_MXI3_I286_MN0 (I3_n17_0 I3_SEL_AND_b3_3 XI3_I286_n1 VSS) gpdk090_nmos1v w=0.24u l=0.1u ad=0.0816p as=0.0528p pd=1.16u ps=0.68u
    I_MXI4_I29_MN0 (I4_z0_29 Y_58 VSS VSS) gpdk090_nmos1v w=0.12u l=0.1u ad=0.0408p as=0.0696p pd=0.68u ps=1.16u
    I_MXI4_I29_MN1 (VSS Y_59 I4_z0_29 VSS) gpdk090_nmos1v w=0.12u l=0.1u ad=0.0696p as=0.0408p pd=1.16u ps=0.68u
    I_MXI4_I30_MN0 (I4_z0_30 Y_60 VSS VSS) gpdk090_nmos1v w=0.12u l=0.1u ad=0.0408p as=0.0696p pd=0.68u ps=1.16u
    I_MXI4_I30_MN1 (VSS Y_61 I4_z0_30 VSS) gpdk090_nmos1v w=0.12u l=0.1u ad=0.0696p as=0.0408p pd=1.16u ps=0.68u
    I_MXI4_I3_MN0 (I4_z0_3 Y_6 VSS VSS) gpdk090_nmos1v w=0.12u l=0.1u ad=0.0408p as=0.0696p pd=0.68u ps=1.16u
    I_MXI4_I3_MN1 (VSS Y_7 I4_z0_3 VSS) gpdk090_nmos1v w=0.12u l=0.1u ad=0.0696p as=0.0408p pd=1.16u ps=0.68u
    I_MXI2_I2_MN0 (I2_nor0 A_0 VSS VSS) gpdk090_nmos1v w=0.12u l=0.1u ad=0.0408p as=0.0696p pd=0.68u ps=1.16u
    I_MXI2_I2_MN1 (VSS B_0 I2_nor0 VSS) gpdk090_nmos1v w=0.12u l=0.1u ad=0.0696p as=0.0408p pd=1.16u ps=0.68u
    I_MXI4_I2_MN0 (I4_z0_2 Y_4 VSS VSS) gpdk090_nmos1v w=0.12u l=0.1u ad=0.0408p as=0.0696p pd=0.68u ps=1.16u
    I_MXI4_I2_MN1 (VSS Y_5 I4_z0_2 VSS) gpdk090_nmos1v w=0.12u l=0.1u ad=0.0696p as=0.0408p pd=1.16u ps=0.68u
    I_MXI2_I8_MN0 (I2_nor1 A_1 VSS VSS) gpdk090_nmos1v w=0.12u l=0.1u ad=0.0408p as=0.0696p pd=0.68u ps=1.16u
    I_MXI2_I8_MN1 (VSS B_1 I2_nor1 VSS) gpdk090_nmos1v w=0.12u l=0.1u ad=0.0696p as=0.0408p pd=1.16u ps=0.68u
    I_MXI3_I139_MN0 (I3_q4_1 I3_o4_0 VSS VSS) gpdk090_nmos1v w=0.12u l=0.1u ad=0.0408p as=0.0696p pd=0.68u ps=1.16u
    I_MXI3_I139_MN1 (VSS I3_o4_1 I3_q4_1 VSS) gpdk090_nmos1v w=0.12u l=0.1u ad=0.0696p as=0.0408p pd=1.16u ps=0.68u
    I_MXI4_I28_MN0 (I4_z0_28 Y_56 VSS VSS) gpdk090_nmos1v w=0.12u l=0.1u ad=0.0408p as=0.0696p pd=0.68u ps=1.16u
    I_MXI4_I28_MN1 (VSS Y_57 I4_z0_28 VSS) gpdk090_nmos1v w=0.12u l=0.1u ad=0.0696p as=0.0408p pd=1.16u ps=0.68u
    I_MXI4_I55_MN0 (I4_z2_7 I4_z1_14 VSS VSS) gpdk090_nmos1v w=0.12u l=0.1u ad=0.0408p as=0.0696p pd=0.68u ps=1.16u
    I_MXI4_I55_MN1 (VSS I4_z1_15 I4_z2_7 VSS) gpdk090_nmos1v w=0.12u l=0.1u ad=0.0696p as=0.0408p pd=1.16u ps=0.68u
    I_MXI4_I31_MN0 (I4_z0_31 Y_62 VSS VSS) gpdk090_nmos1v w=0.12u l=0.1u ad=0.0408p as=0.0696p pd=0.68u ps=1.16u
    I_MXI4_I31_MN1 (VSS Y_63 I4_z0_31 VSS) gpdk090_nmos1v w=0.12u l=0.1u ad=0.0696p as=0.0408p pd=1.16u ps=0.68u
    I_MXI2_I50_MN0 (I2_nor8 A_8 VSS VSS) gpdk090_nmos1v w=0.12u l=0.1u ad=0.0408p as=0.0696p pd=0.68u ps=1.16u
    I_MXI2_I50_MN1 (VSS B_8 I2_nor8 VSS) gpdk090_nmos1v w=0.12u l=0.1u ad=0.0696p as=0.0408p pd=1.16u ps=0.68u
    I_MXI2_I56_MN0 (I2_nor9 A_9 VSS VSS) gpdk090_nmos1v w=0.12u l=0.1u ad=0.0408p as=0.0696p pd=0.68u ps=1.16u
    I_MXI2_I56_MN1 (VSS B_9 I2_nor9 VSS) gpdk090_nmos1v w=0.12u l=0.1u ad=0.0696p as=0.0408p pd=1.16u ps=0.68u
    I_MXI3_I163_MN0 (I3_q6_1 I3_o6_0 VSS VSS) gpdk090_nmos1v w=0.12u l=0.1u ad=0.0408p as=0.0696p pd=0.68u ps=1.16u
    I_MXI3_I163_MN1 (VSS I3_o6_1 I3_q6_1 VSS) gpdk090_nmos1v w=0.12u l=0.1u ad=0.0696p as=0.0408p pd=1.16u ps=0.68u
    I_MXI2_I38_MN0 (I2_nor6 A_6 VSS VSS) gpdk090_nmos1v w=0.12u l=0.1u ad=0.0408p as=0.0696p pd=0.68u ps=1.16u
    I_MXI2_I38_MN1 (VSS B_6 I2_nor6 VSS) gpdk090_nmos1v w=0.12u l=0.1u ad=0.0696p as=0.0408p pd=1.16u ps=0.68u
    I_MXI4_I48_MN0 (I4_z2_0 I4_z1_0 VSS VSS) gpdk090_nmos1v w=0.12u l=0.1u ad=0.0408p as=0.0696p pd=0.68u ps=1.16u
    I_MXI4_I48_MN1 (VSS I4_z1_1 I4_z2_0 VSS) gpdk090_nmos1v w=0.12u l=0.1u ad=0.0696p as=0.0408p pd=1.16u ps=0.68u
    I_MXI3_I91_MN0 (I3_q0_1 I3_o0_0 VSS VSS) gpdk090_nmos1v w=0.12u l=0.1u ad=0.0408p as=0.0696p pd=0.68u ps=1.16u
    I_MXI3_I91_MN1 (VSS I3_o0_1 I3_q0_1 VSS) gpdk090_nmos1v w=0.12u l=0.1u ad=0.0696p as=0.0408p pd=1.16u ps=0.68u
    I_MXI4_I0_MN0 (I4_z0_0 Y_0 VSS VSS) gpdk090_nmos1v w=0.12u l=0.1u ad=0.0408p as=0.0696p pd=0.68u ps=1.16u
    I_MXI4_I0_MN1 (VSS Y_1 I4_z0_0 VSS) gpdk090_nmos1v w=0.12u l=0.1u ad=0.0696p as=0.0408p pd=1.16u ps=0.68u
    I_MXI3_I103_MN0 (I3_q1_1 I3_o1_0 VSS VSS) gpdk090_nmos1v w=0.12u l=0.1u ad=0.0408p as=0.0696p pd=0.68u ps=1.16u
    I_MXI3_I103_MN1 (VSS I3_o1_1 I3_q1_1 VSS) gpdk090_nmos1v w=0.12u l=0.1u ad=0.0696p as=0.0408p pd=1.16u ps=0.68u
    I_MXI2_I26_MN0 (I2_nor4 A_4 VSS VSS) gpdk090_nmos1v w=0.12u l=0.1u ad=0.0408p as=0.0696p pd=0.68u ps=1.16u
    I_MXI2_I26_MN1 (VSS B_4 I2_nor4 VSS) gpdk090_nmos1v w=0.12u l=0.1u ad=0.0696p as=0.0408p pd=1.16u ps=0.68u
    I_MXI4_I26_MN0 (I4_z0_26 Y_52 VSS VSS) gpdk090_nmos1v w=0.12u l=0.1u ad=0.0408p as=0.0696p pd=0.68u ps=1.16u
    I_MXI4_I26_MN1 (VSS Y_53 I4_z0_26 VSS) gpdk090_nmos1v w=0.12u l=0.1u ad=0.0696p as=0.0408p pd=1.16u ps=0.68u
    I_MXI4_I27_MN0 (I4_z0_27 Y_54 VSS VSS) gpdk090_nmos1v w=0.12u l=0.1u ad=0.0408p as=0.0696p pd=0.68u ps=1.16u
    I_MXI4_I27_MN1 (VSS Y_55 I4_z0_27 VSS) gpdk090_nmos1v w=0.12u l=0.1u ad=0.0696p as=0.0408p pd=1.16u ps=0.68u
    I_MXI4_I54_MN0 (I4_z2_6 I4_z1_12 VSS VSS) gpdk090_nmos1v w=0.12u l=0.1u ad=0.0408p as=0.0696p pd=0.68u ps=1.16u
    I_MXI4_I54_MN1 (VSS I4_z1_13 I4_z2_6 VSS) gpdk090_nmos1v w=0.12u l=0.1u ad=0.0696p as=0.0408p pd=1.16u ps=0.68u
    I_MXI4_I61_MN0 (I4_z4_1 I4_z3_2 VSS VSS) gpdk090_nmos1v w=0.12u l=0.1u ad=0.0408p as=0.0696p pd=0.68u ps=1.16u
    I_MXI4_I61_MN1 (VSS I4_z3_3 I4_z4_1 VSS) gpdk090_nmos1v w=0.12u l=0.1u ad=0.0696p as=0.0408p pd=1.16u ps=0.68u
    I_MXI4_I22_MN0 (I4_z0_22 Y_44 VSS VSS) gpdk090_nmos1v w=0.12u l=0.1u ad=0.0408p as=0.0696p pd=0.68u ps=1.16u
    I_MXI4_I22_MN1 (VSS Y_45 I4_z0_22 VSS) gpdk090_nmos1v w=0.12u l=0.1u ad=0.0696p as=0.0408p pd=1.16u ps=0.68u
    I_MXI3_I187_MN0 (I3_q8_1 I3_o8_0 VSS VSS) gpdk090_nmos1v w=0.12u l=0.1u ad=0.0408p as=0.0696p pd=0.68u ps=1.16u
    I_MXI3_I187_MN1 (VSS I3_o8_1 I3_q8_1 VSS) gpdk090_nmos1v w=0.12u l=0.1u ad=0.0696p as=0.0408p pd=1.16u ps=0.68u
    I_MXI4_I4_MN0 (I4_z0_4 Y_8 VSS VSS) gpdk090_nmos1v w=0.12u l=0.1u ad=0.0408p as=0.0696p pd=0.68u ps=1.16u
    I_MXI4_I4_MN1 (VSS Y_9 I4_z0_4 VSS) gpdk090_nmos1v w=0.12u l=0.1u ad=0.0696p as=0.0408p pd=1.16u ps=0.68u
    I_MXI3_I199_MN0 (I3_q9_1 I3_o9_0 VSS VSS) gpdk090_nmos1v w=0.12u l=0.1u ad=0.0408p as=0.0696p pd=0.68u ps=1.16u
    I_MXI3_I199_MN1 (VSS I3_o9_1 I3_q9_1 VSS) gpdk090_nmos1v w=0.12u l=0.1u ad=0.0696p as=0.0408p pd=1.16u ps=0.68u
    I_MXI2_I44_MN0 (I2_nor7 A_7 VSS VSS) gpdk090_nmos1v w=0.12u l=0.1u ad=0.0408p as=0.0696p pd=0.68u ps=1.16u
    I_MXI2_I44_MN1 (VSS B_7 I2_nor7 VSS) gpdk090_nmos1v w=0.12u l=0.1u ad=0.0696p as=0.0408p pd=1.16u ps=0.68u
    I_MXI2_I14_MN0 (I2_nor2 A_2 VSS VSS) gpdk090_nmos1v w=0.12u l=0.1u ad=0.0408p as=0.0696p pd=0.68u ps=1.16u
    I_MXI2_I14_MN1 (VSS B_2 I2_nor2 VSS) gpdk090_nmos1v w=0.12u l=0.1u ad=0.0696p as=0.0408p pd=1.16u ps=0.68u
    I_MXI4_I24_MN0 (I4_z0_24 Y_48 VSS VSS) gpdk090_nmos1v w=0.12u l=0.1u ad=0.0408p as=0.0696p pd=0.68u ps=1.16u
    I_MXI4_I24_MN1 (VSS Y_49 I4_z0_24 VSS) gpdk090_nmos1v w=0.12u l=0.1u ad=0.0696p as=0.0408p pd=1.16u ps=0.68u
    I_MXI4_I25_MN0 (I4_z0_25 Y_50 VSS VSS) gpdk090_nmos1v w=0.12u l=0.1u ad=0.0408p as=0.0696p pd=0.68u ps=1.16u
    I_MXI4_I25_MN1 (VSS Y_51 I4_z0_25 VSS) gpdk090_nmos1v w=0.12u l=0.1u ad=0.0696p as=0.0408p pd=1.16u ps=0.68u
    I_MXI4_I23_MN0 (I4_z0_23 Y_46 VSS VSS) gpdk090_nmos1v w=0.12u l=0.1u ad=0.0408p as=0.0696p pd=0.68u ps=1.16u
    I_MXI4_I23_MN1 (VSS Y_47 I4_z0_23 VSS) gpdk090_nmos1v w=0.12u l=0.1u ad=0.0696p as=0.0408p pd=1.16u ps=0.68u
    I_MXI4_I53_MN0 (I4_z2_5 I4_z1_10 VSS VSS) gpdk090_nmos1v w=0.12u l=0.1u ad=0.0408p as=0.0696p pd=0.68u ps=1.16u
    I_MXI4_I53_MN1 (VSS I4_z1_11 I4_z2_5 VSS) gpdk090_nmos1v w=0.12u l=0.1u ad=0.0696p as=0.0408p pd=1.16u ps=0.68u
    I_MXI4_I21_MN0 (I4_z0_21 Y_42 VSS VSS) gpdk090_nmos1v w=0.12u l=0.1u ad=0.0408p as=0.0696p pd=0.68u ps=1.16u
    I_MXI4_I21_MN1 (VSS Y_43 I4_z0_21 VSS) gpdk090_nmos1v w=0.12u l=0.1u ad=0.0696p as=0.0408p pd=1.16u ps=0.68u
    I_MXI4_I60_MN0 (I4_z4_0 I4_z3_0 VSS VSS) gpdk090_nmos1v w=0.12u l=0.1u ad=0.0408p as=0.0696p pd=0.68u ps=1.16u
    I_MXI4_I60_MN1 (VSS I4_z3_1 I4_z4_0 VSS) gpdk090_nmos1v w=0.12u l=0.1u ad=0.0696p as=0.0408p pd=1.16u ps=0.68u
    I_MXI3_I211_MN0 (I3_q10_1 I3_o10_0 VSS VSS) gpdk090_nmos1v w=0.12u l=0.1u ad=0.0408p as=0.0696p pd=0.68u ps=1.16u
    I_MXI3_I211_MN1 (VSS I3_o10_1 I3_q10_1 VSS) gpdk090_nmos1v w=0.12u l=0.1u ad=0.0696p as=0.0408p pd=1.16u ps=0.68u
    I_MXI4_I5_MN0 (I4_z0_5 Y_10 VSS VSS) gpdk090_nmos1v w=0.12u l=0.1u ad=0.0408p as=0.0696p pd=0.68u ps=1.16u
    I_MXI4_I5_MN1 (VSS Y_11 I4_z0_5 VSS) gpdk090_nmos1v w=0.12u l=0.1u ad=0.0696p as=0.0408p pd=1.16u ps=0.68u
    I_MXI3_I175_MN0 (I3_q7_1 I3_o7_0 VSS VSS) gpdk090_nmos1v w=0.12u l=0.1u ad=0.0408p as=0.0696p pd=0.68u ps=1.16u
    I_MXI3_I175_MN1 (VSS I3_o7_1 I3_q7_1 VSS) gpdk090_nmos1v w=0.12u l=0.1u ad=0.0696p as=0.0408p pd=1.16u ps=0.68u
    I_MXI4_I49_MN0 (I4_z2_1 I4_z1_2 VSS VSS) gpdk090_nmos1v w=0.12u l=0.1u ad=0.0408p as=0.0696p pd=0.68u ps=1.16u
    I_MXI4_I49_MN1 (VSS I4_z1_3 I4_z2_1 VSS) gpdk090_nmos1v w=0.12u l=0.1u ad=0.0696p as=0.0408p pd=1.16u ps=0.68u
    I_MXI3_I151_MN0 (I3_q5_1 I3_o5_0 VSS VSS) gpdk090_nmos1v w=0.12u l=0.1u ad=0.0408p as=0.0696p pd=0.68u ps=1.16u
    I_MXI3_I151_MN1 (VSS I3_o5_1 I3_q5_1 VSS) gpdk090_nmos1v w=0.12u l=0.1u ad=0.0696p as=0.0408p pd=1.16u ps=0.68u
    I_MXI3_I115_MN0 (I3_q2_1 I3_o2_0 VSS VSS) gpdk090_nmos1v w=0.12u l=0.1u ad=0.0408p as=0.0696p pd=0.68u ps=1.16u
    I_MXI3_I115_MN1 (VSS I3_o2_1 I3_q2_1 VSS) gpdk090_nmos1v w=0.12u l=0.1u ad=0.0696p as=0.0408p pd=1.16u ps=0.68u
    I_MXI4_I20_MN0 (I4_z0_20 Y_40 VSS VSS) gpdk090_nmos1v w=0.12u l=0.1u ad=0.0408p as=0.0696p pd=0.68u ps=1.16u
    I_MXI4_I20_MN1 (VSS Y_41 I4_z0_20 VSS) gpdk090_nmos1v w=0.12u l=0.1u ad=0.0696p as=0.0408p pd=1.16u ps=0.68u
    I_MXI2_I62_MN0 (I2_nor10 A_10 VSS VSS) gpdk090_nmos1v w=0.12u l=0.1u ad=0.0408p as=0.0696p pd=0.68u ps=1.16u
    I_MXI2_I62_MN1 (VSS B_10 I2_nor10 VSS) gpdk090_nmos1v w=0.12u l=0.1u ad=0.0696p as=0.0408p pd=1.16u ps=0.68u
    I_MXI2_I32_MN0 (I2_nor5 A_5 VSS VSS) gpdk090_nmos1v w=0.12u l=0.1u ad=0.0408p as=0.0696p pd=0.68u ps=1.16u
    I_MXI2_I32_MN1 (VSS B_5 I2_nor5 VSS) gpdk090_nmos1v w=0.12u l=0.1u ad=0.0696p as=0.0408p pd=1.16u ps=0.68u
    I_MXI4_I1_MN0 (I4_z0_1 Y_2 VSS VSS) gpdk090_nmos1v w=0.12u l=0.1u ad=0.0408p as=0.0696p pd=0.68u ps=1.16u
    I_MXI4_I1_MN1 (VSS Y_3 I4_z0_1 VSS) gpdk090_nmos1v w=0.12u l=0.1u ad=0.0696p as=0.0408p pd=1.16u ps=0.68u
    I_MXI3_I127_MN0 (I3_q3_1 I3_o3_0 VSS VSS) gpdk090_nmos1v w=0.12u l=0.1u ad=0.0408p as=0.0696p pd=0.68u ps=1.16u
    I_MXI3_I127_MN1 (VSS I3_o3_1 I3_q3_1 VSS) gpdk090_nmos1v w=0.12u l=0.1u ad=0.0696p as=0.0408p pd=1.16u ps=0.68u
    I_MXI4_I19_MN0 (I4_z0_19 Y_38 VSS VSS) gpdk090_nmos1v w=0.12u l=0.1u ad=0.0408p as=0.0696p pd=0.68u ps=1.16u
    I_MXI4_I19_MN1 (VSS Y_39 I4_z0_19 VSS) gpdk090_nmos1v w=0.12u l=0.1u ad=0.0696p as=0.0408p pd=1.16u ps=0.68u
    I_MXI4_I52_MN0 (I4_z2_4 I4_z1_8 VSS VSS) gpdk090_nmos1v w=0.12u l=0.1u ad=0.0408p as=0.0696p pd=0.68u ps=1.16u
    I_MXI4_I52_MN1 (VSS I4_z1_9 I4_z2_4 VSS) gpdk090_nmos1v w=0.12u l=0.1u ad=0.0696p as=0.0408p pd=1.16u ps=0.68u
    I_MXI0_I16_MN0 (SEL_MUL I0_h10 VSS VSS) gpdk090_nmos1v w=0.12u l=0.1u ad=0.0408p as=0.0696p pd=0.68u ps=1.16u
    I_MXI0_I16_MN1 (VSS I0_l01 SEL_MUL VSS) gpdk090_nmos1v w=0.12u l=0.1u ad=0.0696p as=0.0408p pd=1.16u ps=0.68u
    I_MXI0_I15_MN0 (SEL_NOT I0_h01 VSS VSS) gpdk090_nmos1v w=0.12u l=0.1u ad=0.0408p as=0.0696p pd=0.68u ps=1.16u
    I_MXI0_I15_MN1 (VSS I0_l01 SEL_NOT VSS) gpdk090_nmos1v w=0.12u l=0.1u ad=0.0696p as=0.0408p pd=1.16u ps=0.68u
    I_MXI1_I42_I71_XP_MN0 (I1_I42_P5_4 I1_I42_pn5 VSS VSS) gpdk090_nmos1v w=0.12u l=0.1u ad=0.0408p as=0.0696p pd=0.68u ps=1.16u
    I_MXI1_I42_I71_XP_MN1 (VSS I1_I42_pn4 I1_I42_P5_4 VSS) gpdk090_nmos1v w=0.12u l=0.1u ad=0.0696p as=0.0408p pd=1.16u ps=0.68u
    I_MXI4_I18_MN0 (I4_z0_18 Y_36 VSS VSS) gpdk090_nmos1v w=0.12u l=0.1u ad=0.0408p as=0.0696p pd=0.68u ps=1.16u
    I_MXI4_I18_MN1 (VSS Y_37 I4_z0_18 VSS) gpdk090_nmos1v w=0.12u l=0.1u ad=0.0696p as=0.0408p pd=1.16u ps=0.68u
    I_MXI4_I17_MN0 (I4_z0_17 Y_34 VSS VSS) gpdk090_nmos1v w=0.12u l=0.1u ad=0.0408p as=0.0696p pd=0.68u ps=1.16u
    I_MXI4_I17_MN1 (VSS Y_35 I4_z0_17 VSS) gpdk090_nmos1v w=0.12u l=0.1u ad=0.0696p as=0.0408p pd=1.16u ps=0.68u
    I_MXI4_I16_MN0 (I4_z0_16 Y_32 VSS VSS) gpdk090_nmos1v w=0.12u l=0.1u ad=0.0408p as=0.0696p pd=0.68u ps=1.16u
    I_MXI4_I16_MN1 (VSS Y_33 I4_z0_16 VSS) gpdk090_nmos1v w=0.12u l=0.1u ad=0.0696p as=0.0408p pd=1.16u ps=0.68u
    I_MXI0_I17_MN0 (SEL_DIV I0_h10 VSS VSS) gpdk090_nmos1v w=0.12u l=0.1u ad=0.0408p as=0.0696p pd=0.68u ps=1.16u
    I_MXI0_I17_MN1 (VSS I0_l11 SEL_DIV VSS) gpdk090_nmos1v w=0.12u l=0.1u ad=0.0696p as=0.0408p pd=1.16u ps=0.68u
    I_MXI0_I13_MN0 (SEL_OR I0_h00 VSS VSS) gpdk090_nmos1v w=0.12u l=0.1u ad=0.0408p as=0.0696p pd=0.68u ps=1.16u
    I_MXI0_I13_MN1 (VSS I0_l11 SEL_OR VSS) gpdk090_nmos1v w=0.12u l=0.1u ad=0.0696p as=0.0408p pd=1.16u ps=0.68u
    I_MXI0_I14_MN0 (SEL_XOR I0_h01 VSS VSS) gpdk090_nmos1v w=0.12u l=0.1u ad=0.0408p as=0.0696p pd=0.68u ps=1.16u
    I_MXI0_I14_MN1 (VSS I0_l00 SEL_XOR VSS) gpdk090_nmos1v w=0.12u l=0.1u ad=0.0696p as=0.0408p pd=1.16u ps=0.68u
    I_MXI1_I42_I134_XP_MN0 (I1_I42_P9_2 I1_I42_P9_6n VSS VSS) gpdk090_nmos1v w=0.12u l=0.1u ad=0.0408p as=0.0696p pd=0.68u ps=1.16u
    I_MXI1_I42_I134_XP_MN1 (VSS I1_I42_P5_2n I1_I42_P9_2 VSS) gpdk090_nmos1v w=0.12u l=0.1u ad=0.0696p as=0.0408p pd=1.16u ps=0.68u
    I_MXI1_I42_I75_XP_MN0 (I1_I42_P9_8 I1_I42_pn9 VSS VSS) gpdk090_nmos1v w=0.12u l=0.1u ad=0.0408p as=0.0696p pd=0.68u ps=1.16u
    I_MXI1_I42_I75_XP_MN1 (VSS I1_I42_pn8 I1_I42_P9_8 VSS) gpdk090_nmos1v w=0.12u l=0.1u ad=0.0696p as=0.0408p pd=1.16u ps=0.68u
    I_MXI1_I42_I76_XP_MN0 (I1_I42_P10_9 I1_I42_pn10 VSS VSS) gpdk090_nmos1v w=0.12u l=0.1u ad=0.0408p as=0.0696p pd=0.68u ps=1.16u
    I_MXI1_I42_I76_XP_MN1 (VSS I1_I42_pn9 I1_I42_P10_9 VSS) gpdk090_nmos1v w=0.12u l=0.1u ad=0.0696p as=0.0408p pd=1.16u ps=0.68u
    I_MXI1_I42_I73_XP_MN0 (I1_I42_P7_6 I1_I42_pn7 VSS VSS) gpdk090_nmos1v w=0.12u l=0.1u ad=0.0408p as=0.0696p pd=0.68u ps=1.16u
    I_MXI1_I42_I73_XP_MN1 (VSS I1_I42_pn6 I1_I42_P7_6 VSS) gpdk090_nmos1v w=0.12u l=0.1u ad=0.0696p as=0.0408p pd=1.16u ps=0.68u
    I_MXI1_I42_I74_XP_MN0 (I1_I42_P8_7 I1_I42_pn8 VSS VSS) gpdk090_nmos1v w=0.12u l=0.1u ad=0.0408p as=0.0696p pd=0.68u ps=1.16u
    I_MXI1_I42_I74_XP_MN1 (VSS I1_I42_pn7 I1_I42_P8_7 VSS) gpdk090_nmos1v w=0.12u l=0.1u ad=0.0696p as=0.0408p pd=1.16u ps=0.68u
    I_MXI1_I42_I72_XP_MN0 (I1_I42_P6_5 I1_I42_pn6 VSS VSS) gpdk090_nmos1v w=0.12u l=0.1u ad=0.0408p as=0.0696p pd=0.68u ps=1.16u
    I_MXI1_I42_I72_XP_MN1 (VSS I1_I42_pn5 I1_I42_P6_5 VSS) gpdk090_nmos1v w=0.12u l=0.1u ad=0.0696p as=0.0408p pd=1.16u ps=0.68u
    I_MXI1_I42_I70_XP_MN0 (I1_I42_P4_3 I1_I42_pn4 VSS VSS) gpdk090_nmos1v w=0.12u l=0.1u ad=0.0408p as=0.0696p pd=0.68u ps=1.16u
    I_MXI1_I42_I70_XP_MN1 (VSS I1_I42_pn3 I1_I42_P4_3 VSS) gpdk090_nmos1v w=0.12u l=0.1u ad=0.0696p as=0.0408p pd=1.16u ps=0.68u
    I_MXI1_I42_I69_XP_MN0 (I1_I42_P3_2 I1_I42_pn3 VSS VSS) gpdk090_nmos1v w=0.12u l=0.1u ad=0.0408p as=0.0696p pd=0.68u ps=1.16u
    I_MXI1_I42_I69_XP_MN1 (VSS I1_I42_pn2 I1_I42_P3_2 VSS) gpdk090_nmos1v w=0.12u l=0.1u ad=0.0696p as=0.0408p pd=1.16u ps=0.68u
    I_MXI1_I42_I68_XP_MN0 (I1_I42_P2_1 I1_I42_pn2 VSS VSS) gpdk090_nmos1v w=0.12u l=0.1u ad=0.0408p as=0.0696p pd=0.68u ps=1.16u
    I_MXI1_I42_I68_XP_MN1 (VSS I1_I42_pn1 I1_I42_P2_1 VSS) gpdk090_nmos1v w=0.12u l=0.1u ad=0.0696p as=0.0408p pd=1.16u ps=0.68u
    I_MXI2_I20_MN0 (I2_nor3 A_3 VSS VSS) gpdk090_nmos1v w=0.12u l=0.1u ad=0.0408p as=0.0696p pd=0.68u ps=1.16u
    I_MXI2_I20_MN1 (VSS B_3 I2_nor3 VSS) gpdk090_nmos1v w=0.12u l=0.1u ad=0.0696p as=0.0408p pd=1.16u ps=0.68u
    I_MXI0_I11_MN0 (SEL_AS I0_h00 VSS VSS) gpdk090_nmos1v w=0.12u l=0.1u ad=0.0408p as=0.0696p pd=0.68u ps=1.16u
    I_MXI0_I11_MN1 (VSS OP_1 SEL_AS VSS) gpdk090_nmos1v w=0.12u l=0.1u ad=0.0696p as=0.0408p pd=1.16u ps=0.68u
    I_MXI0_I12_MN0 (SEL_AND I0_h00 VSS VSS) gpdk090_nmos1v w=0.12u l=0.1u ad=0.0408p as=0.0696p pd=0.68u ps=1.16u
    I_MXI0_I12_MN1 (VSS I0_l10 SEL_AND VSS) gpdk090_nmos1v w=0.12u l=0.1u ad=0.0696p as=0.0408p pd=1.16u ps=0.68u
    I_MXI1_I42_I77_XP_MN0 (I1_I42_P11_10 I1_I42_pn11 VSS VSS) gpdk090_nmos1v w=0.12u l=0.1u ad=0.0408p as=0.0696p pd=0.68u ps=1.16u
    I_MXI1_I42_I77_XP_MN1 (VSS I1_I42_pn10 I1_I42_P11_10 VSS) gpdk090_nmos1v w=0.12u l=0.1u ad=0.0696p as=0.0408p pd=1.16u ps=0.68u
    I_MXI1_I42_I136_XP_MN0 (I1_I42_P11_4 I1_I42_P11_8n VSS VSS) gpdk090_nmos1v w=0.12u l=0.1u ad=0.0408p as=0.0696p pd=0.68u ps=1.16u
    I_MXI1_I42_I136_XP_MN1 (VSS I1_I42_P7_4n I1_I42_P11_4 VSS) gpdk090_nmos1v w=0.12u l=0.1u ad=0.0696p as=0.0408p pd=1.16u ps=0.68u
    I_MXI1_I42_I133_XP_MN0 (I1_I42_P8_1 I1_I42_P8_5n VSS VSS) gpdk090_nmos1v w=0.12u l=0.1u ad=0.0408p as=0.0696p pd=0.68u ps=1.16u
    I_MXI1_I42_I133_XP_MN1 (VSS I1_I42_P4_1n I1_I42_P8_1 VSS) gpdk090_nmos1v w=0.12u l=0.1u ad=0.0696p as=0.0408p pd=1.16u ps=0.68u
    I_MXI3_I223_MN0 (I3_q11_1 I3_o11_0 VSS VSS) gpdk090_nmos1v w=0.12u l=0.1u ad=0.0408p as=0.0696p pd=0.68u ps=1.16u
    I_MXI3_I223_MN1 (VSS I3_o11_1 I3_q11_1 VSS) gpdk090_nmos1v w=0.12u l=0.1u ad=0.0696p as=0.0408p pd=1.16u ps=0.68u
    I_MXI2_I68_MN0 (I2_nor11 A_11 VSS VSS) gpdk090_nmos1v w=0.12u l=0.1u ad=0.0408p as=0.0696p pd=0.68u ps=1.16u
    I_MXI2_I68_MN1 (VSS B_11 I2_nor11 VSS) gpdk090_nmos1v w=0.12u l=0.1u ad=0.0696p as=0.0408p pd=1.16u ps=0.68u
    I_MXI2_I182_MN0 (I2_nor30 A_30 VSS VSS) gpdk090_nmos1v w=0.12u l=0.1u ad=0.0408p as=0.0696p pd=0.68u ps=1.16u
    I_MXI2_I182_MN1 (VSS B_30 I2_nor30 VSS) gpdk090_nmos1v w=0.12u l=0.1u ad=0.0696p as=0.0408p pd=1.16u ps=0.68u
    I_MXI3_I451_MN0 (I3_q30_1 I3_o30_0 VSS VSS) gpdk090_nmos1v w=0.12u l=0.1u ad=0.0408p as=0.0696p pd=0.68u ps=1.16u
    I_MXI3_I451_MN1 (VSS I3_o30_1 I3_q30_1 VSS) gpdk090_nmos1v w=0.12u l=0.1u ad=0.0696p as=0.0408p pd=1.16u ps=0.68u
    I_MXI3_I463_MN0 (I3_q31_1 I3_o31_0 VSS VSS) gpdk090_nmos1v w=0.12u l=0.1u ad=0.0408p as=0.0696p pd=0.68u ps=1.16u
    I_MXI3_I463_MN1 (VSS I3_o31_1 I3_q31_1 VSS) gpdk090_nmos1v w=0.12u l=0.1u ad=0.0696p as=0.0408p pd=1.16u ps=0.68u
    I_MXI1_I42_I142_XP_MN0 (I1_I42_P17_10 I1_I42_P17_14n VSS VSS) gpdk090_nmos1v w=0.12u l=0.1u ad=0.0408p as=0.0696p pd=0.68u ps=1.16u
    I_MXI1_I42_I142_XP_MN1 (VSS I1_I42_P13_10n I1_I42_P17_10 VSS) gpdk090_nmos1v w=0.12u l=0.1u ad=0.0696p as=0.0408p pd=1.16u ps=0.68u
    I_MXI1_I42_I138_XP_MN0 (I1_I42_P13_6 I1_I42_P13_10n VSS VSS) gpdk090_nmos1v w=0.12u l=0.1u ad=0.0408p as=0.0696p pd=0.68u ps=1.16u
    I_MXI1_I42_I138_XP_MN1 (VSS I1_I42_P9_6n I1_I42_P13_6 VSS) gpdk090_nmos1v w=0.12u l=0.1u ad=0.0696p as=0.0408p pd=1.16u ps=0.68u
    I_MXI1_I42_I135_XP_MN0 (I1_I42_P10_3 I1_I42_P10_7n VSS VSS) gpdk090_nmos1v w=0.12u l=0.1u ad=0.0408p as=0.0696p pd=0.68u ps=1.16u
    I_MXI1_I42_I135_XP_MN1 (VSS I1_I42_P6_3n I1_I42_P10_3 VSS) gpdk090_nmos1v w=0.12u l=0.1u ad=0.0696p as=0.0408p pd=1.16u ps=0.68u
    I_MXI1_I42_I78_XP_MN0 (I1_I42_P12_11 I1_I42_pn12 VSS VSS) gpdk090_nmos1v w=0.12u l=0.1u ad=0.0408p as=0.0696p pd=0.68u ps=1.16u
    I_MXI1_I42_I78_XP_MN1 (VSS I1_I42_pn11 I1_I42_P12_11 VSS) gpdk090_nmos1v w=0.12u l=0.1u ad=0.0696p as=0.0408p pd=1.16u ps=0.68u
    I_MXI2_I74_MN0 (I2_nor12 A_12 VSS VSS) gpdk090_nmos1v w=0.12u l=0.1u ad=0.0408p as=0.0696p pd=0.68u ps=1.16u
    I_MXI2_I74_MN1 (VSS B_12 I2_nor12 VSS) gpdk090_nmos1v w=0.12u l=0.1u ad=0.0696p as=0.0408p pd=1.16u ps=0.68u
    I_MXI4_I15_MN0 (I4_z0_15 Y_30 VSS VSS) gpdk090_nmos1v w=0.12u l=0.1u ad=0.0408p as=0.0696p pd=0.68u ps=1.16u
    I_MXI4_I15_MN1 (VSS Y_31 I4_z0_15 VSS) gpdk090_nmos1v w=0.12u l=0.1u ad=0.0696p as=0.0408p pd=1.16u ps=0.68u
    I_MXI2_I188_MN0 (I2_nor31 A_31 VSS VSS) gpdk090_nmos1v w=0.12u l=0.1u ad=0.0408p as=0.0696p pd=0.68u ps=1.16u
    I_MXI2_I188_MN1 (VSS B_31 I2_nor31 VSS) gpdk090_nmos1v w=0.12u l=0.1u ad=0.0696p as=0.0408p pd=1.16u ps=0.68u
    I_MXI1_I42_I97_XP_MN0 (I1_I42_P31_30 I1_I42_pn31 VSS VSS) gpdk090_nmos1v w=0.12u l=0.1u ad=0.0408p as=0.0696p pd=0.68u ps=1.16u
    I_MXI1_I42_I97_XP_MN1 (VSS I1_I42_pn30 I1_I42_P31_30 VSS) gpdk090_nmos1v w=0.12u l=0.1u ad=0.0696p as=0.0408p pd=1.16u ps=0.68u
    I_MXI1_I42_I154_XP_MN0 (I1_I42_P29_22 I1_I42_P29_26n VSS VSS) gpdk090_nmos1v w=0.12u l=0.1u ad=0.0408p as=0.0696p pd=0.68u ps=1.16u
    I_MXI1_I42_I154_XP_MN1 (VSS I1_I42_P25_22n I1_I42_P29_22 VSS) gpdk090_nmos1v w=0.12u l=0.1u ad=0.0696p as=0.0408p pd=1.16u ps=0.68u
    I_MXI1_I42_I150_XP_MN0 (I1_I42_P25_18 I1_I42_P25_22n VSS VSS) gpdk090_nmos1v w=0.12u l=0.1u ad=0.0408p as=0.0696p pd=0.68u ps=1.16u
    I_MXI1_I42_I150_XP_MN1 (VSS I1_I42_P21_18n I1_I42_P25_18 VSS) gpdk090_nmos1v w=0.12u l=0.1u ad=0.0696p as=0.0408p pd=1.16u ps=0.68u
    I_MXI1_I42_I146_XP_MN0 (I1_I42_P21_14 I1_I42_P21_18n VSS VSS) gpdk090_nmos1v w=0.12u l=0.1u ad=0.0408p as=0.0696p pd=0.68u ps=1.16u
    I_MXI1_I42_I146_XP_MN1 (VSS I1_I42_P17_14n I1_I42_P21_14 VSS) gpdk090_nmos1v w=0.12u l=0.1u ad=0.0696p as=0.0408p pd=1.16u ps=0.68u
    I_MXI1_I42_I140_XP_MN0 (I1_I42_P15_8 I1_I42_P15_12n VSS VSS) gpdk090_nmos1v w=0.12u l=0.1u ad=0.0408p as=0.0696p pd=0.68u ps=1.16u
    I_MXI1_I42_I140_XP_MN1 (VSS I1_I42_P11_8n I1_I42_P15_8 VSS) gpdk090_nmos1v w=0.12u l=0.1u ad=0.0696p as=0.0408p pd=1.16u ps=0.68u
    I_MXI1_I42_I137_XP_MN0 (I1_I42_P12_5 I1_I42_P12_9n VSS VSS) gpdk090_nmos1v w=0.12u l=0.1u ad=0.0408p as=0.0696p pd=0.68u ps=1.16u
    I_MXI1_I42_I137_XP_MN1 (VSS I1_I42_P8_5n I1_I42_P12_5 VSS) gpdk090_nmos1v w=0.12u l=0.1u ad=0.0696p as=0.0408p pd=1.16u ps=0.68u
    I_MXI1_I42_I141_XP_MN0 (I1_I42_P16_9 I1_I42_P16_13n VSS VSS) gpdk090_nmos1v w=0.12u l=0.1u ad=0.0408p as=0.0696p pd=0.68u ps=1.16u
    I_MXI1_I42_I141_XP_MN1 (VSS I1_I42_P12_9n I1_I42_P16_9 VSS) gpdk090_nmos1v w=0.12u l=0.1u ad=0.0696p as=0.0408p pd=1.16u ps=0.68u
    I_MXI1_I42_I79_XP_MN0 (I1_I42_P13_12 I1_I42_pn13 VSS VSS) gpdk090_nmos1v w=0.12u l=0.1u ad=0.0408p as=0.0696p pd=0.68u ps=1.16u
    I_MXI1_I42_I79_XP_MN1 (VSS I1_I42_pn12 I1_I42_P13_12 VSS) gpdk090_nmos1v w=0.12u l=0.1u ad=0.0696p as=0.0408p pd=1.16u ps=0.68u
    I_MXI2_I80_MN0 (I2_nor13 A_13 VSS VSS) gpdk090_nmos1v w=0.12u l=0.1u ad=0.0408p as=0.0696p pd=0.68u ps=1.16u
    I_MXI2_I80_MN1 (VSS B_13 I2_nor13 VSS) gpdk090_nmos1v w=0.12u l=0.1u ad=0.0696p as=0.0408p pd=1.16u ps=0.68u
    I_MXI3_I235_MN0 (I3_q12_1 I3_o12_0 VSS VSS) gpdk090_nmos1v w=0.12u l=0.1u ad=0.0408p as=0.0696p pd=0.68u ps=1.16u
    I_MXI3_I235_MN1 (VSS I3_o12_1 I3_q12_1 VSS) gpdk090_nmos1v w=0.12u l=0.1u ad=0.0696p as=0.0408p pd=1.16u ps=0.68u
    I_MXI4_I6_MN0 (I4_z0_6 Y_12 VSS VSS) gpdk090_nmos1v w=0.12u l=0.1u ad=0.0408p as=0.0696p pd=0.68u ps=1.16u
    I_MXI4_I6_MN1 (VSS Y_13 I4_z0_6 VSS) gpdk090_nmos1v w=0.12u l=0.1u ad=0.0696p as=0.0408p pd=1.16u ps=0.68u
    I_MXI4_I14_MN0 (I4_z0_14 Y_28 VSS VSS) gpdk090_nmos1v w=0.12u l=0.1u ad=0.0408p as=0.0696p pd=0.68u ps=1.16u
    I_MXI4_I14_MN1 (VSS Y_29 I4_z0_14 VSS) gpdk090_nmos1v w=0.12u l=0.1u ad=0.0696p as=0.0408p pd=1.16u ps=0.68u
    I_MXI3_I439_MN0 (I3_q29_1 I3_o29_0 VSS VSS) gpdk090_nmos1v w=0.12u l=0.1u ad=0.0408p as=0.0696p pd=0.68u ps=1.16u
    I_MXI3_I439_MN1 (VSS I3_o29_1 I3_q29_1 VSS) gpdk090_nmos1v w=0.12u l=0.1u ad=0.0696p as=0.0408p pd=1.16u ps=0.68u
    I_MXI2_I176_MN0 (I2_nor29 A_29 VSS VSS) gpdk090_nmos1v w=0.12u l=0.1u ad=0.0408p as=0.0696p pd=0.68u ps=1.16u
    I_MXI2_I176_MN1 (VSS B_29 I2_nor29 VSS) gpdk090_nmos1v w=0.12u l=0.1u ad=0.0696p as=0.0408p pd=1.16u ps=0.68u
    I_MXI1_I42_I156_XP_MN0 (I1_I42_P31_24 I1_I42_P31_28n VSS VSS) gpdk090_nmos1v w=0.12u l=0.1u ad=0.0408p as=0.0696p pd=0.68u ps=1.16u
    I_MXI1_I42_I156_XP_MN1 (VSS I1_I42_P27_24n I1_I42_P31_24 VSS) gpdk090_nmos1v w=0.12u l=0.1u ad=0.0696p as=0.0408p pd=1.16u ps=0.68u
    I_MXI1_I42_I144_XP_MN0 (I1_I42_P19_12 I1_I42_P19_16n VSS VSS) gpdk090_nmos1v w=0.12u l=0.1u ad=0.0408p as=0.0696p pd=0.68u ps=1.16u
    I_MXI1_I42_I144_XP_MN1 (VSS I1_I42_P15_12n I1_I42_P19_12 VSS) gpdk090_nmos1v w=0.12u l=0.1u ad=0.0696p as=0.0408p pd=1.16u ps=0.68u
    I_MXI1_I42_I81_XP_MN0 (I1_I42_P15_14 I1_I42_pn15 VSS VSS) gpdk090_nmos1v w=0.12u l=0.1u ad=0.0408p as=0.0696p pd=0.68u ps=1.16u
    I_MXI1_I42_I81_XP_MN1 (VSS I1_I42_pn14 I1_I42_P15_14 VSS) gpdk090_nmos1v w=0.12u l=0.1u ad=0.0696p as=0.0408p pd=1.16u ps=0.68u
    I_MXI3_I247_MN0 (I3_q13_1 I3_o13_0 VSS VSS) gpdk090_nmos1v w=0.12u l=0.1u ad=0.0408p as=0.0696p pd=0.68u ps=1.16u
    I_MXI3_I247_MN1 (VSS I3_o13_1 I3_q13_1 VSS) gpdk090_nmos1v w=0.12u l=0.1u ad=0.0696p as=0.0408p pd=1.16u ps=0.68u
    I_MXI3_I427_MN0 (I3_q28_1 I3_o28_0 VSS VSS) gpdk090_nmos1v w=0.12u l=0.1u ad=0.0408p as=0.0696p pd=0.68u ps=1.16u
    I_MXI3_I427_MN1 (VSS I3_o28_1 I3_q28_1 VSS) gpdk090_nmos1v w=0.12u l=0.1u ad=0.0696p as=0.0408p pd=1.16u ps=0.68u
    I_MXI1_I42_I96_XP_MN0 (I1_I42_P30_29 I1_I42_pn30 VSS VSS) gpdk090_nmos1v w=0.12u l=0.1u ad=0.0408p as=0.0696p pd=0.68u ps=1.16u
    I_MXI1_I42_I96_XP_MN1 (VSS I1_I42_pn29 I1_I42_P30_29 VSS) gpdk090_nmos1v w=0.12u l=0.1u ad=0.0696p as=0.0408p pd=1.16u ps=0.68u
    I_MXI1_I42_I95_XP_MN0 (I1_I42_P29_28 I1_I42_pn29 VSS VSS) gpdk090_nmos1v w=0.12u l=0.1u ad=0.0408p as=0.0696p pd=0.68u ps=1.16u
    I_MXI1_I42_I95_XP_MN1 (VSS I1_I42_pn28 I1_I42_P29_28 VSS) gpdk090_nmos1v w=0.12u l=0.1u ad=0.0696p as=0.0408p pd=1.16u ps=0.68u
    I_MXI1_I42_I152_XP_MN0 (I1_I42_P27_20 I1_I42_P27_24n VSS VSS) gpdk090_nmos1v w=0.12u l=0.1u ad=0.0408p as=0.0696p pd=0.68u ps=1.16u
    I_MXI1_I42_I152_XP_MN1 (VSS I1_I42_P23_20n I1_I42_P27_20 VSS) gpdk090_nmos1v w=0.12u l=0.1u ad=0.0696p as=0.0408p pd=1.16u ps=0.68u
    I_MXI1_I42_I148_XP_MN0 (I1_I42_P23_16 I1_I42_P23_20n VSS VSS) gpdk090_nmos1v w=0.12u l=0.1u ad=0.0408p as=0.0696p pd=0.68u ps=1.16u
    I_MXI1_I42_I148_XP_MN1 (VSS I1_I42_P19_16n I1_I42_P23_16 VSS) gpdk090_nmos1v w=0.12u l=0.1u ad=0.0696p as=0.0408p pd=1.16u ps=0.68u
    I_MXI1_I42_I139_XP_MN0 (I1_I42_P14_7 I1_I42_P14_11n VSS VSS) gpdk090_nmos1v w=0.12u l=0.1u ad=0.0408p as=0.0696p pd=0.68u ps=1.16u
    I_MXI1_I42_I139_XP_MN1 (VSS I1_I42_P10_7n I1_I42_P14_7 VSS) gpdk090_nmos1v w=0.12u l=0.1u ad=0.0696p as=0.0408p pd=1.16u ps=0.68u
    I_MXI1_I42_I145_XP_MN0 (I1_I42_P20_13 I1_I42_P20_17n VSS VSS) gpdk090_nmos1v w=0.12u l=0.1u ad=0.0408p as=0.0696p pd=0.68u ps=1.16u
    I_MXI1_I42_I145_XP_MN1 (VSS I1_I42_P16_13n I1_I42_P20_13 VSS) gpdk090_nmos1v w=0.12u l=0.1u ad=0.0696p as=0.0408p pd=1.16u ps=0.68u
    I_MXI1_I42_I80_XP_MN0 (I1_I42_P14_13 I1_I42_pn14 VSS VSS) gpdk090_nmos1v w=0.12u l=0.1u ad=0.0408p as=0.0696p pd=0.68u ps=1.16u
    I_MXI1_I42_I80_XP_MN1 (VSS I1_I42_pn13 I1_I42_P14_13 VSS) gpdk090_nmos1v w=0.12u l=0.1u ad=0.0696p as=0.0408p pd=1.16u ps=0.68u
    I_MXI3_I259_MN0 (I3_q14_1 I3_o14_0 VSS VSS) gpdk090_nmos1v w=0.12u l=0.1u ad=0.0408p as=0.0696p pd=0.68u ps=1.16u
    I_MXI3_I259_MN1 (VSS I3_o14_1 I3_q14_1 VSS) gpdk090_nmos1v w=0.12u l=0.1u ad=0.0696p as=0.0408p pd=1.16u ps=0.68u
    I_MXI4_I7_MN0 (I4_z0_7 Y_14 VSS VSS) gpdk090_nmos1v w=0.12u l=0.1u ad=0.0408p as=0.0696p pd=0.68u ps=1.16u
    I_MXI4_I7_MN1 (VSS Y_15 I4_z0_7 VSS) gpdk090_nmos1v w=0.12u l=0.1u ad=0.0696p as=0.0408p pd=1.16u ps=0.68u
    I_MXI2_I170_MN0 (I2_nor28 A_28 VSS VSS) gpdk090_nmos1v w=0.12u l=0.1u ad=0.0408p as=0.0696p pd=0.68u ps=1.16u
    I_MXI2_I170_MN1 (VSS B_28 I2_nor28 VSS) gpdk090_nmos1v w=0.12u l=0.1u ad=0.0696p as=0.0408p pd=1.16u ps=0.68u
    I_MXI4_I51_MN0 (I4_z2_3 I4_z1_6 VSS VSS) gpdk090_nmos1v w=0.12u l=0.1u ad=0.0408p as=0.0696p pd=0.68u ps=1.16u
    I_MXI4_I51_MN1 (VSS I4_z1_7 I4_z2_3 VSS) gpdk090_nmos1v w=0.12u l=0.1u ad=0.0696p as=0.0408p pd=1.16u ps=0.68u
    I_MXI3_I415_MN0 (I3_q27_1 I3_o27_0 VSS VSS) gpdk090_nmos1v w=0.12u l=0.1u ad=0.0408p as=0.0696p pd=0.68u ps=1.16u
    I_MXI3_I415_MN1 (VSS I3_o27_1 I3_q27_1 VSS) gpdk090_nmos1v w=0.12u l=0.1u ad=0.0696p as=0.0408p pd=1.16u ps=0.68u
    I_MXI1_I42_I94_XP_MN0 (I1_I42_P28_27 I1_I42_pn28 VSS VSS) gpdk090_nmos1v w=0.12u l=0.1u ad=0.0408p as=0.0696p pd=0.68u ps=1.16u
    I_MXI1_I42_I94_XP_MN1 (VSS I1_I42_pn27 I1_I42_P28_27 VSS) gpdk090_nmos1v w=0.12u l=0.1u ad=0.0696p as=0.0408p pd=1.16u ps=0.68u
    I_MXI1_I42_I155_XP_MN0 (I1_I42_P30_23 I1_I42_P30_27n VSS VSS) gpdk090_nmos1v w=0.12u l=0.1u ad=0.0408p as=0.0696p pd=0.68u ps=1.16u
    I_MXI1_I42_I155_XP_MN1 (VSS I1_I42_P26_23n I1_I42_P30_23 VSS) gpdk090_nmos1v w=0.12u l=0.1u ad=0.0696p as=0.0408p pd=1.16u ps=0.68u
    I_MXI1_I42_I153_XP_MN0 (I1_I42_P28_21 I1_I42_P28_25n VSS VSS) gpdk090_nmos1v w=0.12u l=0.1u ad=0.0408p as=0.0696p pd=0.68u ps=1.16u
    I_MXI1_I42_I153_XP_MN1 (VSS I1_I42_P24_21n I1_I42_P28_21 VSS) gpdk090_nmos1v w=0.12u l=0.1u ad=0.0696p as=0.0408p pd=1.16u ps=0.68u
    I_MXI1_I42_I151_XP_MN0 (I1_I42_P26_19 I1_I42_P26_23n VSS VSS) gpdk090_nmos1v w=0.12u l=0.1u ad=0.0408p as=0.0696p pd=0.68u ps=1.16u
    I_MXI1_I42_I151_XP_MN1 (VSS I1_I42_P22_19n I1_I42_P26_19 VSS) gpdk090_nmos1v w=0.12u l=0.1u ad=0.0696p as=0.0408p pd=1.16u ps=0.68u
    I_MXI1_I42_I147_XP_MN0 (I1_I42_P22_15 I1_I42_P22_19n VSS VSS) gpdk090_nmos1v w=0.12u l=0.1u ad=0.0408p as=0.0696p pd=0.68u ps=1.16u
    I_MXI1_I42_I147_XP_MN1 (VSS I1_I42_P18_15n I1_I42_P22_15 VSS) gpdk090_nmos1v w=0.12u l=0.1u ad=0.0696p as=0.0408p pd=1.16u ps=0.68u
    I_MXI1_I42_I143_XP_MN0 (I1_I42_P18_11 I1_I42_P18_15n VSS VSS) gpdk090_nmos1v w=0.12u l=0.1u ad=0.0408p as=0.0696p pd=0.68u ps=1.16u
    I_MXI1_I42_I143_XP_MN1 (VSS I1_I42_P14_11n I1_I42_P18_11 VSS) gpdk090_nmos1v w=0.12u l=0.1u ad=0.0696p as=0.0408p pd=1.16u ps=0.68u
    I_MXI1_I42_I149_XP_MN0 (I1_I42_P24_17 I1_I42_P24_21n VSS VSS) gpdk090_nmos1v w=0.12u l=0.1u ad=0.0408p as=0.0696p pd=0.68u ps=1.16u
    I_MXI1_I42_I149_XP_MN1 (VSS I1_I42_P20_17n I1_I42_P24_17 VSS) gpdk090_nmos1v w=0.12u l=0.1u ad=0.0696p as=0.0408p pd=1.16u ps=0.68u
    I_MXI1_I42_I83_XP_MN0 (I1_I42_P17_16 I1_I42_pn17 VSS VSS) gpdk090_nmos1v w=0.12u l=0.1u ad=0.0408p as=0.0696p pd=0.68u ps=1.16u
    I_MXI1_I42_I83_XP_MN1 (VSS I1_I42_pn16 I1_I42_P17_16 VSS) gpdk090_nmos1v w=0.12u l=0.1u ad=0.0696p as=0.0408p pd=1.16u ps=0.68u
    I_MXI1_I42_I82_XP_MN0 (I1_I42_P16_15 I1_I42_pn16 VSS VSS) gpdk090_nmos1v w=0.12u l=0.1u ad=0.0408p as=0.0696p pd=0.68u ps=1.16u
    I_MXI1_I42_I82_XP_MN1 (VSS I1_I42_pn15 I1_I42_P16_15 VSS) gpdk090_nmos1v w=0.12u l=0.1u ad=0.0696p as=0.0408p pd=1.16u ps=0.68u
    I_MXI2_I86_MN0 (I2_nor14 A_14 VSS VSS) gpdk090_nmos1v w=0.12u l=0.1u ad=0.0408p as=0.0696p pd=0.68u ps=1.16u
    I_MXI2_I86_MN1 (VSS B_14 I2_nor14 VSS) gpdk090_nmos1v w=0.12u l=0.1u ad=0.0696p as=0.0408p pd=1.16u ps=0.68u
    I_MXI3_I271_MN0 (I3_q15_1 I3_o15_0 VSS VSS) gpdk090_nmos1v w=0.12u l=0.1u ad=0.0408p as=0.0696p pd=0.68u ps=1.16u
    I_MXI3_I271_MN1 (VSS I3_o15_1 I3_q15_1 VSS) gpdk090_nmos1v w=0.12u l=0.1u ad=0.0696p as=0.0408p pd=1.16u ps=0.68u
    I_MXI2_I164_MN0 (I2_nor27 A_27 VSS VSS) gpdk090_nmos1v w=0.12u l=0.1u ad=0.0408p as=0.0696p pd=0.68u ps=1.16u
    I_MXI2_I164_MN1 (VSS B_27 I2_nor27 VSS) gpdk090_nmos1v w=0.12u l=0.1u ad=0.0696p as=0.0408p pd=1.16u ps=0.68u
    I_MXI1_I42_I93_XP_MN0 (I1_I42_P27_26 I1_I42_pn27 VSS VSS) gpdk090_nmos1v w=0.12u l=0.1u ad=0.0408p as=0.0696p pd=0.68u ps=1.16u
    I_MXI1_I42_I93_XP_MN1 (VSS I1_I42_pn26 I1_I42_P27_26 VSS) gpdk090_nmos1v w=0.12u l=0.1u ad=0.0696p as=0.0408p pd=1.16u ps=0.68u
    I_MXI1_I42_I92_XP_MN0 (I1_I42_P26_25 I1_I42_pn26 VSS VSS) gpdk090_nmos1v w=0.12u l=0.1u ad=0.0408p as=0.0696p pd=0.68u ps=1.16u
    I_MXI1_I42_I92_XP_MN1 (VSS I1_I42_pn25 I1_I42_P26_25 VSS) gpdk090_nmos1v w=0.12u l=0.1u ad=0.0696p as=0.0408p pd=1.16u ps=0.68u
    I_MXI1_I42_I91_XP_MN0 (I1_I42_P25_24 I1_I42_pn25 VSS VSS) gpdk090_nmos1v w=0.12u l=0.1u ad=0.0408p as=0.0696p pd=0.68u ps=1.16u
    I_MXI1_I42_I91_XP_MN1 (VSS I1_I42_pn24 I1_I42_P25_24 VSS) gpdk090_nmos1v w=0.12u l=0.1u ad=0.0696p as=0.0408p pd=1.16u ps=0.68u
    I_MXI1_I42_I90_XP_MN0 (I1_I42_P24_23 I1_I42_pn24 VSS VSS) gpdk090_nmos1v w=0.12u l=0.1u ad=0.0408p as=0.0696p pd=0.68u ps=1.16u
    I_MXI1_I42_I90_XP_MN1 (VSS I1_I42_pn23 I1_I42_P24_23 VSS) gpdk090_nmos1v w=0.12u l=0.1u ad=0.0696p as=0.0408p pd=1.16u ps=0.68u
    I_MXI1_I42_I89_XP_MN0 (I1_I42_P23_22 I1_I42_pn23 VSS VSS) gpdk090_nmos1v w=0.12u l=0.1u ad=0.0408p as=0.0696p pd=0.68u ps=1.16u
    I_MXI1_I42_I89_XP_MN1 (VSS I1_I42_pn22 I1_I42_P23_22 VSS) gpdk090_nmos1v w=0.12u l=0.1u ad=0.0696p as=0.0408p pd=1.16u ps=0.68u
    I_MXI1_I42_I88_XP_MN0 (I1_I42_P22_21 I1_I42_pn22 VSS VSS) gpdk090_nmos1v w=0.12u l=0.1u ad=0.0408p as=0.0696p pd=0.68u ps=1.16u
    I_MXI1_I42_I88_XP_MN1 (VSS I1_I42_pn21 I1_I42_P22_21 VSS) gpdk090_nmos1v w=0.12u l=0.1u ad=0.0696p as=0.0408p pd=1.16u ps=0.68u
    I_MXI1_I42_I87_XP_MN0 (I1_I42_P21_20 I1_I42_pn21 VSS VSS) gpdk090_nmos1v w=0.12u l=0.1u ad=0.0408p as=0.0696p pd=0.68u ps=1.16u
    I_MXI1_I42_I87_XP_MN1 (VSS I1_I42_pn20 I1_I42_P21_20 VSS) gpdk090_nmos1v w=0.12u l=0.1u ad=0.0696p as=0.0408p pd=1.16u ps=0.68u
    I_MXI1_I42_I86_XP_MN0 (I1_I42_P20_19 I1_I42_pn20 VSS VSS) gpdk090_nmos1v w=0.12u l=0.1u ad=0.0408p as=0.0696p pd=0.68u ps=1.16u
    I_MXI1_I42_I86_XP_MN1 (VSS I1_I42_pn19 I1_I42_P20_19 VSS) gpdk090_nmos1v w=0.12u l=0.1u ad=0.0696p as=0.0408p pd=1.16u ps=0.68u
    I_MXI1_I42_I85_XP_MN0 (I1_I42_P19_18 I1_I42_pn19 VSS VSS) gpdk090_nmos1v w=0.12u l=0.1u ad=0.0408p as=0.0696p pd=0.68u ps=1.16u
    I_MXI1_I42_I85_XP_MN1 (VSS I1_I42_pn18 I1_I42_P19_18 VSS) gpdk090_nmos1v w=0.12u l=0.1u ad=0.0696p as=0.0408p pd=1.16u ps=0.68u
    I_MXI1_I42_I84_XP_MN0 (I1_I42_P18_17 I1_I42_pn18 VSS VSS) gpdk090_nmos1v w=0.12u l=0.1u ad=0.0408p as=0.0696p pd=0.68u ps=1.16u
    I_MXI1_I42_I84_XP_MN1 (VSS I1_I42_pn17 I1_I42_P18_17 VSS) gpdk090_nmos1v w=0.12u l=0.1u ad=0.0696p as=0.0408p pd=1.16u ps=0.68u
    I_MXI2_I92_MN0 (I2_nor15 A_15 VSS VSS) gpdk090_nmos1v w=0.12u l=0.1u ad=0.0408p as=0.0696p pd=0.68u ps=1.16u
    I_MXI2_I92_MN1 (VSS B_15 I2_nor15 VSS) gpdk090_nmos1v w=0.12u l=0.1u ad=0.0696p as=0.0408p pd=1.16u ps=0.68u
    I_MXI4_I13_MN0 (I4_z0_13 Y_26 VSS VSS) gpdk090_nmos1v w=0.12u l=0.1u ad=0.0408p as=0.0696p pd=0.68u ps=1.16u
    I_MXI4_I13_MN1 (VSS Y_27 I4_z0_13 VSS) gpdk090_nmos1v w=0.12u l=0.1u ad=0.0696p as=0.0408p pd=1.16u ps=0.68u
    I_MXI2_I158_MN0 (I2_nor26 A_26 VSS VSS) gpdk090_nmos1v w=0.12u l=0.1u ad=0.0408p as=0.0696p pd=0.68u ps=1.16u
    I_MXI2_I158_MN1 (VSS B_26 I2_nor26 VSS) gpdk090_nmos1v w=0.12u l=0.1u ad=0.0696p as=0.0408p pd=1.16u ps=0.68u
    I_MXI4_I12_MN0 (I4_z0_12 Y_24 VSS VSS) gpdk090_nmos1v w=0.12u l=0.1u ad=0.0408p as=0.0696p pd=0.68u ps=1.16u
    I_MXI4_I12_MN1 (VSS Y_25 I4_z0_12 VSS) gpdk090_nmos1v w=0.12u l=0.1u ad=0.0696p as=0.0408p pd=1.16u ps=0.68u
    I_MXI3_I403_MN0 (I3_q26_1 I3_o26_0 VSS VSS) gpdk090_nmos1v w=0.12u l=0.1u ad=0.0408p as=0.0696p pd=0.68u ps=1.16u
    I_MXI3_I403_MN1 (VSS I3_o26_1 I3_q26_1 VSS) gpdk090_nmos1v w=0.12u l=0.1u ad=0.0696p as=0.0408p pd=1.16u ps=0.68u
    I_MXI2_I128_MN0 (I2_nor21 A_21 VSS VSS) gpdk090_nmos1v w=0.12u l=0.1u ad=0.0408p as=0.0696p pd=0.68u ps=1.16u
    I_MXI2_I128_MN1 (VSS B_21 I2_nor21 VSS) gpdk090_nmos1v w=0.12u l=0.1u ad=0.0696p as=0.0408p pd=1.16u ps=0.68u
    I_MXI2_I98_MN0 (I2_nor16 A_16 VSS VSS) gpdk090_nmos1v w=0.12u l=0.1u ad=0.0408p as=0.0696p pd=0.68u ps=1.16u
    I_MXI2_I98_MN1 (VSS B_16 I2_nor16 VSS) gpdk090_nmos1v w=0.12u l=0.1u ad=0.0696p as=0.0408p pd=1.16u ps=0.68u
    I_MXI3_I391_MN0 (I3_q25_1 I3_o25_0 VSS VSS) gpdk090_nmos1v w=0.12u l=0.1u ad=0.0408p as=0.0696p pd=0.68u ps=1.16u
    I_MXI3_I391_MN1 (VSS I3_o25_1 I3_q25_1 VSS) gpdk090_nmos1v w=0.12u l=0.1u ad=0.0696p as=0.0408p pd=1.16u ps=0.68u
    I_MXI3_I379_MN0 (I3_q24_1 I3_o24_0 VSS VSS) gpdk090_nmos1v w=0.12u l=0.1u ad=0.0408p as=0.0696p pd=0.68u ps=1.16u
    I_MXI3_I379_MN1 (VSS I3_o24_1 I3_q24_1 VSS) gpdk090_nmos1v w=0.12u l=0.1u ad=0.0696p as=0.0408p pd=1.16u ps=0.68u
    I_MXI3_I367_MN0 (I3_q23_1 I3_o23_0 VSS VSS) gpdk090_nmos1v w=0.12u l=0.1u ad=0.0408p as=0.0696p pd=0.68u ps=1.16u
    I_MXI3_I367_MN1 (VSS I3_o23_1 I3_q23_1 VSS) gpdk090_nmos1v w=0.12u l=0.1u ad=0.0696p as=0.0408p pd=1.16u ps=0.68u
    I_MXI3_I319_MN0 (I3_q19_1 I3_o19_0 VSS VSS) gpdk090_nmos1v w=0.12u l=0.1u ad=0.0408p as=0.0696p pd=0.68u ps=1.16u
    I_MXI3_I319_MN1 (VSS I3_o19_1 I3_q19_1 VSS) gpdk090_nmos1v w=0.12u l=0.1u ad=0.0696p as=0.0408p pd=1.16u ps=0.68u
    I_MXI3_I307_MN0 (I3_q18_1 I3_o18_0 VSS VSS) gpdk090_nmos1v w=0.12u l=0.1u ad=0.0408p as=0.0696p pd=0.68u ps=1.16u
    I_MXI3_I307_MN1 (VSS I3_o18_1 I3_q18_1 VSS) gpdk090_nmos1v w=0.12u l=0.1u ad=0.0696p as=0.0408p pd=1.16u ps=0.68u
    I_MXI2_I110_MN0 (I2_nor18 A_18 VSS VSS) gpdk090_nmos1v w=0.12u l=0.1u ad=0.0408p as=0.0696p pd=0.68u ps=1.16u
    I_MXI2_I110_MN1 (VSS B_18 I2_nor18 VSS) gpdk090_nmos1v w=0.12u l=0.1u ad=0.0696p as=0.0408p pd=1.16u ps=0.68u
    I_MXI3_I283_MN0 (I3_q16_1 I3_o16_0 VSS VSS) gpdk090_nmos1v w=0.12u l=0.1u ad=0.0408p as=0.0696p pd=0.68u ps=1.16u
    I_MXI3_I283_MN1 (VSS I3_o16_1 I3_q16_1 VSS) gpdk090_nmos1v w=0.12u l=0.1u ad=0.0696p as=0.0408p pd=1.16u ps=0.68u
    I_MXI3_I295_MN0 (I3_q17_1 I3_o17_0 VSS VSS) gpdk090_nmos1v w=0.12u l=0.1u ad=0.0408p as=0.0696p pd=0.68u ps=1.16u
    I_MXI3_I295_MN1 (VSS I3_o17_1 I3_q17_1 VSS) gpdk090_nmos1v w=0.12u l=0.1u ad=0.0696p as=0.0408p pd=1.16u ps=0.68u
    I_MXI2_I152_MN0 (I2_nor25 A_25 VSS VSS) gpdk090_nmos1v w=0.12u l=0.1u ad=0.0408p as=0.0696p pd=0.68u ps=1.16u
    I_MXI2_I152_MN1 (VSS B_25 I2_nor25 VSS) gpdk090_nmos1v w=0.12u l=0.1u ad=0.0696p as=0.0408p pd=1.16u ps=0.68u
    I_MXI2_I146_MN0 (I2_nor24 A_24 VSS VSS) gpdk090_nmos1v w=0.12u l=0.1u ad=0.0408p as=0.0696p pd=0.68u ps=1.16u
    I_MXI2_I146_MN1 (VSS B_24 I2_nor24 VSS) gpdk090_nmos1v w=0.12u l=0.1u ad=0.0696p as=0.0408p pd=1.16u ps=0.68u
    I_MXI2_I140_MN0 (I2_nor23 A_23 VSS VSS) gpdk090_nmos1v w=0.12u l=0.1u ad=0.0408p as=0.0696p pd=0.68u ps=1.16u
    I_MXI2_I140_MN1 (VSS B_23 I2_nor23 VSS) gpdk090_nmos1v w=0.12u l=0.1u ad=0.0696p as=0.0408p pd=1.16u ps=0.68u
    I_MXI3_I355_MN0 (I3_q22_1 I3_o22_0 VSS VSS) gpdk090_nmos1v w=0.12u l=0.1u ad=0.0408p as=0.0696p pd=0.68u ps=1.16u
    I_MXI3_I355_MN1 (VSS I3_o22_1 I3_q22_1 VSS) gpdk090_nmos1v w=0.12u l=0.1u ad=0.0696p as=0.0408p pd=1.16u ps=0.68u
    I_MXI2_I134_MN0 (I2_nor22 A_22 VSS VSS) gpdk090_nmos1v w=0.12u l=0.1u ad=0.0408p as=0.0696p pd=0.68u ps=1.16u
    I_MXI2_I134_MN1 (VSS B_22 I2_nor22 VSS) gpdk090_nmos1v w=0.12u l=0.1u ad=0.0696p as=0.0408p pd=1.16u ps=0.68u
    I_MXI4_I50_MN0 (I4_z2_2 I4_z1_4 VSS VSS) gpdk090_nmos1v w=0.12u l=0.1u ad=0.0408p as=0.0696p pd=0.68u ps=1.16u
    I_MXI4_I50_MN1 (VSS I4_z1_5 I4_z2_2 VSS) gpdk090_nmos1v w=0.12u l=0.1u ad=0.0696p as=0.0408p pd=1.16u ps=0.68u
    I_MXI4_I11_MN0 (I4_z0_11 Y_22 VSS VSS) gpdk090_nmos1v w=0.12u l=0.1u ad=0.0408p as=0.0696p pd=0.68u ps=1.16u
    I_MXI4_I11_MN1 (VSS Y_23 I4_z0_11 VSS) gpdk090_nmos1v w=0.12u l=0.1u ad=0.0696p as=0.0408p pd=1.16u ps=0.68u
    I_MXI3_I343_MN0 (I3_q21_1 I3_o21_0 VSS VSS) gpdk090_nmos1v w=0.12u l=0.1u ad=0.0408p as=0.0696p pd=0.68u ps=1.16u
    I_MXI3_I343_MN1 (VSS I3_o21_1 I3_q21_1 VSS) gpdk090_nmos1v w=0.12u l=0.1u ad=0.0696p as=0.0408p pd=1.16u ps=0.68u
    I_MXI4_I10_MN0 (I4_z0_10 Y_20 VSS VSS) gpdk090_nmos1v w=0.12u l=0.1u ad=0.0408p as=0.0696p pd=0.68u ps=1.16u
    I_MXI4_I10_MN1 (VSS Y_21 I4_z0_10 VSS) gpdk090_nmos1v w=0.12u l=0.1u ad=0.0696p as=0.0408p pd=1.16u ps=0.68u
    I_MXI2_I122_MN0 (I2_nor20 A_20 VSS VSS) gpdk090_nmos1v w=0.12u l=0.1u ad=0.0408p as=0.0696p pd=0.68u ps=1.16u
    I_MXI2_I122_MN1 (VSS B_20 I2_nor20 VSS) gpdk090_nmos1v w=0.12u l=0.1u ad=0.0696p as=0.0408p pd=1.16u ps=0.68u
    I_MXI3_I331_MN0 (I3_q20_1 I3_o20_0 VSS VSS) gpdk090_nmos1v w=0.12u l=0.1u ad=0.0408p as=0.0696p pd=0.68u ps=1.16u
    I_MXI3_I331_MN1 (VSS I3_o20_1 I3_q20_1 VSS) gpdk090_nmos1v w=0.12u l=0.1u ad=0.0696p as=0.0408p pd=1.16u ps=0.68u
    I_MXI2_I116_MN0 (I2_nor19 A_19 VSS VSS) gpdk090_nmos1v w=0.12u l=0.1u ad=0.0408p as=0.0696p pd=0.68u ps=1.16u
    I_MXI2_I116_MN1 (VSS B_19 I2_nor19 VSS) gpdk090_nmos1v w=0.12u l=0.1u ad=0.0696p as=0.0408p pd=1.16u ps=0.68u
    I_MXI4_I9_MN0 (I4_z0_9 Y_18 VSS VSS) gpdk090_nmos1v w=0.12u l=0.1u ad=0.0408p as=0.0696p pd=0.68u ps=1.16u
    I_MXI4_I9_MN1 (VSS Y_19 I4_z0_9 VSS) gpdk090_nmos1v w=0.12u l=0.1u ad=0.0696p as=0.0408p pd=1.16u ps=0.68u
    I_MXI4_I8_MN0 (I4_z0_8 Y_16 VSS VSS) gpdk090_nmos1v w=0.12u l=0.1u ad=0.0408p as=0.0696p pd=0.68u ps=1.16u
    I_MXI4_I8_MN1 (VSS Y_17 I4_z0_8 VSS) gpdk090_nmos1v w=0.12u l=0.1u ad=0.0696p as=0.0408p pd=1.16u ps=0.68u
    I_MXI2_I104_MN0 (I2_nor17 A_17 VSS VSS) gpdk090_nmos1v w=0.12u l=0.1u ad=0.0408p as=0.0696p pd=0.68u ps=1.16u
    I_MXI2_I104_MN1 (VSS B_17 I2_nor17 VSS) gpdk090_nmos1v w=0.12u l=0.1u ad=0.0696p as=0.0408p pd=1.16u ps=0.68u
    I_MXI4_I71_MN0 (DZ I4_dzn VSS VSS) gpdk090_nmos1v w=0.12u l=0.1u ad=0.0696p as=0.0696p pd=1.16u ps=1.16u
    I_MXI2_I55_MN0 (AND_9 I2_nand9 VSS VSS) gpdk090_nmos1v w=0.12u l=0.1u ad=0.0696p as=0.0696p pd=1.16u ps=1.16u
    I_MXI2_I37_MN0 (AND_6 I2_nand6 VSS VSS) gpdk090_nmos1v w=0.12u l=0.1u ad=0.0696p as=0.0696p pd=1.16u ps=1.16u
    I_MXI2_I1_MN0 (AND_0 I2_nand0 VSS VSS) gpdk090_nmos1v w=0.12u l=0.1u ad=0.0696p as=0.0696p pd=1.16u ps=1.16u
    I_MXI2_I3_MN0 (OR_0 I2_nor0 VSS VSS) gpdk090_nmos1v w=0.12u l=0.1u ad=0.0696p as=0.0696p pd=1.16u ps=1.16u
    I_MXI2_I51_MN0 (OR_8 I2_nor8 VSS VSS) gpdk090_nmos1v w=0.12u l=0.1u ad=0.0696p as=0.0696p pd=1.16u ps=1.16u
    I_MXI2_I49_MN0 (AND_8 I2_nand8 VSS VSS) gpdk090_nmos1v w=0.12u l=0.1u ad=0.0696p as=0.0696p pd=1.16u ps=1.16u
    I_MXI2_I57_MN0 (OR_9 I2_nor9 VSS VSS) gpdk090_nmos1v w=0.12u l=0.1u ad=0.0696p as=0.0696p pd=1.16u ps=1.16u
    I_MXI2_I39_MN0 (OR_6 I2_nor6 VSS VSS) gpdk090_nmos1v w=0.12u l=0.1u ad=0.0696p as=0.0696p pd=1.16u ps=1.16u
    I_MXI2_I5_MN0 (NOT_0 A_0 VSS VSS) gpdk090_nmos1v w=0.12u l=0.1u ad=0.0696p as=0.0696p pd=1.16u ps=1.16u
    I_MXI2_I7_MN0 (AND_1 I2_nand1 VSS VSS) gpdk090_nmos1v w=0.12u l=0.1u ad=0.0696p as=0.0696p pd=1.16u ps=1.16u
    I_MXI2_I9_MN0 (OR_1 I2_nor1 VSS VSS) gpdk090_nmos1v w=0.12u l=0.1u ad=0.0696p as=0.0696p pd=1.16u ps=1.16u
    I_MXI2_I27_MN0 (OR_4 I2_nor4 VSS VSS) gpdk090_nmos1v w=0.12u l=0.1u ad=0.0696p as=0.0696p pd=1.16u ps=1.16u
    I_MXI2_I25_MN0 (AND_4 I2_nand4 VSS VSS) gpdk090_nmos1v w=0.12u l=0.1u ad=0.0696p as=0.0696p pd=1.16u ps=1.16u
    I_MXI4_I63_MN0 (Z I4_z5_0 VSS VSS) gpdk090_nmos1v w=0.12u l=0.1u ad=0.0696p as=0.0696p pd=1.16u ps=1.16u
    I_MXI2_I53_MN0 (NOT_8 A_8 VSS VSS) gpdk090_nmos1v w=0.12u l=0.1u ad=0.0696p as=0.0696p pd=1.16u ps=1.16u
    I_MXI2_I43_MN0 (AND_7 I2_nand7 VSS VSS) gpdk090_nmos1v w=0.12u l=0.1u ad=0.0696p as=0.0696p pd=1.16u ps=1.16u
    I_MXI2_I41_MN0 (NOT_6 A_6 VSS VSS) gpdk090_nmos1v w=0.12u l=0.1u ad=0.0696p as=0.0696p pd=1.16u ps=1.16u
    I_MXI2_I45_MN0 (OR_7 I2_nor7 VSS VSS) gpdk090_nmos1v w=0.12u l=0.1u ad=0.0696p as=0.0696p pd=1.16u ps=1.16u
    I_MXI2_I35_MN0 (NOT_5 A_5 VSS VSS) gpdk090_nmos1v w=0.12u l=0.1u ad=0.0696p as=0.0696p pd=1.16u ps=1.16u
    I_MXI2_I11_MN0 (NOT_1 A_1 VSS VSS) gpdk090_nmos1v w=0.12u l=0.1u ad=0.0696p as=0.0696p pd=1.16u ps=1.16u
    I_MXI2_I29_MN0 (NOT_4 A_4 VSS VSS) gpdk090_nmos1v w=0.12u l=0.1u ad=0.0696p as=0.0696p pd=1.16u ps=1.16u
    I_MXI2_I15_MN0 (OR_2 I2_nor2 VSS VSS) gpdk090_nmos1v w=0.12u l=0.1u ad=0.0696p as=0.0696p pd=1.16u ps=1.16u
    I_MXI2_I13_MN0 (AND_2 I2_nand2 VSS VSS) gpdk090_nmos1v w=0.12u l=0.1u ad=0.0696p as=0.0696p pd=1.16u ps=1.16u
    I_MXI2_I65_MN0 (NOT_10 A_10 VSS VSS) gpdk090_nmos1v w=0.12u l=0.1u ad=0.0696p as=0.0696p pd=1.16u ps=1.16u
    I_MXI2_I59_MN0 (NOT_9 A_9 VSS VSS) gpdk090_nmos1v w=0.12u l=0.1u ad=0.0696p as=0.0696p pd=1.16u ps=1.16u
    I_MXI2_I47_MN0 (NOT_7 A_7 VSS VSS) gpdk090_nmos1v w=0.12u l=0.1u ad=0.0696p as=0.0696p pd=1.16u ps=1.16u
    I_MXI1_I42_I64_MN0 (I1_I42_cinn I1_SUB_b3_5 VSS VSS) gpdk090_nmos1v w=0.12u l=0.1u ad=0.0696p as=0.0696p pd=1.16u ps=1.16u
    I_MXI2_I17_MN0 (NOT_2 A_2 VSS VSS) gpdk090_nmos1v w=0.12u l=0.1u ad=0.0696p as=0.0696p pd=1.16u ps=1.16u
    I_MXI3_I56_MN0 (I3_SEL_DIV_b0 SEL_DIV VSS VSS) gpdk090_nmos1v w=0.12u l=0.1u ad=0.0696p as=0.0696p pd=1.16u ps=1.16u
    I_MXI2_I61_MN0 (AND_10 I2_nand10 VSS VSS) gpdk090_nmos1v w=0.12u l=0.1u ad=0.0696p as=0.0696p pd=1.16u ps=1.16u
    I_MXI2_I63_MN0 (OR_10 I2_nor10 VSS VSS) gpdk090_nmos1v w=0.12u l=0.1u ad=0.0696p as=0.0696p pd=1.16u ps=1.16u
    I_MXI2_I33_MN0 (OR_5 I2_nor5 VSS VSS) gpdk090_nmos1v w=0.12u l=0.1u ad=0.0696p as=0.0696p pd=1.16u ps=1.16u
    I_MXI2_I31_MN0 (AND_5 I2_nand5 VSS VSS) gpdk090_nmos1v w=0.12u l=0.1u ad=0.0696p as=0.0696p pd=1.16u ps=1.16u
    I_MXI0_I2_MN0 (I0_opn2 OP_2 VSS VSS) gpdk090_nmos1v w=0.12u l=0.1u ad=0.0696p as=0.0696p pd=1.16u ps=1.16u
    I_MXI0_I3_MN0 (I0_opn3 OP_3 VSS VSS) gpdk090_nmos1v w=0.12u l=0.1u ad=0.0696p as=0.0696p pd=1.16u ps=1.16u
    I_MXI3_I40_MN0 (I3_SEL_MUL_b0 SEL_MUL VSS VSS) gpdk090_nmos1v w=0.12u l=0.1u ad=0.0696p as=0.0696p pd=1.16u ps=1.16u
    I_MXI3_I30_MN0 (I3_SEL_NOT_b0 SEL_NOT VSS VSS) gpdk090_nmos1v w=0.12u l=0.1u ad=0.0696p as=0.0696p pd=1.16u ps=1.16u
    I_MXI2_I23_MN0 (NOT_3 A_3 VSS VSS) gpdk090_nmos1v w=0.12u l=0.1u ad=0.0696p as=0.0696p pd=1.16u ps=1.16u
    I_MXI0_I0_MN0 (I0_opn0 OP_0 VSS VSS) gpdk090_nmos1v w=0.12u l=0.1u ad=0.0696p as=0.0696p pd=1.16u ps=1.16u
    I_MXI0_I1_MN0 (I0_opn1 OP_1 VSS VSS) gpdk090_nmos1v w=0.12u l=0.1u ad=0.0696p as=0.0696p pd=1.16u ps=1.16u
    I_MXI3_I10_MN0 (I3_SEL_OR_b0 SEL_OR VSS VSS) gpdk090_nmos1v w=0.12u l=0.1u ad=0.0696p as=0.0696p pd=1.16u ps=1.16u
    I_MXI3_I20_MN0 (I3_SEL_XOR_b0 SEL_XOR VSS VSS) gpdk090_nmos1v w=0.12u l=0.1u ad=0.0696p as=0.0696p pd=1.16u ps=1.16u
    I_MXI1_I0_MN0 (I1_SUB_b0 OP_0 VSS VSS) gpdk090_nmos1v w=0.12u l=0.1u ad=0.0696p as=0.0696p pd=1.16u ps=1.16u
    I_MXI1_I42_I129_MN0 (I1_I42_G1_0n I1_I42_G1_0 VSS VSS) gpdk090_nmos1v w=0.12u l=0.1u ad=0.0696p as=0.0696p pd=1.16u ps=1.16u
    I_MXI2_I19_MN0 (AND_3 I2_nand3 VSS VSS) gpdk090_nmos1v w=0.12u l=0.1u ad=0.0696p as=0.0696p pd=1.16u ps=1.16u
    I_MXI2_I21_MN0 (OR_3 I2_nor3 VSS VSS) gpdk090_nmos1v w=0.12u l=0.1u ad=0.0696p as=0.0696p pd=1.16u ps=1.16u
    I_MXI3_I72_MN0 (I3_SEL_AS_b0 SEL_AS VSS VSS) gpdk090_nmos1v w=0.12u l=0.1u ad=0.0696p as=0.0696p pd=1.16u ps=1.16u
    I_MXI3_I0_MN0 (I3_SEL_AND_b0 SEL_AND VSS VSS) gpdk090_nmos1v w=0.12u l=0.1u ad=0.0696p as=0.0696p pd=1.16u ps=1.16u
    I_MXI1_I42_I66_MN0 (I1_I42_G0_0n I1_I42_G0_0 VSS VSS) gpdk090_nmos1v w=0.12u l=0.1u ad=0.0696p as=0.0696p pd=1.16u ps=1.16u
    I_MXI2_I67_MN0 (AND_11 I2_nand11 VSS VSS) gpdk090_nmos1v w=0.12u l=0.1u ad=0.0696p as=0.0696p pd=1.16u ps=1.16u
    I_MXI2_I69_MN0 (OR_11 I2_nor11 VSS VSS) gpdk090_nmos1v w=0.12u l=0.1u ad=0.0696p as=0.0696p pd=1.16u ps=1.16u
    I_MXI2_I71_MN0 (NOT_11 A_11 VSS VSS) gpdk090_nmos1v w=0.12u l=0.1u ad=0.0696p as=0.0696p pd=1.16u ps=1.16u
    I_MXI2_I75_MN0 (OR_12 I2_nor12 VSS VSS) gpdk090_nmos1v w=0.12u l=0.1u ad=0.0696p as=0.0696p pd=1.16u ps=1.16u
    I_MXI2_I183_MN0 (OR_30 I2_nor30 VSS VSS) gpdk090_nmos1v w=0.12u l=0.1u ad=0.0696p as=0.0696p pd=1.16u ps=1.16u
    I_MXI2_I185_MN0 (NOT_30 A_30 VSS VSS) gpdk090_nmos1v w=0.12u l=0.1u ad=0.0696p as=0.0696p pd=1.16u ps=1.16u
    I_MXI2_I191_MN0 (NOT_31 A_31 VSS VSS) gpdk090_nmos1v w=0.12u l=0.1u ad=0.0696p as=0.0696p pd=1.16u ps=1.16u
    I_MXI4_I65_MN0 (C I4_cn VSS VSS) gpdk090_nmos1v w=0.12u l=0.1u ad=0.0696p as=0.0696p pd=1.16u ps=1.16u
    I_MXI1_I42_I189_MN0 (I1_I42_G5_0n I1_I42_G5_0 VSS VSS) gpdk090_nmos1v w=0.12u l=0.1u ad=0.0696p as=0.0696p pd=1.16u ps=1.16u
    I_MXI2_I73_MN0 (AND_12 I2_nand12 VSS VSS) gpdk090_nmos1v w=0.12u l=0.1u ad=0.0696p as=0.0696p pd=1.16u ps=1.16u
    I_MXI2_I181_MN0 (AND_30 I2_nand30 VSS VSS) gpdk090_nmos1v w=0.12u l=0.1u ad=0.0696p as=0.0696p pd=1.16u ps=1.16u
    I_MXI2_I175_MN0 (AND_29 I2_nand29 VSS VSS) gpdk090_nmos1v w=0.12u l=0.1u ad=0.0696p as=0.0696p pd=1.16u ps=1.16u
    I_MXI2_I177_MN0 (OR_29 I2_nor29 VSS VSS) gpdk090_nmos1v w=0.12u l=0.1u ad=0.0696p as=0.0696p pd=1.16u ps=1.16u
    I_MXI2_I187_MN0 (AND_31 I2_nand31 VSS VSS) gpdk090_nmos1v w=0.12u l=0.1u ad=0.0696p as=0.0696p pd=1.16u ps=1.16u
    I_MXI2_I189_MN0 (OR_31 I2_nor31 VSS VSS) gpdk090_nmos1v w=0.12u l=0.1u ad=0.0696p as=0.0696p pd=1.16u ps=1.16u
    I_MXI1_I42_I161_MN0 (I1_I42_G3_0np I1_I42_G3_0n VSS VSS) gpdk090_nmos1v w=0.12u l=0.1u ad=0.0696p as=0.0696p pd=1.16u ps=1.16u
    I_MXI1_I42_I159_MN0 (I1_I42_G2_0np I1_I42_G2_0n VSS VSS) gpdk090_nmos1v w=0.12u l=0.1u ad=0.0696p as=0.0696p pd=1.16u ps=1.16u
    I_MXI2_I83_MN0 (NOT_13 A_13 VSS VSS) gpdk090_nmos1v w=0.12u l=0.1u ad=0.0696p as=0.0696p pd=1.16u ps=1.16u
    I_MXI2_I77_MN0 (NOT_12 A_12 VSS VSS) gpdk090_nmos1v w=0.12u l=0.1u ad=0.0696p as=0.0696p pd=1.16u ps=1.16u
    I_MXI2_I81_MN0 (OR_13 I2_nor13 VSS VSS) gpdk090_nmos1v w=0.12u l=0.1u ad=0.0696p as=0.0696p pd=1.16u ps=1.16u
    I_MXI2_I179_MN0 (NOT_29 A_29 VSS VSS) gpdk090_nmos1v w=0.12u l=0.1u ad=0.0696p as=0.0696p pd=1.16u ps=1.16u
    I_MXI1_I42_I193_MN0 (I1_I42_G7_0n I1_I42_G7_0 VSS VSS) gpdk090_nmos1v w=0.12u l=0.1u ad=0.0696p as=0.0696p pd=1.16u ps=1.16u
    I_MXI1_I42_I187_MN0 (I1_I42_G4_0n I1_I42_G4_0 VSS VSS) gpdk090_nmos1v w=0.12u l=0.1u ad=0.0696p as=0.0696p pd=1.16u ps=1.16u
    I_MXI2_I79_MN0 (AND_13 I2_nand13 VSS VSS) gpdk090_nmos1v w=0.12u l=0.1u ad=0.0696p as=0.0696p pd=1.16u ps=1.16u
    I_MXI2_I169_MN0 (AND_28 I2_nand28 VSS VSS) gpdk090_nmos1v w=0.12u l=0.1u ad=0.0696p as=0.0696p pd=1.16u ps=1.16u
    I_MXI2_I171_MN0 (OR_28 I2_nor28 VSS VSS) gpdk090_nmos1v w=0.12u l=0.1u ad=0.0696p as=0.0696p pd=1.16u ps=1.16u
    I_MXI2_I173_MN0 (NOT_28 A_28 VSS VSS) gpdk090_nmos1v w=0.12u l=0.1u ad=0.0696p as=0.0696p pd=1.16u ps=1.16u
    I_MXI2_I89_MN0 (NOT_14 A_14 VSS VSS) gpdk090_nmos1v w=0.12u l=0.1u ad=0.0696p as=0.0696p pd=1.16u ps=1.16u
    I_MXI2_I85_MN0 (AND_14 I2_nand14 VSS VSS) gpdk090_nmos1v w=0.12u l=0.1u ad=0.0696p as=0.0696p pd=1.16u ps=1.16u
    I_MXI1_I42_I191_MN0 (I1_I42_G6_0n I1_I42_G6_0 VSS VSS) gpdk090_nmos1v w=0.12u l=0.1u ad=0.0696p as=0.0696p pd=1.16u ps=1.16u
    I_MXI2_I87_MN0 (OR_14 I2_nor14 VSS VSS) gpdk090_nmos1v w=0.12u l=0.1u ad=0.0696p as=0.0696p pd=1.16u ps=1.16u
    I_MXI2_I165_MN0 (OR_27 I2_nor27 VSS VSS) gpdk090_nmos1v w=0.12u l=0.1u ad=0.0696p as=0.0696p pd=1.16u ps=1.16u
    I_MXI2_I163_MN0 (AND_27 I2_nand27 VSS VSS) gpdk090_nmos1v w=0.12u l=0.1u ad=0.0696p as=0.0696p pd=1.16u ps=1.16u
    I_MXI2_I167_MN0 (NOT_27 A_27 VSS VSS) gpdk090_nmos1v w=0.12u l=0.1u ad=0.0696p as=0.0696p pd=1.16u ps=1.16u
    I_MXI2_I95_MN0 (NOT_15 A_15 VSS VSS) gpdk090_nmos1v w=0.12u l=0.1u ad=0.0696p as=0.0696p pd=1.16u ps=1.16u
    I_MXI2_I93_MN0 (OR_15 I2_nor15 VSS VSS) gpdk090_nmos1v w=0.12u l=0.1u ad=0.0696p as=0.0696p pd=1.16u ps=1.16u
    I_MXI2_I91_MN0 (AND_15 I2_nand15 VSS VSS) gpdk090_nmos1v w=0.12u l=0.1u ad=0.0696p as=0.0696p pd=1.16u ps=1.16u
    I_MXI2_I157_MN0 (AND_26 I2_nand26 VSS VSS) gpdk090_nmos1v w=0.12u l=0.1u ad=0.0696p as=0.0696p pd=1.16u ps=1.16u
    I_MXI2_I161_MN0 (NOT_26 A_26 VSS VSS) gpdk090_nmos1v w=0.12u l=0.1u ad=0.0696p as=0.0696p pd=1.16u ps=1.16u
    I_MXI2_I149_MN0 (NOT_24 A_24 VSS VSS) gpdk090_nmos1v w=0.12u l=0.1u ad=0.0696p as=0.0696p pd=1.16u ps=1.16u
    I_MXI2_I119_MN0 (NOT_19 A_19 VSS VSS) gpdk090_nmos1v w=0.12u l=0.1u ad=0.0696p as=0.0696p pd=1.16u ps=1.16u
    I_MXI2_I101_MN0 (NOT_16 A_16 VSS VSS) gpdk090_nmos1v w=0.12u l=0.1u ad=0.0696p as=0.0696p pd=1.16u ps=1.16u
    I_MXI2_I97_MN0 (AND_16 I2_nand16 VSS VSS) gpdk090_nmos1v w=0.12u l=0.1u ad=0.0696p as=0.0696p pd=1.16u ps=1.16u
    I_MXI2_I159_MN0 (OR_26 I2_nor26 VSS VSS) gpdk090_nmos1v w=0.12u l=0.1u ad=0.0696p as=0.0696p pd=1.16u ps=1.16u
    I_MXI2_I155_MN0 (NOT_25 A_25 VSS VSS) gpdk090_nmos1v w=0.12u l=0.1u ad=0.0696p as=0.0696p pd=1.16u ps=1.16u
    I_MXI2_I143_MN0 (NOT_23 A_23 VSS VSS) gpdk090_nmos1v w=0.12u l=0.1u ad=0.0696p as=0.0696p pd=1.16u ps=1.16u
    I_MXI2_I137_MN0 (NOT_22 A_22 VSS VSS) gpdk090_nmos1v w=0.12u l=0.1u ad=0.0696p as=0.0696p pd=1.16u ps=1.16u
    I_MXI2_I129_MN0 (OR_21 I2_nor21 VSS VSS) gpdk090_nmos1v w=0.12u l=0.1u ad=0.0696p as=0.0696p pd=1.16u ps=1.16u
    I_MXI2_I131_MN0 (NOT_21 A_21 VSS VSS) gpdk090_nmos1v w=0.12u l=0.1u ad=0.0696p as=0.0696p pd=1.16u ps=1.16u
    I_MXI2_I125_MN0 (NOT_20 A_20 VSS VSS) gpdk090_nmos1v w=0.12u l=0.1u ad=0.0696p as=0.0696p pd=1.16u ps=1.16u
    I_MXI2_I113_MN0 (NOT_18 A_18 VSS VSS) gpdk090_nmos1v w=0.12u l=0.1u ad=0.0696p as=0.0696p pd=1.16u ps=1.16u
    I_MXI2_I107_MN0 (NOT_17 A_17 VSS VSS) gpdk090_nmos1v w=0.12u l=0.1u ad=0.0696p as=0.0696p pd=1.16u ps=1.16u
    I_MXI2_I99_MN0 (OR_16 I2_nor16 VSS VSS) gpdk090_nmos1v w=0.12u l=0.1u ad=0.0696p as=0.0696p pd=1.16u ps=1.16u
    I_MXI2_I151_MN0 (AND_25 I2_nand25 VSS VSS) gpdk090_nmos1v w=0.12u l=0.1u ad=0.0696p as=0.0696p pd=1.16u ps=1.16u
    I_MXI2_I153_MN0 (OR_25 I2_nor25 VSS VSS) gpdk090_nmos1v w=0.12u l=0.1u ad=0.0696p as=0.0696p pd=1.16u ps=1.16u
    I_MXI2_I145_MN0 (AND_24 I2_nand24 VSS VSS) gpdk090_nmos1v w=0.12u l=0.1u ad=0.0696p as=0.0696p pd=1.16u ps=1.16u
    I_MXI2_I147_MN0 (OR_24 I2_nor24 VSS VSS) gpdk090_nmos1v w=0.12u l=0.1u ad=0.0696p as=0.0696p pd=1.16u ps=1.16u
    I_MXI2_I141_MN0 (OR_23 I2_nor23 VSS VSS) gpdk090_nmos1v w=0.12u l=0.1u ad=0.0696p as=0.0696p pd=1.16u ps=1.16u
    I_MXI2_I139_MN0 (AND_23 I2_nand23 VSS VSS) gpdk090_nmos1v w=0.12u l=0.1u ad=0.0696p as=0.0696p pd=1.16u ps=1.16u
    I_MXI2_I133_MN0 (AND_22 I2_nand22 VSS VSS) gpdk090_nmos1v w=0.12u l=0.1u ad=0.0696p as=0.0696p pd=1.16u ps=1.16u
    I_MXI2_I135_MN0 (OR_22 I2_nor22 VSS VSS) gpdk090_nmos1v w=0.12u l=0.1u ad=0.0696p as=0.0696p pd=1.16u ps=1.16u
    I_MXI2_I127_MN0 (AND_21 I2_nand21 VSS VSS) gpdk090_nmos1v w=0.12u l=0.1u ad=0.0696p as=0.0696p pd=1.16u ps=1.16u
    I_MXI2_I121_MN0 (AND_20 I2_nand20 VSS VSS) gpdk090_nmos1v w=0.12u l=0.1u ad=0.0696p as=0.0696p pd=1.16u ps=1.16u
    I_MXI2_I123_MN0 (OR_20 I2_nor20 VSS VSS) gpdk090_nmos1v w=0.12u l=0.1u ad=0.0696p as=0.0696p pd=1.16u ps=1.16u
    I_MXI2_I115_MN0 (AND_19 I2_nand19 VSS VSS) gpdk090_nmos1v w=0.12u l=0.1u ad=0.0696p as=0.0696p pd=1.16u ps=1.16u
    I_MXI2_I117_MN0 (OR_19 I2_nor19 VSS VSS) gpdk090_nmos1v w=0.12u l=0.1u ad=0.0696p as=0.0696p pd=1.16u ps=1.16u
    I_MXI2_I109_MN0 (AND_18 I2_nand18 VSS VSS) gpdk090_nmos1v w=0.12u l=0.1u ad=0.0696p as=0.0696p pd=1.16u ps=1.16u
    I_MXI2_I111_MN0 (OR_18 I2_nor18 VSS VSS) gpdk090_nmos1v w=0.12u l=0.1u ad=0.0696p as=0.0696p pd=1.16u ps=1.16u
    I_MXI2_I103_MN0 (AND_17 I2_nand17 VSS VSS) gpdk090_nmos1v w=0.12u l=0.1u ad=0.0696p as=0.0696p pd=1.16u ps=1.16u
    I_MXI2_I105_MN0 (OR_17 I2_nor17 VSS VSS) gpdk090_nmos1v w=0.12u l=0.1u ad=0.0696p as=0.0696p pd=1.16u ps=1.16u
    I_MXI1_I10_MN1 (XI1_I10_Bn I1_SUB_b3_0 VSS VSS) gpdk090_nmos1v w=0.12u l=0.1u ad=0.0696p as=0.0696p pd=1.16u ps=1.16u
    I_MXI1_I10_MN5 (XI1_I10_n2 XI1_I10_Bn VSS VSS) gpdk090_nmos1v w=0.24u l=0.1u ad=0.0528p as=0.0816p pd=0.68u ps=1.16u
    I_MXI1_I10_MN4 (I1_bx0 XI1_I10_An XI1_I10_n2 VSS) gpdk090_nmos1v w=0.24u l=0.1u ad=0.0528p as=0.0528p pd=0.68u ps=0.68u
    I_MXI1_I10_MN2 (XI1_I10_n1 B_0 I1_bx0 VSS) gpdk090_nmos1v w=0.24u l=0.1u ad=0.0528p as=0.0528p pd=0.68u ps=0.68u
    I_MXI1_I10_MN3 (VSS I1_SUB_b3_0 XI1_I10_n1 VSS) gpdk090_nmos1v w=0.24u l=0.1u ad=0.0816p as=0.0528p pd=1.16u ps=0.68u
    I_MXI1_I10_MN0 (XI1_I10_An B_0 VSS VSS) gpdk090_nmos1v w=0.12u l=0.1u ad=0.0696p as=0.0696p pd=1.16u ps=1.16u
    I_MXI2_I4_MN1 (XI2_I4_Bn B_0 VSS VSS) gpdk090_nmos1v w=0.12u l=0.1u ad=0.0696p as=0.0696p pd=1.16u ps=1.16u
    I_MXI2_I4_MN5 (XI2_I4_n2 XI2_I4_Bn VSS VSS) gpdk090_nmos1v w=0.24u l=0.1u ad=0.0528p as=0.0816p pd=0.68u ps=1.16u
    I_MXI2_I4_MN4 (XOR_0 XI2_I4_An XI2_I4_n2 VSS) gpdk090_nmos1v w=0.24u l=0.1u ad=0.0528p as=0.0528p pd=0.68u ps=0.68u
    I_MXI2_I4_MN2 (XI2_I4_n1 A_0 XOR_0 VSS) gpdk090_nmos1v w=0.24u l=0.1u ad=0.0528p as=0.0528p pd=0.68u ps=0.68u
    I_MXI2_I4_MN3 (VSS B_0 XI2_I4_n1 VSS) gpdk090_nmos1v w=0.24u l=0.1u ad=0.0816p as=0.0528p pd=1.16u ps=0.68u
    I_MXI2_I4_MN0 (XI2_I4_An A_0 VSS VSS) gpdk090_nmos1v w=0.12u l=0.1u ad=0.0696p as=0.0696p pd=1.16u ps=1.16u
    I_MXI2_I10_MN1 (XI2_I10_Bn B_1 VSS VSS) gpdk090_nmos1v w=0.12u l=0.1u ad=0.0696p as=0.0696p pd=1.16u ps=1.16u
    I_MXI2_I10_MN5 (XI2_I10_n2 XI2_I10_Bn VSS VSS) gpdk090_nmos1v w=0.24u l=0.1u ad=0.0528p as=0.0816p pd=0.68u ps=1.16u
    I_MXI2_I10_MN4 (XOR_1 XI2_I10_An XI2_I10_n2 VSS) gpdk090_nmos1v w=0.24u l=0.1u ad=0.0528p as=0.0528p pd=0.68u ps=0.68u
    I_MXI2_I10_MN2 (XI2_I10_n1 A_1 XOR_1 VSS) gpdk090_nmos1v w=0.24u l=0.1u ad=0.0528p as=0.0528p pd=0.68u ps=0.68u
    I_MXI2_I10_MN3 (VSS B_1 XI2_I10_n1 VSS) gpdk090_nmos1v w=0.24u l=0.1u ad=0.0816p as=0.0528p pd=1.16u ps=0.68u
    I_MXI2_I10_MN0 (XI2_I10_An A_1 VSS VSS) gpdk090_nmos1v w=0.12u l=0.1u ad=0.0696p as=0.0696p pd=1.16u ps=1.16u
    I_MXI2_I28_MN1 (XI2_I28_Bn B_4 VSS VSS) gpdk090_nmos1v w=0.12u l=0.1u ad=0.0696p as=0.0696p pd=1.16u ps=1.16u
    I_MXI2_I28_MN5 (XI2_I28_n2 XI2_I28_Bn VSS VSS) gpdk090_nmos1v w=0.24u l=0.1u ad=0.0528p as=0.0816p pd=0.68u ps=1.16u
    I_MXI2_I28_MN4 (XOR_4 XI2_I28_An XI2_I28_n2 VSS) gpdk090_nmos1v w=0.24u l=0.1u ad=0.0528p as=0.0528p pd=0.68u ps=0.68u
    I_MXI2_I28_MN2 (XI2_I28_n1 A_4 XOR_4 VSS) gpdk090_nmos1v w=0.24u l=0.1u ad=0.0528p as=0.0528p pd=0.68u ps=0.68u
    I_MXI2_I28_MN3 (VSS B_4 XI2_I28_n1 VSS) gpdk090_nmos1v w=0.24u l=0.1u ad=0.0816p as=0.0528p pd=1.16u ps=0.68u
    I_MXI2_I28_MN0 (XI2_I28_An A_4 VSS VSS) gpdk090_nmos1v w=0.12u l=0.1u ad=0.0696p as=0.0696p pd=1.16u ps=1.16u
    I_MXI2_I52_MN1 (XI2_I52_Bn B_8 VSS VSS) gpdk090_nmos1v w=0.12u l=0.1u ad=0.0696p as=0.0696p pd=1.16u ps=1.16u
    I_MXI2_I52_MN5 (XI2_I52_n2 XI2_I52_Bn VSS VSS) gpdk090_nmos1v w=0.24u l=0.1u ad=0.0528p as=0.0816p pd=0.68u ps=1.16u
    I_MXI2_I52_MN4 (XOR_8 XI2_I52_An XI2_I52_n2 VSS) gpdk090_nmos1v w=0.24u l=0.1u ad=0.0528p as=0.0528p pd=0.68u ps=0.68u
    I_MXI2_I52_MN2 (XI2_I52_n1 A_8 XOR_8 VSS) gpdk090_nmos1v w=0.24u l=0.1u ad=0.0528p as=0.0528p pd=0.68u ps=0.68u
    I_MXI2_I52_MN3 (VSS B_8 XI2_I52_n1 VSS) gpdk090_nmos1v w=0.24u l=0.1u ad=0.0816p as=0.0528p pd=1.16u ps=0.68u
    I_MXI2_I52_MN0 (XI2_I52_An A_8 VSS VSS) gpdk090_nmos1v w=0.12u l=0.1u ad=0.0696p as=0.0696p pd=1.16u ps=1.16u
    I_MXI2_I58_MN1 (XI2_I58_Bn B_9 VSS VSS) gpdk090_nmos1v w=0.12u l=0.1u ad=0.0696p as=0.0696p pd=1.16u ps=1.16u
    I_MXI2_I58_MN5 (XI2_I58_n2 XI2_I58_Bn VSS VSS) gpdk090_nmos1v w=0.24u l=0.1u ad=0.0528p as=0.0816p pd=0.68u ps=1.16u
    I_MXI2_I58_MN4 (XOR_9 XI2_I58_An XI2_I58_n2 VSS) gpdk090_nmos1v w=0.24u l=0.1u ad=0.0528p as=0.0528p pd=0.68u ps=0.68u
    I_MXI2_I58_MN2 (XI2_I58_n1 A_9 XOR_9 VSS) gpdk090_nmos1v w=0.24u l=0.1u ad=0.0528p as=0.0528p pd=0.68u ps=0.68u
    I_MXI2_I58_MN3 (VSS B_9 XI2_I58_n1 VSS) gpdk090_nmos1v w=0.24u l=0.1u ad=0.0816p as=0.0528p pd=1.16u ps=0.68u
    I_MXI2_I58_MN0 (XI2_I58_An A_9 VSS VSS) gpdk090_nmos1v w=0.12u l=0.1u ad=0.0696p as=0.0696p pd=1.16u ps=1.16u
    I_MXI2_I40_MN1 (XI2_I40_Bn B_6 VSS VSS) gpdk090_nmos1v w=0.12u l=0.1u ad=0.0696p as=0.0696p pd=1.16u ps=1.16u
    I_MXI2_I40_MN5 (XI2_I40_n2 XI2_I40_Bn VSS VSS) gpdk090_nmos1v w=0.24u l=0.1u ad=0.0528p as=0.0816p pd=0.68u ps=1.16u
    I_MXI2_I40_MN4 (XOR_6 XI2_I40_An XI2_I40_n2 VSS) gpdk090_nmos1v w=0.24u l=0.1u ad=0.0528p as=0.0528p pd=0.68u ps=0.68u
    I_MXI2_I40_MN2 (XI2_I40_n1 A_6 XOR_6 VSS) gpdk090_nmos1v w=0.24u l=0.1u ad=0.0528p as=0.0528p pd=0.68u ps=0.68u
    I_MXI2_I40_MN3 (VSS B_6 XI2_I40_n1 VSS) gpdk090_nmos1v w=0.24u l=0.1u ad=0.0816p as=0.0528p pd=1.16u ps=0.68u
    I_MXI2_I40_MN0 (XI2_I40_An A_6 VSS VSS) gpdk090_nmos1v w=0.12u l=0.1u ad=0.0696p as=0.0696p pd=1.16u ps=1.16u
    I_MXI1_I11_MN1 (XI1_I11_Bn I1_SUB_b3_0 VSS VSS) gpdk090_nmos1v w=0.12u l=0.1u ad=0.0696p as=0.0696p pd=1.16u ps=1.16u
    I_MXI1_I11_MN5 (XI1_I11_n2 XI1_I11_Bn VSS VSS) gpdk090_nmos1v w=0.24u l=0.1u ad=0.0528p as=0.0816p pd=0.68u ps=1.16u
    I_MXI1_I11_MN4 (I1_bx1 XI1_I11_An XI1_I11_n2 VSS) gpdk090_nmos1v w=0.24u l=0.1u ad=0.0528p as=0.0528p pd=0.68u ps=0.68u
    I_MXI1_I11_MN2 (XI1_I11_n1 B_1 I1_bx1 VSS) gpdk090_nmos1v w=0.24u l=0.1u ad=0.0528p as=0.0528p pd=0.68u ps=0.68u
    I_MXI1_I11_MN3 (VSS I1_SUB_b3_0 XI1_I11_n1 VSS) gpdk090_nmos1v w=0.24u l=0.1u ad=0.0816p as=0.0528p pd=1.16u ps=0.68u
    I_MXI1_I11_MN0 (XI1_I11_An B_1 VSS VSS) gpdk090_nmos1v w=0.12u l=0.1u ad=0.0696p as=0.0696p pd=1.16u ps=1.16u
    I_MXI1_I14_MN1 (XI1_I14_Bn I1_SUB_b3_0 VSS VSS) gpdk090_nmos1v w=0.12u l=0.1u ad=0.0696p as=0.0696p pd=1.16u ps=1.16u
    I_MXI1_I14_MN5 (XI1_I14_n2 XI1_I14_Bn VSS VSS) gpdk090_nmos1v w=0.24u l=0.1u ad=0.0528p as=0.0816p pd=0.68u ps=1.16u
    I_MXI1_I14_MN4 (I1_bx4 XI1_I14_An XI1_I14_n2 VSS) gpdk090_nmos1v w=0.24u l=0.1u ad=0.0528p as=0.0528p pd=0.68u ps=0.68u
    I_MXI1_I14_MN2 (XI1_I14_n1 B_4 I1_bx4 VSS) gpdk090_nmos1v w=0.24u l=0.1u ad=0.0528p as=0.0528p pd=0.68u ps=0.68u
    I_MXI1_I14_MN3 (VSS I1_SUB_b3_0 XI1_I14_n1 VSS) gpdk090_nmos1v w=0.24u l=0.1u ad=0.0816p as=0.0528p pd=1.16u ps=0.68u
    I_MXI1_I14_MN0 (XI1_I14_An B_4 VSS VSS) gpdk090_nmos1v w=0.12u l=0.1u ad=0.0696p as=0.0696p pd=1.16u ps=1.16u
    I_MXI2_I64_MN1 (XI2_I64_Bn B_10 VSS VSS) gpdk090_nmos1v w=0.12u l=0.1u ad=0.0696p as=0.0696p pd=1.16u ps=1.16u
    I_MXI2_I64_MN5 (XI2_I64_n2 XI2_I64_Bn VSS VSS) gpdk090_nmos1v w=0.24u l=0.1u ad=0.0528p as=0.0816p pd=0.68u ps=1.16u
    I_MXI2_I64_MN4 (XOR_10 XI2_I64_An XI2_I64_n2 VSS) gpdk090_nmos1v w=0.24u l=0.1u ad=0.0528p as=0.0528p pd=0.68u ps=0.68u
    I_MXI2_I64_MN2 (XI2_I64_n1 A_10 XOR_10 VSS) gpdk090_nmos1v w=0.24u l=0.1u ad=0.0528p as=0.0528p pd=0.68u ps=0.68u
    I_MXI2_I64_MN3 (VSS B_10 XI2_I64_n1 VSS) gpdk090_nmos1v w=0.24u l=0.1u ad=0.0816p as=0.0528p pd=1.16u ps=0.68u
    I_MXI2_I64_MN0 (XI2_I64_An A_10 VSS VSS) gpdk090_nmos1v w=0.12u l=0.1u ad=0.0696p as=0.0696p pd=1.16u ps=1.16u
    I_MXI2_I46_MN1 (XI2_I46_Bn B_7 VSS VSS) gpdk090_nmos1v w=0.12u l=0.1u ad=0.0696p as=0.0696p pd=1.16u ps=1.16u
    I_MXI2_I46_MN5 (XI2_I46_n2 XI2_I46_Bn VSS VSS) gpdk090_nmos1v w=0.24u l=0.1u ad=0.0528p as=0.0816p pd=0.68u ps=1.16u
    I_MXI2_I46_MN4 (XOR_7 XI2_I46_An XI2_I46_n2 VSS) gpdk090_nmos1v w=0.24u l=0.1u ad=0.0528p as=0.0528p pd=0.68u ps=0.68u
    I_MXI2_I46_MN2 (XI2_I46_n1 A_7 XOR_7 VSS) gpdk090_nmos1v w=0.24u l=0.1u ad=0.0528p as=0.0528p pd=0.68u ps=0.68u
    I_MXI2_I46_MN3 (VSS B_7 XI2_I46_n1 VSS) gpdk090_nmos1v w=0.24u l=0.1u ad=0.0816p as=0.0528p pd=1.16u ps=0.68u
    I_MXI2_I46_MN0 (XI2_I46_An A_7 VSS VSS) gpdk090_nmos1v w=0.12u l=0.1u ad=0.0696p as=0.0696p pd=1.16u ps=1.16u
    I_MXI2_I34_MN1 (XI2_I34_Bn B_5 VSS VSS) gpdk090_nmos1v w=0.12u l=0.1u ad=0.0696p as=0.0696p pd=1.16u ps=1.16u
    I_MXI2_I34_MN5 (XI2_I34_n2 XI2_I34_Bn VSS VSS) gpdk090_nmos1v w=0.24u l=0.1u ad=0.0528p as=0.0816p pd=0.68u ps=1.16u
    I_MXI2_I34_MN4 (XOR_5 XI2_I34_An XI2_I34_n2 VSS) gpdk090_nmos1v w=0.24u l=0.1u ad=0.0528p as=0.0528p pd=0.68u ps=0.68u
    I_MXI2_I34_MN2 (XI2_I34_n1 A_5 XOR_5 VSS) gpdk090_nmos1v w=0.24u l=0.1u ad=0.0528p as=0.0528p pd=0.68u ps=0.68u
    I_MXI2_I34_MN3 (VSS B_5 XI2_I34_n1 VSS) gpdk090_nmos1v w=0.24u l=0.1u ad=0.0816p as=0.0528p pd=1.16u ps=0.68u
    I_MXI2_I34_MN0 (XI2_I34_An A_5 VSS VSS) gpdk090_nmos1v w=0.12u l=0.1u ad=0.0696p as=0.0696p pd=1.16u ps=1.16u
    I_MXI2_I16_MN1 (XI2_I16_Bn B_2 VSS VSS) gpdk090_nmos1v w=0.12u l=0.1u ad=0.0696p as=0.0696p pd=1.16u ps=1.16u
    I_MXI2_I16_MN5 (XI2_I16_n2 XI2_I16_Bn VSS VSS) gpdk090_nmos1v w=0.24u l=0.1u ad=0.0528p as=0.0816p pd=0.68u ps=1.16u
    I_MXI2_I16_MN4 (XOR_2 XI2_I16_An XI2_I16_n2 VSS) gpdk090_nmos1v w=0.24u l=0.1u ad=0.0528p as=0.0528p pd=0.68u ps=0.68u
    I_MXI2_I16_MN2 (XI2_I16_n1 A_2 XOR_2 VSS) gpdk090_nmos1v w=0.24u l=0.1u ad=0.0528p as=0.0528p pd=0.68u ps=0.68u
    I_MXI2_I16_MN3 (VSS B_2 XI2_I16_n1 VSS) gpdk090_nmos1v w=0.24u l=0.1u ad=0.0816p as=0.0528p pd=1.16u ps=0.68u
    I_MXI2_I16_MN0 (XI2_I16_An A_2 VSS VSS) gpdk090_nmos1v w=0.12u l=0.1u ad=0.0696p as=0.0696p pd=1.16u ps=1.16u
    I_MXI1_I18_MN1 (XI1_I18_Bn I1_SUB_b3_1 VSS VSS) gpdk090_nmos1v w=0.12u l=0.1u ad=0.0696p as=0.0696p pd=1.16u ps=1.16u
    I_MXI1_I18_MN5 (XI1_I18_n2 XI1_I18_Bn VSS VSS) gpdk090_nmos1v w=0.24u l=0.1u ad=0.0528p as=0.0816p pd=0.68u ps=1.16u
    I_MXI1_I18_MN4 (I1_bx8 XI1_I18_An XI1_I18_n2 VSS) gpdk090_nmos1v w=0.24u l=0.1u ad=0.0528p as=0.0528p pd=0.68u ps=0.68u
    I_MXI1_I18_MN2 (XI1_I18_n1 B_8 I1_bx8 VSS) gpdk090_nmos1v w=0.24u l=0.1u ad=0.0528p as=0.0528p pd=0.68u ps=0.68u
    I_MXI1_I18_MN3 (VSS I1_SUB_b3_1 XI1_I18_n1 VSS) gpdk090_nmos1v w=0.24u l=0.1u ad=0.0816p as=0.0528p pd=1.16u ps=0.68u
    I_MXI1_I18_MN0 (XI1_I18_An B_8 VSS VSS) gpdk090_nmos1v w=0.12u l=0.1u ad=0.0696p as=0.0696p pd=1.16u ps=1.16u
    I_MXI1_I19_MN1 (XI1_I19_Bn I1_SUB_b3_1 VSS VSS) gpdk090_nmos1v w=0.12u l=0.1u ad=0.0696p as=0.0696p pd=1.16u ps=1.16u
    I_MXI1_I19_MN5 (XI1_I19_n2 XI1_I19_Bn VSS VSS) gpdk090_nmos1v w=0.24u l=0.1u ad=0.0528p as=0.0816p pd=0.68u ps=1.16u
    I_MXI1_I19_MN4 (I1_bx9 XI1_I19_An XI1_I19_n2 VSS) gpdk090_nmos1v w=0.24u l=0.1u ad=0.0528p as=0.0528p pd=0.68u ps=0.68u
    I_MXI1_I19_MN2 (XI1_I19_n1 B_9 I1_bx9 VSS) gpdk090_nmos1v w=0.24u l=0.1u ad=0.0528p as=0.0528p pd=0.68u ps=0.68u
    I_MXI1_I19_MN3 (VSS I1_SUB_b3_1 XI1_I19_n1 VSS) gpdk090_nmos1v w=0.24u l=0.1u ad=0.0816p as=0.0528p pd=1.16u ps=0.68u
    I_MXI1_I19_MN0 (XI1_I19_An B_9 VSS VSS) gpdk090_nmos1v w=0.12u l=0.1u ad=0.0696p as=0.0696p pd=1.16u ps=1.16u
    I_MXI1_I17_MN1 (XI1_I17_Bn I1_SUB_b3_1 VSS VSS) gpdk090_nmos1v w=0.12u l=0.1u ad=0.0696p as=0.0696p pd=1.16u ps=1.16u
    I_MXI1_I17_MN5 (XI1_I17_n2 XI1_I17_Bn VSS VSS) gpdk090_nmos1v w=0.24u l=0.1u ad=0.0528p as=0.0816p pd=0.68u ps=1.16u
    I_MXI1_I17_MN4 (I1_bx7 XI1_I17_An XI1_I17_n2 VSS) gpdk090_nmos1v w=0.24u l=0.1u ad=0.0528p as=0.0528p pd=0.68u ps=0.68u
    I_MXI1_I17_MN2 (XI1_I17_n1 B_7 I1_bx7 VSS) gpdk090_nmos1v w=0.24u l=0.1u ad=0.0528p as=0.0528p pd=0.68u ps=0.68u
    I_MXI1_I17_MN3 (VSS I1_SUB_b3_1 XI1_I17_n1 VSS) gpdk090_nmos1v w=0.24u l=0.1u ad=0.0816p as=0.0528p pd=1.16u ps=0.68u
    I_MXI1_I17_MN0 (XI1_I17_An B_7 VSS VSS) gpdk090_nmos1v w=0.12u l=0.1u ad=0.0696p as=0.0696p pd=1.16u ps=1.16u
    I_MXI1_I16_MN1 (XI1_I16_Bn I1_SUB_b3_1 VSS VSS) gpdk090_nmos1v w=0.12u l=0.1u ad=0.0696p as=0.0696p pd=1.16u ps=1.16u
    I_MXI1_I16_MN5 (XI1_I16_n2 XI1_I16_Bn VSS VSS) gpdk090_nmos1v w=0.24u l=0.1u ad=0.0528p as=0.0816p pd=0.68u ps=1.16u
    I_MXI1_I16_MN4 (I1_bx6 XI1_I16_An XI1_I16_n2 VSS) gpdk090_nmos1v w=0.24u l=0.1u ad=0.0528p as=0.0528p pd=0.68u ps=0.68u
    I_MXI1_I16_MN2 (XI1_I16_n1 B_6 I1_bx6 VSS) gpdk090_nmos1v w=0.24u l=0.1u ad=0.0528p as=0.0528p pd=0.68u ps=0.68u
    I_MXI1_I16_MN3 (VSS I1_SUB_b3_1 XI1_I16_n1 VSS) gpdk090_nmos1v w=0.24u l=0.1u ad=0.0816p as=0.0528p pd=1.16u ps=0.68u
    I_MXI1_I16_MN0 (XI1_I16_An B_6 VSS VSS) gpdk090_nmos1v w=0.12u l=0.1u ad=0.0696p as=0.0696p pd=1.16u ps=1.16u
    I_MXI1_I15_MN1 (XI1_I15_Bn I1_SUB_b3_0 VSS VSS) gpdk090_nmos1v w=0.12u l=0.1u ad=0.0696p as=0.0696p pd=1.16u ps=1.16u
    I_MXI1_I15_MN5 (XI1_I15_n2 XI1_I15_Bn VSS VSS) gpdk090_nmos1v w=0.24u l=0.1u ad=0.0528p as=0.0816p pd=0.68u ps=1.16u
    I_MXI1_I15_MN4 (I1_bx5 XI1_I15_An XI1_I15_n2 VSS) gpdk090_nmos1v w=0.24u l=0.1u ad=0.0528p as=0.0528p pd=0.68u ps=0.68u
    I_MXI1_I15_MN2 (XI1_I15_n1 B_5 I1_bx5 VSS) gpdk090_nmos1v w=0.24u l=0.1u ad=0.0528p as=0.0528p pd=0.68u ps=0.68u
    I_MXI1_I15_MN3 (VSS I1_SUB_b3_0 XI1_I15_n1 VSS) gpdk090_nmos1v w=0.24u l=0.1u ad=0.0816p as=0.0528p pd=1.16u ps=0.68u
    I_MXI1_I15_MN0 (XI1_I15_An B_5 VSS VSS) gpdk090_nmos1v w=0.12u l=0.1u ad=0.0696p as=0.0696p pd=1.16u ps=1.16u
    I_MXI1_I20_MN1 (XI1_I20_Bn I1_SUB_b3_1 VSS VSS) gpdk090_nmos1v w=0.12u l=0.1u ad=0.0696p as=0.0696p pd=1.16u ps=1.16u
    I_MXI1_I20_MN5 (XI1_I20_n2 XI1_I20_Bn VSS VSS) gpdk090_nmos1v w=0.24u l=0.1u ad=0.0528p as=0.0816p pd=0.68u ps=1.16u
    I_MXI1_I20_MN4 (I1_bx10 XI1_I20_An XI1_I20_n2 VSS) gpdk090_nmos1v w=0.24u l=0.1u ad=0.0528p as=0.0528p pd=0.68u ps=0.68u
    I_MXI1_I20_MN2 (XI1_I20_n1 B_10 I1_bx10 VSS) gpdk090_nmos1v w=0.24u l=0.1u ad=0.0528p as=0.0528p pd=0.68u ps=0.68u
    I_MXI1_I20_MN3 (VSS I1_SUB_b3_1 XI1_I20_n1 VSS) gpdk090_nmos1v w=0.24u l=0.1u ad=0.0816p as=0.0528p pd=1.16u ps=0.68u
    I_MXI1_I20_MN0 (XI1_I20_An B_10 VSS VSS) gpdk090_nmos1v w=0.12u l=0.1u ad=0.0696p as=0.0696p pd=1.16u ps=1.16u
    I_MXI1_I42_I212_MN1 (XI1_I42_I212_Bn I1_I42_G8_0n VSS VSS) gpdk090_nmos1v w=0.12u l=0.1u ad=0.0696p as=0.0696p pd=1.16u ps=1.16u
    I_MXI1_I42_I212_MN5 (XI1_I42_I212_n2 XI1_I42_I212_Bn VSS VSS) gpdk090_nmos1v w=0.24u l=0.1u ad=0.0528p as=0.0816p pd=0.68u ps=1.16u
    I_MXI1_I42_I212_MN4 (S_9 XI1_I42_I212_An XI1_I42_I212_n2 VSS) gpdk090_nmos1v w=0.24u l=0.1u ad=0.0528p as=0.0528p pd=0.68u ps=0.68u
    I_MXI1_I42_I212_MN2 (XI1_I42_I212_n1 I1_I42_pn9 S_9 VSS) gpdk090_nmos1v w=0.24u l=0.1u ad=0.0528p as=0.0528p pd=0.68u ps=0.68u
    I_MXI1_I42_I212_MN3 (VSS I1_I42_G8_0n XI1_I42_I212_n1 VSS) gpdk090_nmos1v w=0.24u l=0.1u ad=0.0816p as=0.0528p pd=1.16u ps=0.68u
    I_MXI1_I42_I212_MN0 (XI1_I42_I212_An I1_I42_pn9 VSS VSS) gpdk090_nmos1v w=0.12u l=0.1u ad=0.0696p as=0.0696p pd=1.16u ps=1.16u
    I_MXI1_I42_I207_MN1 (XI1_I42_I207_Bn I1_I42_G3_0n VSS VSS) gpdk090_nmos1v w=0.12u l=0.1u ad=0.0696p as=0.0696p pd=1.16u ps=1.16u
    I_MXI1_I42_I207_MN5 (XI1_I42_I207_n2 XI1_I42_I207_Bn VSS VSS) gpdk090_nmos1v w=0.24u l=0.1u ad=0.0528p as=0.0816p pd=0.68u ps=1.16u
    I_MXI1_I42_I207_MN4 (S_4 XI1_I42_I207_An XI1_I42_I207_n2 VSS) gpdk090_nmos1v w=0.24u l=0.1u ad=0.0528p as=0.0528p pd=0.68u ps=0.68u
    I_MXI1_I42_I207_MN2 (XI1_I42_I207_n1 I1_I42_pn4 S_4 VSS) gpdk090_nmos1v w=0.24u l=0.1u ad=0.0528p as=0.0528p pd=0.68u ps=0.68u
    I_MXI1_I42_I207_MN3 (VSS I1_I42_G3_0n XI1_I42_I207_n1 VSS) gpdk090_nmos1v w=0.24u l=0.1u ad=0.0816p as=0.0528p pd=1.16u ps=0.68u
    I_MXI1_I42_I207_MN0 (XI1_I42_I207_An I1_I42_pn4 VSS VSS) gpdk090_nmos1v w=0.12u l=0.1u ad=0.0696p as=0.0696p pd=1.16u ps=1.16u
    I_MXI1_I12_MN1 (XI1_I12_Bn I1_SUB_b3_0 VSS VSS) gpdk090_nmos1v w=0.12u l=0.1u ad=0.0696p as=0.0696p pd=1.16u ps=1.16u
    I_MXI1_I12_MN5 (XI1_I12_n2 XI1_I12_Bn VSS VSS) gpdk090_nmos1v w=0.24u l=0.1u ad=0.0528p as=0.0816p pd=0.68u ps=1.16u
    I_MXI1_I12_MN4 (I1_bx2 XI1_I12_An XI1_I12_n2 VSS) gpdk090_nmos1v w=0.24u l=0.1u ad=0.0528p as=0.0528p pd=0.68u ps=0.68u
    I_MXI1_I12_MN2 (XI1_I12_n1 B_2 I1_bx2 VSS) gpdk090_nmos1v w=0.24u l=0.1u ad=0.0528p as=0.0528p pd=0.68u ps=0.68u
    I_MXI1_I12_MN3 (VSS I1_SUB_b3_0 XI1_I12_n1 VSS) gpdk090_nmos1v w=0.24u l=0.1u ad=0.0816p as=0.0528p pd=1.16u ps=0.68u
    I_MXI1_I12_MN0 (XI1_I12_An B_2 VSS VSS) gpdk090_nmos1v w=0.12u l=0.1u ad=0.0696p as=0.0696p pd=1.16u ps=1.16u
    I_MXI2_I22_MN1 (XI2_I22_Bn B_3 VSS VSS) gpdk090_nmos1v w=0.12u l=0.1u ad=0.0696p as=0.0696p pd=1.16u ps=1.16u
    I_MXI2_I22_MN5 (XI2_I22_n2 XI2_I22_Bn VSS VSS) gpdk090_nmos1v w=0.24u l=0.1u ad=0.0528p as=0.0816p pd=0.68u ps=1.16u
    I_MXI2_I22_MN4 (XOR_3 XI2_I22_An XI2_I22_n2 VSS) gpdk090_nmos1v w=0.24u l=0.1u ad=0.0528p as=0.0528p pd=0.68u ps=0.68u
    I_MXI2_I22_MN2 (XI2_I22_n1 A_3 XOR_3 VSS) gpdk090_nmos1v w=0.24u l=0.1u ad=0.0528p as=0.0528p pd=0.68u ps=0.68u
    I_MXI2_I22_MN3 (VSS B_3 XI2_I22_n1 VSS) gpdk090_nmos1v w=0.24u l=0.1u ad=0.0816p as=0.0528p pd=1.16u ps=0.68u
    I_MXI2_I22_MN0 (XI2_I22_An A_3 VSS VSS) gpdk090_nmos1v w=0.12u l=0.1u ad=0.0696p as=0.0696p pd=1.16u ps=1.16u
    I_MXI1_I42_I213_MN1 (XI1_I42_I213_Bn I1_I42_G9_0n VSS VSS) gpdk090_nmos1v w=0.12u l=0.1u ad=0.0696p as=0.0696p pd=1.16u ps=1.16u
    I_MXI1_I42_I213_MN5 (XI1_I42_I213_n2 XI1_I42_I213_Bn VSS VSS) gpdk090_nmos1v w=0.24u l=0.1u ad=0.0528p as=0.0816p pd=0.68u ps=1.16u
    I_MXI1_I42_I213_MN4 (S_10 XI1_I42_I213_An XI1_I42_I213_n2 VSS) gpdk090_nmos1v w=0.24u l=0.1u ad=0.0528p as=0.0528p pd=0.68u ps=0.68u
    I_MXI1_I42_I213_MN2 (XI1_I42_I213_n1 I1_I42_pn10 S_10 VSS) gpdk090_nmos1v w=0.24u l=0.1u ad=0.0528p as=0.0528p pd=0.68u ps=0.68u
    I_MXI1_I42_I213_MN3 (VSS I1_I42_G9_0n XI1_I42_I213_n1 VSS) gpdk090_nmos1v w=0.24u l=0.1u ad=0.0816p as=0.0528p pd=1.16u ps=0.68u
    I_MXI1_I42_I213_MN0 (XI1_I42_I213_An I1_I42_pn10 VSS VSS) gpdk090_nmos1v w=0.12u l=0.1u ad=0.0696p as=0.0696p pd=1.16u ps=1.16u
    I_MXI1_I42_I206_MN1 (XI1_I42_I206_Bn I1_I42_G2_0n VSS VSS) gpdk090_nmos1v w=0.12u l=0.1u ad=0.0696p as=0.0696p pd=1.16u ps=1.16u
    I_MXI1_I42_I206_MN5 (XI1_I42_I206_n2 XI1_I42_I206_Bn VSS VSS) gpdk090_nmos1v w=0.24u l=0.1u ad=0.0528p as=0.0816p pd=0.68u ps=1.16u
    I_MXI1_I42_I206_MN4 (S_3 XI1_I42_I206_An XI1_I42_I206_n2 VSS) gpdk090_nmos1v w=0.24u l=0.1u ad=0.0528p as=0.0528p pd=0.68u ps=0.68u
    I_MXI1_I42_I206_MN2 (XI1_I42_I206_n1 I1_I42_pn3 S_3 VSS) gpdk090_nmos1v w=0.24u l=0.1u ad=0.0528p as=0.0528p pd=0.68u ps=0.68u
    I_MXI1_I42_I206_MN3 (VSS I1_I42_G2_0n XI1_I42_I206_n1 VSS) gpdk090_nmos1v w=0.24u l=0.1u ad=0.0816p as=0.0528p pd=1.16u ps=0.68u
    I_MXI1_I42_I206_MN0 (XI1_I42_I206_An I1_I42_pn3 VSS VSS) gpdk090_nmos1v w=0.12u l=0.1u ad=0.0696p as=0.0696p pd=1.16u ps=1.16u
    I_MXI1_I13_MN1 (XI1_I13_Bn I1_SUB_b3_0 VSS VSS) gpdk090_nmos1v w=0.12u l=0.1u ad=0.0696p as=0.0696p pd=1.16u ps=1.16u
    I_MXI1_I13_MN5 (XI1_I13_n2 XI1_I13_Bn VSS VSS) gpdk090_nmos1v w=0.24u l=0.1u ad=0.0528p as=0.0816p pd=0.68u ps=1.16u
    I_MXI1_I13_MN4 (I1_bx3 XI1_I13_An XI1_I13_n2 VSS) gpdk090_nmos1v w=0.24u l=0.1u ad=0.0528p as=0.0528p pd=0.68u ps=0.68u
    I_MXI1_I13_MN2 (XI1_I13_n1 B_3 I1_bx3 VSS) gpdk090_nmos1v w=0.24u l=0.1u ad=0.0528p as=0.0528p pd=0.68u ps=0.68u
    I_MXI1_I13_MN3 (VSS I1_SUB_b3_0 XI1_I13_n1 VSS) gpdk090_nmos1v w=0.24u l=0.1u ad=0.0816p as=0.0528p pd=1.16u ps=0.68u
    I_MXI1_I13_MN0 (XI1_I13_An B_3 VSS VSS) gpdk090_nmos1v w=0.12u l=0.1u ad=0.0696p as=0.0696p pd=1.16u ps=1.16u
    I_MXI2_I184_MN1 (XI2_I184_Bn B_30 VSS VSS) gpdk090_nmos1v w=0.12u l=0.1u ad=0.0696p as=0.0696p pd=1.16u ps=1.16u
    I_MXI2_I184_MN5 (XI2_I184_n2 XI2_I184_Bn VSS VSS) gpdk090_nmos1v w=0.24u l=0.1u ad=0.0528p as=0.0816p pd=0.68u ps=1.16u
    I_MXI2_I184_MN4 (XOR_30 XI2_I184_An XI2_I184_n2 VSS) gpdk090_nmos1v w=0.24u l=0.1u ad=0.0528p as=0.0528p pd=0.68u ps=0.68u
    I_MXI2_I184_MN2 (XI2_I184_n1 A_30 XOR_30 VSS) gpdk090_nmos1v w=0.24u l=0.1u ad=0.0528p as=0.0528p pd=0.68u ps=0.68u
    I_MXI2_I184_MN3 (VSS B_30 XI2_I184_n1 VSS) gpdk090_nmos1v w=0.24u l=0.1u ad=0.0816p as=0.0528p pd=1.16u ps=0.68u
    I_MXI2_I184_MN0 (XI2_I184_An A_30 VSS VSS) gpdk090_nmos1v w=0.12u l=0.1u ad=0.0696p as=0.0696p pd=1.16u ps=1.16u
    I_MXI1_I40_MN1 (XI1_I40_Bn I1_SUB_b3_5 VSS VSS) gpdk090_nmos1v w=0.12u l=0.1u ad=0.0696p as=0.0696p pd=1.16u ps=1.16u
    I_MXI1_I40_MN5 (XI1_I40_n2 XI1_I40_Bn VSS VSS) gpdk090_nmos1v w=0.24u l=0.1u ad=0.0528p as=0.0816p pd=0.68u ps=1.16u
    I_MXI1_I40_MN4 (I1_bx30 XI1_I40_An XI1_I40_n2 VSS) gpdk090_nmos1v w=0.24u l=0.1u ad=0.0528p as=0.0528p pd=0.68u ps=0.68u
    I_MXI1_I40_MN2 (XI1_I40_n1 B_30 I1_bx30 VSS) gpdk090_nmos1v w=0.24u l=0.1u ad=0.0528p as=0.0528p pd=0.68u ps=0.68u
    I_MXI1_I40_MN3 (VSS I1_SUB_b3_5 XI1_I40_n1 VSS) gpdk090_nmos1v w=0.24u l=0.1u ad=0.0816p as=0.0528p pd=1.16u ps=0.68u
    I_MXI1_I40_MN0 (XI1_I40_An B_30 VSS VSS) gpdk090_nmos1v w=0.12u l=0.1u ad=0.0696p as=0.0696p pd=1.16u ps=1.16u
    I_MXI4_I66_MN1 (XI4_I66_Bn CO VSS VSS) gpdk090_nmos1v w=0.12u l=0.1u ad=0.0696p as=0.0696p pd=1.16u ps=1.16u
    I_MXI4_I66_MN5 (XI4_I66_n2 XI4_I66_Bn VSS VSS) gpdk090_nmos1v w=0.24u l=0.1u ad=0.0528p as=0.0816p pd=0.68u ps=1.16u
    I_MXI4_I66_MN4 (I4_ovf XI4_I66_An XI4_I66_n2 VSS) gpdk090_nmos1v w=0.24u l=0.1u ad=0.0528p as=0.0528p pd=0.68u ps=0.68u
    I_MXI4_I66_MN2 (XI4_I66_n1 CM I4_ovf VSS) gpdk090_nmos1v w=0.24u l=0.1u ad=0.0528p as=0.0528p pd=0.68u ps=0.68u
    I_MXI4_I66_MN3 (VSS CO XI4_I66_n1 VSS) gpdk090_nmos1v w=0.24u l=0.1u ad=0.0816p as=0.0528p pd=1.16u ps=0.68u
    I_MXI4_I66_MN0 (XI4_I66_An CM VSS VSS) gpdk090_nmos1v w=0.12u l=0.1u ad=0.0696p as=0.0696p pd=1.16u ps=1.16u
    I_MXI2_I70_MN1 (XI2_I70_Bn B_11 VSS VSS) gpdk090_nmos1v w=0.12u l=0.1u ad=0.0696p as=0.0696p pd=1.16u ps=1.16u
    I_MXI2_I70_MN5 (XI2_I70_n2 XI2_I70_Bn VSS VSS) gpdk090_nmos1v w=0.24u l=0.1u ad=0.0528p as=0.0816p pd=0.68u ps=1.16u
    I_MXI2_I70_MN4 (XOR_11 XI2_I70_An XI2_I70_n2 VSS) gpdk090_nmos1v w=0.24u l=0.1u ad=0.0528p as=0.0528p pd=0.68u ps=0.68u
    I_MXI2_I70_MN2 (XI2_I70_n1 A_11 XOR_11 VSS) gpdk090_nmos1v w=0.24u l=0.1u ad=0.0528p as=0.0528p pd=0.68u ps=0.68u
    I_MXI2_I70_MN3 (VSS B_11 XI2_I70_n1 VSS) gpdk090_nmos1v w=0.24u l=0.1u ad=0.0816p as=0.0528p pd=1.16u ps=0.68u
    I_MXI2_I70_MN0 (XI2_I70_An A_11 VSS VSS) gpdk090_nmos1v w=0.12u l=0.1u ad=0.0696p as=0.0696p pd=1.16u ps=1.16u
    I_MXI2_I190_MN1 (XI2_I190_Bn B_31 VSS VSS) gpdk090_nmos1v w=0.12u l=0.1u ad=0.0696p as=0.0696p pd=1.16u ps=1.16u
    I_MXI2_I190_MN5 (XI2_I190_n2 XI2_I190_Bn VSS VSS) gpdk090_nmos1v w=0.24u l=0.1u ad=0.0528p as=0.0816p pd=0.68u ps=1.16u
    I_MXI2_I190_MN4 (XOR_31 XI2_I190_An XI2_I190_n2 VSS) gpdk090_nmos1v w=0.24u l=0.1u ad=0.0528p as=0.0528p pd=0.68u ps=0.68u
    I_MXI2_I190_MN2 (XI2_I190_n1 A_31 XOR_31 VSS) gpdk090_nmos1v w=0.24u l=0.1u ad=0.0528p as=0.0528p pd=0.68u ps=0.68u
    I_MXI2_I190_MN3 (VSS B_31 XI2_I190_n1 VSS) gpdk090_nmos1v w=0.24u l=0.1u ad=0.0816p as=0.0528p pd=1.16u ps=0.68u
    I_MXI2_I190_MN0 (XI2_I190_An A_31 VSS VSS) gpdk090_nmos1v w=0.12u l=0.1u ad=0.0696p as=0.0696p pd=1.16u ps=1.16u
    I_MXI1_I42_I214_MN1 (XI1_I42_I214_Bn I1_I42_G10_0n VSS VSS) gpdk090_nmos1v w=0.12u l=0.1u ad=0.0696p as=0.0696p pd=1.16u ps=1.16u
    I_MXI1_I42_I214_MN5 (XI1_I42_I214_n2 XI1_I42_I214_Bn VSS VSS) gpdk090_nmos1v w=0.24u l=0.1u ad=0.0528p as=0.0816p pd=0.68u ps=1.16u
    I_MXI1_I42_I214_MN4 (S_11 XI1_I42_I214_An XI1_I42_I214_n2 VSS) gpdk090_nmos1v w=0.24u l=0.1u ad=0.0528p as=0.0528p pd=0.68u ps=0.68u
    I_MXI1_I42_I214_MN2 (XI1_I42_I214_n1 I1_I42_pn11 S_11 VSS) gpdk090_nmos1v w=0.24u l=0.1u ad=0.0528p as=0.0528p pd=0.68u ps=0.68u
    I_MXI1_I42_I214_MN3 (VSS I1_I42_G10_0n XI1_I42_I214_n1 VSS) gpdk090_nmos1v w=0.24u l=0.1u ad=0.0816p as=0.0528p pd=1.16u ps=0.68u
    I_MXI1_I42_I214_MN0 (XI1_I42_I214_An I1_I42_pn11 VSS VSS) gpdk090_nmos1v w=0.12u l=0.1u ad=0.0696p as=0.0696p pd=1.16u ps=1.16u
    I_MXI1_I21_MN1 (XI1_I21_Bn I1_SUB_b3_2 VSS VSS) gpdk090_nmos1v w=0.12u l=0.1u ad=0.0696p as=0.0696p pd=1.16u ps=1.16u
    I_MXI1_I21_MN5 (XI1_I21_n2 XI1_I21_Bn VSS VSS) gpdk090_nmos1v w=0.24u l=0.1u ad=0.0528p as=0.0816p pd=0.68u ps=1.16u
    I_MXI1_I21_MN4 (I1_bx11 XI1_I21_An XI1_I21_n2 VSS) gpdk090_nmos1v w=0.24u l=0.1u ad=0.0528p as=0.0528p pd=0.68u ps=0.68u
    I_MXI1_I21_MN2 (XI1_I21_n1 B_11 I1_bx11 VSS) gpdk090_nmos1v w=0.24u l=0.1u ad=0.0528p as=0.0528p pd=0.68u ps=0.68u
    I_MXI1_I21_MN3 (VSS I1_SUB_b3_2 XI1_I21_n1 VSS) gpdk090_nmos1v w=0.24u l=0.1u ad=0.0816p as=0.0528p pd=1.16u ps=0.68u
    I_MXI1_I21_MN0 (XI1_I21_An B_11 VSS VSS) gpdk090_nmos1v w=0.12u l=0.1u ad=0.0696p as=0.0696p pd=1.16u ps=1.16u
    I_MXI1_I22_MN1 (XI1_I22_Bn I1_SUB_b3_2 VSS VSS) gpdk090_nmos1v w=0.12u l=0.1u ad=0.0696p as=0.0696p pd=1.16u ps=1.16u
    I_MXI1_I22_MN5 (XI1_I22_n2 XI1_I22_Bn VSS VSS) gpdk090_nmos1v w=0.24u l=0.1u ad=0.0528p as=0.0816p pd=0.68u ps=1.16u
    I_MXI1_I22_MN4 (I1_bx12 XI1_I22_An XI1_I22_n2 VSS) gpdk090_nmos1v w=0.24u l=0.1u ad=0.0528p as=0.0528p pd=0.68u ps=0.68u
    I_MXI1_I22_MN2 (XI1_I22_n1 B_12 I1_bx12 VSS) gpdk090_nmos1v w=0.24u l=0.1u ad=0.0528p as=0.0528p pd=0.68u ps=0.68u
    I_MXI1_I22_MN3 (VSS I1_SUB_b3_2 XI1_I22_n1 VSS) gpdk090_nmos1v w=0.24u l=0.1u ad=0.0816p as=0.0528p pd=1.16u ps=0.68u
    I_MXI1_I22_MN0 (XI1_I22_An B_12 VSS VSS) gpdk090_nmos1v w=0.12u l=0.1u ad=0.0696p as=0.0696p pd=1.16u ps=1.16u
    I_MXI2_I76_MN1 (XI2_I76_Bn B_12 VSS VSS) gpdk090_nmos1v w=0.12u l=0.1u ad=0.0696p as=0.0696p pd=1.16u ps=1.16u
    I_MXI2_I76_MN5 (XI2_I76_n2 XI2_I76_Bn VSS VSS) gpdk090_nmos1v w=0.24u l=0.1u ad=0.0528p as=0.0816p pd=0.68u ps=1.16u
    I_MXI2_I76_MN4 (XOR_12 XI2_I76_An XI2_I76_n2 VSS) gpdk090_nmos1v w=0.24u l=0.1u ad=0.0528p as=0.0528p pd=0.68u ps=0.68u
    I_MXI2_I76_MN2 (XI2_I76_n1 A_12 XOR_12 VSS) gpdk090_nmos1v w=0.24u l=0.1u ad=0.0528p as=0.0528p pd=0.68u ps=0.68u
    I_MXI2_I76_MN3 (VSS B_12 XI2_I76_n1 VSS) gpdk090_nmos1v w=0.24u l=0.1u ad=0.0816p as=0.0528p pd=1.16u ps=0.68u
    I_MXI2_I76_MN0 (XI2_I76_An A_12 VSS VSS) gpdk090_nmos1v w=0.12u l=0.1u ad=0.0696p as=0.0696p pd=1.16u ps=1.16u
    I_MXI1_I41_MN1 (XI1_I41_Bn I1_SUB_b3_5 VSS VSS) gpdk090_nmos1v w=0.12u l=0.1u ad=0.0696p as=0.0696p pd=1.16u ps=1.16u
    I_MXI1_I41_MN5 (XI1_I41_n2 XI1_I41_Bn VSS VSS) gpdk090_nmos1v w=0.24u l=0.1u ad=0.0528p as=0.0816p pd=0.68u ps=1.16u
    I_MXI1_I41_MN4 (I1_bx31 XI1_I41_An XI1_I41_n2 VSS) gpdk090_nmos1v w=0.24u l=0.1u ad=0.0528p as=0.0528p pd=0.68u ps=0.68u
    I_MXI1_I41_MN2 (XI1_I41_n1 B_31 I1_bx31 VSS) gpdk090_nmos1v w=0.24u l=0.1u ad=0.0528p as=0.0528p pd=0.68u ps=0.68u
    I_MXI1_I41_MN3 (VSS I1_SUB_b3_5 XI1_I41_n1 VSS) gpdk090_nmos1v w=0.24u l=0.1u ad=0.0816p as=0.0528p pd=1.16u ps=0.68u
    I_MXI1_I41_MN0 (XI1_I41_An B_31 VSS VSS) gpdk090_nmos1v w=0.12u l=0.1u ad=0.0696p as=0.0696p pd=1.16u ps=1.16u
    I_MXI1_I42_I215_MN1 (XI1_I42_I215_Bn I1_I42_G11_0n VSS VSS) gpdk090_nmos1v w=0.12u l=0.1u ad=0.0696p as=0.0696p pd=1.16u ps=1.16u
    I_MXI1_I42_I215_MN5 (XI1_I42_I215_n2 XI1_I42_I215_Bn VSS VSS) gpdk090_nmos1v w=0.24u l=0.1u ad=0.0528p as=0.0816p pd=0.68u ps=1.16u
    I_MXI1_I42_I215_MN4 (S_12 XI1_I42_I215_An XI1_I42_I215_n2 VSS) gpdk090_nmos1v w=0.24u l=0.1u ad=0.0528p as=0.0528p pd=0.68u ps=0.68u
    I_MXI1_I42_I215_MN2 (XI1_I42_I215_n1 I1_I42_pn12 S_12 VSS) gpdk090_nmos1v w=0.24u l=0.1u ad=0.0528p as=0.0528p pd=0.68u ps=0.68u
    I_MXI1_I42_I215_MN3 (VSS I1_I42_G11_0n XI1_I42_I215_n1 VSS) gpdk090_nmos1v w=0.24u l=0.1u ad=0.0816p as=0.0528p pd=1.16u ps=0.68u
    I_MXI1_I42_I215_MN0 (XI1_I42_I215_An I1_I42_pn12 VSS VSS) gpdk090_nmos1v w=0.12u l=0.1u ad=0.0696p as=0.0696p pd=1.16u ps=1.16u
    I_MXI1_I23_MN1 (XI1_I23_Bn I1_SUB_b3_2 VSS VSS) gpdk090_nmos1v w=0.12u l=0.1u ad=0.0696p as=0.0696p pd=1.16u ps=1.16u
    I_MXI1_I23_MN5 (XI1_I23_n2 XI1_I23_Bn VSS VSS) gpdk090_nmos1v w=0.24u l=0.1u ad=0.0528p as=0.0816p pd=0.68u ps=1.16u
    I_MXI1_I23_MN4 (I1_bx13 XI1_I23_An XI1_I23_n2 VSS) gpdk090_nmos1v w=0.24u l=0.1u ad=0.0528p as=0.0528p pd=0.68u ps=0.68u
    I_MXI1_I23_MN2 (XI1_I23_n1 B_13 I1_bx13 VSS) gpdk090_nmos1v w=0.24u l=0.1u ad=0.0528p as=0.0528p pd=0.68u ps=0.68u
    I_MXI1_I23_MN3 (VSS I1_SUB_b3_2 XI1_I23_n1 VSS) gpdk090_nmos1v w=0.24u l=0.1u ad=0.0816p as=0.0528p pd=1.16u ps=0.68u
    I_MXI1_I23_MN0 (XI1_I23_An B_13 VSS VSS) gpdk090_nmos1v w=0.12u l=0.1u ad=0.0696p as=0.0696p pd=1.16u ps=1.16u
    I_MXI2_I178_MN1 (XI2_I178_Bn B_29 VSS VSS) gpdk090_nmos1v w=0.12u l=0.1u ad=0.0696p as=0.0696p pd=1.16u ps=1.16u
    I_MXI2_I178_MN5 (XI2_I178_n2 XI2_I178_Bn VSS VSS) gpdk090_nmos1v w=0.24u l=0.1u ad=0.0528p as=0.0816p pd=0.68u ps=1.16u
    I_MXI2_I178_MN4 (XOR_29 XI2_I178_An XI2_I178_n2 VSS) gpdk090_nmos1v w=0.24u l=0.1u ad=0.0528p as=0.0528p pd=0.68u ps=0.68u
    I_MXI2_I178_MN2 (XI2_I178_n1 A_29 XOR_29 VSS) gpdk090_nmos1v w=0.24u l=0.1u ad=0.0528p as=0.0528p pd=0.68u ps=0.68u
    I_MXI2_I178_MN3 (VSS B_29 XI2_I178_n1 VSS) gpdk090_nmos1v w=0.24u l=0.1u ad=0.0816p as=0.0528p pd=1.16u ps=0.68u
    I_MXI2_I178_MN0 (XI2_I178_An A_29 VSS VSS) gpdk090_nmos1v w=0.12u l=0.1u ad=0.0696p as=0.0696p pd=1.16u ps=1.16u
    I_MXI1_I39_MN1 (XI1_I39_Bn I1_SUB_b3_5 VSS VSS) gpdk090_nmos1v w=0.12u l=0.1u ad=0.0696p as=0.0696p pd=1.16u ps=1.16u
    I_MXI1_I39_MN5 (XI1_I39_n2 XI1_I39_Bn VSS VSS) gpdk090_nmos1v w=0.24u l=0.1u ad=0.0528p as=0.0816p pd=0.68u ps=1.16u
    I_MXI1_I39_MN4 (I1_bx29 XI1_I39_An XI1_I39_n2 VSS) gpdk090_nmos1v w=0.24u l=0.1u ad=0.0528p as=0.0528p pd=0.68u ps=0.68u
    I_MXI1_I39_MN2 (XI1_I39_n1 B_29 I1_bx29 VSS) gpdk090_nmos1v w=0.24u l=0.1u ad=0.0528p as=0.0528p pd=0.68u ps=0.68u
    I_MXI1_I39_MN3 (VSS I1_SUB_b3_5 XI1_I39_n1 VSS) gpdk090_nmos1v w=0.24u l=0.1u ad=0.0816p as=0.0528p pd=1.16u ps=0.68u
    I_MXI1_I39_MN0 (XI1_I39_An B_29 VSS VSS) gpdk090_nmos1v w=0.12u l=0.1u ad=0.0696p as=0.0696p pd=1.16u ps=1.16u
    I_MXI1_I42_I216_MN1 (XI1_I42_I216_Bn I1_I42_G12_0n VSS VSS) gpdk090_nmos1v w=0.12u l=0.1u ad=0.0696p as=0.0696p pd=1.16u ps=1.16u
    I_MXI1_I42_I216_MN5 (XI1_I42_I216_n2 XI1_I42_I216_Bn VSS VSS) gpdk090_nmos1v w=0.24u l=0.1u ad=0.0528p as=0.0816p pd=0.68u ps=1.16u
    I_MXI1_I42_I216_MN4 (S_13 XI1_I42_I216_An XI1_I42_I216_n2 VSS) gpdk090_nmos1v w=0.24u l=0.1u ad=0.0528p as=0.0528p pd=0.68u ps=0.68u
    I_MXI1_I42_I216_MN2 (XI1_I42_I216_n1 I1_I42_pn13 S_13 VSS) gpdk090_nmos1v w=0.24u l=0.1u ad=0.0528p as=0.0528p pd=0.68u ps=0.68u
    I_MXI1_I42_I216_MN3 (VSS I1_I42_G12_0n XI1_I42_I216_n1 VSS) gpdk090_nmos1v w=0.24u l=0.1u ad=0.0816p as=0.0528p pd=1.16u ps=0.68u
    I_MXI1_I42_I216_MN0 (XI1_I42_I216_An I1_I42_pn13 VSS VSS) gpdk090_nmos1v w=0.12u l=0.1u ad=0.0696p as=0.0696p pd=1.16u ps=1.16u
    I_MXI1_I42_I217_MN1 (XI1_I42_I217_Bn I1_I42_G13_0n VSS VSS) gpdk090_nmos1v w=0.12u l=0.1u ad=0.0696p as=0.0696p pd=1.16u ps=1.16u
    I_MXI1_I42_I217_MN5 (XI1_I42_I217_n2 XI1_I42_I217_Bn VSS VSS) gpdk090_nmos1v w=0.24u l=0.1u ad=0.0528p as=0.0816p pd=0.68u ps=1.16u
    I_MXI1_I42_I217_MN4 (S_14 XI1_I42_I217_An XI1_I42_I217_n2 VSS) gpdk090_nmos1v w=0.24u l=0.1u ad=0.0528p as=0.0528p pd=0.68u ps=0.68u
    I_MXI1_I42_I217_MN2 (XI1_I42_I217_n1 I1_I42_pn14 S_14 VSS) gpdk090_nmos1v w=0.24u l=0.1u ad=0.0528p as=0.0528p pd=0.68u ps=0.68u
    I_MXI1_I42_I217_MN3 (VSS I1_I42_G13_0n XI1_I42_I217_n1 VSS) gpdk090_nmos1v w=0.24u l=0.1u ad=0.0816p as=0.0528p pd=1.16u ps=0.68u
    I_MXI1_I42_I217_MN0 (XI1_I42_I217_An I1_I42_pn14 VSS VSS) gpdk090_nmos1v w=0.12u l=0.1u ad=0.0696p as=0.0696p pd=1.16u ps=1.16u
    I_MXI2_I82_MN1 (XI2_I82_Bn B_13 VSS VSS) gpdk090_nmos1v w=0.12u l=0.1u ad=0.0696p as=0.0696p pd=1.16u ps=1.16u
    I_MXI2_I82_MN5 (XI2_I82_n2 XI2_I82_Bn VSS VSS) gpdk090_nmos1v w=0.24u l=0.1u ad=0.0528p as=0.0816p pd=0.68u ps=1.16u
    I_MXI2_I82_MN4 (XOR_13 XI2_I82_An XI2_I82_n2 VSS) gpdk090_nmos1v w=0.24u l=0.1u ad=0.0528p as=0.0528p pd=0.68u ps=0.68u
    I_MXI2_I82_MN2 (XI2_I82_n1 A_13 XOR_13 VSS) gpdk090_nmos1v w=0.24u l=0.1u ad=0.0528p as=0.0528p pd=0.68u ps=0.68u
    I_MXI2_I82_MN3 (VSS B_13 XI2_I82_n1 VSS) gpdk090_nmos1v w=0.24u l=0.1u ad=0.0816p as=0.0528p pd=1.16u ps=0.68u
    I_MXI2_I82_MN0 (XI2_I82_An A_13 VSS VSS) gpdk090_nmos1v w=0.12u l=0.1u ad=0.0696p as=0.0696p pd=1.16u ps=1.16u
    I_MXI1_I38_MN1 (XI1_I38_Bn I1_SUB_b3_5 VSS VSS) gpdk090_nmos1v w=0.12u l=0.1u ad=0.0696p as=0.0696p pd=1.16u ps=1.16u
    I_MXI1_I38_MN5 (XI1_I38_n2 XI1_I38_Bn VSS VSS) gpdk090_nmos1v w=0.24u l=0.1u ad=0.0528p as=0.0816p pd=0.68u ps=1.16u
    I_MXI1_I38_MN4 (I1_bx28 XI1_I38_An XI1_I38_n2 VSS) gpdk090_nmos1v w=0.24u l=0.1u ad=0.0528p as=0.0528p pd=0.68u ps=0.68u
    I_MXI1_I38_MN2 (XI1_I38_n1 B_28 I1_bx28 VSS) gpdk090_nmos1v w=0.24u l=0.1u ad=0.0528p as=0.0528p pd=0.68u ps=0.68u
    I_MXI1_I38_MN3 (VSS I1_SUB_b3_5 XI1_I38_n1 VSS) gpdk090_nmos1v w=0.24u l=0.1u ad=0.0816p as=0.0528p pd=1.16u ps=0.68u
    I_MXI1_I38_MN0 (XI1_I38_An B_28 VSS VSS) gpdk090_nmos1v w=0.12u l=0.1u ad=0.0696p as=0.0696p pd=1.16u ps=1.16u
    I_MXI2_I88_MN1 (XI2_I88_Bn B_14 VSS VSS) gpdk090_nmos1v w=0.12u l=0.1u ad=0.0696p as=0.0696p pd=1.16u ps=1.16u
    I_MXI2_I88_MN5 (XI2_I88_n2 XI2_I88_Bn VSS VSS) gpdk090_nmos1v w=0.24u l=0.1u ad=0.0528p as=0.0816p pd=0.68u ps=1.16u
    I_MXI2_I88_MN4 (XOR_14 XI2_I88_An XI2_I88_n2 VSS) gpdk090_nmos1v w=0.24u l=0.1u ad=0.0528p as=0.0528p pd=0.68u ps=0.68u
    I_MXI2_I88_MN2 (XI2_I88_n1 A_14 XOR_14 VSS) gpdk090_nmos1v w=0.24u l=0.1u ad=0.0528p as=0.0528p pd=0.68u ps=0.68u
    I_MXI2_I88_MN3 (VSS B_14 XI2_I88_n1 VSS) gpdk090_nmos1v w=0.24u l=0.1u ad=0.0816p as=0.0528p pd=1.16u ps=0.68u
    I_MXI2_I88_MN0 (XI2_I88_An A_14 VSS VSS) gpdk090_nmos1v w=0.12u l=0.1u ad=0.0696p as=0.0696p pd=1.16u ps=1.16u
    I_MXI2_I172_MN1 (XI2_I172_Bn B_28 VSS VSS) gpdk090_nmos1v w=0.12u l=0.1u ad=0.0696p as=0.0696p pd=1.16u ps=1.16u
    I_MXI2_I172_MN5 (XI2_I172_n2 XI2_I172_Bn VSS VSS) gpdk090_nmos1v w=0.24u l=0.1u ad=0.0528p as=0.0816p pd=0.68u ps=1.16u
    I_MXI2_I172_MN4 (XOR_28 XI2_I172_An XI2_I172_n2 VSS) gpdk090_nmos1v w=0.24u l=0.1u ad=0.0528p as=0.0528p pd=0.68u ps=0.68u
    I_MXI2_I172_MN2 (XI2_I172_n1 A_28 XOR_28 VSS) gpdk090_nmos1v w=0.24u l=0.1u ad=0.0528p as=0.0528p pd=0.68u ps=0.68u
    I_MXI2_I172_MN3 (VSS B_28 XI2_I172_n1 VSS) gpdk090_nmos1v w=0.24u l=0.1u ad=0.0816p as=0.0528p pd=1.16u ps=0.68u
    I_MXI2_I172_MN0 (XI2_I172_An A_28 VSS VSS) gpdk090_nmos1v w=0.12u l=0.1u ad=0.0696p as=0.0696p pd=1.16u ps=1.16u
    I_MXI1_I42_I218_MN1 (XI1_I42_I218_Bn I1_I42_G14_0n VSS VSS) gpdk090_nmos1v w=0.12u l=0.1u ad=0.0696p as=0.0696p pd=1.16u ps=1.16u
    I_MXI1_I42_I218_MN5 (XI1_I42_I218_n2 XI1_I42_I218_Bn VSS VSS) gpdk090_nmos1v w=0.24u l=0.1u ad=0.0528p as=0.0816p pd=0.68u ps=1.16u
    I_MXI1_I42_I218_MN4 (S_15 XI1_I42_I218_An XI1_I42_I218_n2 VSS) gpdk090_nmos1v w=0.24u l=0.1u ad=0.0528p as=0.0528p pd=0.68u ps=0.68u
    I_MXI1_I42_I218_MN2 (XI1_I42_I218_n1 I1_I42_pn15 S_15 VSS) gpdk090_nmos1v w=0.24u l=0.1u ad=0.0528p as=0.0528p pd=0.68u ps=0.68u
    I_MXI1_I42_I218_MN3 (VSS I1_I42_G14_0n XI1_I42_I218_n1 VSS) gpdk090_nmos1v w=0.24u l=0.1u ad=0.0816p as=0.0528p pd=1.16u ps=0.68u
    I_MXI1_I42_I218_MN0 (XI1_I42_I218_An I1_I42_pn15 VSS VSS) gpdk090_nmos1v w=0.12u l=0.1u ad=0.0696p as=0.0696p pd=1.16u ps=1.16u
    I_MXI1_I24_MN1 (XI1_I24_Bn I1_SUB_b3_2 VSS VSS) gpdk090_nmos1v w=0.12u l=0.1u ad=0.0696p as=0.0696p pd=1.16u ps=1.16u
    I_MXI1_I24_MN5 (XI1_I24_n2 XI1_I24_Bn VSS VSS) gpdk090_nmos1v w=0.24u l=0.1u ad=0.0528p as=0.0816p pd=0.68u ps=1.16u
    I_MXI1_I24_MN4 (I1_bx14 XI1_I24_An XI1_I24_n2 VSS) gpdk090_nmos1v w=0.24u l=0.1u ad=0.0528p as=0.0528p pd=0.68u ps=0.68u
    I_MXI1_I24_MN2 (XI1_I24_n1 B_14 I1_bx14 VSS) gpdk090_nmos1v w=0.24u l=0.1u ad=0.0528p as=0.0528p pd=0.68u ps=0.68u
    I_MXI1_I24_MN3 (VSS I1_SUB_b3_2 XI1_I24_n1 VSS) gpdk090_nmos1v w=0.24u l=0.1u ad=0.0816p as=0.0528p pd=1.16u ps=0.68u
    I_MXI1_I24_MN0 (XI1_I24_An B_14 VSS VSS) gpdk090_nmos1v w=0.12u l=0.1u ad=0.0696p as=0.0696p pd=1.16u ps=1.16u
    I_MXI2_I166_MN1 (XI2_I166_Bn B_27 VSS VSS) gpdk090_nmos1v w=0.12u l=0.1u ad=0.0696p as=0.0696p pd=1.16u ps=1.16u
    I_MXI2_I166_MN5 (XI2_I166_n2 XI2_I166_Bn VSS VSS) gpdk090_nmos1v w=0.24u l=0.1u ad=0.0528p as=0.0816p pd=0.68u ps=1.16u
    I_MXI2_I166_MN4 (XOR_27 XI2_I166_An XI2_I166_n2 VSS) gpdk090_nmos1v w=0.24u l=0.1u ad=0.0528p as=0.0528p pd=0.68u ps=0.68u
    I_MXI2_I166_MN2 (XI2_I166_n1 A_27 XOR_27 VSS) gpdk090_nmos1v w=0.24u l=0.1u ad=0.0528p as=0.0528p pd=0.68u ps=0.68u
    I_MXI2_I166_MN3 (VSS B_27 XI2_I166_n1 VSS) gpdk090_nmos1v w=0.24u l=0.1u ad=0.0816p as=0.0528p pd=1.16u ps=0.68u
    I_MXI2_I166_MN0 (XI2_I166_An A_27 VSS VSS) gpdk090_nmos1v w=0.12u l=0.1u ad=0.0696p as=0.0696p pd=1.16u ps=1.16u
    I_MXI1_I25_MN1 (XI1_I25_Bn I1_SUB_b3_2 VSS VSS) gpdk090_nmos1v w=0.12u l=0.1u ad=0.0696p as=0.0696p pd=1.16u ps=1.16u
    I_MXI1_I25_MN5 (XI1_I25_n2 XI1_I25_Bn VSS VSS) gpdk090_nmos1v w=0.24u l=0.1u ad=0.0528p as=0.0816p pd=0.68u ps=1.16u
    I_MXI1_I25_MN4 (I1_bx15 XI1_I25_An XI1_I25_n2 VSS) gpdk090_nmos1v w=0.24u l=0.1u ad=0.0528p as=0.0528p pd=0.68u ps=0.68u
    I_MXI1_I25_MN2 (XI1_I25_n1 B_15 I1_bx15 VSS) gpdk090_nmos1v w=0.24u l=0.1u ad=0.0528p as=0.0528p pd=0.68u ps=0.68u
    I_MXI1_I25_MN3 (VSS I1_SUB_b3_2 XI1_I25_n1 VSS) gpdk090_nmos1v w=0.24u l=0.1u ad=0.0816p as=0.0528p pd=1.16u ps=0.68u
    I_MXI1_I25_MN0 (XI1_I25_An B_15 VSS VSS) gpdk090_nmos1v w=0.12u l=0.1u ad=0.0696p as=0.0696p pd=1.16u ps=1.16u
    I_MXI2_I94_MN1 (XI2_I94_Bn B_15 VSS VSS) gpdk090_nmos1v w=0.12u l=0.1u ad=0.0696p as=0.0696p pd=1.16u ps=1.16u
    I_MXI2_I94_MN5 (XI2_I94_n2 XI2_I94_Bn VSS VSS) gpdk090_nmos1v w=0.24u l=0.1u ad=0.0528p as=0.0816p pd=0.68u ps=1.16u
    I_MXI2_I94_MN4 (XOR_15 XI2_I94_An XI2_I94_n2 VSS) gpdk090_nmos1v w=0.24u l=0.1u ad=0.0528p as=0.0528p pd=0.68u ps=0.68u
    I_MXI2_I94_MN2 (XI2_I94_n1 A_15 XOR_15 VSS) gpdk090_nmos1v w=0.24u l=0.1u ad=0.0528p as=0.0528p pd=0.68u ps=0.68u
    I_MXI2_I94_MN3 (VSS B_15 XI2_I94_n1 VSS) gpdk090_nmos1v w=0.24u l=0.1u ad=0.0816p as=0.0528p pd=1.16u ps=0.68u
    I_MXI2_I94_MN0 (XI2_I94_An A_15 VSS VSS) gpdk090_nmos1v w=0.12u l=0.1u ad=0.0696p as=0.0696p pd=1.16u ps=1.16u
    I_MXI1_I37_MN1 (XI1_I37_Bn I1_SUB_b3_4 VSS VSS) gpdk090_nmos1v w=0.12u l=0.1u ad=0.0696p as=0.0696p pd=1.16u ps=1.16u
    I_MXI1_I37_MN5 (XI1_I37_n2 XI1_I37_Bn VSS VSS) gpdk090_nmos1v w=0.24u l=0.1u ad=0.0528p as=0.0816p pd=0.68u ps=1.16u
    I_MXI1_I37_MN4 (I1_bx27 XI1_I37_An XI1_I37_n2 VSS) gpdk090_nmos1v w=0.24u l=0.1u ad=0.0528p as=0.0528p pd=0.68u ps=0.68u
    I_MXI1_I37_MN2 (XI1_I37_n1 B_27 I1_bx27 VSS) gpdk090_nmos1v w=0.24u l=0.1u ad=0.0528p as=0.0528p pd=0.68u ps=0.68u
    I_MXI1_I37_MN3 (VSS I1_SUB_b3_4 XI1_I37_n1 VSS) gpdk090_nmos1v w=0.24u l=0.1u ad=0.0816p as=0.0528p pd=1.16u ps=0.68u
    I_MXI1_I37_MN0 (XI1_I37_An B_27 VSS VSS) gpdk090_nmos1v w=0.12u l=0.1u ad=0.0696p as=0.0696p pd=1.16u ps=1.16u
    I_MXI1_I42_I219_MN1 (XI1_I42_I219_Bn I1_I42_G15_0n VSS VSS) gpdk090_nmos1v w=0.12u l=0.1u ad=0.0696p as=0.0696p pd=1.16u ps=1.16u
    I_MXI1_I42_I219_MN5 (XI1_I42_I219_n2 XI1_I42_I219_Bn VSS VSS) gpdk090_nmos1v w=0.24u l=0.1u ad=0.0528p as=0.0816p pd=0.68u ps=1.16u
    I_MXI1_I42_I219_MN4 (S_16 XI1_I42_I219_An XI1_I42_I219_n2 VSS) gpdk090_nmos1v w=0.24u l=0.1u ad=0.0528p as=0.0528p pd=0.68u ps=0.68u
    I_MXI1_I42_I219_MN2 (XI1_I42_I219_n1 I1_I42_pn16 S_16 VSS) gpdk090_nmos1v w=0.24u l=0.1u ad=0.0528p as=0.0528p pd=0.68u ps=0.68u
    I_MXI1_I42_I219_MN3 (VSS I1_I42_G15_0n XI1_I42_I219_n1 VSS) gpdk090_nmos1v w=0.24u l=0.1u ad=0.0816p as=0.0528p pd=1.16u ps=0.68u
    I_MXI1_I42_I219_MN0 (XI1_I42_I219_An I1_I42_pn16 VSS VSS) gpdk090_nmos1v w=0.12u l=0.1u ad=0.0696p as=0.0696p pd=1.16u ps=1.16u
    I_MXI1_I26_MN1 (XI1_I26_Bn I1_SUB_b3_2 VSS VSS) gpdk090_nmos1v w=0.12u l=0.1u ad=0.0696p as=0.0696p pd=1.16u ps=1.16u
    I_MXI1_I26_MN5 (XI1_I26_n2 XI1_I26_Bn VSS VSS) gpdk090_nmos1v w=0.24u l=0.1u ad=0.0528p as=0.0816p pd=0.68u ps=1.16u
    I_MXI1_I26_MN4 (I1_bx16 XI1_I26_An XI1_I26_n2 VSS) gpdk090_nmos1v w=0.24u l=0.1u ad=0.0528p as=0.0528p pd=0.68u ps=0.68u
    I_MXI1_I26_MN2 (XI1_I26_n1 B_16 I1_bx16 VSS) gpdk090_nmos1v w=0.24u l=0.1u ad=0.0528p as=0.0528p pd=0.68u ps=0.68u
    I_MXI1_I26_MN3 (VSS I1_SUB_b3_2 XI1_I26_n1 VSS) gpdk090_nmos1v w=0.24u l=0.1u ad=0.0816p as=0.0528p pd=1.16u ps=0.68u
    I_MXI1_I26_MN0 (XI1_I26_An B_16 VSS VSS) gpdk090_nmos1v w=0.12u l=0.1u ad=0.0696p as=0.0696p pd=1.16u ps=1.16u
    I_MXI2_I160_MN1 (XI2_I160_Bn B_26 VSS VSS) gpdk090_nmos1v w=0.12u l=0.1u ad=0.0696p as=0.0696p pd=1.16u ps=1.16u
    I_MXI2_I160_MN5 (XI2_I160_n2 XI2_I160_Bn VSS VSS) gpdk090_nmos1v w=0.24u l=0.1u ad=0.0528p as=0.0816p pd=0.68u ps=1.16u
    I_MXI2_I160_MN4 (XOR_26 XI2_I160_An XI2_I160_n2 VSS) gpdk090_nmos1v w=0.24u l=0.1u ad=0.0528p as=0.0528p pd=0.68u ps=0.68u
    I_MXI2_I160_MN2 (XI2_I160_n1 A_26 XOR_26 VSS) gpdk090_nmos1v w=0.24u l=0.1u ad=0.0528p as=0.0528p pd=0.68u ps=0.68u
    I_MXI2_I160_MN3 (VSS B_26 XI2_I160_n1 VSS) gpdk090_nmos1v w=0.24u l=0.1u ad=0.0816p as=0.0528p pd=1.16u ps=0.68u
    I_MXI2_I160_MN0 (XI2_I160_An A_26 VSS VSS) gpdk090_nmos1v w=0.12u l=0.1u ad=0.0696p as=0.0696p pd=1.16u ps=1.16u
    I_MXI1_I35_MN1 (XI1_I35_Bn I1_SUB_b3_4 VSS VSS) gpdk090_nmos1v w=0.12u l=0.1u ad=0.0696p as=0.0696p pd=1.16u ps=1.16u
    I_MXI1_I35_MN5 (XI1_I35_n2 XI1_I35_Bn VSS VSS) gpdk090_nmos1v w=0.24u l=0.1u ad=0.0528p as=0.0816p pd=0.68u ps=1.16u
    I_MXI1_I35_MN4 (I1_bx25 XI1_I35_An XI1_I35_n2 VSS) gpdk090_nmos1v w=0.24u l=0.1u ad=0.0528p as=0.0528p pd=0.68u ps=0.68u
    I_MXI1_I35_MN2 (XI1_I35_n1 B_25 I1_bx25 VSS) gpdk090_nmos1v w=0.24u l=0.1u ad=0.0528p as=0.0528p pd=0.68u ps=0.68u
    I_MXI1_I35_MN3 (VSS I1_SUB_b3_4 XI1_I35_n1 VSS) gpdk090_nmos1v w=0.24u l=0.1u ad=0.0816p as=0.0528p pd=1.16u ps=0.68u
    I_MXI1_I35_MN0 (XI1_I35_An B_25 VSS VSS) gpdk090_nmos1v w=0.12u l=0.1u ad=0.0696p as=0.0696p pd=1.16u ps=1.16u
    I_MXI1_I36_MN1 (XI1_I36_Bn I1_SUB_b3_4 VSS VSS) gpdk090_nmos1v w=0.12u l=0.1u ad=0.0696p as=0.0696p pd=1.16u ps=1.16u
    I_MXI1_I36_MN5 (XI1_I36_n2 XI1_I36_Bn VSS VSS) gpdk090_nmos1v w=0.24u l=0.1u ad=0.0528p as=0.0816p pd=0.68u ps=1.16u
    I_MXI1_I36_MN4 (I1_bx26 XI1_I36_An XI1_I36_n2 VSS) gpdk090_nmos1v w=0.24u l=0.1u ad=0.0528p as=0.0528p pd=0.68u ps=0.68u
    I_MXI1_I36_MN2 (XI1_I36_n1 B_26 I1_bx26 VSS) gpdk090_nmos1v w=0.24u l=0.1u ad=0.0528p as=0.0528p pd=0.68u ps=0.68u
    I_MXI1_I36_MN3 (VSS I1_SUB_b3_4 XI1_I36_n1 VSS) gpdk090_nmos1v w=0.24u l=0.1u ad=0.0816p as=0.0528p pd=1.16u ps=0.68u
    I_MXI1_I36_MN0 (XI1_I36_An B_26 VSS VSS) gpdk090_nmos1v w=0.12u l=0.1u ad=0.0696p as=0.0696p pd=1.16u ps=1.16u
    I_MXI1_I34_MN1 (XI1_I34_Bn I1_SUB_b3_4 VSS VSS) gpdk090_nmos1v w=0.12u l=0.1u ad=0.0696p as=0.0696p pd=1.16u ps=1.16u
    I_MXI1_I34_MN5 (XI1_I34_n2 XI1_I34_Bn VSS VSS) gpdk090_nmos1v w=0.24u l=0.1u ad=0.0528p as=0.0816p pd=0.68u ps=1.16u
    I_MXI1_I34_MN4 (I1_bx24 XI1_I34_An XI1_I34_n2 VSS) gpdk090_nmos1v w=0.24u l=0.1u ad=0.0528p as=0.0528p pd=0.68u ps=0.68u
    I_MXI1_I34_MN2 (XI1_I34_n1 B_24 I1_bx24 VSS) gpdk090_nmos1v w=0.24u l=0.1u ad=0.0528p as=0.0528p pd=0.68u ps=0.68u
    I_MXI1_I34_MN3 (VSS I1_SUB_b3_4 XI1_I34_n1 VSS) gpdk090_nmos1v w=0.24u l=0.1u ad=0.0816p as=0.0528p pd=1.16u ps=0.68u
    I_MXI1_I34_MN0 (XI1_I34_An B_24 VSS VSS) gpdk090_nmos1v w=0.12u l=0.1u ad=0.0696p as=0.0696p pd=1.16u ps=1.16u
    I_MXI1_I33_MN1 (XI1_I33_Bn I1_SUB_b3_4 VSS VSS) gpdk090_nmos1v w=0.12u l=0.1u ad=0.0696p as=0.0696p pd=1.16u ps=1.16u
    I_MXI1_I33_MN5 (XI1_I33_n2 XI1_I33_Bn VSS VSS) gpdk090_nmos1v w=0.24u l=0.1u ad=0.0528p as=0.0816p pd=0.68u ps=1.16u
    I_MXI1_I33_MN4 (I1_bx23 XI1_I33_An XI1_I33_n2 VSS) gpdk090_nmos1v w=0.24u l=0.1u ad=0.0528p as=0.0528p pd=0.68u ps=0.68u
    I_MXI1_I33_MN2 (XI1_I33_n1 B_23 I1_bx23 VSS) gpdk090_nmos1v w=0.24u l=0.1u ad=0.0528p as=0.0528p pd=0.68u ps=0.68u
    I_MXI1_I33_MN3 (VSS I1_SUB_b3_4 XI1_I33_n1 VSS) gpdk090_nmos1v w=0.24u l=0.1u ad=0.0816p as=0.0528p pd=1.16u ps=0.68u
    I_MXI1_I33_MN0 (XI1_I33_An B_23 VSS VSS) gpdk090_nmos1v w=0.12u l=0.1u ad=0.0696p as=0.0696p pd=1.16u ps=1.16u
    I_MXI1_I32_MN1 (XI1_I32_Bn I1_SUB_b3_4 VSS VSS) gpdk090_nmos1v w=0.12u l=0.1u ad=0.0696p as=0.0696p pd=1.16u ps=1.16u
    I_MXI1_I32_MN5 (XI1_I32_n2 XI1_I32_Bn VSS VSS) gpdk090_nmos1v w=0.24u l=0.1u ad=0.0528p as=0.0816p pd=0.68u ps=1.16u
    I_MXI1_I32_MN4 (I1_bx22 XI1_I32_An XI1_I32_n2 VSS) gpdk090_nmos1v w=0.24u l=0.1u ad=0.0528p as=0.0528p pd=0.68u ps=0.68u
    I_MXI1_I32_MN2 (XI1_I32_n1 B_22 I1_bx22 VSS) gpdk090_nmos1v w=0.24u l=0.1u ad=0.0528p as=0.0528p pd=0.68u ps=0.68u
    I_MXI1_I32_MN3 (VSS I1_SUB_b3_4 XI1_I32_n1 VSS) gpdk090_nmos1v w=0.24u l=0.1u ad=0.0816p as=0.0528p pd=1.16u ps=0.68u
    I_MXI1_I32_MN0 (XI1_I32_An B_22 VSS VSS) gpdk090_nmos1v w=0.12u l=0.1u ad=0.0696p as=0.0696p pd=1.16u ps=1.16u
    I_MXI1_I31_MN1 (XI1_I31_Bn I1_SUB_b3_3 VSS VSS) gpdk090_nmos1v w=0.12u l=0.1u ad=0.0696p as=0.0696p pd=1.16u ps=1.16u
    I_MXI1_I31_MN5 (XI1_I31_n2 XI1_I31_Bn VSS VSS) gpdk090_nmos1v w=0.24u l=0.1u ad=0.0528p as=0.0816p pd=0.68u ps=1.16u
    I_MXI1_I31_MN4 (I1_bx21 XI1_I31_An XI1_I31_n2 VSS) gpdk090_nmos1v w=0.24u l=0.1u ad=0.0528p as=0.0528p pd=0.68u ps=0.68u
    I_MXI1_I31_MN2 (XI1_I31_n1 B_21 I1_bx21 VSS) gpdk090_nmos1v w=0.24u l=0.1u ad=0.0528p as=0.0528p pd=0.68u ps=0.68u
    I_MXI1_I31_MN3 (VSS I1_SUB_b3_3 XI1_I31_n1 VSS) gpdk090_nmos1v w=0.24u l=0.1u ad=0.0816p as=0.0528p pd=1.16u ps=0.68u
    I_MXI1_I31_MN0 (XI1_I31_An B_21 VSS VSS) gpdk090_nmos1v w=0.12u l=0.1u ad=0.0696p as=0.0696p pd=1.16u ps=1.16u
    I_MXI1_I30_MN1 (XI1_I30_Bn I1_SUB_b3_3 VSS VSS) gpdk090_nmos1v w=0.12u l=0.1u ad=0.0696p as=0.0696p pd=1.16u ps=1.16u
    I_MXI1_I30_MN5 (XI1_I30_n2 XI1_I30_Bn VSS VSS) gpdk090_nmos1v w=0.24u l=0.1u ad=0.0528p as=0.0816p pd=0.68u ps=1.16u
    I_MXI1_I30_MN4 (I1_bx20 XI1_I30_An XI1_I30_n2 VSS) gpdk090_nmos1v w=0.24u l=0.1u ad=0.0528p as=0.0528p pd=0.68u ps=0.68u
    I_MXI1_I30_MN2 (XI1_I30_n1 B_20 I1_bx20 VSS) gpdk090_nmos1v w=0.24u l=0.1u ad=0.0528p as=0.0528p pd=0.68u ps=0.68u
    I_MXI1_I30_MN3 (VSS I1_SUB_b3_3 XI1_I30_n1 VSS) gpdk090_nmos1v w=0.24u l=0.1u ad=0.0816p as=0.0528p pd=1.16u ps=0.68u
    I_MXI1_I30_MN0 (XI1_I30_An B_20 VSS VSS) gpdk090_nmos1v w=0.12u l=0.1u ad=0.0696p as=0.0696p pd=1.16u ps=1.16u
    I_MXI2_I124_MN1 (XI2_I124_Bn B_20 VSS VSS) gpdk090_nmos1v w=0.12u l=0.1u ad=0.0696p as=0.0696p pd=1.16u ps=1.16u
    I_MXI2_I124_MN5 (XI2_I124_n2 XI2_I124_Bn VSS VSS) gpdk090_nmos1v w=0.24u l=0.1u ad=0.0528p as=0.0816p pd=0.68u ps=1.16u
    I_MXI2_I124_MN4 (XOR_20 XI2_I124_An XI2_I124_n2 VSS) gpdk090_nmos1v w=0.24u l=0.1u ad=0.0528p as=0.0528p pd=0.68u ps=0.68u
    I_MXI2_I124_MN2 (XI2_I124_n1 A_20 XOR_20 VSS) gpdk090_nmos1v w=0.24u l=0.1u ad=0.0528p as=0.0528p pd=0.68u ps=0.68u
    I_MXI2_I124_MN3 (VSS B_20 XI2_I124_n1 VSS) gpdk090_nmos1v w=0.24u l=0.1u ad=0.0816p as=0.0528p pd=1.16u ps=0.68u
    I_MXI2_I124_MN0 (XI2_I124_An A_20 VSS VSS) gpdk090_nmos1v w=0.12u l=0.1u ad=0.0696p as=0.0696p pd=1.16u ps=1.16u
    I_MXI1_I29_MN1 (XI1_I29_Bn I1_SUB_b3_3 VSS VSS) gpdk090_nmos1v w=0.12u l=0.1u ad=0.0696p as=0.0696p pd=1.16u ps=1.16u
    I_MXI1_I29_MN5 (XI1_I29_n2 XI1_I29_Bn VSS VSS) gpdk090_nmos1v w=0.24u l=0.1u ad=0.0528p as=0.0816p pd=0.68u ps=1.16u
    I_MXI1_I29_MN4 (I1_bx19 XI1_I29_An XI1_I29_n2 VSS) gpdk090_nmos1v w=0.24u l=0.1u ad=0.0528p as=0.0528p pd=0.68u ps=0.68u
    I_MXI1_I29_MN2 (XI1_I29_n1 B_19 I1_bx19 VSS) gpdk090_nmos1v w=0.24u l=0.1u ad=0.0528p as=0.0528p pd=0.68u ps=0.68u
    I_MXI1_I29_MN3 (VSS I1_SUB_b3_3 XI1_I29_n1 VSS) gpdk090_nmos1v w=0.24u l=0.1u ad=0.0816p as=0.0528p pd=1.16u ps=0.68u
    I_MXI1_I29_MN0 (XI1_I29_An B_19 VSS VSS) gpdk090_nmos1v w=0.12u l=0.1u ad=0.0696p as=0.0696p pd=1.16u ps=1.16u
    I_MXI1_I28_MN1 (XI1_I28_Bn I1_SUB_b3_3 VSS VSS) gpdk090_nmos1v w=0.12u l=0.1u ad=0.0696p as=0.0696p pd=1.16u ps=1.16u
    I_MXI1_I28_MN5 (XI1_I28_n2 XI1_I28_Bn VSS VSS) gpdk090_nmos1v w=0.24u l=0.1u ad=0.0528p as=0.0816p pd=0.68u ps=1.16u
    I_MXI1_I28_MN4 (I1_bx18 XI1_I28_An XI1_I28_n2 VSS) gpdk090_nmos1v w=0.24u l=0.1u ad=0.0528p as=0.0528p pd=0.68u ps=0.68u
    I_MXI1_I28_MN2 (XI1_I28_n1 B_18 I1_bx18 VSS) gpdk090_nmos1v w=0.24u l=0.1u ad=0.0528p as=0.0528p pd=0.68u ps=0.68u
    I_MXI1_I28_MN3 (VSS I1_SUB_b3_3 XI1_I28_n1 VSS) gpdk090_nmos1v w=0.24u l=0.1u ad=0.0816p as=0.0528p pd=1.16u ps=0.68u
    I_MXI1_I28_MN0 (XI1_I28_An B_18 VSS VSS) gpdk090_nmos1v w=0.12u l=0.1u ad=0.0696p as=0.0696p pd=1.16u ps=1.16u
    I_MXI1_I27_MN1 (XI1_I27_Bn I1_SUB_b3_3 VSS VSS) gpdk090_nmos1v w=0.12u l=0.1u ad=0.0696p as=0.0696p pd=1.16u ps=1.16u
    I_MXI1_I27_MN5 (XI1_I27_n2 XI1_I27_Bn VSS VSS) gpdk090_nmos1v w=0.24u l=0.1u ad=0.0528p as=0.0816p pd=0.68u ps=1.16u
    I_MXI1_I27_MN4 (I1_bx17 XI1_I27_An XI1_I27_n2 VSS) gpdk090_nmos1v w=0.24u l=0.1u ad=0.0528p as=0.0528p pd=0.68u ps=0.68u
    I_MXI1_I27_MN2 (XI1_I27_n1 B_17 I1_bx17 VSS) gpdk090_nmos1v w=0.24u l=0.1u ad=0.0528p as=0.0528p pd=0.68u ps=0.68u
    I_MXI1_I27_MN3 (VSS I1_SUB_b3_3 XI1_I27_n1 VSS) gpdk090_nmos1v w=0.24u l=0.1u ad=0.0816p as=0.0528p pd=1.16u ps=0.68u
    I_MXI1_I27_MN0 (XI1_I27_An B_17 VSS VSS) gpdk090_nmos1v w=0.12u l=0.1u ad=0.0696p as=0.0696p pd=1.16u ps=1.16u
    I_MXI2_I100_MN1 (XI2_I100_Bn B_16 VSS VSS) gpdk090_nmos1v w=0.12u l=0.1u ad=0.0696p as=0.0696p pd=1.16u ps=1.16u
    I_MXI2_I100_MN5 (XI2_I100_n2 XI2_I100_Bn VSS VSS) gpdk090_nmos1v w=0.24u l=0.1u ad=0.0528p as=0.0816p pd=0.68u ps=1.16u
    I_MXI2_I100_MN4 (XOR_16 XI2_I100_An XI2_I100_n2 VSS) gpdk090_nmos1v w=0.24u l=0.1u ad=0.0528p as=0.0528p pd=0.68u ps=0.68u
    I_MXI2_I100_MN2 (XI2_I100_n1 A_16 XOR_16 VSS) gpdk090_nmos1v w=0.24u l=0.1u ad=0.0528p as=0.0528p pd=0.68u ps=0.68u
    I_MXI2_I100_MN3 (VSS B_16 XI2_I100_n1 VSS) gpdk090_nmos1v w=0.24u l=0.1u ad=0.0816p as=0.0528p pd=1.16u ps=0.68u
    I_MXI2_I100_MN0 (XI2_I100_An A_16 VSS VSS) gpdk090_nmos1v w=0.12u l=0.1u ad=0.0696p as=0.0696p pd=1.16u ps=1.16u
    I_MXI2_I148_MN1 (XI2_I148_Bn B_24 VSS VSS) gpdk090_nmos1v w=0.12u l=0.1u ad=0.0696p as=0.0696p pd=1.16u ps=1.16u
    I_MXI2_I148_MN5 (XI2_I148_n2 XI2_I148_Bn VSS VSS) gpdk090_nmos1v w=0.24u l=0.1u ad=0.0528p as=0.0816p pd=0.68u ps=1.16u
    I_MXI2_I148_MN4 (XOR_24 XI2_I148_An XI2_I148_n2 VSS) gpdk090_nmos1v w=0.24u l=0.1u ad=0.0528p as=0.0528p pd=0.68u ps=0.68u
    I_MXI2_I148_MN2 (XI2_I148_n1 A_24 XOR_24 VSS) gpdk090_nmos1v w=0.24u l=0.1u ad=0.0528p as=0.0528p pd=0.68u ps=0.68u
    I_MXI2_I148_MN3 (VSS B_24 XI2_I148_n1 VSS) gpdk090_nmos1v w=0.24u l=0.1u ad=0.0816p as=0.0528p pd=1.16u ps=0.68u
    I_MXI2_I148_MN0 (XI2_I148_An A_24 VSS VSS) gpdk090_nmos1v w=0.12u l=0.1u ad=0.0696p as=0.0696p pd=1.16u ps=1.16u
    I_MXI2_I142_MN1 (XI2_I142_Bn B_23 VSS VSS) gpdk090_nmos1v w=0.12u l=0.1u ad=0.0696p as=0.0696p pd=1.16u ps=1.16u
    I_MXI2_I142_MN5 (XI2_I142_n2 XI2_I142_Bn VSS VSS) gpdk090_nmos1v w=0.24u l=0.1u ad=0.0528p as=0.0816p pd=0.68u ps=1.16u
    I_MXI2_I142_MN4 (XOR_23 XI2_I142_An XI2_I142_n2 VSS) gpdk090_nmos1v w=0.24u l=0.1u ad=0.0528p as=0.0528p pd=0.68u ps=0.68u
    I_MXI2_I142_MN2 (XI2_I142_n1 A_23 XOR_23 VSS) gpdk090_nmos1v w=0.24u l=0.1u ad=0.0528p as=0.0528p pd=0.68u ps=0.68u
    I_MXI2_I142_MN3 (VSS B_23 XI2_I142_n1 VSS) gpdk090_nmos1v w=0.24u l=0.1u ad=0.0816p as=0.0528p pd=1.16u ps=0.68u
    I_MXI2_I142_MN0 (XI2_I142_An A_23 VSS VSS) gpdk090_nmos1v w=0.12u l=0.1u ad=0.0696p as=0.0696p pd=1.16u ps=1.16u
    I_MXI2_I136_MN1 (XI2_I136_Bn B_22 VSS VSS) gpdk090_nmos1v w=0.12u l=0.1u ad=0.0696p as=0.0696p pd=1.16u ps=1.16u
    I_MXI2_I136_MN5 (XI2_I136_n2 XI2_I136_Bn VSS VSS) gpdk090_nmos1v w=0.24u l=0.1u ad=0.0528p as=0.0816p pd=0.68u ps=1.16u
    I_MXI2_I136_MN4 (XOR_22 XI2_I136_An XI2_I136_n2 VSS) gpdk090_nmos1v w=0.24u l=0.1u ad=0.0528p as=0.0528p pd=0.68u ps=0.68u
    I_MXI2_I136_MN2 (XI2_I136_n1 A_22 XOR_22 VSS) gpdk090_nmos1v w=0.24u l=0.1u ad=0.0528p as=0.0528p pd=0.68u ps=0.68u
    I_MXI2_I136_MN3 (VSS B_22 XI2_I136_n1 VSS) gpdk090_nmos1v w=0.24u l=0.1u ad=0.0816p as=0.0528p pd=1.16u ps=0.68u
    I_MXI2_I136_MN0 (XI2_I136_An A_22 VSS VSS) gpdk090_nmos1v w=0.12u l=0.1u ad=0.0696p as=0.0696p pd=1.16u ps=1.16u
    I_MXI2_I112_MN1 (XI2_I112_Bn B_18 VSS VSS) gpdk090_nmos1v w=0.12u l=0.1u ad=0.0696p as=0.0696p pd=1.16u ps=1.16u
    I_MXI2_I112_MN5 (XI2_I112_n2 XI2_I112_Bn VSS VSS) gpdk090_nmos1v w=0.24u l=0.1u ad=0.0528p as=0.0816p pd=0.68u ps=1.16u
    I_MXI2_I112_MN4 (XOR_18 XI2_I112_An XI2_I112_n2 VSS) gpdk090_nmos1v w=0.24u l=0.1u ad=0.0528p as=0.0528p pd=0.68u ps=0.68u
    I_MXI2_I112_MN2 (XI2_I112_n1 A_18 XOR_18 VSS) gpdk090_nmos1v w=0.24u l=0.1u ad=0.0528p as=0.0528p pd=0.68u ps=0.68u
    I_MXI2_I112_MN3 (VSS B_18 XI2_I112_n1 VSS) gpdk090_nmos1v w=0.24u l=0.1u ad=0.0816p as=0.0528p pd=1.16u ps=0.68u
    I_MXI2_I112_MN0 (XI2_I112_An A_18 VSS VSS) gpdk090_nmos1v w=0.12u l=0.1u ad=0.0696p as=0.0696p pd=1.16u ps=1.16u
    I_MXI2_I154_MN1 (XI2_I154_Bn B_25 VSS VSS) gpdk090_nmos1v w=0.12u l=0.1u ad=0.0696p as=0.0696p pd=1.16u ps=1.16u
    I_MXI2_I154_MN5 (XI2_I154_n2 XI2_I154_Bn VSS VSS) gpdk090_nmos1v w=0.24u l=0.1u ad=0.0528p as=0.0816p pd=0.68u ps=1.16u
    I_MXI2_I154_MN4 (XOR_25 XI2_I154_An XI2_I154_n2 VSS) gpdk090_nmos1v w=0.24u l=0.1u ad=0.0528p as=0.0528p pd=0.68u ps=0.68u
    I_MXI2_I154_MN2 (XI2_I154_n1 A_25 XOR_25 VSS) gpdk090_nmos1v w=0.24u l=0.1u ad=0.0528p as=0.0528p pd=0.68u ps=0.68u
    I_MXI2_I154_MN3 (VSS B_25 XI2_I154_n1 VSS) gpdk090_nmos1v w=0.24u l=0.1u ad=0.0816p as=0.0528p pd=1.16u ps=0.68u
    I_MXI2_I154_MN0 (XI2_I154_An A_25 VSS VSS) gpdk090_nmos1v w=0.12u l=0.1u ad=0.0696p as=0.0696p pd=1.16u ps=1.16u
    I_MXI2_I130_MN1 (XI2_I130_Bn B_21 VSS VSS) gpdk090_nmos1v w=0.12u l=0.1u ad=0.0696p as=0.0696p pd=1.16u ps=1.16u
    I_MXI2_I130_MN5 (XI2_I130_n2 XI2_I130_Bn VSS VSS) gpdk090_nmos1v w=0.24u l=0.1u ad=0.0528p as=0.0816p pd=0.68u ps=1.16u
    I_MXI2_I130_MN4 (XOR_21 XI2_I130_An XI2_I130_n2 VSS) gpdk090_nmos1v w=0.24u l=0.1u ad=0.0528p as=0.0528p pd=0.68u ps=0.68u
    I_MXI2_I130_MN2 (XI2_I130_n1 A_21 XOR_21 VSS) gpdk090_nmos1v w=0.24u l=0.1u ad=0.0528p as=0.0528p pd=0.68u ps=0.68u
    I_MXI2_I130_MN3 (VSS B_21 XI2_I130_n1 VSS) gpdk090_nmos1v w=0.24u l=0.1u ad=0.0816p as=0.0528p pd=1.16u ps=0.68u
    I_MXI2_I130_MN0 (XI2_I130_An A_21 VSS VSS) gpdk090_nmos1v w=0.12u l=0.1u ad=0.0696p as=0.0696p pd=1.16u ps=1.16u
    I_MXI2_I118_MN1 (XI2_I118_Bn B_19 VSS VSS) gpdk090_nmos1v w=0.12u l=0.1u ad=0.0696p as=0.0696p pd=1.16u ps=1.16u
    I_MXI2_I118_MN5 (XI2_I118_n2 XI2_I118_Bn VSS VSS) gpdk090_nmos1v w=0.24u l=0.1u ad=0.0528p as=0.0816p pd=0.68u ps=1.16u
    I_MXI2_I118_MN4 (XOR_19 XI2_I118_An XI2_I118_n2 VSS) gpdk090_nmos1v w=0.24u l=0.1u ad=0.0528p as=0.0528p pd=0.68u ps=0.68u
    I_MXI2_I118_MN2 (XI2_I118_n1 A_19 XOR_19 VSS) gpdk090_nmos1v w=0.24u l=0.1u ad=0.0528p as=0.0528p pd=0.68u ps=0.68u
    I_MXI2_I118_MN3 (VSS B_19 XI2_I118_n1 VSS) gpdk090_nmos1v w=0.24u l=0.1u ad=0.0816p as=0.0528p pd=1.16u ps=0.68u
    I_MXI2_I118_MN0 (XI2_I118_An A_19 VSS VSS) gpdk090_nmos1v w=0.12u l=0.1u ad=0.0696p as=0.0696p pd=1.16u ps=1.16u
    I_MXI2_I106_MN1 (XI2_I106_Bn B_17 VSS VSS) gpdk090_nmos1v w=0.12u l=0.1u ad=0.0696p as=0.0696p pd=1.16u ps=1.16u
    I_MXI2_I106_MN5 (XI2_I106_n2 XI2_I106_Bn VSS VSS) gpdk090_nmos1v w=0.24u l=0.1u ad=0.0528p as=0.0816p pd=0.68u ps=1.16u
    I_MXI2_I106_MN4 (XOR_17 XI2_I106_An XI2_I106_n2 VSS) gpdk090_nmos1v w=0.24u l=0.1u ad=0.0528p as=0.0528p pd=0.68u ps=0.68u
    I_MXI2_I106_MN2 (XI2_I106_n1 A_17 XOR_17 VSS) gpdk090_nmos1v w=0.24u l=0.1u ad=0.0528p as=0.0528p pd=0.68u ps=0.68u
    I_MXI2_I106_MN3 (VSS B_17 XI2_I106_n1 VSS) gpdk090_nmos1v w=0.24u l=0.1u ad=0.0816p as=0.0528p pd=1.16u ps=0.68u
    I_MXI2_I106_MN0 (XI2_I106_An A_17 VSS VSS) gpdk090_nmos1v w=0.12u l=0.1u ad=0.0696p as=0.0696p pd=1.16u ps=1.16u
    I_MXI1_I42_I203_MP1 (VDD I1_SUB_b3_5 XI1_I42_I203_Bn VDD) gpdk090_pmos1v w=0.24u l=0.1u ad=0.0816p as=0.0816p pd=1.16u ps=1.16u
    I_MXI1_I42_I203_MP5 (S_0 I1_SUB_b3_5 XI1_I42_I203_p1 VDD) gpdk090_pmos1v w=0.48u l=0.1u ad=0.1056p as=0.1632p pd=0.92u ps=1.64u
    I_MXI1_I42_I203_MP4 (XI1_I42_I203_p1 XI1_I42_I203_An S_0 VDD) gpdk090_pmos1v w=0.48u l=0.1u ad=0.1056p as=0.1056p pd=0.92u ps=0.92u
    I_MXI1_I42_I203_MP2 (VDD I1_I42_pn0 XI1_I42_I203_p1 VDD) gpdk090_pmos1v w=0.48u l=0.1u ad=0.1056p as=0.1056p pd=0.92u ps=0.92u
    I_MXI1_I42_I203_MP3 (XI1_I42_I203_p1 XI1_I42_I203_Bn VDD VDD) gpdk090_pmos1v w=0.48u l=0.1u ad=0.1632p as=0.1056p pd=1.64u ps=0.92u
    I_MXI1_I42_I203_MP0 (VDD I1_I42_pn0 XI1_I42_I203_An VDD) gpdk090_pmos1v w=0.24u l=0.1u ad=0.0816p as=0.0816p pd=1.16u ps=1.16u
    I_MXI1_I42_I32_MP1 (VDD I1_bx0 XI1_I42_I32_Bn VDD) gpdk090_pmos1v w=0.24u l=0.1u ad=0.0816p as=0.0816p pd=1.16u ps=1.16u
    I_MXI1_I42_I32_MP5 (I1_I42_pn0 I1_bx0 XI1_I42_I32_p1 VDD) gpdk090_pmos1v w=0.48u l=0.1u ad=0.1056p as=0.1632p pd=0.92u ps=1.64u
    I_MXI1_I42_I32_MP4 (XI1_I42_I32_p1 XI1_I42_I32_An I1_I42_pn0 VDD) gpdk090_pmos1v w=0.48u l=0.1u ad=0.1056p as=0.1056p pd=0.92u ps=0.92u
    I_MXI1_I42_I32_MP2 (VDD A_0 XI1_I42_I32_p1 VDD) gpdk090_pmos1v w=0.48u l=0.1u ad=0.1056p as=0.1056p pd=0.92u ps=0.92u
    I_MXI1_I42_I32_MP3 (XI1_I42_I32_p1 XI1_I42_I32_Bn VDD VDD) gpdk090_pmos1v w=0.48u l=0.1u ad=0.1632p as=0.1056p pd=1.64u ps=0.92u
    I_MXI1_I42_I32_MP0 (VDD A_0 XI1_I42_I32_An VDD) gpdk090_pmos1v w=0.24u l=0.1u ad=0.0816p as=0.0816p pd=1.16u ps=1.16u
    I_MXI1_I42_I33_MP1 (VDD I1_bx1 XI1_I42_I33_Bn VDD) gpdk090_pmos1v w=0.24u l=0.1u ad=0.0816p as=0.0816p pd=1.16u ps=1.16u
    I_MXI1_I42_I33_MP5 (I1_I42_pn1 I1_bx1 XI1_I42_I33_p1 VDD) gpdk090_pmos1v w=0.48u l=0.1u ad=0.1056p as=0.1632p pd=0.92u ps=1.64u
    I_MXI1_I42_I33_MP4 (XI1_I42_I33_p1 XI1_I42_I33_An I1_I42_pn1 VDD) gpdk090_pmos1v w=0.48u l=0.1u ad=0.1056p as=0.1056p pd=0.92u ps=0.92u
    I_MXI1_I42_I33_MP2 (VDD A_1 XI1_I42_I33_p1 VDD) gpdk090_pmos1v w=0.48u l=0.1u ad=0.1056p as=0.1056p pd=0.92u ps=0.92u
    I_MXI1_I42_I33_MP3 (XI1_I42_I33_p1 XI1_I42_I33_Bn VDD VDD) gpdk090_pmos1v w=0.48u l=0.1u ad=0.1632p as=0.1056p pd=1.64u ps=0.92u
    I_MXI1_I42_I33_MP0 (VDD A_1 XI1_I42_I33_An VDD) gpdk090_pmos1v w=0.24u l=0.1u ad=0.0816p as=0.0816p pd=1.16u ps=1.16u
    I_MXI1_I42_I36_MP1 (VDD I1_bx4 XI1_I42_I36_Bn VDD) gpdk090_pmos1v w=0.24u l=0.1u ad=0.0816p as=0.0816p pd=1.16u ps=1.16u
    I_MXI1_I42_I36_MP5 (I1_I42_pn4 I1_bx4 XI1_I42_I36_p1 VDD) gpdk090_pmos1v w=0.48u l=0.1u ad=0.1056p as=0.1632p pd=0.92u ps=1.64u
    I_MXI1_I42_I36_MP4 (XI1_I42_I36_p1 XI1_I42_I36_An I1_I42_pn4 VDD) gpdk090_pmos1v w=0.48u l=0.1u ad=0.1056p as=0.1056p pd=0.92u ps=0.92u
    I_MXI1_I42_I36_MP2 (VDD A_4 XI1_I42_I36_p1 VDD) gpdk090_pmos1v w=0.48u l=0.1u ad=0.1056p as=0.1056p pd=0.92u ps=0.92u
    I_MXI1_I42_I36_MP3 (XI1_I42_I36_p1 XI1_I42_I36_Bn VDD VDD) gpdk090_pmos1v w=0.48u l=0.1u ad=0.1632p as=0.1056p pd=1.64u ps=0.92u
    I_MXI1_I42_I36_MP0 (VDD A_4 XI1_I42_I36_An VDD) gpdk090_pmos1v w=0.24u l=0.1u ad=0.0816p as=0.0816p pd=1.16u ps=1.16u
    I_MXI1_I42_I40_MP1 (VDD I1_bx8 XI1_I42_I40_Bn VDD) gpdk090_pmos1v w=0.24u l=0.1u ad=0.0816p as=0.0816p pd=1.16u ps=1.16u
    I_MXI1_I42_I40_MP5 (I1_I42_pn8 I1_bx8 XI1_I42_I40_p1 VDD) gpdk090_pmos1v w=0.48u l=0.1u ad=0.1056p as=0.1632p pd=0.92u ps=1.64u
    I_MXI1_I42_I40_MP4 (XI1_I42_I40_p1 XI1_I42_I40_An I1_I42_pn8 VDD) gpdk090_pmos1v w=0.48u l=0.1u ad=0.1056p as=0.1056p pd=0.92u ps=0.92u
    I_MXI1_I42_I40_MP2 (VDD A_8 XI1_I42_I40_p1 VDD) gpdk090_pmos1v w=0.48u l=0.1u ad=0.1056p as=0.1056p pd=0.92u ps=0.92u
    I_MXI1_I42_I40_MP3 (XI1_I42_I40_p1 XI1_I42_I40_Bn VDD VDD) gpdk090_pmos1v w=0.48u l=0.1u ad=0.1632p as=0.1056p pd=1.64u ps=0.92u
    I_MXI1_I42_I40_MP0 (VDD A_8 XI1_I42_I40_An VDD) gpdk090_pmos1v w=0.24u l=0.1u ad=0.0816p as=0.0816p pd=1.16u ps=1.16u
    I_MXI1_I42_I41_MP1 (VDD I1_bx9 XI1_I42_I41_Bn VDD) gpdk090_pmos1v w=0.24u l=0.1u ad=0.0816p as=0.0816p pd=1.16u ps=1.16u
    I_MXI1_I42_I41_MP5 (I1_I42_pn9 I1_bx9 XI1_I42_I41_p1 VDD) gpdk090_pmos1v w=0.48u l=0.1u ad=0.1056p as=0.1632p pd=0.92u ps=1.64u
    I_MXI1_I42_I41_MP4 (XI1_I42_I41_p1 XI1_I42_I41_An I1_I42_pn9 VDD) gpdk090_pmos1v w=0.48u l=0.1u ad=0.1056p as=0.1056p pd=0.92u ps=0.92u
    I_MXI1_I42_I41_MP2 (VDD A_9 XI1_I42_I41_p1 VDD) gpdk090_pmos1v w=0.48u l=0.1u ad=0.1056p as=0.1056p pd=0.92u ps=0.92u
    I_MXI1_I42_I41_MP3 (XI1_I42_I41_p1 XI1_I42_I41_Bn VDD VDD) gpdk090_pmos1v w=0.48u l=0.1u ad=0.1632p as=0.1056p pd=1.64u ps=0.92u
    I_MXI1_I42_I41_MP0 (VDD A_9 XI1_I42_I41_An VDD) gpdk090_pmos1v w=0.24u l=0.1u ad=0.0816p as=0.0816p pd=1.16u ps=1.16u
    I_MXI1_I42_I39_MP1 (VDD I1_bx7 XI1_I42_I39_Bn VDD) gpdk090_pmos1v w=0.24u l=0.1u ad=0.0816p as=0.0816p pd=1.16u ps=1.16u
    I_MXI1_I42_I39_MP5 (I1_I42_pn7 I1_bx7 XI1_I42_I39_p1 VDD) gpdk090_pmos1v w=0.48u l=0.1u ad=0.1056p as=0.1632p pd=0.92u ps=1.64u
    I_MXI1_I42_I39_MP4 (XI1_I42_I39_p1 XI1_I42_I39_An I1_I42_pn7 VDD) gpdk090_pmos1v w=0.48u l=0.1u ad=0.1056p as=0.1056p pd=0.92u ps=0.92u
    I_MXI1_I42_I39_MP2 (VDD A_7 XI1_I42_I39_p1 VDD) gpdk090_pmos1v w=0.48u l=0.1u ad=0.1056p as=0.1056p pd=0.92u ps=0.92u
    I_MXI1_I42_I39_MP3 (XI1_I42_I39_p1 XI1_I42_I39_Bn VDD VDD) gpdk090_pmos1v w=0.48u l=0.1u ad=0.1632p as=0.1056p pd=1.64u ps=0.92u
    I_MXI1_I42_I39_MP0 (VDD A_7 XI1_I42_I39_An VDD) gpdk090_pmos1v w=0.24u l=0.1u ad=0.0816p as=0.0816p pd=1.16u ps=1.16u
    I_MXI1_I42_I37_MP1 (VDD I1_bx5 XI1_I42_I37_Bn VDD) gpdk090_pmos1v w=0.24u l=0.1u ad=0.0816p as=0.0816p pd=1.16u ps=1.16u
    I_MXI1_I42_I37_MP5 (I1_I42_pn5 I1_bx5 XI1_I42_I37_p1 VDD) gpdk090_pmos1v w=0.48u l=0.1u ad=0.1056p as=0.1632p pd=0.92u ps=1.64u
    I_MXI1_I42_I37_MP4 (XI1_I42_I37_p1 XI1_I42_I37_An I1_I42_pn5 VDD) gpdk090_pmos1v w=0.48u l=0.1u ad=0.1056p as=0.1056p pd=0.92u ps=0.92u
    I_MXI1_I42_I37_MP2 (VDD A_5 XI1_I42_I37_p1 VDD) gpdk090_pmos1v w=0.48u l=0.1u ad=0.1056p as=0.1056p pd=0.92u ps=0.92u
    I_MXI1_I42_I37_MP3 (XI1_I42_I37_p1 XI1_I42_I37_Bn VDD VDD) gpdk090_pmos1v w=0.48u l=0.1u ad=0.1632p as=0.1056p pd=1.64u ps=0.92u
    I_MXI1_I42_I37_MP0 (VDD A_5 XI1_I42_I37_An VDD) gpdk090_pmos1v w=0.24u l=0.1u ad=0.0816p as=0.0816p pd=1.16u ps=1.16u
    I_MXI1_I42_I204_MP1 (VDD I1_I42_G0_0 XI1_I42_I204_Bn VDD) gpdk090_pmos1v w=0.24u l=0.1u ad=0.0816p as=0.0816p pd=1.16u ps=1.16u
    I_MXI1_I42_I204_MP5 (S_1 I1_I42_G0_0 XI1_I42_I204_p1 VDD) gpdk090_pmos1v w=0.48u l=0.1u ad=0.1056p as=0.1632p pd=0.92u ps=1.64u
    I_MXI1_I42_I204_MP4 (XI1_I42_I204_p1 XI1_I42_I204_An S_1 VDD) gpdk090_pmos1v w=0.48u l=0.1u ad=0.1056p as=0.1056p pd=0.92u ps=0.92u
    I_MXI1_I42_I204_MP2 (VDD I1_I42_pn1 XI1_I42_I204_p1 VDD) gpdk090_pmos1v w=0.48u l=0.1u ad=0.1056p as=0.1056p pd=0.92u ps=0.92u
    I_MXI1_I42_I204_MP3 (XI1_I42_I204_p1 XI1_I42_I204_Bn VDD VDD) gpdk090_pmos1v w=0.48u l=0.1u ad=0.1632p as=0.1056p pd=1.64u ps=0.92u
    I_MXI1_I42_I204_MP0 (VDD I1_I42_pn1 XI1_I42_I204_An VDD) gpdk090_pmos1v w=0.24u l=0.1u ad=0.0816p as=0.0816p pd=1.16u ps=1.16u
    I_MXI1_I42_I42_MP1 (VDD I1_bx10 XI1_I42_I42_Bn VDD) gpdk090_pmos1v w=0.24u l=0.1u ad=0.0816p as=0.0816p pd=1.16u ps=1.16u
    I_MXI1_I42_I42_MP5 (I1_I42_pn10 I1_bx10 XI1_I42_I42_p1 VDD) gpdk090_pmos1v w=0.48u l=0.1u ad=0.1056p as=0.1632p pd=0.92u ps=1.64u
    I_MXI1_I42_I42_MP4 (XI1_I42_I42_p1 XI1_I42_I42_An I1_I42_pn10 VDD) gpdk090_pmos1v w=0.48u l=0.1u ad=0.1056p as=0.1056p pd=0.92u ps=0.92u
    I_MXI1_I42_I42_MP2 (VDD A_10 XI1_I42_I42_p1 VDD) gpdk090_pmos1v w=0.48u l=0.1u ad=0.1056p as=0.1056p pd=0.92u ps=0.92u
    I_MXI1_I42_I42_MP3 (XI1_I42_I42_p1 XI1_I42_I42_Bn VDD VDD) gpdk090_pmos1v w=0.48u l=0.1u ad=0.1632p as=0.1056p pd=1.64u ps=0.92u
    I_MXI1_I42_I42_MP0 (VDD A_10 XI1_I42_I42_An VDD) gpdk090_pmos1v w=0.24u l=0.1u ad=0.0816p as=0.0816p pd=1.16u ps=1.16u
    I_MXI1_I42_I211_MP1 (VDD I1_I42_G7_0 XI1_I42_I211_Bn VDD) gpdk090_pmos1v w=0.24u l=0.1u ad=0.0816p as=0.0816p pd=1.16u ps=1.16u
    I_MXI1_I42_I211_MP5 (S_8 I1_I42_G7_0 XI1_I42_I211_p1 VDD) gpdk090_pmos1v w=0.48u l=0.1u ad=0.1056p as=0.1632p pd=0.92u ps=1.64u
    I_MXI1_I42_I211_MP4 (XI1_I42_I211_p1 XI1_I42_I211_An S_8 VDD) gpdk090_pmos1v w=0.48u l=0.1u ad=0.1056p as=0.1056p pd=0.92u ps=0.92u
    I_MXI1_I42_I211_MP2 (VDD I1_I42_pn8 XI1_I42_I211_p1 VDD) gpdk090_pmos1v w=0.48u l=0.1u ad=0.1056p as=0.1056p pd=0.92u ps=0.92u
    I_MXI1_I42_I211_MP3 (XI1_I42_I211_p1 XI1_I42_I211_Bn VDD VDD) gpdk090_pmos1v w=0.48u l=0.1u ad=0.1632p as=0.1056p pd=1.64u ps=0.92u
    I_MXI1_I42_I211_MP0 (VDD I1_I42_pn8 XI1_I42_I211_An VDD) gpdk090_pmos1v w=0.24u l=0.1u ad=0.0816p as=0.0816p pd=1.16u ps=1.16u
    I_MXI1_I42_I209_MP1 (VDD I1_I42_G5_0 XI1_I42_I209_Bn VDD) gpdk090_pmos1v w=0.24u l=0.1u ad=0.0816p as=0.0816p pd=1.16u ps=1.16u
    I_MXI1_I42_I209_MP5 (S_6 I1_I42_G5_0 XI1_I42_I209_p1 VDD) gpdk090_pmos1v w=0.48u l=0.1u ad=0.1056p as=0.1632p pd=0.92u ps=1.64u
    I_MXI1_I42_I209_MP4 (XI1_I42_I209_p1 XI1_I42_I209_An S_6 VDD) gpdk090_pmos1v w=0.48u l=0.1u ad=0.1056p as=0.1056p pd=0.92u ps=0.92u
    I_MXI1_I42_I209_MP2 (VDD I1_I42_pn6 XI1_I42_I209_p1 VDD) gpdk090_pmos1v w=0.48u l=0.1u ad=0.1056p as=0.1056p pd=0.92u ps=0.92u
    I_MXI1_I42_I209_MP3 (XI1_I42_I209_p1 XI1_I42_I209_Bn VDD VDD) gpdk090_pmos1v w=0.48u l=0.1u ad=0.1632p as=0.1056p pd=1.64u ps=0.92u
    I_MXI1_I42_I209_MP0 (VDD I1_I42_pn6 XI1_I42_I209_An VDD) gpdk090_pmos1v w=0.24u l=0.1u ad=0.0816p as=0.0816p pd=1.16u ps=1.16u
    I_MXI1_I42_I210_MP1 (VDD I1_I42_G6_0 XI1_I42_I210_Bn VDD) gpdk090_pmos1v w=0.24u l=0.1u ad=0.0816p as=0.0816p pd=1.16u ps=1.16u
    I_MXI1_I42_I210_MP5 (S_7 I1_I42_G6_0 XI1_I42_I210_p1 VDD) gpdk090_pmos1v w=0.48u l=0.1u ad=0.1056p as=0.1632p pd=0.92u ps=1.64u
    I_MXI1_I42_I210_MP4 (XI1_I42_I210_p1 XI1_I42_I210_An S_7 VDD) gpdk090_pmos1v w=0.48u l=0.1u ad=0.1056p as=0.1056p pd=0.92u ps=0.92u
    I_MXI1_I42_I210_MP2 (VDD I1_I42_pn7 XI1_I42_I210_p1 VDD) gpdk090_pmos1v w=0.48u l=0.1u ad=0.1056p as=0.1056p pd=0.92u ps=0.92u
    I_MXI1_I42_I210_MP3 (XI1_I42_I210_p1 XI1_I42_I210_Bn VDD VDD) gpdk090_pmos1v w=0.48u l=0.1u ad=0.1632p as=0.1056p pd=1.64u ps=0.92u
    I_MXI1_I42_I210_MP0 (VDD I1_I42_pn7 XI1_I42_I210_An VDD) gpdk090_pmos1v w=0.24u l=0.1u ad=0.0816p as=0.0816p pd=1.16u ps=1.16u
    I_MXI1_I42_I38_MP1 (VDD I1_bx6 XI1_I42_I38_Bn VDD) gpdk090_pmos1v w=0.24u l=0.1u ad=0.0816p as=0.0816p pd=1.16u ps=1.16u
    I_MXI1_I42_I38_MP5 (I1_I42_pn6 I1_bx6 XI1_I42_I38_p1 VDD) gpdk090_pmos1v w=0.48u l=0.1u ad=0.1056p as=0.1632p pd=0.92u ps=1.64u
    I_MXI1_I42_I38_MP4 (XI1_I42_I38_p1 XI1_I42_I38_An I1_I42_pn6 VDD) gpdk090_pmos1v w=0.48u l=0.1u ad=0.1056p as=0.1056p pd=0.92u ps=0.92u
    I_MXI1_I42_I38_MP2 (VDD A_6 XI1_I42_I38_p1 VDD) gpdk090_pmos1v w=0.48u l=0.1u ad=0.1056p as=0.1056p pd=0.92u ps=0.92u
    I_MXI1_I42_I38_MP3 (XI1_I42_I38_p1 XI1_I42_I38_Bn VDD VDD) gpdk090_pmos1v w=0.48u l=0.1u ad=0.1632p as=0.1056p pd=1.64u ps=0.92u
    I_MXI1_I42_I38_MP0 (VDD A_6 XI1_I42_I38_An VDD) gpdk090_pmos1v w=0.24u l=0.1u ad=0.0816p as=0.0816p pd=1.16u ps=1.16u
    I_MXI1_I42_I208_MP1 (VDD I1_I42_G4_0 XI1_I42_I208_Bn VDD) gpdk090_pmos1v w=0.24u l=0.1u ad=0.0816p as=0.0816p pd=1.16u ps=1.16u
    I_MXI1_I42_I208_MP5 (S_5 I1_I42_G4_0 XI1_I42_I208_p1 VDD) gpdk090_pmos1v w=0.48u l=0.1u ad=0.1056p as=0.1632p pd=0.92u ps=1.64u
    I_MXI1_I42_I208_MP4 (XI1_I42_I208_p1 XI1_I42_I208_An S_5 VDD) gpdk090_pmos1v w=0.48u l=0.1u ad=0.1056p as=0.1056p pd=0.92u ps=0.92u
    I_MXI1_I42_I208_MP2 (VDD I1_I42_pn5 XI1_I42_I208_p1 VDD) gpdk090_pmos1v w=0.48u l=0.1u ad=0.1056p as=0.1056p pd=0.92u ps=0.92u
    I_MXI1_I42_I208_MP3 (XI1_I42_I208_p1 XI1_I42_I208_Bn VDD VDD) gpdk090_pmos1v w=0.48u l=0.1u ad=0.1632p as=0.1056p pd=1.64u ps=0.92u
    I_MXI1_I42_I208_MP0 (VDD I1_I42_pn5 XI1_I42_I208_An VDD) gpdk090_pmos1v w=0.24u l=0.1u ad=0.0816p as=0.0816p pd=1.16u ps=1.16u
    I_MXI1_I42_I205_MP1 (VDD I1_I42_G1_0 XI1_I42_I205_Bn VDD) gpdk090_pmos1v w=0.24u l=0.1u ad=0.0816p as=0.0816p pd=1.16u ps=1.16u
    I_MXI1_I42_I205_MP5 (S_2 I1_I42_G1_0 XI1_I42_I205_p1 VDD) gpdk090_pmos1v w=0.48u l=0.1u ad=0.1056p as=0.1632p pd=0.92u ps=1.64u
    I_MXI1_I42_I205_MP4 (XI1_I42_I205_p1 XI1_I42_I205_An S_2 VDD) gpdk090_pmos1v w=0.48u l=0.1u ad=0.1056p as=0.1056p pd=0.92u ps=0.92u
    I_MXI1_I42_I205_MP2 (VDD I1_I42_pn2 XI1_I42_I205_p1 VDD) gpdk090_pmos1v w=0.48u l=0.1u ad=0.1056p as=0.1056p pd=0.92u ps=0.92u
    I_MXI1_I42_I205_MP3 (XI1_I42_I205_p1 XI1_I42_I205_Bn VDD VDD) gpdk090_pmos1v w=0.48u l=0.1u ad=0.1632p as=0.1056p pd=1.64u ps=0.92u
    I_MXI1_I42_I205_MP0 (VDD I1_I42_pn2 XI1_I42_I205_An VDD) gpdk090_pmos1v w=0.24u l=0.1u ad=0.0816p as=0.0816p pd=1.16u ps=1.16u
    I_MXI1_I42_I34_MP1 (VDD I1_bx2 XI1_I42_I34_Bn VDD) gpdk090_pmos1v w=0.24u l=0.1u ad=0.0816p as=0.0816p pd=1.16u ps=1.16u
    I_MXI1_I42_I34_MP5 (I1_I42_pn2 I1_bx2 XI1_I42_I34_p1 VDD) gpdk090_pmos1v w=0.48u l=0.1u ad=0.1056p as=0.1632p pd=0.92u ps=1.64u
    I_MXI1_I42_I34_MP4 (XI1_I42_I34_p1 XI1_I42_I34_An I1_I42_pn2 VDD) gpdk090_pmos1v w=0.48u l=0.1u ad=0.1056p as=0.1056p pd=0.92u ps=0.92u
    I_MXI1_I42_I34_MP2 (VDD A_2 XI1_I42_I34_p1 VDD) gpdk090_pmos1v w=0.48u l=0.1u ad=0.1056p as=0.1056p pd=0.92u ps=0.92u
    I_MXI1_I42_I34_MP3 (XI1_I42_I34_p1 XI1_I42_I34_Bn VDD VDD) gpdk090_pmos1v w=0.48u l=0.1u ad=0.1632p as=0.1056p pd=1.64u ps=0.92u
    I_MXI1_I42_I34_MP0 (VDD A_2 XI1_I42_I34_An VDD) gpdk090_pmos1v w=0.24u l=0.1u ad=0.0816p as=0.0816p pd=1.16u ps=1.16u
    I_MXI1_I42_I35_MP1 (VDD I1_bx3 XI1_I42_I35_Bn VDD) gpdk090_pmos1v w=0.24u l=0.1u ad=0.0816p as=0.0816p pd=1.16u ps=1.16u
    I_MXI1_I42_I35_MP5 (I1_I42_pn3 I1_bx3 XI1_I42_I35_p1 VDD) gpdk090_pmos1v w=0.48u l=0.1u ad=0.1056p as=0.1632p pd=0.92u ps=1.64u
    I_MXI1_I42_I35_MP4 (XI1_I42_I35_p1 XI1_I42_I35_An I1_I42_pn3 VDD) gpdk090_pmos1v w=0.48u l=0.1u ad=0.1056p as=0.1056p pd=0.92u ps=0.92u
    I_MXI1_I42_I35_MP2 (VDD A_3 XI1_I42_I35_p1 VDD) gpdk090_pmos1v w=0.48u l=0.1u ad=0.1056p as=0.1056p pd=0.92u ps=0.92u
    I_MXI1_I42_I35_MP3 (XI1_I42_I35_p1 XI1_I42_I35_Bn VDD VDD) gpdk090_pmos1v w=0.48u l=0.1u ad=0.1632p as=0.1056p pd=1.64u ps=0.92u
    I_MXI1_I42_I35_MP0 (VDD A_3 XI1_I42_I35_An VDD) gpdk090_pmos1v w=0.24u l=0.1u ad=0.0816p as=0.0816p pd=1.16u ps=1.16u
    I_MXI1_I42_I62_MP1 (VDD I1_bx30 XI1_I42_I62_Bn VDD) gpdk090_pmos1v w=0.24u l=0.1u ad=0.0816p as=0.0816p pd=1.16u ps=1.16u
    I_MXI1_I42_I62_MP5 (I1_I42_pn30 I1_bx30 XI1_I42_I62_p1 VDD) gpdk090_pmos1v w=0.48u l=0.1u ad=0.1056p as=0.1632p pd=0.92u ps=1.64u
    I_MXI1_I42_I62_MP4 (XI1_I42_I62_p1 XI1_I42_I62_An I1_I42_pn30 VDD) gpdk090_pmos1v w=0.48u l=0.1u ad=0.1056p as=0.1056p pd=0.92u ps=0.92u
    I_MXI1_I42_I62_MP2 (VDD A_30 XI1_I42_I62_p1 VDD) gpdk090_pmos1v w=0.48u l=0.1u ad=0.1056p as=0.1056p pd=0.92u ps=0.92u
    I_MXI1_I42_I62_MP3 (XI1_I42_I62_p1 XI1_I42_I62_Bn VDD VDD) gpdk090_pmos1v w=0.48u l=0.1u ad=0.1632p as=0.1056p pd=1.64u ps=0.92u
    I_MXI1_I42_I62_MP0 (VDD A_30 XI1_I42_I62_An VDD) gpdk090_pmos1v w=0.24u l=0.1u ad=0.0816p as=0.0816p pd=1.16u ps=1.16u
    I_MXI1_I42_I233_MP1 (VDD I1_I42_G29_0 XI1_I42_I233_Bn VDD) gpdk090_pmos1v w=0.24u l=0.1u ad=0.0816p as=0.0816p pd=1.16u ps=1.16u
    I_MXI1_I42_I233_MP5 (S_30 I1_I42_G29_0 XI1_I42_I233_p1 VDD) gpdk090_pmos1v w=0.48u l=0.1u ad=0.1056p as=0.1632p pd=0.92u ps=1.64u
    I_MXI1_I42_I233_MP4 (XI1_I42_I233_p1 XI1_I42_I233_An S_30 VDD) gpdk090_pmos1v w=0.48u l=0.1u ad=0.1056p as=0.1056p pd=0.92u ps=0.92u
    I_MXI1_I42_I233_MP2 (VDD I1_I42_pn30 XI1_I42_I233_p1 VDD) gpdk090_pmos1v w=0.48u l=0.1u ad=0.1056p as=0.1056p pd=0.92u ps=0.92u
    I_MXI1_I42_I233_MP3 (XI1_I42_I233_p1 XI1_I42_I233_Bn VDD VDD) gpdk090_pmos1v w=0.48u l=0.1u ad=0.1632p as=0.1056p pd=1.64u ps=0.92u
    I_MXI1_I42_I233_MP0 (VDD I1_I42_pn30 XI1_I42_I233_An VDD) gpdk090_pmos1v w=0.24u l=0.1u ad=0.0816p as=0.0816p pd=1.16u ps=1.16u
    I_MXI1_I42_I43_MP1 (VDD I1_bx11 XI1_I42_I43_Bn VDD) gpdk090_pmos1v w=0.24u l=0.1u ad=0.0816p as=0.0816p pd=1.16u ps=1.16u
    I_MXI1_I42_I43_MP5 (I1_I42_pn11 I1_bx11 XI1_I42_I43_p1 VDD) gpdk090_pmos1v w=0.48u l=0.1u ad=0.1056p as=0.1632p pd=0.92u ps=1.64u
    I_MXI1_I42_I43_MP4 (XI1_I42_I43_p1 XI1_I42_I43_An I1_I42_pn11 VDD) gpdk090_pmos1v w=0.48u l=0.1u ad=0.1056p as=0.1056p pd=0.92u ps=0.92u
    I_MXI1_I42_I43_MP2 (VDD A_11 XI1_I42_I43_p1 VDD) gpdk090_pmos1v w=0.48u l=0.1u ad=0.1056p as=0.1056p pd=0.92u ps=0.92u
    I_MXI1_I42_I43_MP3 (XI1_I42_I43_p1 XI1_I42_I43_Bn VDD VDD) gpdk090_pmos1v w=0.48u l=0.1u ad=0.1632p as=0.1056p pd=1.64u ps=0.92u
    I_MXI1_I42_I43_MP0 (VDD A_11 XI1_I42_I43_An VDD) gpdk090_pmos1v w=0.24u l=0.1u ad=0.0816p as=0.0816p pd=1.16u ps=1.16u
    I_MXI1_I42_I44_MP1 (VDD I1_bx12 XI1_I42_I44_Bn VDD) gpdk090_pmos1v w=0.24u l=0.1u ad=0.0816p as=0.0816p pd=1.16u ps=1.16u
    I_MXI1_I42_I44_MP5 (I1_I42_pn12 I1_bx12 XI1_I42_I44_p1 VDD) gpdk090_pmos1v w=0.48u l=0.1u ad=0.1056p as=0.1632p pd=0.92u ps=1.64u
    I_MXI1_I42_I44_MP4 (XI1_I42_I44_p1 XI1_I42_I44_An I1_I42_pn12 VDD) gpdk090_pmos1v w=0.48u l=0.1u ad=0.1056p as=0.1056p pd=0.92u ps=0.92u
    I_MXI1_I42_I44_MP2 (VDD A_12 XI1_I42_I44_p1 VDD) gpdk090_pmos1v w=0.48u l=0.1u ad=0.1056p as=0.1056p pd=0.92u ps=0.92u
    I_MXI1_I42_I44_MP3 (XI1_I42_I44_p1 XI1_I42_I44_Bn VDD VDD) gpdk090_pmos1v w=0.48u l=0.1u ad=0.1632p as=0.1056p pd=1.64u ps=0.92u
    I_MXI1_I42_I44_MP0 (VDD A_12 XI1_I42_I44_An VDD) gpdk090_pmos1v w=0.24u l=0.1u ad=0.0816p as=0.0816p pd=1.16u ps=1.16u
    I_MXI1_I42_I63_MP1 (VDD I1_bx31 XI1_I42_I63_Bn VDD) gpdk090_pmos1v w=0.24u l=0.1u ad=0.0816p as=0.0816p pd=1.16u ps=1.16u
    I_MXI1_I42_I63_MP5 (I1_I42_pn31 I1_bx31 XI1_I42_I63_p1 VDD) gpdk090_pmos1v w=0.48u l=0.1u ad=0.1056p as=0.1632p pd=0.92u ps=1.64u
    I_MXI1_I42_I63_MP4 (XI1_I42_I63_p1 XI1_I42_I63_An I1_I42_pn31 VDD) gpdk090_pmos1v w=0.48u l=0.1u ad=0.1056p as=0.1056p pd=0.92u ps=0.92u
    I_MXI1_I42_I63_MP2 (VDD A_31 XI1_I42_I63_p1 VDD) gpdk090_pmos1v w=0.48u l=0.1u ad=0.1056p as=0.1056p pd=0.92u ps=0.92u
    I_MXI1_I42_I63_MP3 (XI1_I42_I63_p1 XI1_I42_I63_Bn VDD VDD) gpdk090_pmos1v w=0.48u l=0.1u ad=0.1632p as=0.1056p pd=1.64u ps=0.92u
    I_MXI1_I42_I63_MP0 (VDD A_31 XI1_I42_I63_An VDD) gpdk090_pmos1v w=0.24u l=0.1u ad=0.0816p as=0.0816p pd=1.16u ps=1.16u
    I_MXI1_I42_I234_MP1 (VDD CM XI1_I42_I234_Bn VDD) gpdk090_pmos1v w=0.24u l=0.1u ad=0.0816p as=0.0816p pd=1.16u ps=1.16u
    I_MXI1_I42_I234_MP5 (S_31 CM XI1_I42_I234_p1 VDD) gpdk090_pmos1v w=0.48u l=0.1u ad=0.1056p as=0.1632p pd=0.92u ps=1.64u
    I_MXI1_I42_I234_MP4 (XI1_I42_I234_p1 XI1_I42_I234_An S_31 VDD) gpdk090_pmos1v w=0.48u l=0.1u ad=0.1056p as=0.1056p pd=0.92u ps=0.92u
    I_MXI1_I42_I234_MP2 (VDD I1_I42_pn31 XI1_I42_I234_p1 VDD) gpdk090_pmos1v w=0.48u l=0.1u ad=0.1056p as=0.1056p pd=0.92u ps=0.92u
    I_MXI1_I42_I234_MP3 (XI1_I42_I234_p1 XI1_I42_I234_Bn VDD VDD) gpdk090_pmos1v w=0.48u l=0.1u ad=0.1632p as=0.1056p pd=1.64u ps=0.92u
    I_MXI1_I42_I234_MP0 (VDD I1_I42_pn31 XI1_I42_I234_An VDD) gpdk090_pmos1v w=0.24u l=0.1u ad=0.0816p as=0.0816p pd=1.16u ps=1.16u
    I_MXI1_I42_I232_MP1 (VDD I1_I42_G28_0 XI1_I42_I232_Bn VDD) gpdk090_pmos1v w=0.24u l=0.1u ad=0.0816p as=0.0816p pd=1.16u ps=1.16u
    I_MXI1_I42_I232_MP5 (S_29 I1_I42_G28_0 XI1_I42_I232_p1 VDD) gpdk090_pmos1v w=0.48u l=0.1u ad=0.1056p as=0.1632p pd=0.92u ps=1.64u
    I_MXI1_I42_I232_MP4 (XI1_I42_I232_p1 XI1_I42_I232_An S_29 VDD) gpdk090_pmos1v w=0.48u l=0.1u ad=0.1056p as=0.1056p pd=0.92u ps=0.92u
    I_MXI1_I42_I232_MP2 (VDD I1_I42_pn29 XI1_I42_I232_p1 VDD) gpdk090_pmos1v w=0.48u l=0.1u ad=0.1056p as=0.1056p pd=0.92u ps=0.92u
    I_MXI1_I42_I232_MP3 (XI1_I42_I232_p1 XI1_I42_I232_Bn VDD VDD) gpdk090_pmos1v w=0.48u l=0.1u ad=0.1632p as=0.1056p pd=1.64u ps=0.92u
    I_MXI1_I42_I232_MP0 (VDD I1_I42_pn29 XI1_I42_I232_An VDD) gpdk090_pmos1v w=0.24u l=0.1u ad=0.0816p as=0.0816p pd=1.16u ps=1.16u
    I_MXI1_I42_I45_MP1 (VDD I1_bx13 XI1_I42_I45_Bn VDD) gpdk090_pmos1v w=0.24u l=0.1u ad=0.0816p as=0.0816p pd=1.16u ps=1.16u
    I_MXI1_I42_I45_MP5 (I1_I42_pn13 I1_bx13 XI1_I42_I45_p1 VDD) gpdk090_pmos1v w=0.48u l=0.1u ad=0.1056p as=0.1632p pd=0.92u ps=1.64u
    I_MXI1_I42_I45_MP4 (XI1_I42_I45_p1 XI1_I42_I45_An I1_I42_pn13 VDD) gpdk090_pmos1v w=0.48u l=0.1u ad=0.1056p as=0.1056p pd=0.92u ps=0.92u
    I_MXI1_I42_I45_MP2 (VDD A_13 XI1_I42_I45_p1 VDD) gpdk090_pmos1v w=0.48u l=0.1u ad=0.1056p as=0.1056p pd=0.92u ps=0.92u
    I_MXI1_I42_I45_MP3 (XI1_I42_I45_p1 XI1_I42_I45_Bn VDD VDD) gpdk090_pmos1v w=0.48u l=0.1u ad=0.1632p as=0.1056p pd=1.64u ps=0.92u
    I_MXI1_I42_I45_MP0 (VDD A_13 XI1_I42_I45_An VDD) gpdk090_pmos1v w=0.24u l=0.1u ad=0.0816p as=0.0816p pd=1.16u ps=1.16u
    I_MXI1_I42_I61_MP1 (VDD I1_bx29 XI1_I42_I61_Bn VDD) gpdk090_pmos1v w=0.24u l=0.1u ad=0.0816p as=0.0816p pd=1.16u ps=1.16u
    I_MXI1_I42_I61_MP5 (I1_I42_pn29 I1_bx29 XI1_I42_I61_p1 VDD) gpdk090_pmos1v w=0.48u l=0.1u ad=0.1056p as=0.1632p pd=0.92u ps=1.64u
    I_MXI1_I42_I61_MP4 (XI1_I42_I61_p1 XI1_I42_I61_An I1_I42_pn29 VDD) gpdk090_pmos1v w=0.48u l=0.1u ad=0.1056p as=0.1056p pd=0.92u ps=0.92u
    I_MXI1_I42_I61_MP2 (VDD A_29 XI1_I42_I61_p1 VDD) gpdk090_pmos1v w=0.48u l=0.1u ad=0.1056p as=0.1056p pd=0.92u ps=0.92u
    I_MXI1_I42_I61_MP3 (XI1_I42_I61_p1 XI1_I42_I61_Bn VDD VDD) gpdk090_pmos1v w=0.48u l=0.1u ad=0.1632p as=0.1056p pd=1.64u ps=0.92u
    I_MXI1_I42_I61_MP0 (VDD A_29 XI1_I42_I61_An VDD) gpdk090_pmos1v w=0.24u l=0.1u ad=0.0816p as=0.0816p pd=1.16u ps=1.16u
    I_MXI1_I42_I231_MP1 (VDD I1_I42_G27_0 XI1_I42_I231_Bn VDD) gpdk090_pmos1v w=0.24u l=0.1u ad=0.0816p as=0.0816p pd=1.16u ps=1.16u
    I_MXI1_I42_I231_MP5 (S_28 I1_I42_G27_0 XI1_I42_I231_p1 VDD) gpdk090_pmos1v w=0.48u l=0.1u ad=0.1056p as=0.1632p pd=0.92u ps=1.64u
    I_MXI1_I42_I231_MP4 (XI1_I42_I231_p1 XI1_I42_I231_An S_28 VDD) gpdk090_pmos1v w=0.48u l=0.1u ad=0.1056p as=0.1056p pd=0.92u ps=0.92u
    I_MXI1_I42_I231_MP2 (VDD I1_I42_pn28 XI1_I42_I231_p1 VDD) gpdk090_pmos1v w=0.48u l=0.1u ad=0.1056p as=0.1056p pd=0.92u ps=0.92u
    I_MXI1_I42_I231_MP3 (XI1_I42_I231_p1 XI1_I42_I231_Bn VDD VDD) gpdk090_pmos1v w=0.48u l=0.1u ad=0.1632p as=0.1056p pd=1.64u ps=0.92u
    I_MXI1_I42_I231_MP0 (VDD I1_I42_pn28 XI1_I42_I231_An VDD) gpdk090_pmos1v w=0.24u l=0.1u ad=0.0816p as=0.0816p pd=1.16u ps=1.16u
    I_MXI1_I42_I46_MP1 (VDD I1_bx14 XI1_I42_I46_Bn VDD) gpdk090_pmos1v w=0.24u l=0.1u ad=0.0816p as=0.0816p pd=1.16u ps=1.16u
    I_MXI1_I42_I46_MP5 (I1_I42_pn14 I1_bx14 XI1_I42_I46_p1 VDD) gpdk090_pmos1v w=0.48u l=0.1u ad=0.1056p as=0.1632p pd=0.92u ps=1.64u
    I_MXI1_I42_I46_MP4 (XI1_I42_I46_p1 XI1_I42_I46_An I1_I42_pn14 VDD) gpdk090_pmos1v w=0.48u l=0.1u ad=0.1056p as=0.1056p pd=0.92u ps=0.92u
    I_MXI1_I42_I46_MP2 (VDD A_14 XI1_I42_I46_p1 VDD) gpdk090_pmos1v w=0.48u l=0.1u ad=0.1056p as=0.1056p pd=0.92u ps=0.92u
    I_MXI1_I42_I46_MP3 (XI1_I42_I46_p1 XI1_I42_I46_Bn VDD VDD) gpdk090_pmos1v w=0.48u l=0.1u ad=0.1632p as=0.1056p pd=1.64u ps=0.92u
    I_MXI1_I42_I46_MP0 (VDD A_14 XI1_I42_I46_An VDD) gpdk090_pmos1v w=0.24u l=0.1u ad=0.0816p as=0.0816p pd=1.16u ps=1.16u
    I_MXI1_I42_I60_MP1 (VDD I1_bx28 XI1_I42_I60_Bn VDD) gpdk090_pmos1v w=0.24u l=0.1u ad=0.0816p as=0.0816p pd=1.16u ps=1.16u
    I_MXI1_I42_I60_MP5 (I1_I42_pn28 I1_bx28 XI1_I42_I60_p1 VDD) gpdk090_pmos1v w=0.48u l=0.1u ad=0.1056p as=0.1632p pd=0.92u ps=1.64u
    I_MXI1_I42_I60_MP4 (XI1_I42_I60_p1 XI1_I42_I60_An I1_I42_pn28 VDD) gpdk090_pmos1v w=0.48u l=0.1u ad=0.1056p as=0.1056p pd=0.92u ps=0.92u
    I_MXI1_I42_I60_MP2 (VDD A_28 XI1_I42_I60_p1 VDD) gpdk090_pmos1v w=0.48u l=0.1u ad=0.1056p as=0.1056p pd=0.92u ps=0.92u
    I_MXI1_I42_I60_MP3 (XI1_I42_I60_p1 XI1_I42_I60_Bn VDD VDD) gpdk090_pmos1v w=0.48u l=0.1u ad=0.1632p as=0.1056p pd=1.64u ps=0.92u
    I_MXI1_I42_I60_MP0 (VDD A_28 XI1_I42_I60_An VDD) gpdk090_pmos1v w=0.24u l=0.1u ad=0.0816p as=0.0816p pd=1.16u ps=1.16u
    I_MXI1_I42_I230_MP1 (VDD I1_I42_G26_0 XI1_I42_I230_Bn VDD) gpdk090_pmos1v w=0.24u l=0.1u ad=0.0816p as=0.0816p pd=1.16u ps=1.16u
    I_MXI1_I42_I230_MP5 (S_27 I1_I42_G26_0 XI1_I42_I230_p1 VDD) gpdk090_pmos1v w=0.48u l=0.1u ad=0.1056p as=0.1632p pd=0.92u ps=1.64u
    I_MXI1_I42_I230_MP4 (XI1_I42_I230_p1 XI1_I42_I230_An S_27 VDD) gpdk090_pmos1v w=0.48u l=0.1u ad=0.1056p as=0.1056p pd=0.92u ps=0.92u
    I_MXI1_I42_I230_MP2 (VDD I1_I42_pn27 XI1_I42_I230_p1 VDD) gpdk090_pmos1v w=0.48u l=0.1u ad=0.1056p as=0.1056p pd=0.92u ps=0.92u
    I_MXI1_I42_I230_MP3 (XI1_I42_I230_p1 XI1_I42_I230_Bn VDD VDD) gpdk090_pmos1v w=0.48u l=0.1u ad=0.1632p as=0.1056p pd=1.64u ps=0.92u
    I_MXI1_I42_I230_MP0 (VDD I1_I42_pn27 XI1_I42_I230_An VDD) gpdk090_pmos1v w=0.24u l=0.1u ad=0.0816p as=0.0816p pd=1.16u ps=1.16u
    I_MXI1_I42_I59_MP1 (VDD I1_bx27 XI1_I42_I59_Bn VDD) gpdk090_pmos1v w=0.24u l=0.1u ad=0.0816p as=0.0816p pd=1.16u ps=1.16u
    I_MXI1_I42_I59_MP5 (I1_I42_pn27 I1_bx27 XI1_I42_I59_p1 VDD) gpdk090_pmos1v w=0.48u l=0.1u ad=0.1056p as=0.1632p pd=0.92u ps=1.64u
    I_MXI1_I42_I59_MP4 (XI1_I42_I59_p1 XI1_I42_I59_An I1_I42_pn27 VDD) gpdk090_pmos1v w=0.48u l=0.1u ad=0.1056p as=0.1056p pd=0.92u ps=0.92u
    I_MXI1_I42_I59_MP2 (VDD A_27 XI1_I42_I59_p1 VDD) gpdk090_pmos1v w=0.48u l=0.1u ad=0.1056p as=0.1056p pd=0.92u ps=0.92u
    I_MXI1_I42_I59_MP3 (XI1_I42_I59_p1 XI1_I42_I59_Bn VDD VDD) gpdk090_pmos1v w=0.48u l=0.1u ad=0.1632p as=0.1056p pd=1.64u ps=0.92u
    I_MXI1_I42_I59_MP0 (VDD A_27 XI1_I42_I59_An VDD) gpdk090_pmos1v w=0.24u l=0.1u ad=0.0816p as=0.0816p pd=1.16u ps=1.16u
    I_MXI1_I42_I229_MP1 (VDD I1_I42_G25_0 XI1_I42_I229_Bn VDD) gpdk090_pmos1v w=0.24u l=0.1u ad=0.0816p as=0.0816p pd=1.16u ps=1.16u
    I_MXI1_I42_I229_MP5 (S_26 I1_I42_G25_0 XI1_I42_I229_p1 VDD) gpdk090_pmos1v w=0.48u l=0.1u ad=0.1056p as=0.1632p pd=0.92u ps=1.64u
    I_MXI1_I42_I229_MP4 (XI1_I42_I229_p1 XI1_I42_I229_An S_26 VDD) gpdk090_pmos1v w=0.48u l=0.1u ad=0.1056p as=0.1056p pd=0.92u ps=0.92u
    I_MXI1_I42_I229_MP2 (VDD I1_I42_pn26 XI1_I42_I229_p1 VDD) gpdk090_pmos1v w=0.48u l=0.1u ad=0.1056p as=0.1056p pd=0.92u ps=0.92u
    I_MXI1_I42_I229_MP3 (XI1_I42_I229_p1 XI1_I42_I229_Bn VDD VDD) gpdk090_pmos1v w=0.48u l=0.1u ad=0.1632p as=0.1056p pd=1.64u ps=0.92u
    I_MXI1_I42_I229_MP0 (VDD I1_I42_pn26 XI1_I42_I229_An VDD) gpdk090_pmos1v w=0.24u l=0.1u ad=0.0816p as=0.0816p pd=1.16u ps=1.16u
    I_MXI1_I42_I227_MP1 (VDD I1_I42_G23_0 XI1_I42_I227_Bn VDD) gpdk090_pmos1v w=0.24u l=0.1u ad=0.0816p as=0.0816p pd=1.16u ps=1.16u
    I_MXI1_I42_I227_MP5 (S_24 I1_I42_G23_0 XI1_I42_I227_p1 VDD) gpdk090_pmos1v w=0.48u l=0.1u ad=0.1056p as=0.1632p pd=0.92u ps=1.64u
    I_MXI1_I42_I227_MP4 (XI1_I42_I227_p1 XI1_I42_I227_An S_24 VDD) gpdk090_pmos1v w=0.48u l=0.1u ad=0.1056p as=0.1056p pd=0.92u ps=0.92u
    I_MXI1_I42_I227_MP2 (VDD I1_I42_pn24 XI1_I42_I227_p1 VDD) gpdk090_pmos1v w=0.48u l=0.1u ad=0.1056p as=0.1056p pd=0.92u ps=0.92u
    I_MXI1_I42_I227_MP3 (XI1_I42_I227_p1 XI1_I42_I227_Bn VDD VDD) gpdk090_pmos1v w=0.48u l=0.1u ad=0.1632p as=0.1056p pd=1.64u ps=0.92u
    I_MXI1_I42_I227_MP0 (VDD I1_I42_pn24 XI1_I42_I227_An VDD) gpdk090_pmos1v w=0.24u l=0.1u ad=0.0816p as=0.0816p pd=1.16u ps=1.16u
    I_MXI1_I42_I226_MP1 (VDD I1_I42_G22_0 XI1_I42_I226_Bn VDD) gpdk090_pmos1v w=0.24u l=0.1u ad=0.0816p as=0.0816p pd=1.16u ps=1.16u
    I_MXI1_I42_I226_MP5 (S_23 I1_I42_G22_0 XI1_I42_I226_p1 VDD) gpdk090_pmos1v w=0.48u l=0.1u ad=0.1056p as=0.1632p pd=0.92u ps=1.64u
    I_MXI1_I42_I226_MP4 (XI1_I42_I226_p1 XI1_I42_I226_An S_23 VDD) gpdk090_pmos1v w=0.48u l=0.1u ad=0.1056p as=0.1056p pd=0.92u ps=0.92u
    I_MXI1_I42_I226_MP2 (VDD I1_I42_pn23 XI1_I42_I226_p1 VDD) gpdk090_pmos1v w=0.48u l=0.1u ad=0.1056p as=0.1056p pd=0.92u ps=0.92u
    I_MXI1_I42_I226_MP3 (XI1_I42_I226_p1 XI1_I42_I226_Bn VDD VDD) gpdk090_pmos1v w=0.48u l=0.1u ad=0.1632p as=0.1056p pd=1.64u ps=0.92u
    I_MXI1_I42_I226_MP0 (VDD I1_I42_pn23 XI1_I42_I226_An VDD) gpdk090_pmos1v w=0.24u l=0.1u ad=0.0816p as=0.0816p pd=1.16u ps=1.16u
    I_MXI1_I42_I222_MP1 (VDD I1_I42_G18_0 XI1_I42_I222_Bn VDD) gpdk090_pmos1v w=0.24u l=0.1u ad=0.0816p as=0.0816p pd=1.16u ps=1.16u
    I_MXI1_I42_I222_MP5 (S_19 I1_I42_G18_0 XI1_I42_I222_p1 VDD) gpdk090_pmos1v w=0.48u l=0.1u ad=0.1056p as=0.1632p pd=0.92u ps=1.64u
    I_MXI1_I42_I222_MP4 (XI1_I42_I222_p1 XI1_I42_I222_An S_19 VDD) gpdk090_pmos1v w=0.48u l=0.1u ad=0.1056p as=0.1056p pd=0.92u ps=0.92u
    I_MXI1_I42_I222_MP2 (VDD I1_I42_pn19 XI1_I42_I222_p1 VDD) gpdk090_pmos1v w=0.48u l=0.1u ad=0.1056p as=0.1056p pd=0.92u ps=0.92u
    I_MXI1_I42_I222_MP3 (XI1_I42_I222_p1 XI1_I42_I222_Bn VDD VDD) gpdk090_pmos1v w=0.48u l=0.1u ad=0.1632p as=0.1056p pd=1.64u ps=0.92u
    I_MXI1_I42_I222_MP0 (VDD I1_I42_pn19 XI1_I42_I222_An VDD) gpdk090_pmos1v w=0.24u l=0.1u ad=0.0816p as=0.0816p pd=1.16u ps=1.16u
    I_MXI1_I42_I47_MP1 (VDD I1_bx15 XI1_I42_I47_Bn VDD) gpdk090_pmos1v w=0.24u l=0.1u ad=0.0816p as=0.0816p pd=1.16u ps=1.16u
    I_MXI1_I42_I47_MP5 (I1_I42_pn15 I1_bx15 XI1_I42_I47_p1 VDD) gpdk090_pmos1v w=0.48u l=0.1u ad=0.1056p as=0.1632p pd=0.92u ps=1.64u
    I_MXI1_I42_I47_MP4 (XI1_I42_I47_p1 XI1_I42_I47_An I1_I42_pn15 VDD) gpdk090_pmos1v w=0.48u l=0.1u ad=0.1056p as=0.1056p pd=0.92u ps=0.92u
    I_MXI1_I42_I47_MP2 (VDD A_15 XI1_I42_I47_p1 VDD) gpdk090_pmos1v w=0.48u l=0.1u ad=0.1056p as=0.1056p pd=0.92u ps=0.92u
    I_MXI1_I42_I47_MP3 (XI1_I42_I47_p1 XI1_I42_I47_Bn VDD VDD) gpdk090_pmos1v w=0.48u l=0.1u ad=0.1632p as=0.1056p pd=1.64u ps=0.92u
    I_MXI1_I42_I47_MP0 (VDD A_15 XI1_I42_I47_An VDD) gpdk090_pmos1v w=0.24u l=0.1u ad=0.0816p as=0.0816p pd=1.16u ps=1.16u
    I_MXI1_I42_I58_MP1 (VDD I1_bx26 XI1_I42_I58_Bn VDD) gpdk090_pmos1v w=0.24u l=0.1u ad=0.0816p as=0.0816p pd=1.16u ps=1.16u
    I_MXI1_I42_I58_MP5 (I1_I42_pn26 I1_bx26 XI1_I42_I58_p1 VDD) gpdk090_pmos1v w=0.48u l=0.1u ad=0.1056p as=0.1632p pd=0.92u ps=1.64u
    I_MXI1_I42_I58_MP4 (XI1_I42_I58_p1 XI1_I42_I58_An I1_I42_pn26 VDD) gpdk090_pmos1v w=0.48u l=0.1u ad=0.1056p as=0.1056p pd=0.92u ps=0.92u
    I_MXI1_I42_I58_MP2 (VDD A_26 XI1_I42_I58_p1 VDD) gpdk090_pmos1v w=0.48u l=0.1u ad=0.1056p as=0.1056p pd=0.92u ps=0.92u
    I_MXI1_I42_I58_MP3 (XI1_I42_I58_p1 XI1_I42_I58_Bn VDD VDD) gpdk090_pmos1v w=0.48u l=0.1u ad=0.1632p as=0.1056p pd=1.64u ps=0.92u
    I_MXI1_I42_I58_MP0 (VDD A_26 XI1_I42_I58_An VDD) gpdk090_pmos1v w=0.24u l=0.1u ad=0.0816p as=0.0816p pd=1.16u ps=1.16u
    I_MXI1_I42_I228_MP1 (VDD I1_I42_G24_0 XI1_I42_I228_Bn VDD) gpdk090_pmos1v w=0.24u l=0.1u ad=0.0816p as=0.0816p pd=1.16u ps=1.16u
    I_MXI1_I42_I228_MP5 (S_25 I1_I42_G24_0 XI1_I42_I228_p1 VDD) gpdk090_pmos1v w=0.48u l=0.1u ad=0.1056p as=0.1632p pd=0.92u ps=1.64u
    I_MXI1_I42_I228_MP4 (XI1_I42_I228_p1 XI1_I42_I228_An S_25 VDD) gpdk090_pmos1v w=0.48u l=0.1u ad=0.1056p as=0.1056p pd=0.92u ps=0.92u
    I_MXI1_I42_I228_MP2 (VDD I1_I42_pn25 XI1_I42_I228_p1 VDD) gpdk090_pmos1v w=0.48u l=0.1u ad=0.1056p as=0.1056p pd=0.92u ps=0.92u
    I_MXI1_I42_I228_MP3 (XI1_I42_I228_p1 XI1_I42_I228_Bn VDD VDD) gpdk090_pmos1v w=0.48u l=0.1u ad=0.1632p as=0.1056p pd=1.64u ps=0.92u
    I_MXI1_I42_I228_MP0 (VDD I1_I42_pn25 XI1_I42_I228_An VDD) gpdk090_pmos1v w=0.24u l=0.1u ad=0.0816p as=0.0816p pd=1.16u ps=1.16u
    I_MXI1_I42_I56_MP1 (VDD I1_bx24 XI1_I42_I56_Bn VDD) gpdk090_pmos1v w=0.24u l=0.1u ad=0.0816p as=0.0816p pd=1.16u ps=1.16u
    I_MXI1_I42_I56_MP5 (I1_I42_pn24 I1_bx24 XI1_I42_I56_p1 VDD) gpdk090_pmos1v w=0.48u l=0.1u ad=0.1056p as=0.1632p pd=0.92u ps=1.64u
    I_MXI1_I42_I56_MP4 (XI1_I42_I56_p1 XI1_I42_I56_An I1_I42_pn24 VDD) gpdk090_pmos1v w=0.48u l=0.1u ad=0.1056p as=0.1056p pd=0.92u ps=0.92u
    I_MXI1_I42_I56_MP2 (VDD A_24 XI1_I42_I56_p1 VDD) gpdk090_pmos1v w=0.48u l=0.1u ad=0.1056p as=0.1056p pd=0.92u ps=0.92u
    I_MXI1_I42_I56_MP3 (XI1_I42_I56_p1 XI1_I42_I56_Bn VDD VDD) gpdk090_pmos1v w=0.48u l=0.1u ad=0.1632p as=0.1056p pd=1.64u ps=0.92u
    I_MXI1_I42_I56_MP0 (VDD A_24 XI1_I42_I56_An VDD) gpdk090_pmos1v w=0.24u l=0.1u ad=0.0816p as=0.0816p pd=1.16u ps=1.16u
    I_MXI1_I42_I55_MP1 (VDD I1_bx23 XI1_I42_I55_Bn VDD) gpdk090_pmos1v w=0.24u l=0.1u ad=0.0816p as=0.0816p pd=1.16u ps=1.16u
    I_MXI1_I42_I55_MP5 (I1_I42_pn23 I1_bx23 XI1_I42_I55_p1 VDD) gpdk090_pmos1v w=0.48u l=0.1u ad=0.1056p as=0.1632p pd=0.92u ps=1.64u
    I_MXI1_I42_I55_MP4 (XI1_I42_I55_p1 XI1_I42_I55_An I1_I42_pn23 VDD) gpdk090_pmos1v w=0.48u l=0.1u ad=0.1056p as=0.1056p pd=0.92u ps=0.92u
    I_MXI1_I42_I55_MP2 (VDD A_23 XI1_I42_I55_p1 VDD) gpdk090_pmos1v w=0.48u l=0.1u ad=0.1056p as=0.1056p pd=0.92u ps=0.92u
    I_MXI1_I42_I55_MP3 (XI1_I42_I55_p1 XI1_I42_I55_Bn VDD VDD) gpdk090_pmos1v w=0.48u l=0.1u ad=0.1632p as=0.1056p pd=1.64u ps=0.92u
    I_MXI1_I42_I55_MP0 (VDD A_23 XI1_I42_I55_An VDD) gpdk090_pmos1v w=0.24u l=0.1u ad=0.0816p as=0.0816p pd=1.16u ps=1.16u
    I_MXI1_I42_I225_MP1 (VDD I1_I42_G21_0 XI1_I42_I225_Bn VDD) gpdk090_pmos1v w=0.24u l=0.1u ad=0.0816p as=0.0816p pd=1.16u ps=1.16u
    I_MXI1_I42_I225_MP5 (S_22 I1_I42_G21_0 XI1_I42_I225_p1 VDD) gpdk090_pmos1v w=0.48u l=0.1u ad=0.1056p as=0.1632p pd=0.92u ps=1.64u
    I_MXI1_I42_I225_MP4 (XI1_I42_I225_p1 XI1_I42_I225_An S_22 VDD) gpdk090_pmos1v w=0.48u l=0.1u ad=0.1056p as=0.1056p pd=0.92u ps=0.92u
    I_MXI1_I42_I225_MP2 (VDD I1_I42_pn22 XI1_I42_I225_p1 VDD) gpdk090_pmos1v w=0.48u l=0.1u ad=0.1056p as=0.1056p pd=0.92u ps=0.92u
    I_MXI1_I42_I225_MP3 (XI1_I42_I225_p1 XI1_I42_I225_Bn VDD VDD) gpdk090_pmos1v w=0.48u l=0.1u ad=0.1632p as=0.1056p pd=1.64u ps=0.92u
    I_MXI1_I42_I225_MP0 (VDD I1_I42_pn22 XI1_I42_I225_An VDD) gpdk090_pmos1v w=0.24u l=0.1u ad=0.0816p as=0.0816p pd=1.16u ps=1.16u
    I_MXI1_I42_I53_MP1 (VDD I1_bx21 XI1_I42_I53_Bn VDD) gpdk090_pmos1v w=0.24u l=0.1u ad=0.0816p as=0.0816p pd=1.16u ps=1.16u
    I_MXI1_I42_I53_MP5 (I1_I42_pn21 I1_bx21 XI1_I42_I53_p1 VDD) gpdk090_pmos1v w=0.48u l=0.1u ad=0.1056p as=0.1632p pd=0.92u ps=1.64u
    I_MXI1_I42_I53_MP4 (XI1_I42_I53_p1 XI1_I42_I53_An I1_I42_pn21 VDD) gpdk090_pmos1v w=0.48u l=0.1u ad=0.1056p as=0.1056p pd=0.92u ps=0.92u
    I_MXI1_I42_I53_MP2 (VDD A_21 XI1_I42_I53_p1 VDD) gpdk090_pmos1v w=0.48u l=0.1u ad=0.1056p as=0.1056p pd=0.92u ps=0.92u
    I_MXI1_I42_I53_MP3 (XI1_I42_I53_p1 XI1_I42_I53_Bn VDD VDD) gpdk090_pmos1v w=0.48u l=0.1u ad=0.1632p as=0.1056p pd=1.64u ps=0.92u
    I_MXI1_I42_I53_MP0 (VDD A_21 XI1_I42_I53_An VDD) gpdk090_pmos1v w=0.24u l=0.1u ad=0.0816p as=0.0816p pd=1.16u ps=1.16u
    I_MXI1_I42_I224_MP1 (VDD I1_I42_G20_0 XI1_I42_I224_Bn VDD) gpdk090_pmos1v w=0.24u l=0.1u ad=0.0816p as=0.0816p pd=1.16u ps=1.16u
    I_MXI1_I42_I224_MP5 (S_21 I1_I42_G20_0 XI1_I42_I224_p1 VDD) gpdk090_pmos1v w=0.48u l=0.1u ad=0.1056p as=0.1632p pd=0.92u ps=1.64u
    I_MXI1_I42_I224_MP4 (XI1_I42_I224_p1 XI1_I42_I224_An S_21 VDD) gpdk090_pmos1v w=0.48u l=0.1u ad=0.1056p as=0.1056p pd=0.92u ps=0.92u
    I_MXI1_I42_I224_MP2 (VDD I1_I42_pn21 XI1_I42_I224_p1 VDD) gpdk090_pmos1v w=0.48u l=0.1u ad=0.1056p as=0.1056p pd=0.92u ps=0.92u
    I_MXI1_I42_I224_MP3 (XI1_I42_I224_p1 XI1_I42_I224_Bn VDD VDD) gpdk090_pmos1v w=0.48u l=0.1u ad=0.1632p as=0.1056p pd=1.64u ps=0.92u
    I_MXI1_I42_I224_MP0 (VDD I1_I42_pn21 XI1_I42_I224_An VDD) gpdk090_pmos1v w=0.24u l=0.1u ad=0.0816p as=0.0816p pd=1.16u ps=1.16u
    I_MXI1_I42_I52_MP1 (VDD I1_bx20 XI1_I42_I52_Bn VDD) gpdk090_pmos1v w=0.24u l=0.1u ad=0.0816p as=0.0816p pd=1.16u ps=1.16u
    I_MXI1_I42_I52_MP5 (I1_I42_pn20 I1_bx20 XI1_I42_I52_p1 VDD) gpdk090_pmos1v w=0.48u l=0.1u ad=0.1056p as=0.1632p pd=0.92u ps=1.64u
    I_MXI1_I42_I52_MP4 (XI1_I42_I52_p1 XI1_I42_I52_An I1_I42_pn20 VDD) gpdk090_pmos1v w=0.48u l=0.1u ad=0.1056p as=0.1056p pd=0.92u ps=0.92u
    I_MXI1_I42_I52_MP2 (VDD A_20 XI1_I42_I52_p1 VDD) gpdk090_pmos1v w=0.48u l=0.1u ad=0.1056p as=0.1056p pd=0.92u ps=0.92u
    I_MXI1_I42_I52_MP3 (XI1_I42_I52_p1 XI1_I42_I52_Bn VDD VDD) gpdk090_pmos1v w=0.48u l=0.1u ad=0.1632p as=0.1056p pd=1.64u ps=0.92u
    I_MXI1_I42_I52_MP0 (VDD A_20 XI1_I42_I52_An VDD) gpdk090_pmos1v w=0.24u l=0.1u ad=0.0816p as=0.0816p pd=1.16u ps=1.16u
    I_MXI1_I42_I223_MP1 (VDD I1_I42_G19_0 XI1_I42_I223_Bn VDD) gpdk090_pmos1v w=0.24u l=0.1u ad=0.0816p as=0.0816p pd=1.16u ps=1.16u
    I_MXI1_I42_I223_MP5 (S_20 I1_I42_G19_0 XI1_I42_I223_p1 VDD) gpdk090_pmos1v w=0.48u l=0.1u ad=0.1056p as=0.1632p pd=0.92u ps=1.64u
    I_MXI1_I42_I223_MP4 (XI1_I42_I223_p1 XI1_I42_I223_An S_20 VDD) gpdk090_pmos1v w=0.48u l=0.1u ad=0.1056p as=0.1056p pd=0.92u ps=0.92u
    I_MXI1_I42_I223_MP2 (VDD I1_I42_pn20 XI1_I42_I223_p1 VDD) gpdk090_pmos1v w=0.48u l=0.1u ad=0.1056p as=0.1056p pd=0.92u ps=0.92u
    I_MXI1_I42_I223_MP3 (XI1_I42_I223_p1 XI1_I42_I223_Bn VDD VDD) gpdk090_pmos1v w=0.48u l=0.1u ad=0.1632p as=0.1056p pd=1.64u ps=0.92u
    I_MXI1_I42_I223_MP0 (VDD I1_I42_pn20 XI1_I42_I223_An VDD) gpdk090_pmos1v w=0.24u l=0.1u ad=0.0816p as=0.0816p pd=1.16u ps=1.16u
    I_MXI1_I42_I51_MP1 (VDD I1_bx19 XI1_I42_I51_Bn VDD) gpdk090_pmos1v w=0.24u l=0.1u ad=0.0816p as=0.0816p pd=1.16u ps=1.16u
    I_MXI1_I42_I51_MP5 (I1_I42_pn19 I1_bx19 XI1_I42_I51_p1 VDD) gpdk090_pmos1v w=0.48u l=0.1u ad=0.1056p as=0.1632p pd=0.92u ps=1.64u
    I_MXI1_I42_I51_MP4 (XI1_I42_I51_p1 XI1_I42_I51_An I1_I42_pn19 VDD) gpdk090_pmos1v w=0.48u l=0.1u ad=0.1056p as=0.1056p pd=0.92u ps=0.92u
    I_MXI1_I42_I51_MP2 (VDD A_19 XI1_I42_I51_p1 VDD) gpdk090_pmos1v w=0.48u l=0.1u ad=0.1056p as=0.1056p pd=0.92u ps=0.92u
    I_MXI1_I42_I51_MP3 (XI1_I42_I51_p1 XI1_I42_I51_Bn VDD VDD) gpdk090_pmos1v w=0.48u l=0.1u ad=0.1632p as=0.1056p pd=1.64u ps=0.92u
    I_MXI1_I42_I51_MP0 (VDD A_19 XI1_I42_I51_An VDD) gpdk090_pmos1v w=0.24u l=0.1u ad=0.0816p as=0.0816p pd=1.16u ps=1.16u
    I_MXI1_I42_I221_MP1 (VDD I1_I42_G17_0 XI1_I42_I221_Bn VDD) gpdk090_pmos1v w=0.24u l=0.1u ad=0.0816p as=0.0816p pd=1.16u ps=1.16u
    I_MXI1_I42_I221_MP5 (S_18 I1_I42_G17_0 XI1_I42_I221_p1 VDD) gpdk090_pmos1v w=0.48u l=0.1u ad=0.1056p as=0.1632p pd=0.92u ps=1.64u
    I_MXI1_I42_I221_MP4 (XI1_I42_I221_p1 XI1_I42_I221_An S_18 VDD) gpdk090_pmos1v w=0.48u l=0.1u ad=0.1056p as=0.1056p pd=0.92u ps=0.92u
    I_MXI1_I42_I221_MP2 (VDD I1_I42_pn18 XI1_I42_I221_p1 VDD) gpdk090_pmos1v w=0.48u l=0.1u ad=0.1056p as=0.1056p pd=0.92u ps=0.92u
    I_MXI1_I42_I221_MP3 (XI1_I42_I221_p1 XI1_I42_I221_Bn VDD VDD) gpdk090_pmos1v w=0.48u l=0.1u ad=0.1632p as=0.1056p pd=1.64u ps=0.92u
    I_MXI1_I42_I221_MP0 (VDD I1_I42_pn18 XI1_I42_I221_An VDD) gpdk090_pmos1v w=0.24u l=0.1u ad=0.0816p as=0.0816p pd=1.16u ps=1.16u
    I_MXI1_I42_I50_MP1 (VDD I1_bx18 XI1_I42_I50_Bn VDD) gpdk090_pmos1v w=0.24u l=0.1u ad=0.0816p as=0.0816p pd=1.16u ps=1.16u
    I_MXI1_I42_I50_MP5 (I1_I42_pn18 I1_bx18 XI1_I42_I50_p1 VDD) gpdk090_pmos1v w=0.48u l=0.1u ad=0.1056p as=0.1632p pd=0.92u ps=1.64u
    I_MXI1_I42_I50_MP4 (XI1_I42_I50_p1 XI1_I42_I50_An I1_I42_pn18 VDD) gpdk090_pmos1v w=0.48u l=0.1u ad=0.1056p as=0.1056p pd=0.92u ps=0.92u
    I_MXI1_I42_I50_MP2 (VDD A_18 XI1_I42_I50_p1 VDD) gpdk090_pmos1v w=0.48u l=0.1u ad=0.1056p as=0.1056p pd=0.92u ps=0.92u
    I_MXI1_I42_I50_MP3 (XI1_I42_I50_p1 XI1_I42_I50_Bn VDD VDD) gpdk090_pmos1v w=0.48u l=0.1u ad=0.1632p as=0.1056p pd=1.64u ps=0.92u
    I_MXI1_I42_I50_MP0 (VDD A_18 XI1_I42_I50_An VDD) gpdk090_pmos1v w=0.24u l=0.1u ad=0.0816p as=0.0816p pd=1.16u ps=1.16u
    I_MXI1_I42_I220_MP1 (VDD I1_I42_G16_0 XI1_I42_I220_Bn VDD) gpdk090_pmos1v w=0.24u l=0.1u ad=0.0816p as=0.0816p pd=1.16u ps=1.16u
    I_MXI1_I42_I220_MP5 (S_17 I1_I42_G16_0 XI1_I42_I220_p1 VDD) gpdk090_pmos1v w=0.48u l=0.1u ad=0.1056p as=0.1632p pd=0.92u ps=1.64u
    I_MXI1_I42_I220_MP4 (XI1_I42_I220_p1 XI1_I42_I220_An S_17 VDD) gpdk090_pmos1v w=0.48u l=0.1u ad=0.1056p as=0.1056p pd=0.92u ps=0.92u
    I_MXI1_I42_I220_MP2 (VDD I1_I42_pn17 XI1_I42_I220_p1 VDD) gpdk090_pmos1v w=0.48u l=0.1u ad=0.1056p as=0.1056p pd=0.92u ps=0.92u
    I_MXI1_I42_I220_MP3 (XI1_I42_I220_p1 XI1_I42_I220_Bn VDD VDD) gpdk090_pmos1v w=0.48u l=0.1u ad=0.1632p as=0.1056p pd=1.64u ps=0.92u
    I_MXI1_I42_I220_MP0 (VDD I1_I42_pn17 XI1_I42_I220_An VDD) gpdk090_pmos1v w=0.24u l=0.1u ad=0.0816p as=0.0816p pd=1.16u ps=1.16u
    I_MXI1_I42_I48_MP1 (VDD I1_bx16 XI1_I42_I48_Bn VDD) gpdk090_pmos1v w=0.24u l=0.1u ad=0.0816p as=0.0816p pd=1.16u ps=1.16u
    I_MXI1_I42_I48_MP5 (I1_I42_pn16 I1_bx16 XI1_I42_I48_p1 VDD) gpdk090_pmos1v w=0.48u l=0.1u ad=0.1056p as=0.1632p pd=0.92u ps=1.64u
    I_MXI1_I42_I48_MP4 (XI1_I42_I48_p1 XI1_I42_I48_An I1_I42_pn16 VDD) gpdk090_pmos1v w=0.48u l=0.1u ad=0.1056p as=0.1056p pd=0.92u ps=0.92u
    I_MXI1_I42_I48_MP2 (VDD A_16 XI1_I42_I48_p1 VDD) gpdk090_pmos1v w=0.48u l=0.1u ad=0.1056p as=0.1056p pd=0.92u ps=0.92u
    I_MXI1_I42_I48_MP3 (XI1_I42_I48_p1 XI1_I42_I48_Bn VDD VDD) gpdk090_pmos1v w=0.48u l=0.1u ad=0.1632p as=0.1056p pd=1.64u ps=0.92u
    I_MXI1_I42_I48_MP0 (VDD A_16 XI1_I42_I48_An VDD) gpdk090_pmos1v w=0.24u l=0.1u ad=0.0816p as=0.0816p pd=1.16u ps=1.16u
    I_MXI1_I42_I57_MP1 (VDD I1_bx25 XI1_I42_I57_Bn VDD) gpdk090_pmos1v w=0.24u l=0.1u ad=0.0816p as=0.0816p pd=1.16u ps=1.16u
    I_MXI1_I42_I57_MP5 (I1_I42_pn25 I1_bx25 XI1_I42_I57_p1 VDD) gpdk090_pmos1v w=0.48u l=0.1u ad=0.1056p as=0.1632p pd=0.92u ps=1.64u
    I_MXI1_I42_I57_MP4 (XI1_I42_I57_p1 XI1_I42_I57_An I1_I42_pn25 VDD) gpdk090_pmos1v w=0.48u l=0.1u ad=0.1056p as=0.1056p pd=0.92u ps=0.92u
    I_MXI1_I42_I57_MP2 (VDD A_25 XI1_I42_I57_p1 VDD) gpdk090_pmos1v w=0.48u l=0.1u ad=0.1056p as=0.1056p pd=0.92u ps=0.92u
    I_MXI1_I42_I57_MP3 (XI1_I42_I57_p1 XI1_I42_I57_Bn VDD VDD) gpdk090_pmos1v w=0.48u l=0.1u ad=0.1632p as=0.1056p pd=1.64u ps=0.92u
    I_MXI1_I42_I57_MP0 (VDD A_25 XI1_I42_I57_An VDD) gpdk090_pmos1v w=0.24u l=0.1u ad=0.0816p as=0.0816p pd=1.16u ps=1.16u
    I_MXI1_I42_I54_MP1 (VDD I1_bx22 XI1_I42_I54_Bn VDD) gpdk090_pmos1v w=0.24u l=0.1u ad=0.0816p as=0.0816p pd=1.16u ps=1.16u
    I_MXI1_I42_I54_MP5 (I1_I42_pn22 I1_bx22 XI1_I42_I54_p1 VDD) gpdk090_pmos1v w=0.48u l=0.1u ad=0.1056p as=0.1632p pd=0.92u ps=1.64u
    I_MXI1_I42_I54_MP4 (XI1_I42_I54_p1 XI1_I42_I54_An I1_I42_pn22 VDD) gpdk090_pmos1v w=0.48u l=0.1u ad=0.1056p as=0.1056p pd=0.92u ps=0.92u
    I_MXI1_I42_I54_MP2 (VDD A_22 XI1_I42_I54_p1 VDD) gpdk090_pmos1v w=0.48u l=0.1u ad=0.1056p as=0.1056p pd=0.92u ps=0.92u
    I_MXI1_I42_I54_MP3 (XI1_I42_I54_p1 XI1_I42_I54_Bn VDD VDD) gpdk090_pmos1v w=0.48u l=0.1u ad=0.1632p as=0.1056p pd=1.64u ps=0.92u
    I_MXI1_I42_I54_MP0 (VDD A_22 XI1_I42_I54_An VDD) gpdk090_pmos1v w=0.24u l=0.1u ad=0.0816p as=0.0816p pd=1.16u ps=1.16u
    I_MXI1_I42_I49_MP1 (VDD I1_bx17 XI1_I42_I49_Bn VDD) gpdk090_pmos1v w=0.24u l=0.1u ad=0.0816p as=0.0816p pd=1.16u ps=1.16u
    I_MXI1_I42_I49_MP5 (I1_I42_pn17 I1_bx17 XI1_I42_I49_p1 VDD) gpdk090_pmos1v w=0.48u l=0.1u ad=0.1056p as=0.1632p pd=0.92u ps=1.64u
    I_MXI1_I42_I49_MP4 (XI1_I42_I49_p1 XI1_I42_I49_An I1_I42_pn17 VDD) gpdk090_pmos1v w=0.48u l=0.1u ad=0.1056p as=0.1056p pd=0.92u ps=0.92u
    I_MXI1_I42_I49_MP2 (VDD A_17 XI1_I42_I49_p1 VDD) gpdk090_pmos1v w=0.48u l=0.1u ad=0.1056p as=0.1056p pd=0.92u ps=0.92u
    I_MXI1_I42_I49_MP3 (XI1_I42_I49_p1 XI1_I42_I49_Bn VDD VDD) gpdk090_pmos1v w=0.48u l=0.1u ad=0.1632p as=0.1056p pd=1.64u ps=0.92u
    I_MXI1_I42_I49_MP0 (VDD A_17 XI1_I42_I49_An VDD) gpdk090_pmos1v w=0.24u l=0.1u ad=0.0816p as=0.0816p pd=1.16u ps=1.16u
    I_MXI3_I69_MP2 (I3_SEL_DIV_b3_8 I3_SEL_DIV_b2_2 VDD VDD) gpdk090_pmos1v w=0.48u l=0.1u ad=0.1056p as=0.1632p pd=0.92u ps=1.64u
    I_MXI3_I69_MP2_1 (VDD I3_SEL_DIV_b2_2 I3_SEL_DIV_b3_8 VDD) gpdk090_pmos1v w=0.48u l=0.1u ad=0.1632p as=0.1056p pd=1.64u ps=0.92u
    I_MXI3_I70_MP2 (I3_SEL_DIV_b3_9 I3_SEL_DIV_b2_2 VDD VDD) gpdk090_pmos1v w=0.48u l=0.1u ad=0.1056p as=0.1632p pd=0.92u ps=1.64u
    I_MXI3_I70_MP2_1 (VDD I3_SEL_DIV_b2_2 I3_SEL_DIV_b3_9 VDD) gpdk090_pmos1v w=0.48u l=0.1u ad=0.1632p as=0.1056p pd=1.64u ps=0.92u
    I_MXI3_I54_MP2 (I3_SEL_MUL_b3_9 I3_SEL_MUL_b2_2 VDD VDD) gpdk090_pmos1v w=0.48u l=0.1u ad=0.1056p as=0.1632p pd=0.92u ps=1.64u
    I_MXI3_I54_MP2_1 (VDD I3_SEL_MUL_b2_2 I3_SEL_MUL_b3_9 VDD) gpdk090_pmos1v w=0.48u l=0.1u ad=0.1632p as=0.1056p pd=1.64u ps=0.92u
    I_MXI3_I55_MP2 (I3_SEL_MUL_b3_10 I3_SEL_MUL_b2_2 VDD VDD) gpdk090_pmos1v w=0.48u l=0.1u ad=0.1056p as=0.1632p pd=0.92u ps=1.64u
    I_MXI3_I55_MP2_1 (VDD I3_SEL_MUL_b2_2 I3_SEL_MUL_b3_10 VDD) gpdk090_pmos1v w=0.48u l=0.1u ad=0.1632p as=0.1056p pd=1.64u ps=0.92u
    I_MXI3_I71_MP2 (I3_SEL_DIV_b3_10 I3_SEL_DIV_b2_2 VDD VDD) gpdk090_pmos1v w=0.48u l=0.1u ad=0.1056p as=0.1632p pd=0.92u ps=1.64u
    I_MXI3_I71_MP2_1 (VDD I3_SEL_DIV_b2_2 I3_SEL_DIV_b3_10 VDD) gpdk090_pmos1v w=0.48u l=0.1u ad=0.1632p as=0.1056p pd=1.64u ps=0.92u
    I_MXI3_I53_MP2 (I3_SEL_MUL_b3_8 I3_SEL_MUL_b2_2 VDD VDD) gpdk090_pmos1v w=0.48u l=0.1u ad=0.1056p as=0.1632p pd=0.92u ps=1.64u
    I_MXI3_I53_MP2_1 (VDD I3_SEL_MUL_b2_2 I3_SEL_MUL_b3_8 VDD) gpdk090_pmos1v w=0.48u l=0.1u ad=0.1632p as=0.1056p pd=1.64u ps=0.92u
    I_MXI3_I44_MP2 (I3_SEL_MUL_b2_2 I3_SEL_MUL_b1_0 VDD VDD) gpdk090_pmos1v w=0.48u l=0.1u ad=0.1056p as=0.1632p pd=0.92u ps=1.64u
    I_MXI3_I44_MP2_1 (VDD I3_SEL_MUL_b1_0 I3_SEL_MUL_b2_2 VDD) gpdk090_pmos1v w=0.48u l=0.1u ad=0.1632p as=0.1056p pd=1.64u ps=0.92u
    I_MXI3_I60_MP2 (I3_SEL_DIV_b2_2 I3_SEL_DIV_b1_0 VDD VDD) gpdk090_pmos1v w=0.48u l=0.1u ad=0.1056p as=0.1632p pd=0.92u ps=1.64u
    I_MXI3_I60_MP2_1 (VDD I3_SEL_DIV_b1_0 I3_SEL_DIV_b2_2 VDD) gpdk090_pmos1v w=0.48u l=0.1u ad=0.1632p as=0.1056p pd=1.64u ps=0.92u
    I_MXI3_I46_MP2 (I3_SEL_MUL_b3_1 I3_SEL_MUL_b2_0 VDD VDD) gpdk090_pmos1v w=0.48u l=0.1u ad=0.1056p as=0.1632p pd=0.92u ps=1.64u
    I_MXI3_I46_MP2_1 (VDD I3_SEL_MUL_b2_0 I3_SEL_MUL_b3_1 VDD) gpdk090_pmos1v w=0.48u l=0.1u ad=0.1632p as=0.1056p pd=1.64u ps=0.92u
    I_MXI3_I62_MP2 (I3_SEL_DIV_b3_1 I3_SEL_DIV_b2_0 VDD VDD) gpdk090_pmos1v w=0.48u l=0.1u ad=0.1056p as=0.1632p pd=0.92u ps=1.64u
    I_MXI3_I62_MP2_1 (VDD I3_SEL_DIV_b2_0 I3_SEL_DIV_b3_1 VDD) gpdk090_pmos1v w=0.48u l=0.1u ad=0.1632p as=0.1056p pd=1.64u ps=0.92u
    I_MXI3_I25_MP2 (I3_SEL_XOR_b3_1 I3_SEL_XOR_b2_0 VDD VDD) gpdk090_pmos1v w=0.48u l=0.1u ad=0.1056p as=0.1632p pd=0.92u ps=1.64u
    I_MXI3_I25_MP2_1 (VDD I3_SEL_XOR_b2_0 I3_SEL_XOR_b3_1 VDD) gpdk090_pmos1v w=0.48u l=0.1u ad=0.1632p as=0.1056p pd=1.64u ps=0.92u
    I_MXI3_I24_MP2 (I3_SEL_XOR_b3_0 I3_SEL_XOR_b2_0 VDD VDD) gpdk090_pmos1v w=0.48u l=0.1u ad=0.1056p as=0.1632p pd=0.92u ps=1.64u
    I_MXI3_I24_MP2_1 (VDD I3_SEL_XOR_b2_0 I3_SEL_XOR_b3_0 VDD) gpdk090_pmos1v w=0.48u l=0.1u ad=0.1632p as=0.1056p pd=1.64u ps=0.92u
    I_MXI3_I61_MP2 (I3_SEL_DIV_b3_0 I3_SEL_DIV_b2_0 VDD VDD) gpdk090_pmos1v w=0.48u l=0.1u ad=0.1056p as=0.1632p pd=0.92u ps=1.64u
    I_MXI3_I61_MP2_1 (VDD I3_SEL_DIV_b2_0 I3_SEL_DIV_b3_0 VDD) gpdk090_pmos1v w=0.48u l=0.1u ad=0.1632p as=0.1056p pd=1.64u ps=0.92u
    I_MXI3_I68_MP2 (I3_SEL_DIV_b3_7 I3_SEL_DIV_b2_1 VDD VDD) gpdk090_pmos1v w=0.48u l=0.1u ad=0.1056p as=0.1632p pd=0.92u ps=1.64u
    I_MXI3_I68_MP2_1 (VDD I3_SEL_DIV_b2_1 I3_SEL_DIV_b3_7 VDD) gpdk090_pmos1v w=0.48u l=0.1u ad=0.1632p as=0.1056p pd=1.64u ps=0.92u
    I_MXI3_I59_MP2 (I3_SEL_DIV_b2_1 I3_SEL_DIV_b1_0 VDD VDD) gpdk090_pmos1v w=0.48u l=0.1u ad=0.1056p as=0.1632p pd=0.92u ps=1.64u
    I_MXI3_I59_MP2_1 (VDD I3_SEL_DIV_b1_0 I3_SEL_DIV_b2_1 VDD) gpdk090_pmos1v w=0.48u l=0.1u ad=0.1632p as=0.1056p pd=1.64u ps=0.92u
    I_MXI3_I57_MP2 (I3_SEL_DIV_b1_0 I3_SEL_DIV_b0 VDD VDD) gpdk090_pmos1v w=0.48u l=0.1u ad=0.1056p as=0.1632p pd=0.92u ps=1.64u
    I_MXI3_I57_MP2_1 (VDD I3_SEL_DIV_b0 I3_SEL_DIV_b1_0 VDD) gpdk090_pmos1v w=0.48u l=0.1u ad=0.1632p as=0.1056p pd=1.64u ps=0.92u
    I_MXI3_I42_MP2 (I3_SEL_MUL_b2_0 I3_SEL_MUL_b1_0 VDD VDD) gpdk090_pmos1v w=0.48u l=0.1u ad=0.1056p as=0.1632p pd=0.92u ps=1.64u
    I_MXI3_I42_MP2_1 (VDD I3_SEL_MUL_b1_0 I3_SEL_MUL_b2_0 VDD) gpdk090_pmos1v w=0.48u l=0.1u ad=0.1632p as=0.1056p pd=1.64u ps=0.92u
    I_MXI3_I58_MP2 (I3_SEL_DIV_b2_0 I3_SEL_DIV_b1_0 VDD VDD) gpdk090_pmos1v w=0.48u l=0.1u ad=0.1056p as=0.1632p pd=0.92u ps=1.64u
    I_MXI3_I58_MP2_1 (VDD I3_SEL_DIV_b1_0 I3_SEL_DIV_b2_0 VDD) gpdk090_pmos1v w=0.48u l=0.1u ad=0.1632p as=0.1056p pd=1.64u ps=0.92u
    I_MXI3_I77_MP2 (I3_SEL_AS_b3_1 I3_SEL_AS_b2_0 VDD VDD) gpdk090_pmos1v w=0.48u l=0.1u ad=0.1056p as=0.1632p pd=0.92u ps=1.64u
    I_MXI3_I77_MP2_1 (VDD I3_SEL_AS_b2_0 I3_SEL_AS_b3_1 VDD) gpdk090_pmos1v w=0.48u l=0.1u ad=0.1632p as=0.1056p pd=1.64u ps=0.92u
    I_MXI3_I35_MP2 (I3_SEL_NOT_b3_1 I3_SEL_NOT_b2_0 VDD VDD) gpdk090_pmos1v w=0.48u l=0.1u ad=0.1056p as=0.1632p pd=0.92u ps=1.64u
    I_MXI3_I35_MP2_1 (VDD I3_SEL_NOT_b2_0 I3_SEL_NOT_b3_1 VDD) gpdk090_pmos1v w=0.48u l=0.1u ad=0.1632p as=0.1056p pd=1.64u ps=0.92u
    I_MXI3_I5_MP2 (I3_SEL_AND_b3_1 I3_SEL_AND_b2_0 VDD VDD) gpdk090_pmos1v w=0.48u l=0.1u ad=0.1056p as=0.1632p pd=0.92u ps=1.64u
    I_MXI3_I5_MP2_1 (VDD I3_SEL_AND_b2_0 I3_SEL_AND_b3_1 VDD) gpdk090_pmos1v w=0.48u l=0.1u ad=0.1632p as=0.1056p pd=1.64u ps=0.92u
    I_MXI3_I15_MP2 (I3_SEL_OR_b3_1 I3_SEL_OR_b2_0 VDD VDD) gpdk090_pmos1v w=0.48u l=0.1u ad=0.1056p as=0.1632p pd=0.92u ps=1.64u
    I_MXI3_I15_MP2_1 (VDD I3_SEL_OR_b2_0 I3_SEL_OR_b3_1 VDD) gpdk090_pmos1v w=0.48u l=0.1u ad=0.1632p as=0.1056p pd=1.64u ps=0.92u
    I_MXI3_I76_MP2 (I3_SEL_AS_b3_0 I3_SEL_AS_b2_0 VDD VDD) gpdk090_pmos1v w=0.48u l=0.1u ad=0.1056p as=0.1632p pd=0.92u ps=1.64u
    I_MXI3_I76_MP2_1 (VDD I3_SEL_AS_b2_0 I3_SEL_AS_b3_0 VDD) gpdk090_pmos1v w=0.48u l=0.1u ad=0.1632p as=0.1056p pd=1.64u ps=0.92u
    I_MXI3_I14_MP2 (I3_SEL_OR_b3_0 I3_SEL_OR_b2_0 VDD VDD) gpdk090_pmos1v w=0.48u l=0.1u ad=0.1056p as=0.1632p pd=0.92u ps=1.64u
    I_MXI3_I14_MP2_1 (VDD I3_SEL_OR_b2_0 I3_SEL_OR_b3_0 VDD) gpdk090_pmos1v w=0.48u l=0.1u ad=0.1632p as=0.1056p pd=1.64u ps=0.92u
    I_MXI3_I4_MP2 (I3_SEL_AND_b3_0 I3_SEL_AND_b2_0 VDD VDD) gpdk090_pmos1v w=0.48u l=0.1u ad=0.1056p as=0.1632p pd=0.92u ps=1.64u
    I_MXI3_I4_MP2_1 (VDD I3_SEL_AND_b2_0 I3_SEL_AND_b3_0 VDD) gpdk090_pmos1v w=0.48u l=0.1u ad=0.1632p as=0.1056p pd=1.64u ps=0.92u
    I_MXI3_I45_MP2 (I3_SEL_MUL_b3_0 I3_SEL_MUL_b2_0 VDD VDD) gpdk090_pmos1v w=0.48u l=0.1u ad=0.1056p as=0.1632p pd=0.92u ps=1.64u
    I_MXI3_I45_MP2_1 (VDD I3_SEL_MUL_b2_0 I3_SEL_MUL_b3_0 VDD) gpdk090_pmos1v w=0.48u l=0.1u ad=0.1632p as=0.1056p pd=1.64u ps=0.92u
    I_MXI3_I34_MP2 (I3_SEL_NOT_b3_0 I3_SEL_NOT_b2_0 VDD VDD) gpdk090_pmos1v w=0.48u l=0.1u ad=0.1056p as=0.1632p pd=0.92u ps=1.64u
    I_MXI3_I34_MP2_1 (VDD I3_SEL_NOT_b2_0 I3_SEL_NOT_b3_0 VDD) gpdk090_pmos1v w=0.48u l=0.1u ad=0.1632p as=0.1056p pd=1.64u ps=0.92u
    I_MXI3_I67_MP2 (I3_SEL_DIV_b3_6 I3_SEL_DIV_b2_1 VDD VDD) gpdk090_pmos1v w=0.48u l=0.1u ad=0.1056p as=0.1632p pd=0.92u ps=1.64u
    I_MXI3_I67_MP2_1 (VDD I3_SEL_DIV_b2_1 I3_SEL_DIV_b3_6 VDD) gpdk090_pmos1v w=0.48u l=0.1u ad=0.1632p as=0.1056p pd=1.64u ps=0.92u
    I_MXI3_I51_MP2 (I3_SEL_MUL_b3_6 I3_SEL_MUL_b2_1 VDD VDD) gpdk090_pmos1v w=0.48u l=0.1u ad=0.1056p as=0.1632p pd=0.92u ps=1.64u
    I_MXI3_I51_MP2_1 (VDD I3_SEL_MUL_b2_1 I3_SEL_MUL_b3_6 VDD) gpdk090_pmos1v w=0.48u l=0.1u ad=0.1632p as=0.1056p pd=1.64u ps=0.92u
    I_MXI3_I52_MP2 (I3_SEL_MUL_b3_7 I3_SEL_MUL_b2_1 VDD VDD) gpdk090_pmos1v w=0.48u l=0.1u ad=0.1056p as=0.1632p pd=0.92u ps=1.64u
    I_MXI3_I52_MP2_1 (VDD I3_SEL_MUL_b2_1 I3_SEL_MUL_b3_7 VDD) gpdk090_pmos1v w=0.48u l=0.1u ad=0.1632p as=0.1056p pd=1.64u ps=0.92u
    I_MXI3_I43_MP2 (I3_SEL_MUL_b2_1 I3_SEL_MUL_b1_0 VDD VDD) gpdk090_pmos1v w=0.48u l=0.1u ad=0.1056p as=0.1632p pd=0.92u ps=1.64u
    I_MXI3_I43_MP2_1 (VDD I3_SEL_MUL_b1_0 I3_SEL_MUL_b2_1 VDD) gpdk090_pmos1v w=0.48u l=0.1u ad=0.1632p as=0.1056p pd=1.64u ps=0.92u
    I_MXI3_I41_MP2 (I3_SEL_MUL_b1_0 I3_SEL_MUL_b0 VDD VDD) gpdk090_pmos1v w=0.48u l=0.1u ad=0.1056p as=0.1632p pd=0.92u ps=1.64u
    I_MXI3_I41_MP2_1 (VDD I3_SEL_MUL_b0 I3_SEL_MUL_b1_0 VDD) gpdk090_pmos1v w=0.48u l=0.1u ad=0.1632p as=0.1056p pd=1.64u ps=0.92u
    I_MXI1_I5_MP2 (I1_SUB_b3_1 I1_SUB_b2_0 VDD VDD) gpdk090_pmos1v w=0.48u l=0.1u ad=0.1056p as=0.1632p pd=0.92u ps=1.64u
    I_MXI1_I5_MP2_1 (VDD I1_SUB_b2_0 I1_SUB_b3_1 VDD) gpdk090_pmos1v w=0.48u l=0.1u ad=0.1632p as=0.1056p pd=1.64u ps=0.92u
    I_MXI1_I4_MP2 (I1_SUB_b3_0 I1_SUB_b2_0 VDD VDD) gpdk090_pmos1v w=0.48u l=0.1u ad=0.1056p as=0.1632p pd=0.92u ps=1.64u
    I_MXI1_I4_MP2_1 (VDD I1_SUB_b2_0 I1_SUB_b3_0 VDD) gpdk090_pmos1v w=0.48u l=0.1u ad=0.1632p as=0.1056p pd=1.64u ps=0.92u
    I_MXI3_I31_MP2 (I3_SEL_NOT_b1_0 I3_SEL_NOT_b0 VDD VDD) gpdk090_pmos1v w=0.48u l=0.1u ad=0.1056p as=0.1632p pd=0.92u ps=1.64u
    I_MXI3_I31_MP2_1 (VDD I3_SEL_NOT_b0 I3_SEL_NOT_b1_0 VDD) gpdk090_pmos1v w=0.48u l=0.1u ad=0.1632p as=0.1056p pd=1.64u ps=0.92u
    I_MXI3_I11_MP2 (I3_SEL_OR_b1_0 I3_SEL_OR_b0 VDD VDD) gpdk090_pmos1v w=0.48u l=0.1u ad=0.1056p as=0.1632p pd=0.92u ps=1.64u
    I_MXI3_I11_MP2_1 (VDD I3_SEL_OR_b0 I3_SEL_OR_b1_0 VDD) gpdk090_pmos1v w=0.48u l=0.1u ad=0.1632p as=0.1056p pd=1.64u ps=0.92u
    I_MXI3_I21_MP2 (I3_SEL_XOR_b1_0 I3_SEL_XOR_b0 VDD VDD) gpdk090_pmos1v w=0.48u l=0.1u ad=0.1056p as=0.1632p pd=0.92u ps=1.64u
    I_MXI3_I21_MP2_1 (VDD I3_SEL_XOR_b0 I3_SEL_XOR_b1_0 VDD) gpdk090_pmos1v w=0.48u l=0.1u ad=0.1632p as=0.1056p pd=1.64u ps=0.92u
    I_MXI1_I1_MP2 (I1_SUB_b1_0 I1_SUB_b0 VDD VDD) gpdk090_pmos1v w=0.48u l=0.1u ad=0.1056p as=0.1632p pd=0.92u ps=1.64u
    I_MXI1_I1_MP2_1 (VDD I1_SUB_b0 I1_SUB_b1_0 VDD) gpdk090_pmos1v w=0.48u l=0.1u ad=0.1632p as=0.1056p pd=1.64u ps=0.92u
    I_MXI3_I22_MP2 (I3_SEL_XOR_b2_0 I3_SEL_XOR_b1_0 VDD VDD) gpdk090_pmos1v w=0.48u l=0.1u ad=0.1056p as=0.1632p pd=0.92u ps=1.64u
    I_MXI3_I22_MP2_1 (VDD I3_SEL_XOR_b1_0 I3_SEL_XOR_b2_0 VDD) gpdk090_pmos1v w=0.48u l=0.1u ad=0.1632p as=0.1056p pd=1.64u ps=0.92u
    I_MXI3_I32_MP2 (I3_SEL_NOT_b2_0 I3_SEL_NOT_b1_0 VDD VDD) gpdk090_pmos1v w=0.48u l=0.1u ad=0.1056p as=0.1632p pd=0.92u ps=1.64u
    I_MXI3_I32_MP2_1 (VDD I3_SEL_NOT_b1_0 I3_SEL_NOT_b2_0 VDD) gpdk090_pmos1v w=0.48u l=0.1u ad=0.1632p as=0.1056p pd=1.64u ps=0.92u
    I_MXI3_I26_MP2 (I3_SEL_XOR_b3_2 I3_SEL_XOR_b2_0 VDD VDD) gpdk090_pmos1v w=0.48u l=0.1u ad=0.1056p as=0.1632p pd=0.92u ps=1.64u
    I_MXI3_I26_MP2_1 (VDD I3_SEL_XOR_b2_0 I3_SEL_XOR_b3_2 VDD) gpdk090_pmos1v w=0.48u l=0.1u ad=0.1632p as=0.1056p pd=1.64u ps=0.92u
    I_MXI3_I36_MP2 (I3_SEL_NOT_b3_2 I3_SEL_NOT_b2_0 VDD VDD) gpdk090_pmos1v w=0.48u l=0.1u ad=0.1056p as=0.1632p pd=0.92u ps=1.64u
    I_MXI3_I36_MP2_1 (VDD I3_SEL_NOT_b2_0 I3_SEL_NOT_b3_2 VDD) gpdk090_pmos1v w=0.48u l=0.1u ad=0.1632p as=0.1056p pd=1.64u ps=0.92u
    I_MXI3_I50_MP2 (I3_SEL_MUL_b3_5 I3_SEL_MUL_b2_1 VDD VDD) gpdk090_pmos1v w=0.48u l=0.1u ad=0.1056p as=0.1632p pd=0.92u ps=1.64u
    I_MXI3_I50_MP2_1 (VDD I3_SEL_MUL_b2_1 I3_SEL_MUL_b3_5 VDD) gpdk090_pmos1v w=0.48u l=0.1u ad=0.1632p as=0.1056p pd=1.64u ps=0.92u
    I_MXI3_I66_MP2 (I3_SEL_DIV_b3_5 I3_SEL_DIV_b2_1 VDD VDD) gpdk090_pmos1v w=0.48u l=0.1u ad=0.1056p as=0.1632p pd=0.92u ps=1.64u
    I_MXI3_I66_MP2_1 (VDD I3_SEL_DIV_b2_1 I3_SEL_DIV_b3_5 VDD) gpdk090_pmos1v w=0.48u l=0.1u ad=0.1632p as=0.1056p pd=1.64u ps=0.92u
    I_MXI3_I1_MP2 (I3_SEL_AND_b1_0 I3_SEL_AND_b0 VDD VDD) gpdk090_pmos1v w=0.48u l=0.1u ad=0.1056p as=0.1632p pd=0.92u ps=1.64u
    I_MXI3_I1_MP2_1 (VDD I3_SEL_AND_b0 I3_SEL_AND_b1_0 VDD) gpdk090_pmos1v w=0.48u l=0.1u ad=0.1632p as=0.1056p pd=1.64u ps=0.92u
    I_MXI3_I73_MP2 (I3_SEL_AS_b1_0 I3_SEL_AS_b0 VDD VDD) gpdk090_pmos1v w=0.48u l=0.1u ad=0.1056p as=0.1632p pd=0.92u ps=1.64u
    I_MXI3_I73_MP2_1 (VDD I3_SEL_AS_b0 I3_SEL_AS_b1_0 VDD) gpdk090_pmos1v w=0.48u l=0.1u ad=0.1632p as=0.1056p pd=1.64u ps=0.92u
    I_MXI3_I33_MP2 (I3_SEL_NOT_b2_1 I3_SEL_NOT_b1_0 VDD VDD) gpdk090_pmos1v w=0.48u l=0.1u ad=0.1056p as=0.1632p pd=0.92u ps=1.64u
    I_MXI3_I33_MP2_1 (VDD I3_SEL_NOT_b1_0 I3_SEL_NOT_b2_1 VDD) gpdk090_pmos1v w=0.48u l=0.1u ad=0.1632p as=0.1056p pd=1.64u ps=0.92u
    I_MXI3_I23_MP2 (I3_SEL_XOR_b2_1 I3_SEL_XOR_b1_0 VDD VDD) gpdk090_pmos1v w=0.48u l=0.1u ad=0.1056p as=0.1632p pd=0.92u ps=1.64u
    I_MXI3_I23_MP2_1 (VDD I3_SEL_XOR_b1_0 I3_SEL_XOR_b2_1 VDD) gpdk090_pmos1v w=0.48u l=0.1u ad=0.1632p as=0.1056p pd=1.64u ps=0.92u
    I_MXI3_I2_MP2 (I3_SEL_AND_b2_0 I3_SEL_AND_b1_0 VDD VDD) gpdk090_pmos1v w=0.48u l=0.1u ad=0.1056p as=0.1632p pd=0.92u ps=1.64u
    I_MXI3_I2_MP2_1 (VDD I3_SEL_AND_b1_0 I3_SEL_AND_b2_0 VDD) gpdk090_pmos1v w=0.48u l=0.1u ad=0.1632p as=0.1056p pd=1.64u ps=0.92u
    I_MXI1_I3_MP2 (I1_SUB_b2_1 I1_SUB_b1_0 VDD VDD) gpdk090_pmos1v w=0.48u l=0.1u ad=0.1056p as=0.1632p pd=0.92u ps=1.64u
    I_MXI1_I3_MP2_1 (VDD I1_SUB_b1_0 I1_SUB_b2_1 VDD) gpdk090_pmos1v w=0.48u l=0.1u ad=0.1632p as=0.1056p pd=1.64u ps=0.92u
    I_MXI1_I2_MP2 (I1_SUB_b2_0 I1_SUB_b1_0 VDD VDD) gpdk090_pmos1v w=0.48u l=0.1u ad=0.1056p as=0.1632p pd=0.92u ps=1.64u
    I_MXI1_I2_MP2_1 (VDD I1_SUB_b1_0 I1_SUB_b2_0 VDD) gpdk090_pmos1v w=0.48u l=0.1u ad=0.1632p as=0.1056p pd=1.64u ps=0.92u
    I_MXI1_I9_MP2 (I1_SUB_b3_5 I1_SUB_b2_1 VDD VDD) gpdk090_pmos1v w=0.48u l=0.1u ad=0.1056p as=0.1632p pd=0.92u ps=1.64u
    I_MXI1_I9_MP2_1 (VDD I1_SUB_b2_1 I1_SUB_b3_5 VDD) gpdk090_pmos1v w=0.48u l=0.1u ad=0.1632p as=0.1056p pd=1.64u ps=0.92u
    I_MXI3_I74_MP2 (I3_SEL_AS_b2_0 I3_SEL_AS_b1_0 VDD VDD) gpdk090_pmos1v w=0.48u l=0.1u ad=0.1056p as=0.1632p pd=0.92u ps=1.64u
    I_MXI3_I74_MP2_1 (VDD I3_SEL_AS_b1_0 I3_SEL_AS_b2_0 VDD) gpdk090_pmos1v w=0.48u l=0.1u ad=0.1632p as=0.1056p pd=1.64u ps=0.92u
    I_MXI3_I12_MP2 (I3_SEL_OR_b2_0 I3_SEL_OR_b1_0 VDD VDD) gpdk090_pmos1v w=0.48u l=0.1u ad=0.1056p as=0.1632p pd=0.92u ps=1.64u
    I_MXI3_I12_MP2_1 (VDD I3_SEL_OR_b1_0 I3_SEL_OR_b2_0 VDD) gpdk090_pmos1v w=0.48u l=0.1u ad=0.1632p as=0.1056p pd=1.64u ps=0.92u
    I_MXI3_I78_MP2 (I3_SEL_AS_b3_2 I3_SEL_AS_b2_0 VDD VDD) gpdk090_pmos1v w=0.48u l=0.1u ad=0.1056p as=0.1632p pd=0.92u ps=1.64u
    I_MXI3_I78_MP2_1 (VDD I3_SEL_AS_b2_0 I3_SEL_AS_b3_2 VDD) gpdk090_pmos1v w=0.48u l=0.1u ad=0.1632p as=0.1056p pd=1.64u ps=0.92u
    I_MXI1_I6_MP2 (I1_SUB_b3_2 I1_SUB_b2_0 VDD VDD) gpdk090_pmos1v w=0.48u l=0.1u ad=0.1056p as=0.1632p pd=0.92u ps=1.64u
    I_MXI1_I6_MP2_1 (VDD I1_SUB_b2_0 I1_SUB_b3_2 VDD) gpdk090_pmos1v w=0.48u l=0.1u ad=0.1632p as=0.1056p pd=1.64u ps=0.92u
    I_MXI3_I16_MP2 (I3_SEL_OR_b3_2 I3_SEL_OR_b2_0 VDD VDD) gpdk090_pmos1v w=0.48u l=0.1u ad=0.1056p as=0.1632p pd=0.92u ps=1.64u
    I_MXI3_I16_MP2_1 (VDD I3_SEL_OR_b2_0 I3_SEL_OR_b3_2 VDD) gpdk090_pmos1v w=0.48u l=0.1u ad=0.1632p as=0.1056p pd=1.64u ps=0.92u
    I_MXI3_I6_MP2 (I3_SEL_AND_b3_2 I3_SEL_AND_b2_0 VDD VDD) gpdk090_pmos1v w=0.48u l=0.1u ad=0.1056p as=0.1632p pd=0.92u ps=1.64u
    I_MXI3_I6_MP2_1 (VDD I3_SEL_AND_b2_0 I3_SEL_AND_b3_2 VDD) gpdk090_pmos1v w=0.48u l=0.1u ad=0.1632p as=0.1056p pd=1.64u ps=0.92u
    I_MXI3_I65_MP2 (I3_SEL_DIV_b3_4 I3_SEL_DIV_b2_1 VDD VDD) gpdk090_pmos1v w=0.48u l=0.1u ad=0.1056p as=0.1632p pd=0.92u ps=1.64u
    I_MXI3_I65_MP2_1 (VDD I3_SEL_DIV_b2_1 I3_SEL_DIV_b3_4 VDD) gpdk090_pmos1v w=0.48u l=0.1u ad=0.1632p as=0.1056p pd=1.64u ps=0.92u
    I_MXI3_I39_MP2 (I3_SEL_NOT_b3_5 I3_SEL_NOT_b2_1 VDD VDD) gpdk090_pmos1v w=0.48u l=0.1u ad=0.1056p as=0.1632p pd=0.92u ps=1.64u
    I_MXI3_I39_MP2_1 (VDD I3_SEL_NOT_b2_1 I3_SEL_NOT_b3_5 VDD) gpdk090_pmos1v w=0.48u l=0.1u ad=0.1632p as=0.1056p pd=1.64u ps=0.92u
    I_MXI3_I29_MP2 (I3_SEL_XOR_b3_5 I3_SEL_XOR_b2_1 VDD VDD) gpdk090_pmos1v w=0.48u l=0.1u ad=0.1056p as=0.1632p pd=0.92u ps=1.64u
    I_MXI3_I29_MP2_1 (VDD I3_SEL_XOR_b2_1 I3_SEL_XOR_b3_5 VDD) gpdk090_pmos1v w=0.48u l=0.1u ad=0.1632p as=0.1056p pd=1.64u ps=0.92u
    I_MXI3_I3_MP2 (I3_SEL_AND_b2_1 I3_SEL_AND_b1_0 VDD VDD) gpdk090_pmos1v w=0.48u l=0.1u ad=0.1056p as=0.1632p pd=0.92u ps=1.64u
    I_MXI3_I3_MP2_1 (VDD I3_SEL_AND_b1_0 I3_SEL_AND_b2_1 VDD) gpdk090_pmos1v w=0.48u l=0.1u ad=0.1632p as=0.1056p pd=1.64u ps=0.92u
    I_MXI3_I75_MP2 (I3_SEL_AS_b2_1 I3_SEL_AS_b1_0 VDD VDD) gpdk090_pmos1v w=0.48u l=0.1u ad=0.1056p as=0.1632p pd=0.92u ps=1.64u
    I_MXI3_I75_MP2_1 (VDD I3_SEL_AS_b1_0 I3_SEL_AS_b2_1 VDD) gpdk090_pmos1v w=0.48u l=0.1u ad=0.1632p as=0.1056p pd=1.64u ps=0.92u
    I_MXI3_I49_MP2 (I3_SEL_MUL_b3_4 I3_SEL_MUL_b2_1 VDD VDD) gpdk090_pmos1v w=0.48u l=0.1u ad=0.1056p as=0.1632p pd=0.92u ps=1.64u
    I_MXI3_I49_MP2_1 (VDD I3_SEL_MUL_b2_1 I3_SEL_MUL_b3_4 VDD) gpdk090_pmos1v w=0.48u l=0.1u ad=0.1632p as=0.1056p pd=1.64u ps=0.92u
    I_MXI3_I9_MP2 (I3_SEL_AND_b3_5 I3_SEL_AND_b2_1 VDD VDD) gpdk090_pmos1v w=0.48u l=0.1u ad=0.1056p as=0.1632p pd=0.92u ps=1.64u
    I_MXI3_I9_MP2_1 (VDD I3_SEL_AND_b2_1 I3_SEL_AND_b3_5 VDD) gpdk090_pmos1v w=0.48u l=0.1u ad=0.1632p as=0.1056p pd=1.64u ps=0.92u
    I_MXI3_I13_MP2 (I3_SEL_OR_b2_1 I3_SEL_OR_b1_0 VDD VDD) gpdk090_pmos1v w=0.48u l=0.1u ad=0.1056p as=0.1632p pd=0.92u ps=1.64u
    I_MXI3_I13_MP2_1 (VDD I3_SEL_OR_b1_0 I3_SEL_OR_b2_1 VDD) gpdk090_pmos1v w=0.48u l=0.1u ad=0.1632p as=0.1056p pd=1.64u ps=0.92u
    I_MXI3_I81_MP2 (I3_SEL_AS_b3_5 I3_SEL_AS_b2_1 VDD VDD) gpdk090_pmos1v w=0.48u l=0.1u ad=0.1056p as=0.1632p pd=0.92u ps=1.64u
    I_MXI3_I81_MP2_1 (VDD I3_SEL_AS_b2_1 I3_SEL_AS_b3_5 VDD) gpdk090_pmos1v w=0.48u l=0.1u ad=0.1632p as=0.1056p pd=1.64u ps=0.92u
    I_MXI3_I19_MP2 (I3_SEL_OR_b3_5 I3_SEL_OR_b2_1 VDD VDD) gpdk090_pmos1v w=0.48u l=0.1u ad=0.1056p as=0.1632p pd=0.92u ps=1.64u
    I_MXI3_I19_MP2_1 (VDD I3_SEL_OR_b2_1 I3_SEL_OR_b3_5 VDD) gpdk090_pmos1v w=0.48u l=0.1u ad=0.1632p as=0.1056p pd=1.64u ps=0.92u
    I_MXI3_I47_MP2 (I3_SEL_MUL_b3_2 I3_SEL_MUL_b2_0 VDD VDD) gpdk090_pmos1v w=0.48u l=0.1u ad=0.1056p as=0.1632p pd=0.92u ps=1.64u
    I_MXI3_I47_MP2_1 (VDD I3_SEL_MUL_b2_0 I3_SEL_MUL_b3_2 VDD) gpdk090_pmos1v w=0.48u l=0.1u ad=0.1632p as=0.1056p pd=1.64u ps=0.92u
    I_MXI3_I63_MP2 (I3_SEL_DIV_b3_2 I3_SEL_DIV_b2_0 VDD VDD) gpdk090_pmos1v w=0.48u l=0.1u ad=0.1056p as=0.1632p pd=0.92u ps=1.64u
    I_MXI3_I63_MP2_1 (VDD I3_SEL_DIV_b2_0 I3_SEL_DIV_b3_2 VDD) gpdk090_pmos1v w=0.48u l=0.1u ad=0.1632p as=0.1056p pd=1.64u ps=0.92u
    I_MXI3_I64_MP2 (I3_SEL_DIV_b3_3 I3_SEL_DIV_b2_0 VDD VDD) gpdk090_pmos1v w=0.48u l=0.1u ad=0.1056p as=0.1632p pd=0.92u ps=1.64u
    I_MXI3_I64_MP2_1 (VDD I3_SEL_DIV_b2_0 I3_SEL_DIV_b3_3 VDD) gpdk090_pmos1v w=0.48u l=0.1u ad=0.1632p as=0.1056p pd=1.64u ps=0.92u
    I_MXI1_I8_MP2 (I1_SUB_b3_4 I1_SUB_b2_1 VDD VDD) gpdk090_pmos1v w=0.48u l=0.1u ad=0.1056p as=0.1632p pd=0.92u ps=1.64u
    I_MXI1_I8_MP2_1 (VDD I1_SUB_b2_1 I1_SUB_b3_4 VDD) gpdk090_pmos1v w=0.48u l=0.1u ad=0.1632p as=0.1056p pd=1.64u ps=0.92u
    I_MXI3_I80_MP2 (I3_SEL_AS_b3_4 I3_SEL_AS_b2_1 VDD VDD) gpdk090_pmos1v w=0.48u l=0.1u ad=0.1056p as=0.1632p pd=0.92u ps=1.64u
    I_MXI3_I80_MP2_1 (VDD I3_SEL_AS_b2_1 I3_SEL_AS_b3_4 VDD) gpdk090_pmos1v w=0.48u l=0.1u ad=0.1632p as=0.1056p pd=1.64u ps=0.92u
    I_MXI3_I79_MP2 (I3_SEL_AS_b3_3 I3_SEL_AS_b2_1 VDD VDD) gpdk090_pmos1v w=0.48u l=0.1u ad=0.1056p as=0.1632p pd=0.92u ps=1.64u
    I_MXI3_I79_MP2_1 (VDD I3_SEL_AS_b2_1 I3_SEL_AS_b3_3 VDD) gpdk090_pmos1v w=0.48u l=0.1u ad=0.1632p as=0.1056p pd=1.64u ps=0.92u
    I_MXI3_I38_MP2 (I3_SEL_NOT_b3_4 I3_SEL_NOT_b2_1 VDD VDD) gpdk090_pmos1v w=0.48u l=0.1u ad=0.1056p as=0.1632p pd=0.92u ps=1.64u
    I_MXI3_I38_MP2_1 (VDD I3_SEL_NOT_b2_1 I3_SEL_NOT_b3_4 VDD) gpdk090_pmos1v w=0.48u l=0.1u ad=0.1632p as=0.1056p pd=1.64u ps=0.92u
    I_MXI3_I28_MP2 (I3_SEL_XOR_b3_4 I3_SEL_XOR_b2_1 VDD VDD) gpdk090_pmos1v w=0.48u l=0.1u ad=0.1056p as=0.1632p pd=0.92u ps=1.64u
    I_MXI3_I28_MP2_1 (VDD I3_SEL_XOR_b2_1 I3_SEL_XOR_b3_4 VDD) gpdk090_pmos1v w=0.48u l=0.1u ad=0.1632p as=0.1056p pd=1.64u ps=0.92u
    I_MXI3_I37_MP2 (I3_SEL_NOT_b3_3 I3_SEL_NOT_b2_1 VDD VDD) gpdk090_pmos1v w=0.48u l=0.1u ad=0.1056p as=0.1632p pd=0.92u ps=1.64u
    I_MXI3_I37_MP2_1 (VDD I3_SEL_NOT_b2_1 I3_SEL_NOT_b3_3 VDD) gpdk090_pmos1v w=0.48u l=0.1u ad=0.1632p as=0.1056p pd=1.64u ps=0.92u
    I_MXI1_I7_MP2 (I1_SUB_b3_3 I1_SUB_b2_1 VDD VDD) gpdk090_pmos1v w=0.48u l=0.1u ad=0.1056p as=0.1632p pd=0.92u ps=1.64u
    I_MXI1_I7_MP2_1 (VDD I1_SUB_b2_1 I1_SUB_b3_3 VDD) gpdk090_pmos1v w=0.48u l=0.1u ad=0.1632p as=0.1056p pd=1.64u ps=0.92u
    I_MXI3_I27_MP2 (I3_SEL_XOR_b3_3 I3_SEL_XOR_b2_1 VDD VDD) gpdk090_pmos1v w=0.48u l=0.1u ad=0.1056p as=0.1632p pd=0.92u ps=1.64u
    I_MXI3_I27_MP2_1 (VDD I3_SEL_XOR_b2_1 I3_SEL_XOR_b3_3 VDD) gpdk090_pmos1v w=0.48u l=0.1u ad=0.1632p as=0.1056p pd=1.64u ps=0.92u
    I_MXI3_I48_MP2 (I3_SEL_MUL_b3_3 I3_SEL_MUL_b2_0 VDD VDD) gpdk090_pmos1v w=0.48u l=0.1u ad=0.1056p as=0.1632p pd=0.92u ps=1.64u
    I_MXI3_I48_MP2_1 (VDD I3_SEL_MUL_b2_0 I3_SEL_MUL_b3_3 VDD) gpdk090_pmos1v w=0.48u l=0.1u ad=0.1632p as=0.1056p pd=1.64u ps=0.92u
    I_MXI3_I18_MP2 (I3_SEL_OR_b3_4 I3_SEL_OR_b2_1 VDD VDD) gpdk090_pmos1v w=0.48u l=0.1u ad=0.1056p as=0.1632p pd=0.92u ps=1.64u
    I_MXI3_I18_MP2_1 (VDD I3_SEL_OR_b2_1 I3_SEL_OR_b3_4 VDD) gpdk090_pmos1v w=0.48u l=0.1u ad=0.1632p as=0.1056p pd=1.64u ps=0.92u
    I_MXI3_I8_MP2 (I3_SEL_AND_b3_4 I3_SEL_AND_b2_1 VDD VDD) gpdk090_pmos1v w=0.48u l=0.1u ad=0.1056p as=0.1632p pd=0.92u ps=1.64u
    I_MXI3_I8_MP2_1 (VDD I3_SEL_AND_b2_1 I3_SEL_AND_b3_4 VDD) gpdk090_pmos1v w=0.48u l=0.1u ad=0.1632p as=0.1056p pd=1.64u ps=0.92u
    I_MXI3_I7_MP2 (I3_SEL_AND_b3_3 I3_SEL_AND_b2_1 VDD VDD) gpdk090_pmos1v w=0.48u l=0.1u ad=0.1056p as=0.1632p pd=0.92u ps=1.64u
    I_MXI3_I7_MP2_1 (VDD I3_SEL_AND_b2_1 I3_SEL_AND_b3_3 VDD) gpdk090_pmos1v w=0.48u l=0.1u ad=0.1632p as=0.1056p pd=1.64u ps=0.92u
    I_MXI3_I17_MP2 (I3_SEL_OR_b3_3 I3_SEL_OR_b2_1 VDD VDD) gpdk090_pmos1v w=0.48u l=0.1u ad=0.1056p as=0.1632p pd=0.92u ps=1.64u
    I_MXI3_I17_MP2_1 (VDD I3_SEL_OR_b2_1 I3_SEL_OR_b3_3 VDD) gpdk090_pmos1v w=0.48u l=0.1u ad=0.1632p as=0.1056p pd=1.64u ps=0.92u
    I_MXI3_I188_MP2 (XI3_I188_p1 I3_o8_2 I3_q8_2 VDD) gpdk090_pmos1v w=0.48u l=0.1u ad=0.1056p as=0.1632p pd=0.92u ps=1.64u
    I_MXI3_I188_MP0 (VDD I3_SEL_AS_b3_1 XI3_I188_p1 VDD) gpdk090_pmos1v w=0.48u l=0.1u ad=0.1056p as=0.1056p pd=0.92u ps=0.92u
    I_MXI3_I188_MP1 (XI3_I188_p1 S_8 VDD VDD) gpdk090_pmos1v w=0.48u l=0.1u ad=0.1632p as=0.1056p pd=1.64u ps=0.92u
    I_MXI3_I200_MP2 (XI3_I200_p1 I3_o9_2 I3_q9_2 VDD) gpdk090_pmos1v w=0.48u l=0.1u ad=0.1056p as=0.1632p pd=0.92u ps=1.64u
    I_MXI3_I200_MP0 (VDD I3_SEL_AS_b3_1 XI3_I200_p1 VDD) gpdk090_pmos1v w=0.48u l=0.1u ad=0.1056p as=0.1056p pd=0.92u ps=0.92u
    I_MXI3_I200_MP1 (XI3_I200_p1 S_9 VDD VDD) gpdk090_pmos1v w=0.48u l=0.1u ad=0.1632p as=0.1056p pd=1.64u ps=0.92u
    I_MXI3_I176_MP2 (XI3_I176_p1 I3_o7_2 I3_q7_2 VDD) gpdk090_pmos1v w=0.48u l=0.1u ad=0.1056p as=0.1632p pd=0.92u ps=1.64u
    I_MXI3_I176_MP0 (VDD I3_SEL_AS_b3_1 XI3_I176_p1 VDD) gpdk090_pmos1v w=0.48u l=0.1u ad=0.1056p as=0.1056p pd=0.92u ps=0.92u
    I_MXI3_I176_MP1 (XI3_I176_p1 S_7 VDD VDD) gpdk090_pmos1v w=0.48u l=0.1u ad=0.1632p as=0.1056p pd=1.64u ps=0.92u
    I_MXI3_I164_MP2 (XI3_I164_p1 I3_o6_2 I3_q6_2 VDD) gpdk090_pmos1v w=0.48u l=0.1u ad=0.1056p as=0.1632p pd=0.92u ps=1.64u
    I_MXI3_I164_MP0 (VDD I3_SEL_AS_b3_1 XI3_I164_p1 VDD) gpdk090_pmos1v w=0.48u l=0.1u ad=0.1056p as=0.1056p pd=0.92u ps=0.92u
    I_MXI3_I164_MP1 (XI3_I164_p1 S_6 VDD VDD) gpdk090_pmos1v w=0.48u l=0.1u ad=0.1632p as=0.1056p pd=1.64u ps=0.92u
    I_MXI3_I212_MP2 (XI3_I212_p1 I3_o10_2 I3_q10_2 VDD) gpdk090_pmos1v w=0.48u l=0.1u ad=0.1056p as=0.1632p pd=0.92u ps=1.64u
    I_MXI3_I212_MP0 (VDD I3_SEL_AS_b3_1 XI3_I212_p1 VDD) gpdk090_pmos1v w=0.48u l=0.1u ad=0.1056p as=0.1056p pd=0.92u ps=0.92u
    I_MXI3_I212_MP1 (XI3_I212_p1 S_10 VDD VDD) gpdk090_pmos1v w=0.48u l=0.1u ad=0.1632p as=0.1056p pd=1.64u ps=0.92u
    I_MXI3_I92_MP2 (XI3_I92_p1 I3_o0_2 I3_q0_2 VDD) gpdk090_pmos1v w=0.48u l=0.1u ad=0.1056p as=0.1632p pd=0.92u ps=1.64u
    I_MXI3_I92_MP0 (VDD I3_SEL_AS_b3_0 XI3_I92_p1 VDD) gpdk090_pmos1v w=0.48u l=0.1u ad=0.1056p as=0.1056p pd=0.92u ps=0.92u
    I_MXI3_I92_MP1 (XI3_I92_p1 S_0 VDD VDD) gpdk090_pmos1v w=0.48u l=0.1u ad=0.1632p as=0.1056p pd=1.64u ps=0.92u
    I_MXI3_I104_MP2 (XI3_I104_p1 I3_o1_2 I3_q1_2 VDD) gpdk090_pmos1v w=0.48u l=0.1u ad=0.1056p as=0.1632p pd=0.92u ps=1.64u
    I_MXI3_I104_MP0 (VDD I3_SEL_AS_b3_0 XI3_I104_p1 VDD) gpdk090_pmos1v w=0.48u l=0.1u ad=0.1056p as=0.1056p pd=0.92u ps=0.92u
    I_MXI3_I104_MP1 (XI3_I104_p1 S_1 VDD VDD) gpdk090_pmos1v w=0.48u l=0.1u ad=0.1632p as=0.1056p pd=1.64u ps=0.92u
    I_MXI3_I140_MP2 (XI3_I140_p1 I3_o4_2 I3_q4_2 VDD) gpdk090_pmos1v w=0.48u l=0.1u ad=0.1056p as=0.1632p pd=0.92u ps=1.64u
    I_MXI3_I140_MP0 (VDD I3_SEL_AS_b3_0 XI3_I140_p1 VDD) gpdk090_pmos1v w=0.48u l=0.1u ad=0.1056p as=0.1056p pd=0.92u ps=0.92u
    I_MXI3_I140_MP1 (XI3_I140_p1 S_4 VDD VDD) gpdk090_pmos1v w=0.48u l=0.1u ad=0.1632p as=0.1056p pd=1.64u ps=0.92u
    I_MXI3_I116_MP2 (XI3_I116_p1 I3_o2_2 I3_q2_2 VDD) gpdk090_pmos1v w=0.48u l=0.1u ad=0.1056p as=0.1632p pd=0.92u ps=1.64u
    I_MXI3_I116_MP0 (VDD I3_SEL_AS_b3_0 XI3_I116_p1 VDD) gpdk090_pmos1v w=0.48u l=0.1u ad=0.1056p as=0.1056p pd=0.92u ps=0.92u
    I_MXI3_I116_MP1 (XI3_I116_p1 S_2 VDD VDD) gpdk090_pmos1v w=0.48u l=0.1u ad=0.1632p as=0.1056p pd=1.64u ps=0.92u
    I_MXI3_I128_MP2 (XI3_I128_p1 I3_o3_2 I3_q3_2 VDD) gpdk090_pmos1v w=0.48u l=0.1u ad=0.1056p as=0.1632p pd=0.92u ps=1.64u
    I_MXI3_I128_MP0 (VDD I3_SEL_AS_b3_0 XI3_I128_p1 VDD) gpdk090_pmos1v w=0.48u l=0.1u ad=0.1056p as=0.1056p pd=0.92u ps=0.92u
    I_MXI3_I128_MP1 (XI3_I128_p1 S_3 VDD VDD) gpdk090_pmos1v w=0.48u l=0.1u ad=0.1632p as=0.1056p pd=1.64u ps=0.92u
    I_MXI3_I152_MP2 (XI3_I152_p1 I3_o5_2 I3_q5_2 VDD) gpdk090_pmos1v w=0.48u l=0.1u ad=0.1056p as=0.1632p pd=0.92u ps=1.64u
    I_MXI3_I152_MP0 (VDD I3_SEL_AS_b3_0 XI3_I152_p1 VDD) gpdk090_pmos1v w=0.48u l=0.1u ad=0.1056p as=0.1056p pd=0.92u ps=0.92u
    I_MXI3_I152_MP1 (XI3_I152_p1 S_5 VDD VDD) gpdk090_pmos1v w=0.48u l=0.1u ad=0.1632p as=0.1056p pd=1.64u ps=0.92u
    I_MXI1_I42_I158_XG_MP2 (XI1_I42_I158_XG_p1 I1_I42_G9_2 I1_I42_G9_0n VDD) gpdk090_pmos1v w=0.48u l=0.1u ad=0.1056p as=0.1632p pd=0.92u ps=1.64u
    I_MXI1_I42_I158_XG_MP0 (VDD I1_I42_P9_2 XI1_I42_I158_XG_p1 VDD) gpdk090_pmos1v w=0.48u l=0.1u ad=0.1056p as=0.1056p pd=0.92u ps=0.92u
    I_MXI1_I42_I158_XG_MP1 (XI1_I42_I158_XG_p1 I1_I42_G1_0 VDD VDD) gpdk090_pmos1v w=0.48u l=0.1u ad=0.1632p as=0.1056p pd=1.64u ps=0.92u
    I_MXI1_I42_I105_XG_MP2 (XI1_I42_I105_XG_p1 I1_I42_G9_8 I1_I42_G9_6n VDD) gpdk090_pmos1v w=0.48u l=0.1u ad=0.1056p as=0.1632p pd=0.92u ps=1.64u
    I_MXI1_I42_I105_XG_MP0 (VDD I1_I42_P9_8 XI1_I42_I105_XG_p1 VDD) gpdk090_pmos1v w=0.48u l=0.1u ad=0.1056p as=0.1056p pd=0.92u ps=0.92u
    I_MXI1_I42_I105_XG_MP1 (XI1_I42_I105_XG_p1 I1_I42_G7_6 VDD VDD) gpdk090_pmos1v w=0.48u l=0.1u ad=0.1632p as=0.1056p pd=1.64u ps=0.92u
    I_MXI1_I42_I103_XG_MP2 (XI1_I42_I103_XG_p1 I1_I42_G7_6 I1_I42_G7_4n VDD) gpdk090_pmos1v w=0.48u l=0.1u ad=0.1056p as=0.1632p pd=0.92u ps=1.64u
    I_MXI1_I42_I103_XG_MP0 (VDD I1_I42_P7_6 XI1_I42_I103_XG_p1 VDD) gpdk090_pmos1v w=0.48u l=0.1u ad=0.1056p as=0.1056p pd=0.92u ps=0.92u
    I_MXI1_I42_I103_XG_MP1 (XI1_I42_I103_XG_p1 I1_I42_G5_4 VDD VDD) gpdk090_pmos1v w=0.48u l=0.1u ad=0.1632p as=0.1056p pd=1.64u ps=0.92u
    I_MXI1_I42_I101_XG_MP2 (XI1_I42_I101_XG_p1 I1_I42_G5_4 I1_I42_G5_2n VDD) gpdk090_pmos1v w=0.48u l=0.1u ad=0.1056p as=0.1632p pd=0.92u ps=1.64u
    I_MXI1_I42_I101_XG_MP0 (VDD I1_I42_P5_4 XI1_I42_I101_XG_p1 VDD) gpdk090_pmos1v w=0.48u l=0.1u ad=0.1056p as=0.1056p pd=0.92u ps=0.92u
    I_MXI1_I42_I101_XG_MP1 (XI1_I42_I101_XG_p1 I1_I42_G3_2 VDD VDD) gpdk090_pmos1v w=0.48u l=0.1u ad=0.1632p as=0.1056p pd=1.64u ps=0.92u
    I_MXI1_I42_I104_XG_MP2 (XI1_I42_I104_XG_p1 I1_I42_G8_7 I1_I42_G8_5n VDD) gpdk090_pmos1v w=0.48u l=0.1u ad=0.1056p as=0.1632p pd=0.92u ps=1.64u
    I_MXI1_I42_I104_XG_MP0 (VDD I1_I42_P8_7 XI1_I42_I104_XG_p1 VDD) gpdk090_pmos1v w=0.48u l=0.1u ad=0.1056p as=0.1056p pd=0.92u ps=0.92u
    I_MXI1_I42_I104_XG_MP1 (XI1_I42_I104_XG_p1 I1_I42_G6_5 VDD VDD) gpdk090_pmos1v w=0.48u l=0.1u ad=0.1632p as=0.1056p pd=1.64u ps=0.92u
    I_MXI1_I42_I102_XG_MP2 (XI1_I42_I102_XG_p1 I1_I42_G6_5 I1_I42_G6_3n VDD) gpdk090_pmos1v w=0.48u l=0.1u ad=0.1056p as=0.1632p pd=0.92u ps=1.64u
    I_MXI1_I42_I102_XG_MP0 (VDD I1_I42_P6_5 XI1_I42_I102_XG_p1 VDD) gpdk090_pmos1v w=0.48u l=0.1u ad=0.1056p as=0.1056p pd=0.92u ps=0.92u
    I_MXI1_I42_I102_XG_MP1 (XI1_I42_I102_XG_p1 I1_I42_G4_3 VDD VDD) gpdk090_pmos1v w=0.48u l=0.1u ad=0.1632p as=0.1056p pd=1.64u ps=0.92u
    I_MXI1_I42_I100_XG_MP2 (XI1_I42_I100_XG_p1 I1_I42_G4_3 I1_I42_G4_1n VDD) gpdk090_pmos1v w=0.48u l=0.1u ad=0.1056p as=0.1632p pd=0.92u ps=1.64u
    I_MXI1_I42_I100_XG_MP0 (VDD I1_I42_P4_3 XI1_I42_I100_XG_p1 VDD) gpdk090_pmos1v w=0.48u l=0.1u ad=0.1056p as=0.1056p pd=0.92u ps=0.92u
    I_MXI1_I42_I100_XG_MP1 (XI1_I42_I100_XG_p1 I1_I42_G2_1 VDD VDD) gpdk090_pmos1v w=0.48u l=0.1u ad=0.1632p as=0.1056p pd=1.64u ps=0.92u
    I_MXI1_I42_I99_XG_MP2 (XI1_I42_I99_XG_p1 I1_I42_G3_2 I1_I42_G3_0n VDD) gpdk090_pmos1v w=0.48u l=0.1u ad=0.1056p as=0.1632p pd=0.92u ps=1.64u
    I_MXI1_I42_I99_XG_MP0 (VDD I1_I42_P3_2 XI1_I42_I99_XG_p1 VDD) gpdk090_pmos1v w=0.48u l=0.1u ad=0.1056p as=0.1056p pd=0.92u ps=0.92u
    I_MXI1_I42_I99_XG_MP1 (XI1_I42_I99_XG_p1 I1_I42_G1_0 VDD VDD) gpdk090_pmos1v w=0.48u l=0.1u ad=0.1632p as=0.1056p pd=1.64u ps=0.92u
    I_MXI1_I42_I98_XG_MP2 (XI1_I42_I98_XG_p1 I1_I42_G2_1 I1_I42_G2_0n VDD) gpdk090_pmos1v w=0.48u l=0.1u ad=0.1056p as=0.1632p pd=0.92u ps=1.64u
    I_MXI1_I42_I98_XG_MP0 (VDD I1_I42_P2_1 XI1_I42_I98_XG_p1 VDD) gpdk090_pmos1v w=0.48u l=0.1u ad=0.1056p as=0.1056p pd=0.92u ps=0.92u
    I_MXI1_I42_I98_XG_MP1 (XI1_I42_I98_XG_p1 I1_I42_G0_0 VDD VDD) gpdk090_pmos1v w=0.48u l=0.1u ad=0.1632p as=0.1056p pd=1.64u ps=0.92u
    I_MXI1_I42_I168_XG_MP2 (XI1_I42_I168_XG_p1 I1_I42_G17_10 I1_I42_G17_2n VDD) gpdk090_pmos1v w=0.48u l=0.1u ad=0.1056p as=0.1632p pd=0.92u ps=1.64u
    I_MXI1_I42_I168_XG_MP0 (VDD I1_I42_P17_10 XI1_I42_I168_XG_p1 VDD) gpdk090_pmos1v w=0.48u l=0.1u ad=0.1056p as=0.1056p pd=0.92u ps=0.92u
    I_MXI1_I42_I168_XG_MP1 (XI1_I42_I168_XG_p1 I1_I42_G9_2 VDD VDD) gpdk090_pmos1v w=0.48u l=0.1u ad=0.1632p as=0.1056p pd=1.64u ps=0.92u
    I_MXI3_I224_MP2 (XI3_I224_p1 I3_o11_2 I3_q11_2 VDD) gpdk090_pmos1v w=0.48u l=0.1u ad=0.1056p as=0.1632p pd=0.92u ps=1.64u
    I_MXI3_I224_MP0 (VDD I3_SEL_AS_b3_2 XI3_I224_p1 VDD) gpdk090_pmos1v w=0.48u l=0.1u ad=0.1056p as=0.1056p pd=0.92u ps=0.92u
    I_MXI3_I224_MP1 (XI3_I224_p1 S_11 VDD VDD) gpdk090_pmos1v w=0.48u l=0.1u ad=0.1632p as=0.1056p pd=1.64u ps=0.92u
    I_MXI1_I42_I106_XG_MP2 (XI1_I42_I106_XG_p1 I1_I42_G10_9 I1_I42_G10_7n VDD) gpdk090_pmos1v w=0.48u l=0.1u ad=0.1056p as=0.1632p pd=0.92u ps=1.64u
    I_MXI1_I42_I106_XG_MP0 (VDD I1_I42_P10_9 XI1_I42_I106_XG_p1 VDD) gpdk090_pmos1v w=0.48u l=0.1u ad=0.1056p as=0.1056p pd=0.92u ps=0.92u
    I_MXI1_I42_I106_XG_MP1 (XI1_I42_I106_XG_p1 I1_I42_G8_7 VDD VDD) gpdk090_pmos1v w=0.48u l=0.1u ad=0.1632p as=0.1056p pd=1.64u ps=0.92u
    I_MXI1_I42_I157_XG_MP2 (XI1_I42_I157_XG_p1 I1_I42_G8_1 I1_I42_G8_0n VDD) gpdk090_pmos1v w=0.48u l=0.1u ad=0.1056p as=0.1632p pd=0.92u ps=1.64u
    I_MXI1_I42_I157_XG_MP0 (VDD I1_I42_P8_1 XI1_I42_I157_XG_p1 VDD) gpdk090_pmos1v w=0.48u l=0.1u ad=0.1056p as=0.1056p pd=0.92u ps=0.92u
    I_MXI1_I42_I157_XG_MP1 (XI1_I42_I157_XG_p1 I1_I42_G0_0 VDD VDD) gpdk090_pmos1v w=0.48u l=0.1u ad=0.1632p as=0.1056p pd=1.64u ps=0.92u
    I_MXI3_I452_MP2 (XI3_I452_p1 I3_o30_2 I3_q30_2 VDD) gpdk090_pmos1v w=0.48u l=0.1u ad=0.1056p as=0.1632p pd=0.92u ps=1.64u
    I_MXI3_I452_MP0 (VDD I3_SEL_AS_b3_5 XI3_I452_p1 VDD) gpdk090_pmos1v w=0.48u l=0.1u ad=0.1056p as=0.1056p pd=0.92u ps=0.92u
    I_MXI3_I452_MP1 (XI3_I452_p1 S_30 VDD VDD) gpdk090_pmos1v w=0.48u l=0.1u ad=0.1632p as=0.1056p pd=1.64u ps=0.92u
    I_MXI3_I464_MP2 (XI3_I464_p1 I3_o31_2 I3_q31_2 VDD) gpdk090_pmos1v w=0.48u l=0.1u ad=0.1056p as=0.1632p pd=0.92u ps=1.64u
    I_MXI3_I464_MP0 (VDD I3_SEL_AS_b3_5 XI3_I464_p1 VDD) gpdk090_pmos1v w=0.48u l=0.1u ad=0.1056p as=0.1056p pd=0.92u ps=0.92u
    I_MXI3_I464_MP1 (XI3_I464_p1 S_31 VDD VDD) gpdk090_pmos1v w=0.48u l=0.1u ad=0.1632p as=0.1056p pd=1.64u ps=0.92u
    I_MXI1_I42_I176_XG_MP2 (XI1_I42_I176_XG_p1 I1_I42_G25_18 I1_I42_G25_10n VDD) gpdk090_pmos1v w=0.48u l=0.1u ad=0.1056p as=0.1632p pd=0.92u ps=1.64u
    I_MXI1_I42_I176_XG_MP0 (VDD I1_I42_P25_18 XI1_I42_I176_XG_p1 VDD) gpdk090_pmos1v w=0.48u l=0.1u ad=0.1056p as=0.1056p pd=0.92u ps=0.92u
    I_MXI1_I42_I176_XG_MP1 (XI1_I42_I176_XG_p1 I1_I42_G17_10 VDD VDD) gpdk090_pmos1v w=0.48u l=0.1u ad=0.1632p as=0.1056p pd=1.64u ps=0.92u
    I_MXI1_I42_I164_XG_MP2 (XI1_I42_I164_XG_p1 I1_I42_G13_6 I1_I42_G13_0n VDD) gpdk090_pmos1v w=0.48u l=0.1u ad=0.1056p as=0.1632p pd=0.92u ps=1.64u
    I_MXI1_I42_I164_XG_MP0 (VDD I1_I42_P13_6 XI1_I42_I164_XG_p1 VDD) gpdk090_pmos1v w=0.48u l=0.1u ad=0.1056p as=0.1056p pd=0.92u ps=0.92u
    I_MXI1_I42_I164_XG_MP1 (XI1_I42_I164_XG_p1 I1_I42_G5_0 VDD VDD) gpdk090_pmos1v w=0.48u l=0.1u ad=0.1632p as=0.1056p pd=1.64u ps=0.92u
    I_MXI1_I42_I107_XG_MP2 (XI1_I42_I107_XG_p1 I1_I42_G11_10 I1_I42_G11_8n VDD) gpdk090_pmos1v w=0.48u l=0.1u ad=0.1056p as=0.1632p pd=0.92u ps=1.64u
    I_MXI1_I42_I107_XG_MP0 (VDD I1_I42_P11_10 XI1_I42_I107_XG_p1 VDD) gpdk090_pmos1v w=0.48u l=0.1u ad=0.1056p as=0.1056p pd=0.92u ps=0.92u
    I_MXI1_I42_I107_XG_MP1 (XI1_I42_I107_XG_p1 I1_I42_G9_8 VDD VDD) gpdk090_pmos1v w=0.48u l=0.1u ad=0.1632p as=0.1056p pd=1.64u ps=0.92u
    I_MXI1_I42_I109_XG_MP2 (XI1_I42_I109_XG_p1 I1_I42_G13_12 I1_I42_G13_10n VDD) gpdk090_pmos1v w=0.48u l=0.1u ad=0.1056p as=0.1632p pd=0.92u ps=1.64u
    I_MXI1_I42_I109_XG_MP0 (VDD I1_I42_P13_12 XI1_I42_I109_XG_p1 VDD) gpdk090_pmos1v w=0.48u l=0.1u ad=0.1056p as=0.1056p pd=0.92u ps=0.92u
    I_MXI1_I42_I109_XG_MP1 (XI1_I42_I109_XG_p1 I1_I42_G11_10 VDD VDD) gpdk090_pmos1v w=0.48u l=0.1u ad=0.1632p as=0.1056p pd=1.64u ps=0.92u
    I_MXI1_I42_I167_XG_MP2 (XI1_I42_I167_XG_p1 I1_I42_G16_9 I1_I42_G16_1n VDD) gpdk090_pmos1v w=0.48u l=0.1u ad=0.1056p as=0.1632p pd=0.92u ps=1.64u
    I_MXI1_I42_I167_XG_MP0 (VDD I1_I42_P16_9 XI1_I42_I167_XG_p1 VDD) gpdk090_pmos1v w=0.48u l=0.1u ad=0.1056p as=0.1056p pd=0.92u ps=0.92u
    I_MXI1_I42_I167_XG_MP1 (XI1_I42_I167_XG_p1 I1_I42_G8_1 VDD VDD) gpdk090_pmos1v w=0.48u l=0.1u ad=0.1632p as=0.1056p pd=1.64u ps=0.92u
    I_MXI1_I42_I180_XG_MP2 (XI1_I42_I180_XG_p1 I1_I42_G29_22 I1_I42_G29_14n VDD) gpdk090_pmos1v w=0.48u l=0.1u ad=0.1056p as=0.1632p pd=0.92u ps=1.64u
    I_MXI1_I42_I180_XG_MP0 (VDD I1_I42_P29_22 XI1_I42_I180_XG_p1 VDD) gpdk090_pmos1v w=0.48u l=0.1u ad=0.1056p as=0.1056p pd=0.92u ps=0.92u
    I_MXI1_I42_I180_XG_MP1 (XI1_I42_I180_XG_p1 I1_I42_G21_14 VDD VDD) gpdk090_pmos1v w=0.48u l=0.1u ad=0.1632p as=0.1056p pd=1.64u ps=0.92u
    I_MXI1_I42_I172_XG_MP2 (XI1_I42_I172_XG_p1 I1_I42_G21_14 I1_I42_G21_6n VDD) gpdk090_pmos1v w=0.48u l=0.1u ad=0.1056p as=0.1632p pd=0.92u ps=1.64u
    I_MXI1_I42_I172_XG_MP0 (VDD I1_I42_P21_14 XI1_I42_I172_XG_p1 VDD) gpdk090_pmos1v w=0.48u l=0.1u ad=0.1056p as=0.1056p pd=0.92u ps=0.92u
    I_MXI1_I42_I172_XG_MP1 (XI1_I42_I172_XG_p1 I1_I42_G13_6 VDD VDD) gpdk090_pmos1v w=0.48u l=0.1u ad=0.1632p as=0.1056p pd=1.64u ps=0.92u
    I_MXI1_I42_I162_XG_MP2 (XI1_I42_I162_XG_p1 I1_I42_G11_4 I1_I42_G11_0n VDD) gpdk090_pmos1v w=0.48u l=0.1u ad=0.1056p as=0.1632p pd=0.92u ps=1.64u
    I_MXI1_I42_I162_XG_MP0 (VDD I1_I42_P11_4 XI1_I42_I162_XG_p1 VDD) gpdk090_pmos1v w=0.48u l=0.1u ad=0.1056p as=0.1056p pd=0.92u ps=0.92u
    I_MXI1_I42_I162_XG_MP1 (XI1_I42_I162_XG_p1 I1_I42_G3_0np VDD VDD) gpdk090_pmos1v w=0.48u l=0.1u ad=0.1632p as=0.1056p pd=1.64u ps=0.92u
    I_MXI1_I42_I160_XG_MP2 (XI1_I42_I160_XG_p1 I1_I42_G10_3 I1_I42_G10_0n VDD) gpdk090_pmos1v w=0.48u l=0.1u ad=0.1056p as=0.1632p pd=0.92u ps=1.64u
    I_MXI1_I42_I160_XG_MP0 (VDD I1_I42_P10_3 XI1_I42_I160_XG_p1 VDD) gpdk090_pmos1v w=0.48u l=0.1u ad=0.1056p as=0.1056p pd=0.92u ps=0.92u
    I_MXI1_I42_I160_XG_MP1 (XI1_I42_I160_XG_p1 I1_I42_G2_0np VDD VDD) gpdk090_pmos1v w=0.48u l=0.1u ad=0.1632p as=0.1056p pd=1.64u ps=0.92u
    I_MXI1_I42_I108_XG_MP2 (XI1_I42_I108_XG_p1 I1_I42_G12_11 I1_I42_G12_9n VDD) gpdk090_pmos1v w=0.48u l=0.1u ad=0.1056p as=0.1632p pd=0.92u ps=1.64u
    I_MXI1_I42_I108_XG_MP0 (VDD I1_I42_P12_11 XI1_I42_I108_XG_p1 VDD) gpdk090_pmos1v w=0.48u l=0.1u ad=0.1056p as=0.1056p pd=0.92u ps=0.92u
    I_MXI1_I42_I108_XG_MP1 (XI1_I42_I108_XG_p1 I1_I42_G10_9 VDD VDD) gpdk090_pmos1v w=0.48u l=0.1u ad=0.1632p as=0.1056p pd=1.64u ps=0.92u
    I_MXI3_I236_MP2 (XI3_I236_p1 I3_o12_2 I3_q12_2 VDD) gpdk090_pmos1v w=0.48u l=0.1u ad=0.1056p as=0.1632p pd=0.92u ps=1.64u
    I_MXI3_I236_MP0 (VDD I3_SEL_AS_b3_2 XI3_I236_p1 VDD) gpdk090_pmos1v w=0.48u l=0.1u ad=0.1056p as=0.1056p pd=0.92u ps=0.92u
    I_MXI3_I236_MP1 (XI3_I236_p1 S_12 VDD VDD) gpdk090_pmos1v w=0.48u l=0.1u ad=0.1632p as=0.1056p pd=1.64u ps=0.92u
    I_MXI3_I440_MP2 (XI3_I440_p1 I3_o29_2 I3_q29_2 VDD) gpdk090_pmos1v w=0.48u l=0.1u ad=0.1056p as=0.1632p pd=0.92u ps=1.64u
    I_MXI3_I440_MP0 (VDD I3_SEL_AS_b3_5 XI3_I440_p1 VDD) gpdk090_pmos1v w=0.48u l=0.1u ad=0.1056p as=0.1056p pd=0.92u ps=0.92u
    I_MXI3_I440_MP1 (XI3_I440_p1 S_29 VDD VDD) gpdk090_pmos1v w=0.48u l=0.1u ad=0.1632p as=0.1056p pd=1.64u ps=0.92u
    I_MXI1_I42_I125_XG_MP2 (XI1_I42_I125_XG_p1 I1_I42_G29_28 I1_I42_G29_26n VDD) gpdk090_pmos1v w=0.48u l=0.1u ad=0.1056p as=0.1632p pd=0.92u ps=1.64u
    I_MXI1_I42_I125_XG_MP0 (VDD I1_I42_P29_28 XI1_I42_I125_XG_p1 VDD) gpdk090_pmos1v w=0.48u l=0.1u ad=0.1056p as=0.1056p pd=0.92u ps=0.92u
    I_MXI1_I42_I125_XG_MP1 (XI1_I42_I125_XG_p1 I1_I42_G27_26 VDD VDD) gpdk090_pmos1v w=0.48u l=0.1u ad=0.1632p as=0.1056p pd=1.64u ps=0.92u
    I_MXI1_I42_I127_XG_MP2 (XI1_I42_I127_XG_p1 I1_I42_G31_30 I1_I42_G31_28n VDD) gpdk090_pmos1v w=0.48u l=0.1u ad=0.1056p as=0.1632p pd=0.92u ps=1.64u
    I_MXI1_I42_I127_XG_MP0 (VDD I1_I42_P31_30 XI1_I42_I127_XG_p1 VDD) gpdk090_pmos1v w=0.48u l=0.1u ad=0.1056p as=0.1056p pd=0.92u ps=0.92u
    I_MXI1_I42_I127_XG_MP1 (XI1_I42_I127_XG_p1 I1_I42_G29_28 VDD VDD) gpdk090_pmos1v w=0.48u l=0.1u ad=0.1632p as=0.1056p pd=1.64u ps=0.92u
    I_MXI1_I42_I182_XG_MP2 (XI1_I42_I182_XG_p1 I1_I42_G31_24 I1_I42_G31_16n VDD) gpdk090_pmos1v w=0.48u l=0.1u ad=0.1056p as=0.1632p pd=0.92u ps=1.64u
    I_MXI1_I42_I182_XG_MP0 (VDD I1_I42_P31_24 XI1_I42_I182_XG_p1 VDD) gpdk090_pmos1v w=0.48u l=0.1u ad=0.1056p as=0.1056p pd=0.92u ps=0.92u
    I_MXI1_I42_I182_XG_MP1 (XI1_I42_I182_XG_p1 I1_I42_G23_16 VDD VDD) gpdk090_pmos1v w=0.48u l=0.1u ad=0.1632p as=0.1056p pd=1.64u ps=0.92u
    I_MXI1_I42_I174_XG_MP2 (XI1_I42_I174_XG_p1 I1_I42_G23_16 I1_I42_G23_8n VDD) gpdk090_pmos1v w=0.48u l=0.1u ad=0.1056p as=0.1632p pd=0.92u ps=1.64u
    I_MXI1_I42_I174_XG_MP0 (VDD I1_I42_P23_16 XI1_I42_I174_XG_p1 VDD) gpdk090_pmos1v w=0.48u l=0.1u ad=0.1056p as=0.1056p pd=0.92u ps=0.92u
    I_MXI1_I42_I174_XG_MP1 (XI1_I42_I174_XG_p1 I1_I42_G15_8 VDD VDD) gpdk090_pmos1v w=0.48u l=0.1u ad=0.1632p as=0.1056p pd=1.64u ps=0.92u
    I_MXI1_I42_I166_XG_MP2 (XI1_I42_I166_XG_p1 I1_I42_G15_8 I1_I42_G15_0n VDD) gpdk090_pmos1v w=0.48u l=0.1u ad=0.1056p as=0.1632p pd=0.92u ps=1.64u
    I_MXI1_I42_I166_XG_MP0 (VDD I1_I42_P15_8 XI1_I42_I166_XG_p1 VDD) gpdk090_pmos1v w=0.48u l=0.1u ad=0.1056p as=0.1056p pd=0.92u ps=0.92u
    I_MXI1_I42_I166_XG_MP1 (XI1_I42_I166_XG_p1 I1_I42_G7_0 VDD VDD) gpdk090_pmos1v w=0.48u l=0.1u ad=0.1632p as=0.1056p pd=1.64u ps=0.92u
    I_MXI1_I42_I170_XG_MP2 (XI1_I42_I170_XG_p1 I1_I42_G19_12 I1_I42_G19_4n VDD) gpdk090_pmos1v w=0.48u l=0.1u ad=0.1056p as=0.1632p pd=0.92u ps=1.64u
    I_MXI1_I42_I170_XG_MP0 (VDD I1_I42_P19_12 XI1_I42_I170_XG_p1 VDD) gpdk090_pmos1v w=0.48u l=0.1u ad=0.1056p as=0.1056p pd=0.92u ps=0.92u
    I_MXI1_I42_I170_XG_MP1 (XI1_I42_I170_XG_p1 I1_I42_G11_4 VDD VDD) gpdk090_pmos1v w=0.48u l=0.1u ad=0.1632p as=0.1056p pd=1.64u ps=0.92u
    I_MXI1_I42_I111_XG_MP2 (XI1_I42_I111_XG_p1 I1_I42_G15_14 I1_I42_G15_12n VDD) gpdk090_pmos1v w=0.48u l=0.1u ad=0.1056p as=0.1632p pd=0.92u ps=1.64u
    I_MXI1_I42_I111_XG_MP0 (VDD I1_I42_P15_14 XI1_I42_I111_XG_p1 VDD) gpdk090_pmos1v w=0.48u l=0.1u ad=0.1056p as=0.1056p pd=0.92u ps=0.92u
    I_MXI1_I42_I111_XG_MP1 (XI1_I42_I111_XG_p1 I1_I42_G13_12 VDD VDD) gpdk090_pmos1v w=0.48u l=0.1u ad=0.1632p as=0.1056p pd=1.64u ps=0.92u
    I_MXI1_I42_I169_XG_MP2 (XI1_I42_I169_XG_p1 I1_I42_G18_11 I1_I42_G18_3n VDD) gpdk090_pmos1v w=0.48u l=0.1u ad=0.1056p as=0.1632p pd=0.92u ps=1.64u
    I_MXI1_I42_I169_XG_MP0 (VDD I1_I42_P18_11 XI1_I42_I169_XG_p1 VDD) gpdk090_pmos1v w=0.48u l=0.1u ad=0.1056p as=0.1056p pd=0.92u ps=0.92u
    I_MXI1_I42_I169_XG_MP1 (XI1_I42_I169_XG_p1 I1_I42_G10_3 VDD VDD) gpdk090_pmos1v w=0.48u l=0.1u ad=0.1632p as=0.1056p pd=1.64u ps=0.92u
    I_MXI1_I42_I175_XG_MP2 (XI1_I42_I175_XG_p1 I1_I42_G24_17 I1_I42_G24_9n VDD) gpdk090_pmos1v w=0.48u l=0.1u ad=0.1056p as=0.1632p pd=0.92u ps=1.64u
    I_MXI1_I42_I175_XG_MP0 (VDD I1_I42_P24_17 XI1_I42_I175_XG_p1 VDD) gpdk090_pmos1v w=0.48u l=0.1u ad=0.1056p as=0.1056p pd=0.92u ps=0.92u
    I_MXI1_I42_I175_XG_MP1 (XI1_I42_I175_XG_p1 I1_I42_G16_9 VDD VDD) gpdk090_pmos1v w=0.48u l=0.1u ad=0.1632p as=0.1056p pd=1.64u ps=0.92u
    I_MXI1_I42_I163_XG_MP2 (XI1_I42_I163_XG_p1 I1_I42_G12_5 I1_I42_G12_0n VDD) gpdk090_pmos1v w=0.48u l=0.1u ad=0.1056p as=0.1632p pd=0.92u ps=1.64u
    I_MXI1_I42_I163_XG_MP0 (VDD I1_I42_P12_5 XI1_I42_I163_XG_p1 VDD) gpdk090_pmos1v w=0.48u l=0.1u ad=0.1056p as=0.1056p pd=0.92u ps=0.92u
    I_MXI1_I42_I163_XG_MP1 (XI1_I42_I163_XG_p1 I1_I42_G4_0 VDD VDD) gpdk090_pmos1v w=0.48u l=0.1u ad=0.1632p as=0.1056p pd=1.64u ps=0.92u
    I_MXI3_I248_MP2 (XI3_I248_p1 I3_o13_2 I3_q13_2 VDD) gpdk090_pmos1v w=0.48u l=0.1u ad=0.1056p as=0.1632p pd=0.92u ps=1.64u
    I_MXI3_I248_MP0 (VDD I3_SEL_AS_b3_2 XI3_I248_p1 VDD) gpdk090_pmos1v w=0.48u l=0.1u ad=0.1056p as=0.1056p pd=0.92u ps=0.92u
    I_MXI3_I248_MP1 (XI3_I248_p1 S_13 VDD VDD) gpdk090_pmos1v w=0.48u l=0.1u ad=0.1632p as=0.1056p pd=1.64u ps=0.92u
    I_MXI3_I428_MP2 (XI3_I428_p1 I3_o28_2 I3_q28_2 VDD) gpdk090_pmos1v w=0.48u l=0.1u ad=0.1056p as=0.1632p pd=0.92u ps=1.64u
    I_MXI3_I428_MP0 (VDD I3_SEL_AS_b3_5 XI3_I428_p1 VDD) gpdk090_pmos1v w=0.48u l=0.1u ad=0.1056p as=0.1056p pd=0.92u ps=0.92u
    I_MXI3_I428_MP1 (XI3_I428_p1 S_28 VDD VDD) gpdk090_pmos1v w=0.48u l=0.1u ad=0.1632p as=0.1056p pd=1.64u ps=0.92u
    I_MXI1_I42_I123_XG_MP2 (XI1_I42_I123_XG_p1 I1_I42_G27_26 I1_I42_G27_24n VDD) gpdk090_pmos1v w=0.48u l=0.1u ad=0.1056p as=0.1632p pd=0.92u ps=1.64u
    I_MXI1_I42_I123_XG_MP0 (VDD I1_I42_P27_26 XI1_I42_I123_XG_p1 VDD) gpdk090_pmos1v w=0.48u l=0.1u ad=0.1056p as=0.1056p pd=0.92u ps=0.92u
    I_MXI1_I42_I123_XG_MP1 (XI1_I42_I123_XG_p1 I1_I42_G25_24 VDD VDD) gpdk090_pmos1v w=0.48u l=0.1u ad=0.1632p as=0.1056p pd=1.64u ps=0.92u
    I_MXI1_I42_I178_XG_MP2 (XI1_I42_I178_XG_p1 I1_I42_G27_20 I1_I42_G27_12n VDD) gpdk090_pmos1v w=0.48u l=0.1u ad=0.1056p as=0.1632p pd=0.92u ps=1.64u
    I_MXI1_I42_I178_XG_MP0 (VDD I1_I42_P27_20 XI1_I42_I178_XG_p1 VDD) gpdk090_pmos1v w=0.48u l=0.1u ad=0.1056p as=0.1056p pd=0.92u ps=0.92u
    I_MXI1_I42_I178_XG_MP1 (XI1_I42_I178_XG_p1 I1_I42_G19_12 VDD VDD) gpdk090_pmos1v w=0.48u l=0.1u ad=0.1632p as=0.1056p pd=1.64u ps=0.92u
    I_MXI1_I42_I113_XG_MP2 (XI1_I42_I113_XG_p1 I1_I42_G17_16 I1_I42_G17_14n VDD) gpdk090_pmos1v w=0.48u l=0.1u ad=0.1056p as=0.1632p pd=0.92u ps=1.64u
    I_MXI1_I42_I113_XG_MP0 (VDD I1_I42_P17_16 XI1_I42_I113_XG_p1 VDD) gpdk090_pmos1v w=0.48u l=0.1u ad=0.1056p as=0.1056p pd=0.92u ps=0.92u
    I_MXI1_I42_I113_XG_MP1 (XI1_I42_I113_XG_p1 I1_I42_G15_14 VDD VDD) gpdk090_pmos1v w=0.48u l=0.1u ad=0.1632p as=0.1056p pd=1.64u ps=0.92u
    I_MXI1_I42_I179_XG_MP2 (XI1_I42_I179_XG_p1 I1_I42_G28_21 I1_I42_G28_13n VDD) gpdk090_pmos1v w=0.48u l=0.1u ad=0.1056p as=0.1632p pd=0.92u ps=1.64u
    I_MXI1_I42_I179_XG_MP0 (VDD I1_I42_P28_21 XI1_I42_I179_XG_p1 VDD) gpdk090_pmos1v w=0.48u l=0.1u ad=0.1056p as=0.1056p pd=0.92u ps=0.92u
    I_MXI1_I42_I179_XG_MP1 (XI1_I42_I179_XG_p1 I1_I42_G20_13 VDD VDD) gpdk090_pmos1v w=0.48u l=0.1u ad=0.1632p as=0.1056p pd=1.64u ps=0.92u
    I_MXI1_I42_I171_XG_MP2 (XI1_I42_I171_XG_p1 I1_I42_G20_13 I1_I42_G20_5n VDD) gpdk090_pmos1v w=0.48u l=0.1u ad=0.1056p as=0.1632p pd=0.92u ps=1.64u
    I_MXI1_I42_I171_XG_MP0 (VDD I1_I42_P20_13 XI1_I42_I171_XG_p1 VDD) gpdk090_pmos1v w=0.48u l=0.1u ad=0.1056p as=0.1056p pd=0.92u ps=0.92u
    I_MXI1_I42_I171_XG_MP1 (XI1_I42_I171_XG_p1 I1_I42_G12_5 VDD VDD) gpdk090_pmos1v w=0.48u l=0.1u ad=0.1632p as=0.1056p pd=1.64u ps=0.92u
    I_MXI1_I42_I110_XG_MP2 (XI1_I42_I110_XG_p1 I1_I42_G14_13 I1_I42_G14_11n VDD) gpdk090_pmos1v w=0.48u l=0.1u ad=0.1056p as=0.1632p pd=0.92u ps=1.64u
    I_MXI1_I42_I110_XG_MP0 (VDD I1_I42_P14_13 XI1_I42_I110_XG_p1 VDD) gpdk090_pmos1v w=0.48u l=0.1u ad=0.1056p as=0.1056p pd=0.92u ps=0.92u
    I_MXI1_I42_I110_XG_MP1 (XI1_I42_I110_XG_p1 I1_I42_G12_11 VDD VDD) gpdk090_pmos1v w=0.48u l=0.1u ad=0.1632p as=0.1056p pd=1.64u ps=0.92u
    I_MXI3_I260_MP2 (XI3_I260_p1 I3_o14_2 I3_q14_2 VDD) gpdk090_pmos1v w=0.48u l=0.1u ad=0.1056p as=0.1632p pd=0.92u ps=1.64u
    I_MXI3_I260_MP0 (VDD I3_SEL_AS_b3_2 XI3_I260_p1 VDD) gpdk090_pmos1v w=0.48u l=0.1u ad=0.1056p as=0.1056p pd=0.92u ps=0.92u
    I_MXI3_I260_MP1 (XI3_I260_p1 S_14 VDD VDD) gpdk090_pmos1v w=0.48u l=0.1u ad=0.1632p as=0.1056p pd=1.64u ps=0.92u
    I_MXI3_I416_MP2 (XI3_I416_p1 I3_o27_2 I3_q27_2 VDD) gpdk090_pmos1v w=0.48u l=0.1u ad=0.1056p as=0.1632p pd=0.92u ps=1.64u
    I_MXI3_I416_MP0 (VDD I3_SEL_AS_b3_5 XI3_I416_p1 VDD) gpdk090_pmos1v w=0.48u l=0.1u ad=0.1056p as=0.1056p pd=0.92u ps=0.92u
    I_MXI3_I416_MP1 (XI3_I416_p1 S_27 VDD VDD) gpdk090_pmos1v w=0.48u l=0.1u ad=0.1632p as=0.1056p pd=1.64u ps=0.92u
    I_MXI1_I42_I126_XG_MP2 (XI1_I42_I126_XG_p1 I1_I42_G30_29 I1_I42_G30_27n VDD) gpdk090_pmos1v w=0.48u l=0.1u ad=0.1056p as=0.1632p pd=0.92u ps=1.64u
    I_MXI1_I42_I126_XG_MP0 (VDD I1_I42_P30_29 XI1_I42_I126_XG_p1 VDD) gpdk090_pmos1v w=0.48u l=0.1u ad=0.1056p as=0.1056p pd=0.92u ps=0.92u
    I_MXI1_I42_I126_XG_MP1 (XI1_I42_I126_XG_p1 I1_I42_G28_27 VDD VDD) gpdk090_pmos1v w=0.48u l=0.1u ad=0.1632p as=0.1056p pd=1.64u ps=0.92u
    I_MXI1_I42_I124_XG_MP2 (XI1_I42_I124_XG_p1 I1_I42_G28_27 I1_I42_G28_25n VDD) gpdk090_pmos1v w=0.48u l=0.1u ad=0.1056p as=0.1632p pd=0.92u ps=1.64u
    I_MXI1_I42_I124_XG_MP0 (VDD I1_I42_P28_27 XI1_I42_I124_XG_p1 VDD) gpdk090_pmos1v w=0.48u l=0.1u ad=0.1056p as=0.1056p pd=0.92u ps=0.92u
    I_MXI1_I42_I124_XG_MP1 (XI1_I42_I124_XG_p1 I1_I42_G26_25 VDD VDD) gpdk090_pmos1v w=0.48u l=0.1u ad=0.1632p as=0.1056p pd=1.64u ps=0.92u
    I_MXI1_I42_I121_XG_MP2 (XI1_I42_I121_XG_p1 I1_I42_G25_24 I1_I42_G25_22n VDD) gpdk090_pmos1v w=0.48u l=0.1u ad=0.1056p as=0.1632p pd=0.92u ps=1.64u
    I_MXI1_I42_I121_XG_MP0 (VDD I1_I42_P25_24 XI1_I42_I121_XG_p1 VDD) gpdk090_pmos1v w=0.48u l=0.1u ad=0.1056p as=0.1056p pd=0.92u ps=0.92u
    I_MXI1_I42_I121_XG_MP1 (XI1_I42_I121_XG_p1 I1_I42_G23_22 VDD VDD) gpdk090_pmos1v w=0.48u l=0.1u ad=0.1632p as=0.1056p pd=1.64u ps=0.92u
    I_MXI1_I42_I119_XG_MP2 (XI1_I42_I119_XG_p1 I1_I42_G23_22 I1_I42_G23_20n VDD) gpdk090_pmos1v w=0.48u l=0.1u ad=0.1056p as=0.1632p pd=0.92u ps=1.64u
    I_MXI1_I42_I119_XG_MP0 (VDD I1_I42_P23_22 XI1_I42_I119_XG_p1 VDD) gpdk090_pmos1v w=0.48u l=0.1u ad=0.1056p as=0.1056p pd=0.92u ps=0.92u
    I_MXI1_I42_I119_XG_MP1 (XI1_I42_I119_XG_p1 I1_I42_G21_20 VDD VDD) gpdk090_pmos1v w=0.48u l=0.1u ad=0.1632p as=0.1056p pd=1.64u ps=0.92u
    I_MXI1_I42_I181_XG_MP2 (XI1_I42_I181_XG_p1 I1_I42_G30_23 I1_I42_G30_15n VDD) gpdk090_pmos1v w=0.48u l=0.1u ad=0.1056p as=0.1632p pd=0.92u ps=1.64u
    I_MXI1_I42_I181_XG_MP0 (VDD I1_I42_P30_23 XI1_I42_I181_XG_p1 VDD) gpdk090_pmos1v w=0.48u l=0.1u ad=0.1056p as=0.1056p pd=0.92u ps=0.92u
    I_MXI1_I42_I181_XG_MP1 (XI1_I42_I181_XG_p1 I1_I42_G22_15 VDD VDD) gpdk090_pmos1v w=0.48u l=0.1u ad=0.1632p as=0.1056p pd=1.64u ps=0.92u
    I_MXI1_I42_I117_XG_MP2 (XI1_I42_I117_XG_p1 I1_I42_G21_20 I1_I42_G21_18n VDD) gpdk090_pmos1v w=0.48u l=0.1u ad=0.1056p as=0.1632p pd=0.92u ps=1.64u
    I_MXI1_I42_I117_XG_MP0 (VDD I1_I42_P21_20 XI1_I42_I117_XG_p1 VDD) gpdk090_pmos1v w=0.48u l=0.1u ad=0.1056p as=0.1056p pd=0.92u ps=0.92u
    I_MXI1_I42_I117_XG_MP1 (XI1_I42_I117_XG_p1 I1_I42_G19_18 VDD VDD) gpdk090_pmos1v w=0.48u l=0.1u ad=0.1632p as=0.1056p pd=1.64u ps=0.92u
    I_MXI1_I42_I115_XG_MP2 (XI1_I42_I115_XG_p1 I1_I42_G19_18 I1_I42_G19_16n VDD) gpdk090_pmos1v w=0.48u l=0.1u ad=0.1056p as=0.1632p pd=0.92u ps=1.64u
    I_MXI1_I42_I115_XG_MP0 (VDD I1_I42_P19_18 XI1_I42_I115_XG_p1 VDD) gpdk090_pmos1v w=0.48u l=0.1u ad=0.1056p as=0.1056p pd=0.92u ps=0.92u
    I_MXI1_I42_I115_XG_MP1 (XI1_I42_I115_XG_p1 I1_I42_G17_16 VDD VDD) gpdk090_pmos1v w=0.48u l=0.1u ad=0.1632p as=0.1056p pd=1.64u ps=0.92u
    I_MXI1_I42_I173_XG_MP2 (XI1_I42_I173_XG_p1 I1_I42_G22_15 I1_I42_G22_7n VDD) gpdk090_pmos1v w=0.48u l=0.1u ad=0.1056p as=0.1632p pd=0.92u ps=1.64u
    I_MXI1_I42_I173_XG_MP0 (VDD I1_I42_P22_15 XI1_I42_I173_XG_p1 VDD) gpdk090_pmos1v w=0.48u l=0.1u ad=0.1056p as=0.1056p pd=0.92u ps=0.92u
    I_MXI1_I42_I173_XG_MP1 (XI1_I42_I173_XG_p1 I1_I42_G14_7 VDD VDD) gpdk090_pmos1v w=0.48u l=0.1u ad=0.1632p as=0.1056p pd=1.64u ps=0.92u
    I_MXI1_I42_I165_XG_MP2 (XI1_I42_I165_XG_p1 I1_I42_G14_7 I1_I42_G14_0n VDD) gpdk090_pmos1v w=0.48u l=0.1u ad=0.1056p as=0.1632p pd=0.92u ps=1.64u
    I_MXI1_I42_I165_XG_MP0 (VDD I1_I42_P14_7 XI1_I42_I165_XG_p1 VDD) gpdk090_pmos1v w=0.48u l=0.1u ad=0.1056p as=0.1056p pd=0.92u ps=0.92u
    I_MXI1_I42_I165_XG_MP1 (XI1_I42_I165_XG_p1 I1_I42_G6_0 VDD VDD) gpdk090_pmos1v w=0.48u l=0.1u ad=0.1632p as=0.1056p pd=1.64u ps=0.92u
    I_MXI1_I42_I112_XG_MP2 (XI1_I42_I112_XG_p1 I1_I42_G16_15 I1_I42_G16_13n VDD) gpdk090_pmos1v w=0.48u l=0.1u ad=0.1056p as=0.1632p pd=0.92u ps=1.64u
    I_MXI1_I42_I112_XG_MP0 (VDD I1_I42_P16_15 XI1_I42_I112_XG_p1 VDD) gpdk090_pmos1v w=0.48u l=0.1u ad=0.1056p as=0.1056p pd=0.92u ps=0.92u
    I_MXI1_I42_I112_XG_MP1 (XI1_I42_I112_XG_p1 I1_I42_G14_13 VDD VDD) gpdk090_pmos1v w=0.48u l=0.1u ad=0.1632p as=0.1056p pd=1.64u ps=0.92u
    I_MXI3_I272_MP2 (XI3_I272_p1 I3_o15_2 I3_q15_2 VDD) gpdk090_pmos1v w=0.48u l=0.1u ad=0.1056p as=0.1632p pd=0.92u ps=1.64u
    I_MXI3_I272_MP0 (VDD I3_SEL_AS_b3_2 XI3_I272_p1 VDD) gpdk090_pmos1v w=0.48u l=0.1u ad=0.1056p as=0.1056p pd=0.92u ps=0.92u
    I_MXI3_I272_MP1 (XI3_I272_p1 S_15 VDD VDD) gpdk090_pmos1v w=0.48u l=0.1u ad=0.1632p as=0.1056p pd=1.64u ps=0.92u
    I_MXI1_I42_I122_XG_MP2 (XI1_I42_I122_XG_p1 I1_I42_G26_25 I1_I42_G26_23n VDD) gpdk090_pmos1v w=0.48u l=0.1u ad=0.1056p as=0.1632p pd=0.92u ps=1.64u
    I_MXI1_I42_I122_XG_MP0 (VDD I1_I42_P26_25 XI1_I42_I122_XG_p1 VDD) gpdk090_pmos1v w=0.48u l=0.1u ad=0.1056p as=0.1056p pd=0.92u ps=0.92u
    I_MXI1_I42_I122_XG_MP1 (XI1_I42_I122_XG_p1 I1_I42_G24_23 VDD VDD) gpdk090_pmos1v w=0.48u l=0.1u ad=0.1632p as=0.1056p pd=1.64u ps=0.92u
    I_MXI1_I42_I120_XG_MP2 (XI1_I42_I120_XG_p1 I1_I42_G24_23 I1_I42_G24_21n VDD) gpdk090_pmos1v w=0.48u l=0.1u ad=0.1056p as=0.1632p pd=0.92u ps=1.64u
    I_MXI1_I42_I120_XG_MP0 (VDD I1_I42_P24_23 XI1_I42_I120_XG_p1 VDD) gpdk090_pmos1v w=0.48u l=0.1u ad=0.1056p as=0.1056p pd=0.92u ps=0.92u
    I_MXI1_I42_I120_XG_MP1 (XI1_I42_I120_XG_p1 I1_I42_G22_21 VDD VDD) gpdk090_pmos1v w=0.48u l=0.1u ad=0.1632p as=0.1056p pd=1.64u ps=0.92u
    I_MXI1_I42_I118_XG_MP2 (XI1_I42_I118_XG_p1 I1_I42_G22_21 I1_I42_G22_19n VDD) gpdk090_pmos1v w=0.48u l=0.1u ad=0.1056p as=0.1632p pd=0.92u ps=1.64u
    I_MXI1_I42_I118_XG_MP0 (VDD I1_I42_P22_21 XI1_I42_I118_XG_p1 VDD) gpdk090_pmos1v w=0.48u l=0.1u ad=0.1056p as=0.1056p pd=0.92u ps=0.92u
    I_MXI1_I42_I118_XG_MP1 (XI1_I42_I118_XG_p1 I1_I42_G20_19 VDD VDD) gpdk090_pmos1v w=0.48u l=0.1u ad=0.1632p as=0.1056p pd=1.64u ps=0.92u
    I_MXI1_I42_I177_XG_MP2 (XI1_I42_I177_XG_p1 I1_I42_G26_19 I1_I42_G26_11n VDD) gpdk090_pmos1v w=0.48u l=0.1u ad=0.1056p as=0.1632p pd=0.92u ps=1.64u
    I_MXI1_I42_I177_XG_MP0 (VDD I1_I42_P26_19 XI1_I42_I177_XG_p1 VDD) gpdk090_pmos1v w=0.48u l=0.1u ad=0.1056p as=0.1056p pd=0.92u ps=0.92u
    I_MXI1_I42_I177_XG_MP1 (XI1_I42_I177_XG_p1 I1_I42_G18_11 VDD VDD) gpdk090_pmos1v w=0.48u l=0.1u ad=0.1632p as=0.1056p pd=1.64u ps=0.92u
    I_MXI1_I42_I116_XG_MP2 (XI1_I42_I116_XG_p1 I1_I42_G20_19 I1_I42_G20_17n VDD) gpdk090_pmos1v w=0.48u l=0.1u ad=0.1056p as=0.1632p pd=0.92u ps=1.64u
    I_MXI1_I42_I116_XG_MP0 (VDD I1_I42_P20_19 XI1_I42_I116_XG_p1 VDD) gpdk090_pmos1v w=0.48u l=0.1u ad=0.1056p as=0.1056p pd=0.92u ps=0.92u
    I_MXI1_I42_I116_XG_MP1 (XI1_I42_I116_XG_p1 I1_I42_G18_17 VDD VDD) gpdk090_pmos1v w=0.48u l=0.1u ad=0.1632p as=0.1056p pd=1.64u ps=0.92u
    I_MXI1_I42_I114_XG_MP2 (XI1_I42_I114_XG_p1 I1_I42_G18_17 I1_I42_G18_15n VDD) gpdk090_pmos1v w=0.48u l=0.1u ad=0.1056p as=0.1632p pd=0.92u ps=1.64u
    I_MXI1_I42_I114_XG_MP0 (VDD I1_I42_P18_17 XI1_I42_I114_XG_p1 VDD) gpdk090_pmos1v w=0.48u l=0.1u ad=0.1056p as=0.1056p pd=0.92u ps=0.92u
    I_MXI1_I42_I114_XG_MP1 (XI1_I42_I114_XG_p1 I1_I42_G16_15 VDD VDD) gpdk090_pmos1v w=0.48u l=0.1u ad=0.1632p as=0.1056p pd=1.64u ps=0.92u
    I_MXI3_I392_MP2 (XI3_I392_p1 I3_o25_2 I3_q25_2 VDD) gpdk090_pmos1v w=0.48u l=0.1u ad=0.1056p as=0.1632p pd=0.92u ps=1.64u
    I_MXI3_I392_MP0 (VDD I3_SEL_AS_b3_4 XI3_I392_p1 VDD) gpdk090_pmos1v w=0.48u l=0.1u ad=0.1056p as=0.1056p pd=0.92u ps=0.92u
    I_MXI3_I392_MP1 (XI3_I392_p1 S_25 VDD VDD) gpdk090_pmos1v w=0.48u l=0.1u ad=0.1632p as=0.1056p pd=1.64u ps=0.92u
    I_MXI3_I404_MP2 (XI3_I404_p1 I3_o26_2 I3_q26_2 VDD) gpdk090_pmos1v w=0.48u l=0.1u ad=0.1056p as=0.1632p pd=0.92u ps=1.64u
    I_MXI3_I404_MP0 (VDD I3_SEL_AS_b3_4 XI3_I404_p1 VDD) gpdk090_pmos1v w=0.48u l=0.1u ad=0.1056p as=0.1056p pd=0.92u ps=0.92u
    I_MXI3_I404_MP1 (XI3_I404_p1 S_26 VDD VDD) gpdk090_pmos1v w=0.48u l=0.1u ad=0.1632p as=0.1056p pd=1.64u ps=0.92u
    I_MXI3_I380_MP2 (XI3_I380_p1 I3_o24_2 I3_q24_2 VDD) gpdk090_pmos1v w=0.48u l=0.1u ad=0.1056p as=0.1632p pd=0.92u ps=1.64u
    I_MXI3_I380_MP0 (VDD I3_SEL_AS_b3_4 XI3_I380_p1 VDD) gpdk090_pmos1v w=0.48u l=0.1u ad=0.1056p as=0.1056p pd=0.92u ps=0.92u
    I_MXI3_I380_MP1 (XI3_I380_p1 S_24 VDD VDD) gpdk090_pmos1v w=0.48u l=0.1u ad=0.1632p as=0.1056p pd=1.64u ps=0.92u
    I_MXI3_I284_MP2 (XI3_I284_p1 I3_o16_2 I3_q16_2 VDD) gpdk090_pmos1v w=0.48u l=0.1u ad=0.1056p as=0.1632p pd=0.92u ps=1.64u
    I_MXI3_I284_MP0 (VDD I3_SEL_AS_b3_3 XI3_I284_p1 VDD) gpdk090_pmos1v w=0.48u l=0.1u ad=0.1056p as=0.1056p pd=0.92u ps=0.92u
    I_MXI3_I284_MP1 (XI3_I284_p1 S_16 VDD VDD) gpdk090_pmos1v w=0.48u l=0.1u ad=0.1632p as=0.1056p pd=1.64u ps=0.92u
    I_MXI3_I356_MP2 (XI3_I356_p1 I3_o22_2 I3_q22_2 VDD) gpdk090_pmos1v w=0.48u l=0.1u ad=0.1056p as=0.1632p pd=0.92u ps=1.64u
    I_MXI3_I356_MP0 (VDD I3_SEL_AS_b3_4 XI3_I356_p1 VDD) gpdk090_pmos1v w=0.48u l=0.1u ad=0.1056p as=0.1056p pd=0.92u ps=0.92u
    I_MXI3_I356_MP1 (XI3_I356_p1 S_22 VDD VDD) gpdk090_pmos1v w=0.48u l=0.1u ad=0.1632p as=0.1056p pd=1.64u ps=0.92u
    I_MXI3_I344_MP2 (XI3_I344_p1 I3_o21_2 I3_q21_2 VDD) gpdk090_pmos1v w=0.48u l=0.1u ad=0.1056p as=0.1632p pd=0.92u ps=1.64u
    I_MXI3_I344_MP0 (VDD I3_SEL_AS_b3_3 XI3_I344_p1 VDD) gpdk090_pmos1v w=0.48u l=0.1u ad=0.1056p as=0.1056p pd=0.92u ps=0.92u
    I_MXI3_I344_MP1 (XI3_I344_p1 S_21 VDD VDD) gpdk090_pmos1v w=0.48u l=0.1u ad=0.1632p as=0.1056p pd=1.64u ps=0.92u
    I_MXI3_I332_MP2 (XI3_I332_p1 I3_o20_2 I3_q20_2 VDD) gpdk090_pmos1v w=0.48u l=0.1u ad=0.1056p as=0.1632p pd=0.92u ps=1.64u
    I_MXI3_I332_MP0 (VDD I3_SEL_AS_b3_3 XI3_I332_p1 VDD) gpdk090_pmos1v w=0.48u l=0.1u ad=0.1056p as=0.1056p pd=0.92u ps=0.92u
    I_MXI3_I332_MP1 (XI3_I332_p1 S_20 VDD VDD) gpdk090_pmos1v w=0.48u l=0.1u ad=0.1632p as=0.1056p pd=1.64u ps=0.92u
    I_MXI3_I320_MP2 (XI3_I320_p1 I3_o19_2 I3_q19_2 VDD) gpdk090_pmos1v w=0.48u l=0.1u ad=0.1056p as=0.1632p pd=0.92u ps=1.64u
    I_MXI3_I320_MP0 (VDD I3_SEL_AS_b3_3 XI3_I320_p1 VDD) gpdk090_pmos1v w=0.48u l=0.1u ad=0.1056p as=0.1056p pd=0.92u ps=0.92u
    I_MXI3_I320_MP1 (XI3_I320_p1 S_19 VDD VDD) gpdk090_pmos1v w=0.48u l=0.1u ad=0.1632p as=0.1056p pd=1.64u ps=0.92u
    I_MXI3_I308_MP2 (XI3_I308_p1 I3_o18_2 I3_q18_2 VDD) gpdk090_pmos1v w=0.48u l=0.1u ad=0.1056p as=0.1632p pd=0.92u ps=1.64u
    I_MXI3_I308_MP0 (VDD I3_SEL_AS_b3_3 XI3_I308_p1 VDD) gpdk090_pmos1v w=0.48u l=0.1u ad=0.1056p as=0.1056p pd=0.92u ps=0.92u
    I_MXI3_I308_MP1 (XI3_I308_p1 S_18 VDD VDD) gpdk090_pmos1v w=0.48u l=0.1u ad=0.1632p as=0.1056p pd=1.64u ps=0.92u
    I_MXI3_I296_MP2 (XI3_I296_p1 I3_o17_2 I3_q17_2 VDD) gpdk090_pmos1v w=0.48u l=0.1u ad=0.1056p as=0.1632p pd=0.92u ps=1.64u
    I_MXI3_I296_MP0 (VDD I3_SEL_AS_b3_3 XI3_I296_p1 VDD) gpdk090_pmos1v w=0.48u l=0.1u ad=0.1056p as=0.1056p pd=0.92u ps=0.92u
    I_MXI3_I296_MP1 (XI3_I296_p1 S_17 VDD VDD) gpdk090_pmos1v w=0.48u l=0.1u ad=0.1632p as=0.1056p pd=1.64u ps=0.92u
    I_MXI3_I368_MP2 (XI3_I368_p1 I3_o23_2 I3_q23_2 VDD) gpdk090_pmos1v w=0.48u l=0.1u ad=0.1056p as=0.1632p pd=0.92u ps=1.64u
    I_MXI3_I368_MP0 (VDD I3_SEL_AS_b3_4 XI3_I368_p1 VDD) gpdk090_pmos1v w=0.48u l=0.1u ad=0.1056p as=0.1056p pd=0.92u ps=0.92u
    I_MXI3_I368_MP1 (XI3_I368_p1 S_23 VDD VDD) gpdk090_pmos1v w=0.48u l=0.1u ad=0.1632p as=0.1056p pd=1.64u ps=0.92u
    I_MXI1_I42_I65_XG_MP2 (VDD I1_I42_gn0 I1_I42_G0_0 VDD) gpdk090_pmos1v w=0.24u l=0.1u ad=0.0936p as=0.0816p pd=0.92u ps=1.16u
    I_MXI1_I42_I65_XG_MP0 (XI1_I42_I65_XG_p1 I1_I42_pn0 VDD VDD) gpdk090_pmos1v w=0.48u l=0.1u ad=0.1056p as=0.0936p pd=0.92u ps=0.92u
    I_MXI1_I42_I65_XG_MP1 (I1_I42_G0_0 I1_I42_cinn XI1_I42_I65_XG_p1 VDD) gpdk090_pmos1v w=0.48u l=0.1u ad=0.1632p as=0.1056p pd=1.64u ps=0.92u
    I_MXI1_I42_I75_XG_MP2 (VDD I1_I42_gn9 I1_I42_G9_8 VDD) gpdk090_pmos1v w=0.24u l=0.1u ad=0.0936p as=0.0816p pd=0.92u ps=1.16u
    I_MXI1_I42_I75_XG_MP0 (XI1_I42_I75_XG_p1 I1_I42_pn9 VDD VDD) gpdk090_pmos1v w=0.48u l=0.1u ad=0.1056p as=0.0936p pd=0.92u ps=0.92u
    I_MXI1_I42_I75_XG_MP1 (I1_I42_G9_8 I1_I42_gn8 XI1_I42_I75_XG_p1 VDD) gpdk090_pmos1v w=0.48u l=0.1u ad=0.1632p as=0.1056p pd=1.64u ps=0.92u
    I_MXI1_I42_I74_XG_MP2 (VDD I1_I42_gn8 I1_I42_G8_7 VDD) gpdk090_pmos1v w=0.24u l=0.1u ad=0.0936p as=0.0816p pd=0.92u ps=1.16u
    I_MXI1_I42_I74_XG_MP0 (XI1_I42_I74_XG_p1 I1_I42_pn8 VDD VDD) gpdk090_pmos1v w=0.48u l=0.1u ad=0.1056p as=0.0936p pd=0.92u ps=0.92u
    I_MXI1_I42_I74_XG_MP1 (I1_I42_G8_7 I1_I42_gn7 XI1_I42_I74_XG_p1 VDD) gpdk090_pmos1v w=0.48u l=0.1u ad=0.1632p as=0.1056p pd=1.64u ps=0.92u
    I_MXI1_I42_I73_XG_MP2 (VDD I1_I42_gn7 I1_I42_G7_6 VDD) gpdk090_pmos1v w=0.24u l=0.1u ad=0.0936p as=0.0816p pd=0.92u ps=1.16u
    I_MXI1_I42_I73_XG_MP0 (XI1_I42_I73_XG_p1 I1_I42_pn7 VDD VDD) gpdk090_pmos1v w=0.48u l=0.1u ad=0.1056p as=0.0936p pd=0.92u ps=0.92u
    I_MXI1_I42_I73_XG_MP1 (I1_I42_G7_6 I1_I42_gn6 XI1_I42_I73_XG_p1 VDD) gpdk090_pmos1v w=0.48u l=0.1u ad=0.1632p as=0.1056p pd=1.64u ps=0.92u
    I_MXI1_I42_I72_XG_MP2 (VDD I1_I42_gn6 I1_I42_G6_5 VDD) gpdk090_pmos1v w=0.24u l=0.1u ad=0.0936p as=0.0816p pd=0.92u ps=1.16u
    I_MXI1_I42_I72_XG_MP0 (XI1_I42_I72_XG_p1 I1_I42_pn6 VDD VDD) gpdk090_pmos1v w=0.48u l=0.1u ad=0.1056p as=0.0936p pd=0.92u ps=0.92u
    I_MXI1_I42_I72_XG_MP1 (I1_I42_G6_5 I1_I42_gn5 XI1_I42_I72_XG_p1 VDD) gpdk090_pmos1v w=0.48u l=0.1u ad=0.1632p as=0.1056p pd=1.64u ps=0.92u
    I_MXI1_I42_I71_XG_MP2 (VDD I1_I42_gn5 I1_I42_G5_4 VDD) gpdk090_pmos1v w=0.24u l=0.1u ad=0.0936p as=0.0816p pd=0.92u ps=1.16u
    I_MXI1_I42_I71_XG_MP0 (XI1_I42_I71_XG_p1 I1_I42_pn5 VDD VDD) gpdk090_pmos1v w=0.48u l=0.1u ad=0.1056p as=0.0936p pd=0.92u ps=0.92u
    I_MXI1_I42_I71_XG_MP1 (I1_I42_G5_4 I1_I42_gn4 XI1_I42_I71_XG_p1 VDD) gpdk090_pmos1v w=0.48u l=0.1u ad=0.1632p as=0.1056p pd=1.64u ps=0.92u
    I_MXI1_I42_I70_XG_MP2 (VDD I1_I42_gn4 I1_I42_G4_3 VDD) gpdk090_pmos1v w=0.24u l=0.1u ad=0.0936p as=0.0816p pd=0.92u ps=1.16u
    I_MXI1_I42_I70_XG_MP0 (XI1_I42_I70_XG_p1 I1_I42_pn4 VDD VDD) gpdk090_pmos1v w=0.48u l=0.1u ad=0.1056p as=0.0936p pd=0.92u ps=0.92u
    I_MXI1_I42_I70_XG_MP1 (I1_I42_G4_3 I1_I42_gn3 XI1_I42_I70_XG_p1 VDD) gpdk090_pmos1v w=0.48u l=0.1u ad=0.1632p as=0.1056p pd=1.64u ps=0.92u
    I_MXI1_I42_I130_XG_MP2 (VDD I1_I42_G5_2n I1_I42_G5_0 VDD) gpdk090_pmos1v w=0.24u l=0.1u ad=0.0936p as=0.0816p pd=0.92u ps=1.16u
    I_MXI1_I42_I130_XG_MP0 (XI1_I42_I130_XG_p1 I1_I42_P5_2n VDD VDD) gpdk090_pmos1v w=0.48u l=0.1u ad=0.1056p as=0.0936p pd=0.92u ps=0.92u
    I_MXI1_I42_I130_XG_MP1 (I1_I42_G5_0 I1_I42_G1_0n XI1_I42_I130_XG_p1 VDD) gpdk090_pmos1v w=0.48u l=0.1u ad=0.1632p as=0.1056p pd=1.64u ps=0.92u
    I_MXI1_I42_I134_XG_MP2 (VDD I1_I42_G9_6n I1_I42_G9_2 VDD) gpdk090_pmos1v w=0.24u l=0.1u ad=0.0936p as=0.0816p pd=0.92u ps=1.16u
    I_MXI1_I42_I134_XG_MP0 (XI1_I42_I134_XG_p1 I1_I42_P9_6n VDD VDD) gpdk090_pmos1v w=0.48u l=0.1u ad=0.1056p as=0.0936p pd=0.92u ps=0.92u
    I_MXI1_I42_I134_XG_MP1 (I1_I42_G9_2 I1_I42_G5_2n XI1_I42_I134_XG_p1 VDD) gpdk090_pmos1v w=0.48u l=0.1u ad=0.1632p as=0.1056p pd=1.64u ps=0.92u
    I_MXI1_I42_I76_XG_MP2 (VDD I1_I42_gn10 I1_I42_G10_9 VDD) gpdk090_pmos1v w=0.24u l=0.1u ad=0.0936p as=0.0816p pd=0.92u ps=1.16u
    I_MXI1_I42_I76_XG_MP0 (XI1_I42_I76_XG_p1 I1_I42_pn10 VDD VDD) gpdk090_pmos1v w=0.48u l=0.1u ad=0.1056p as=0.0936p pd=0.92u ps=0.92u
    I_MXI1_I42_I76_XG_MP1 (I1_I42_G10_9 I1_I42_gn9 XI1_I42_I76_XG_p1 VDD) gpdk090_pmos1v w=0.48u l=0.1u ad=0.1632p as=0.1056p pd=1.64u ps=0.92u
    I_MXI1_I42_I69_XG_MP2 (VDD I1_I42_gn3 I1_I42_G3_2 VDD) gpdk090_pmos1v w=0.24u l=0.1u ad=0.0936p as=0.0816p pd=0.92u ps=1.16u
    I_MXI1_I42_I69_XG_MP0 (XI1_I42_I69_XG_p1 I1_I42_pn3 VDD VDD) gpdk090_pmos1v w=0.48u l=0.1u ad=0.1056p as=0.0936p pd=0.92u ps=0.92u
    I_MXI1_I42_I69_XG_MP1 (I1_I42_G3_2 I1_I42_gn2 XI1_I42_I69_XG_p1 VDD) gpdk090_pmos1v w=0.48u l=0.1u ad=0.1632p as=0.1056p pd=1.64u ps=0.92u
    I_MXI1_I42_I68_XG_MP2 (VDD I1_I42_gn2 I1_I42_G2_1 VDD) gpdk090_pmos1v w=0.24u l=0.1u ad=0.0936p as=0.0816p pd=0.92u ps=1.16u
    I_MXI1_I42_I68_XG_MP0 (XI1_I42_I68_XG_p1 I1_I42_pn2 VDD VDD) gpdk090_pmos1v w=0.48u l=0.1u ad=0.1056p as=0.0936p pd=0.92u ps=0.92u
    I_MXI1_I42_I68_XG_MP1 (I1_I42_G2_1 I1_I42_gn1 XI1_I42_I68_XG_p1 VDD) gpdk090_pmos1v w=0.48u l=0.1u ad=0.1632p as=0.1056p pd=1.64u ps=0.92u
    I_MXI1_I42_I67_XG_MP2 (VDD I1_I42_gn1 I1_I42_G1_0 VDD) gpdk090_pmos1v w=0.24u l=0.1u ad=0.0936p as=0.0816p pd=0.92u ps=1.16u
    I_MXI1_I42_I67_XG_MP0 (XI1_I42_I67_XG_p1 I1_I42_pn1 VDD VDD) gpdk090_pmos1v w=0.48u l=0.1u ad=0.1056p as=0.0936p pd=0.92u ps=0.92u
    I_MXI1_I42_I67_XG_MP1 (I1_I42_G1_0 I1_I42_G0_0n XI1_I42_I67_XG_p1 VDD) gpdk090_pmos1v w=0.48u l=0.1u ad=0.1632p as=0.1056p pd=1.64u ps=0.92u
    I_MXI1_I42_I184_XG_MP2 (VDD I1_I42_G17_2n I1_I42_G17_0 VDD) gpdk090_pmos1v w=0.24u l=0.1u ad=0.0936p as=0.0816p pd=0.92u ps=1.16u
    I_MXI1_I42_I184_XG_MP0 (XI1_I42_I184_XG_p1 I1_I42_P17_2n VDD VDD) gpdk090_pmos1v w=0.48u l=0.1u ad=0.1056p as=0.0936p pd=0.92u ps=0.92u
    I_MXI1_I42_I184_XG_MP1 (I1_I42_G17_0 I1_I42_G1_0n XI1_I42_I184_XG_p1 VDD) gpdk090_pmos1v w=0.48u l=0.1u ad=0.1632p as=0.1056p pd=1.64u ps=0.92u
    I_MXI1_I42_I132_XG_MP2 (VDD I1_I42_G7_4n I1_I42_G7_0 VDD) gpdk090_pmos1v w=0.24u l=0.1u ad=0.0936p as=0.0816p pd=0.92u ps=1.16u
    I_MXI1_I42_I132_XG_MP0 (XI1_I42_I132_XG_p1 I1_I42_P7_4n VDD VDD) gpdk090_pmos1v w=0.48u l=0.1u ad=0.1056p as=0.0936p pd=0.92u ps=0.92u
    I_MXI1_I42_I132_XG_MP1 (I1_I42_G7_0 I1_I42_G3_0n XI1_I42_I132_XG_p1 VDD) gpdk090_pmos1v w=0.48u l=0.1u ad=0.1632p as=0.1056p pd=1.64u ps=0.92u
    I_MXI1_I42_I133_XG_MP2 (VDD I1_I42_G8_5n I1_I42_G8_1 VDD) gpdk090_pmos1v w=0.24u l=0.1u ad=0.0936p as=0.0816p pd=0.92u ps=1.16u
    I_MXI1_I42_I133_XG_MP0 (XI1_I42_I133_XG_p1 I1_I42_P8_5n VDD VDD) gpdk090_pmos1v w=0.48u l=0.1u ad=0.1056p as=0.0936p pd=0.92u ps=0.92u
    I_MXI1_I42_I133_XG_MP1 (I1_I42_G8_1 I1_I42_G4_1n XI1_I42_I133_XG_p1 VDD) gpdk090_pmos1v w=0.48u l=0.1u ad=0.1632p as=0.1056p pd=1.64u ps=0.92u
    I_MXI1_I42_I128_XG_MP2 (VDD I1_I42_G4_1n I1_I42_G4_0 VDD) gpdk090_pmos1v w=0.24u l=0.1u ad=0.0936p as=0.0816p pd=0.92u ps=1.16u
    I_MXI1_I42_I128_XG_MP0 (XI1_I42_I128_XG_p1 I1_I42_P4_1n VDD VDD) gpdk090_pmos1v w=0.48u l=0.1u ad=0.1056p as=0.0936p pd=0.92u ps=0.92u
    I_MXI1_I42_I128_XG_MP1 (I1_I42_G4_0 I1_I42_G0_0n XI1_I42_I128_XG_p1 VDD) gpdk090_pmos1v w=0.48u l=0.1u ad=0.1632p as=0.1056p pd=1.64u ps=0.92u
    I_MXI1_I42_I200_XG_MP2 (VDD I1_I42_G29_14n I1_I42_G29_0 VDD) gpdk090_pmos1v w=0.24u l=0.1u ad=0.0936p as=0.0816p pd=0.92u ps=1.16u
    I_MXI1_I42_I200_XG_MP0 (XI1_I42_I200_XG_p1 I1_I42_P29_14n VDD VDD) gpdk090_pmos1v w=0.48u l=0.1u ad=0.1056p as=0.0936p pd=0.92u ps=0.92u
    I_MXI1_I42_I200_XG_MP1 (I1_I42_G29_0 I1_I42_G13_0n XI1_I42_I200_XG_p1 VDD) gpdk090_pmos1v w=0.48u l=0.1u ad=0.1632p as=0.1056p pd=1.64u ps=0.92u
    I_MXI1_I42_I196_XG_MP2 (VDD I1_I42_G25_10n I1_I42_G25_0 VDD) gpdk090_pmos1v w=0.24u l=0.1u ad=0.0936p as=0.0816p pd=0.92u ps=1.16u
    I_MXI1_I42_I196_XG_MP0 (XI1_I42_I196_XG_p1 I1_I42_P25_10n VDD VDD) gpdk090_pmos1v w=0.48u l=0.1u ad=0.1056p as=0.0936p pd=0.92u ps=0.92u
    I_MXI1_I42_I196_XG_MP1 (I1_I42_G25_0 I1_I42_G9_0n XI1_I42_I196_XG_p1 VDD) gpdk090_pmos1v w=0.48u l=0.1u ad=0.1632p as=0.1056p pd=1.64u ps=0.92u
    I_MXI1_I42_I190_XG_MP2 (VDD I1_I42_G21_6n I1_I42_G21_0 VDD) gpdk090_pmos1v w=0.24u l=0.1u ad=0.0936p as=0.0816p pd=0.92u ps=1.16u
    I_MXI1_I42_I190_XG_MP0 (XI1_I42_I190_XG_p1 I1_I42_P21_6n VDD VDD) gpdk090_pmos1v w=0.48u l=0.1u ad=0.1056p as=0.0936p pd=0.92u ps=0.92u
    I_MXI1_I42_I190_XG_MP1 (I1_I42_G21_0 I1_I42_G5_0n XI1_I42_I190_XG_p1 VDD) gpdk090_pmos1v w=0.48u l=0.1u ad=0.1632p as=0.1056p pd=1.64u ps=0.92u
    I_MXI1_I42_I138_XG_MP2 (VDD I1_I42_G13_10n I1_I42_G13_6 VDD) gpdk090_pmos1v w=0.24u l=0.1u ad=0.0936p as=0.0816p pd=0.92u ps=1.16u
    I_MXI1_I42_I138_XG_MP0 (XI1_I42_I138_XG_p1 I1_I42_P13_10n VDD VDD) gpdk090_pmos1v w=0.48u l=0.1u ad=0.1056p as=0.0936p pd=0.92u ps=0.92u
    I_MXI1_I42_I138_XG_MP1 (I1_I42_G13_6 I1_I42_G9_6n XI1_I42_I138_XG_p1 VDD) gpdk090_pmos1v w=0.48u l=0.1u ad=0.1632p as=0.1056p pd=1.64u ps=0.92u
    I_MXI1_I42_I136_XG_MP2 (VDD I1_I42_G11_8n I1_I42_G11_4 VDD) gpdk090_pmos1v w=0.24u l=0.1u ad=0.0936p as=0.0816p pd=0.92u ps=1.16u
    I_MXI1_I42_I136_XG_MP0 (XI1_I42_I136_XG_p1 I1_I42_P11_8n VDD VDD) gpdk090_pmos1v w=0.48u l=0.1u ad=0.1056p as=0.0936p pd=0.92u ps=0.92u
    I_MXI1_I42_I136_XG_MP1 (I1_I42_G11_4 I1_I42_G7_4n XI1_I42_I136_XG_p1 VDD) gpdk090_pmos1v w=0.48u l=0.1u ad=0.1632p as=0.1056p pd=1.64u ps=0.92u
    I_MXI1_I42_I77_XG_MP2 (VDD I1_I42_gn11 I1_I42_G11_10 VDD) gpdk090_pmos1v w=0.24u l=0.1u ad=0.0936p as=0.0816p pd=0.92u ps=1.16u
    I_MXI1_I42_I77_XG_MP0 (XI1_I42_I77_XG_p1 I1_I42_pn11 VDD VDD) gpdk090_pmos1v w=0.48u l=0.1u ad=0.1056p as=0.0936p pd=0.92u ps=0.92u
    I_MXI1_I42_I77_XG_MP1 (I1_I42_G11_10 I1_I42_gn10 XI1_I42_I77_XG_p1 VDD) gpdk090_pmos1v w=0.48u l=0.1u ad=0.1632p as=0.1056p pd=1.64u ps=0.92u
    I_MXI1_I42_I131_XG_MP2 (VDD I1_I42_G6_3n I1_I42_G6_0 VDD) gpdk090_pmos1v w=0.24u l=0.1u ad=0.0936p as=0.0816p pd=0.92u ps=1.16u
    I_MXI1_I42_I131_XG_MP0 (XI1_I42_I131_XG_p1 I1_I42_P6_3n VDD VDD) gpdk090_pmos1v w=0.48u l=0.1u ad=0.1056p as=0.0936p pd=0.92u ps=0.92u
    I_MXI1_I42_I131_XG_MP1 (I1_I42_G6_0 I1_I42_G2_0n XI1_I42_I131_XG_p1 VDD) gpdk090_pmos1v w=0.48u l=0.1u ad=0.1632p as=0.1056p pd=1.64u ps=0.92u
    I_MXI1_I42_I183_XG_MP2 (VDD I1_I42_G16_1n I1_I42_G16_0 VDD) gpdk090_pmos1v w=0.24u l=0.1u ad=0.0936p as=0.0816p pd=0.92u ps=1.16u
    I_MXI1_I42_I183_XG_MP0 (XI1_I42_I183_XG_p1 I1_I42_P16_1n VDD VDD) gpdk090_pmos1v w=0.48u l=0.1u ad=0.1056p as=0.0936p pd=0.92u ps=0.92u
    I_MXI1_I42_I183_XG_MP1 (I1_I42_G16_0 I1_I42_G0_0n XI1_I42_I183_XG_p1 VDD) gpdk090_pmos1v w=0.48u l=0.1u ad=0.1632p as=0.1056p pd=1.64u ps=0.92u
    I_MXI1_I42_I97_XG_MP2 (VDD I1_I42_gn31 I1_I42_G31_30 VDD) gpdk090_pmos1v w=0.24u l=0.1u ad=0.0936p as=0.0816p pd=0.92u ps=1.16u
    I_MXI1_I42_I97_XG_MP0 (XI1_I42_I97_XG_p1 I1_I42_pn31 VDD VDD) gpdk090_pmos1v w=0.48u l=0.1u ad=0.1056p as=0.0936p pd=0.92u ps=0.92u
    I_MXI1_I42_I97_XG_MP1 (I1_I42_G31_30 I1_I42_gn30 XI1_I42_I97_XG_p1 VDD) gpdk090_pmos1v w=0.48u l=0.1u ad=0.1632p as=0.1056p pd=1.64u ps=0.92u
    I_MXI1_I42_I150_XG_MP2 (VDD I1_I42_G25_22n I1_I42_G25_18 VDD) gpdk090_pmos1v w=0.24u l=0.1u ad=0.0936p as=0.0816p pd=0.92u ps=1.16u
    I_MXI1_I42_I150_XG_MP0 (XI1_I42_I150_XG_p1 I1_I42_P25_22n VDD VDD) gpdk090_pmos1v w=0.48u l=0.1u ad=0.1056p as=0.0936p pd=0.92u ps=0.92u
    I_MXI1_I42_I150_XG_MP1 (I1_I42_G25_18 I1_I42_G21_18n XI1_I42_I150_XG_p1 VDD) gpdk090_pmos1v w=0.48u l=0.1u ad=0.1632p as=0.1056p pd=1.64u ps=0.92u
    I_MXI1_I42_I146_XG_MP2 (VDD I1_I42_G21_18n I1_I42_G21_14 VDD) gpdk090_pmos1v w=0.24u l=0.1u ad=0.0936p as=0.0816p pd=0.92u ps=1.16u
    I_MXI1_I42_I146_XG_MP0 (XI1_I42_I146_XG_p1 I1_I42_P21_18n VDD VDD) gpdk090_pmos1v w=0.48u l=0.1u ad=0.1056p as=0.0936p pd=0.92u ps=0.92u
    I_MXI1_I42_I146_XG_MP1 (I1_I42_G21_14 I1_I42_G17_14n XI1_I42_I146_XG_p1 VDD) gpdk090_pmos1v w=0.48u l=0.1u ad=0.1632p as=0.1056p pd=1.64u ps=0.92u
    I_MXI1_I42_I142_XG_MP2 (VDD I1_I42_G17_14n I1_I42_G17_10 VDD) gpdk090_pmos1v w=0.24u l=0.1u ad=0.0936p as=0.0816p pd=0.92u ps=1.16u
    I_MXI1_I42_I142_XG_MP0 (XI1_I42_I142_XG_p1 I1_I42_P17_14n VDD VDD) gpdk090_pmos1v w=0.48u l=0.1u ad=0.1056p as=0.0936p pd=0.92u ps=0.92u
    I_MXI1_I42_I142_XG_MP1 (I1_I42_G17_10 I1_I42_G13_10n XI1_I42_I142_XG_p1 VDD) gpdk090_pmos1v w=0.48u l=0.1u ad=0.1632p as=0.1056p pd=1.64u ps=0.92u
    I_MXI1_I42_I135_XG_MP2 (VDD I1_I42_G10_7n I1_I42_G10_3 VDD) gpdk090_pmos1v w=0.24u l=0.1u ad=0.0936p as=0.0816p pd=0.92u ps=1.16u
    I_MXI1_I42_I135_XG_MP0 (XI1_I42_I135_XG_p1 I1_I42_P10_7n VDD VDD) gpdk090_pmos1v w=0.48u l=0.1u ad=0.1056p as=0.0936p pd=0.92u ps=0.92u
    I_MXI1_I42_I135_XG_MP1 (I1_I42_G10_3 I1_I42_G6_3n XI1_I42_I135_XG_p1 VDD) gpdk090_pmos1v w=0.48u l=0.1u ad=0.1632p as=0.1056p pd=1.64u ps=0.92u
    I_MXI1_I42_I195_XG_MP2 (VDD I1_I42_G24_9n I1_I42_G24_0 VDD) gpdk090_pmos1v w=0.24u l=0.1u ad=0.0936p as=0.0816p pd=0.92u ps=1.16u
    I_MXI1_I42_I195_XG_MP0 (XI1_I42_I195_XG_p1 I1_I42_P24_9n VDD VDD) gpdk090_pmos1v w=0.48u l=0.1u ad=0.1056p as=0.0936p pd=0.92u ps=0.92u
    I_MXI1_I42_I195_XG_MP1 (I1_I42_G24_0 I1_I42_G8_0n XI1_I42_I195_XG_p1 VDD) gpdk090_pmos1v w=0.48u l=0.1u ad=0.1632p as=0.1056p pd=1.64u ps=0.92u
    I_MXI1_I42_I137_XG_MP2 (VDD I1_I42_G12_9n I1_I42_G12_5 VDD) gpdk090_pmos1v w=0.24u l=0.1u ad=0.0936p as=0.0816p pd=0.92u ps=1.16u
    I_MXI1_I42_I137_XG_MP0 (XI1_I42_I137_XG_p1 I1_I42_P12_9n VDD VDD) gpdk090_pmos1v w=0.48u l=0.1u ad=0.1056p as=0.0936p pd=0.92u ps=0.92u
    I_MXI1_I42_I137_XG_MP1 (I1_I42_G12_5 I1_I42_G8_5n XI1_I42_I137_XG_p1 VDD) gpdk090_pmos1v w=0.48u l=0.1u ad=0.1632p as=0.1056p pd=1.64u ps=0.92u
    I_MXI1_I42_I78_XG_MP2 (VDD I1_I42_gn12 I1_I42_G12_11 VDD) gpdk090_pmos1v w=0.24u l=0.1u ad=0.0936p as=0.0816p pd=0.92u ps=1.16u
    I_MXI1_I42_I78_XG_MP0 (XI1_I42_I78_XG_p1 I1_I42_pn12 VDD VDD) gpdk090_pmos1v w=0.48u l=0.1u ad=0.1056p as=0.0936p pd=0.92u ps=0.92u
    I_MXI1_I42_I78_XG_MP1 (I1_I42_G12_11 I1_I42_gn11 XI1_I42_I78_XG_p1 VDD) gpdk090_pmos1v w=0.48u l=0.1u ad=0.1632p as=0.1056p pd=1.64u ps=0.92u
    I_MXI1_I42_I79_XG_MP2 (VDD I1_I42_gn13 I1_I42_G13_12 VDD) gpdk090_pmos1v w=0.24u l=0.1u ad=0.0936p as=0.0816p pd=0.92u ps=1.16u
    I_MXI1_I42_I79_XG_MP0 (XI1_I42_I79_XG_p1 I1_I42_pn13 VDD VDD) gpdk090_pmos1v w=0.48u l=0.1u ad=0.1056p as=0.0936p pd=0.92u ps=0.92u
    I_MXI1_I42_I79_XG_MP1 (I1_I42_G13_12 I1_I42_gn12 XI1_I42_I79_XG_p1 VDD) gpdk090_pmos1v w=0.48u l=0.1u ad=0.1632p as=0.1056p pd=1.64u ps=0.92u
    I_MXI1_I42_I95_XG_MP2 (VDD I1_I42_gn29 I1_I42_G29_28 VDD) gpdk090_pmos1v w=0.24u l=0.1u ad=0.0936p as=0.0816p pd=0.92u ps=1.16u
    I_MXI1_I42_I95_XG_MP0 (XI1_I42_I95_XG_p1 I1_I42_pn29 VDD VDD) gpdk090_pmos1v w=0.48u l=0.1u ad=0.1056p as=0.0936p pd=0.92u ps=0.92u
    I_MXI1_I42_I95_XG_MP1 (I1_I42_G29_28 I1_I42_gn28 XI1_I42_I95_XG_p1 VDD) gpdk090_pmos1v w=0.48u l=0.1u ad=0.1632p as=0.1056p pd=1.64u ps=0.92u
    I_MXI1_I42_I96_XG_MP2 (VDD I1_I42_gn30 I1_I42_G30_29 VDD) gpdk090_pmos1v w=0.24u l=0.1u ad=0.0936p as=0.0816p pd=0.92u ps=1.16u
    I_MXI1_I42_I96_XG_MP0 (XI1_I42_I96_XG_p1 I1_I42_pn30 VDD VDD) gpdk090_pmos1v w=0.48u l=0.1u ad=0.1056p as=0.0936p pd=0.92u ps=0.92u
    I_MXI1_I42_I96_XG_MP1 (I1_I42_G30_29 I1_I42_gn29 XI1_I42_I96_XG_p1 VDD) gpdk090_pmos1v w=0.48u l=0.1u ad=0.1632p as=0.1056p pd=1.64u ps=0.92u
    I_MXI1_I42_I154_XG_MP2 (VDD I1_I42_G29_26n I1_I42_G29_22 VDD) gpdk090_pmos1v w=0.24u l=0.1u ad=0.0936p as=0.0816p pd=0.92u ps=1.16u
    I_MXI1_I42_I154_XG_MP0 (XI1_I42_I154_XG_p1 I1_I42_P29_26n VDD VDD) gpdk090_pmos1v w=0.48u l=0.1u ad=0.1056p as=0.0936p pd=0.92u ps=0.92u
    I_MXI1_I42_I154_XG_MP1 (I1_I42_G29_22 I1_I42_G25_22n XI1_I42_I154_XG_p1 VDD) gpdk090_pmos1v w=0.48u l=0.1u ad=0.1632p as=0.1056p pd=1.64u ps=0.92u
    I_MXI1_I42_I156_XG_MP2 (VDD I1_I42_G31_28n I1_I42_G31_24 VDD) gpdk090_pmos1v w=0.24u l=0.1u ad=0.0936p as=0.0816p pd=0.92u ps=1.16u
    I_MXI1_I42_I156_XG_MP0 (XI1_I42_I156_XG_p1 I1_I42_P31_28n VDD VDD) gpdk090_pmos1v w=0.48u l=0.1u ad=0.1056p as=0.0936p pd=0.92u ps=0.92u
    I_MXI1_I42_I156_XG_MP1 (I1_I42_G31_24 I1_I42_G27_24n XI1_I42_I156_XG_p1 VDD) gpdk090_pmos1v w=0.48u l=0.1u ad=0.1632p as=0.1056p pd=1.64u ps=0.92u
    I_MXI1_I42_I202_XG_MP2 (VDD I1_I42_G31_16n CO VDD) gpdk090_pmos1v w=0.24u l=0.1u ad=0.0936p as=0.0816p pd=0.92u ps=1.16u
    I_MXI1_I42_I202_XG_MP0 (XI1_I42_I202_XG_p1 I1_I42_P31_16n VDD VDD) gpdk090_pmos1v w=0.48u l=0.1u ad=0.1056p as=0.0936p pd=0.92u ps=0.92u
    I_MXI1_I42_I202_XG_MP1 (CO I1_I42_G15_0n XI1_I42_I202_XG_p1 VDD) gpdk090_pmos1v w=0.48u l=0.1u ad=0.1632p as=0.1056p pd=1.64u ps=0.92u
    I_MXI1_I42_I194_XG_MP2 (VDD I1_I42_G23_8n I1_I42_G23_0 VDD) gpdk090_pmos1v w=0.24u l=0.1u ad=0.0936p as=0.0816p pd=0.92u ps=1.16u
    I_MXI1_I42_I194_XG_MP0 (XI1_I42_I194_XG_p1 I1_I42_P23_8n VDD VDD) gpdk090_pmos1v w=0.48u l=0.1u ad=0.1056p as=0.0936p pd=0.92u ps=0.92u
    I_MXI1_I42_I194_XG_MP1 (I1_I42_G23_0 I1_I42_G7_0n XI1_I42_I194_XG_p1 VDD) gpdk090_pmos1v w=0.48u l=0.1u ad=0.1632p as=0.1056p pd=1.64u ps=0.92u
    I_MXI1_I42_I198_XG_MP2 (VDD I1_I42_G27_12n I1_I42_G27_0 VDD) gpdk090_pmos1v w=0.24u l=0.1u ad=0.0936p as=0.0816p pd=0.92u ps=1.16u
    I_MXI1_I42_I198_XG_MP0 (XI1_I42_I198_XG_p1 I1_I42_P27_12n VDD VDD) gpdk090_pmos1v w=0.48u l=0.1u ad=0.1056p as=0.0936p pd=0.92u ps=0.92u
    I_MXI1_I42_I198_XG_MP1 (I1_I42_G27_0 I1_I42_G11_0n XI1_I42_I198_XG_p1 VDD) gpdk090_pmos1v w=0.48u l=0.1u ad=0.1632p as=0.1056p pd=1.64u ps=0.92u
    I_MXI1_I42_I140_XG_MP2 (VDD I1_I42_G15_12n I1_I42_G15_8 VDD) gpdk090_pmos1v w=0.24u l=0.1u ad=0.0936p as=0.0816p pd=0.92u ps=1.16u
    I_MXI1_I42_I140_XG_MP0 (XI1_I42_I140_XG_p1 I1_I42_P15_12n VDD VDD) gpdk090_pmos1v w=0.48u l=0.1u ad=0.1056p as=0.0936p pd=0.92u ps=0.92u
    I_MXI1_I42_I140_XG_MP1 (I1_I42_G15_8 I1_I42_G11_8n XI1_I42_I140_XG_p1 VDD) gpdk090_pmos1v w=0.48u l=0.1u ad=0.1632p as=0.1056p pd=1.64u ps=0.92u
    I_MXI1_I42_I186_XG_MP2 (VDD I1_I42_G19_4n I1_I42_G19_0 VDD) gpdk090_pmos1v w=0.24u l=0.1u ad=0.0936p as=0.0816p pd=0.92u ps=1.16u
    I_MXI1_I42_I186_XG_MP0 (XI1_I42_I186_XG_p1 I1_I42_P19_4n VDD VDD) gpdk090_pmos1v w=0.48u l=0.1u ad=0.1056p as=0.0936p pd=0.92u ps=0.92u
    I_MXI1_I42_I186_XG_MP1 (I1_I42_G19_0 I1_I42_G3_0n XI1_I42_I186_XG_p1 VDD) gpdk090_pmos1v w=0.48u l=0.1u ad=0.1632p as=0.1056p pd=1.64u ps=0.92u
    I_MXI1_I42_I199_XG_MP2 (VDD I1_I42_G28_13n I1_I42_G28_0 VDD) gpdk090_pmos1v w=0.24u l=0.1u ad=0.0936p as=0.0816p pd=0.92u ps=1.16u
    I_MXI1_I42_I199_XG_MP0 (XI1_I42_I199_XG_p1 I1_I42_P28_13n VDD VDD) gpdk090_pmos1v w=0.48u l=0.1u ad=0.1056p as=0.0936p pd=0.92u ps=0.92u
    I_MXI1_I42_I199_XG_MP1 (I1_I42_G28_0 I1_I42_G12_0n XI1_I42_I199_XG_p1 VDD) gpdk090_pmos1v w=0.48u l=0.1u ad=0.1632p as=0.1056p pd=1.64u ps=0.92u
    I_MXI1_I42_I185_XG_MP2 (VDD I1_I42_G18_3n I1_I42_G18_0 VDD) gpdk090_pmos1v w=0.24u l=0.1u ad=0.0936p as=0.0816p pd=0.92u ps=1.16u
    I_MXI1_I42_I185_XG_MP0 (XI1_I42_I185_XG_p1 I1_I42_P18_3n VDD VDD) gpdk090_pmos1v w=0.48u l=0.1u ad=0.1056p as=0.0936p pd=0.92u ps=0.92u
    I_MXI1_I42_I185_XG_MP1 (I1_I42_G18_0 I1_I42_G2_0n XI1_I42_I185_XG_p1 VDD) gpdk090_pmos1v w=0.48u l=0.1u ad=0.1632p as=0.1056p pd=1.64u ps=0.92u
    I_MXI1_I42_I141_XG_MP2 (VDD I1_I42_G16_13n I1_I42_G16_9 VDD) gpdk090_pmos1v w=0.24u l=0.1u ad=0.0936p as=0.0816p pd=0.92u ps=1.16u
    I_MXI1_I42_I141_XG_MP0 (XI1_I42_I141_XG_p1 I1_I42_P16_13n VDD VDD) gpdk090_pmos1v w=0.48u l=0.1u ad=0.1056p as=0.0936p pd=0.92u ps=0.92u
    I_MXI1_I42_I141_XG_MP1 (I1_I42_G16_9 I1_I42_G12_9n XI1_I42_I141_XG_p1 VDD) gpdk090_pmos1v w=0.48u l=0.1u ad=0.1632p as=0.1056p pd=1.64u ps=0.92u
    I_MXI1_I42_I152_XG_MP2 (VDD I1_I42_G27_24n I1_I42_G27_20 VDD) gpdk090_pmos1v w=0.24u l=0.1u ad=0.0936p as=0.0816p pd=0.92u ps=1.16u
    I_MXI1_I42_I152_XG_MP0 (XI1_I42_I152_XG_p1 I1_I42_P27_24n VDD VDD) gpdk090_pmos1v w=0.48u l=0.1u ad=0.1056p as=0.0936p pd=0.92u ps=0.92u
    I_MXI1_I42_I152_XG_MP1 (I1_I42_G27_20 I1_I42_G23_20n XI1_I42_I152_XG_p1 VDD) gpdk090_pmos1v w=0.48u l=0.1u ad=0.1632p as=0.1056p pd=1.64u ps=0.92u
    I_MXI1_I42_I148_XG_MP2 (VDD I1_I42_G23_20n I1_I42_G23_16 VDD) gpdk090_pmos1v w=0.24u l=0.1u ad=0.0936p as=0.0816p pd=0.92u ps=1.16u
    I_MXI1_I42_I148_XG_MP0 (XI1_I42_I148_XG_p1 I1_I42_P23_20n VDD VDD) gpdk090_pmos1v w=0.48u l=0.1u ad=0.1056p as=0.0936p pd=0.92u ps=0.92u
    I_MXI1_I42_I148_XG_MP1 (I1_I42_G23_16 I1_I42_G19_16n XI1_I42_I148_XG_p1 VDD) gpdk090_pmos1v w=0.48u l=0.1u ad=0.1632p as=0.1056p pd=1.64u ps=0.92u
    I_MXI1_I42_I144_XG_MP2 (VDD I1_I42_G19_16n I1_I42_G19_12 VDD) gpdk090_pmos1v w=0.24u l=0.1u ad=0.0936p as=0.0816p pd=0.92u ps=1.16u
    I_MXI1_I42_I144_XG_MP0 (XI1_I42_I144_XG_p1 I1_I42_P19_16n VDD VDD) gpdk090_pmos1v w=0.48u l=0.1u ad=0.1056p as=0.0936p pd=0.92u ps=0.92u
    I_MXI1_I42_I144_XG_MP1 (I1_I42_G19_12 I1_I42_G15_12n XI1_I42_I144_XG_p1 VDD) gpdk090_pmos1v w=0.48u l=0.1u ad=0.1632p as=0.1056p pd=1.64u ps=0.92u
    I_MXI1_I42_I139_XG_MP2 (VDD I1_I42_G14_11n I1_I42_G14_7 VDD) gpdk090_pmos1v w=0.24u l=0.1u ad=0.0936p as=0.0816p pd=0.92u ps=1.16u
    I_MXI1_I42_I139_XG_MP0 (XI1_I42_I139_XG_p1 I1_I42_P14_11n VDD VDD) gpdk090_pmos1v w=0.48u l=0.1u ad=0.1056p as=0.0936p pd=0.92u ps=0.92u
    I_MXI1_I42_I139_XG_MP1 (I1_I42_G14_7 I1_I42_G10_7n XI1_I42_I139_XG_p1 VDD) gpdk090_pmos1v w=0.48u l=0.1u ad=0.1632p as=0.1056p pd=1.64u ps=0.92u
    I_MXI1_I42_I188_XG_MP2 (VDD I1_I42_G20_5n I1_I42_G20_0 VDD) gpdk090_pmos1v w=0.24u l=0.1u ad=0.0936p as=0.0816p pd=0.92u ps=1.16u
    I_MXI1_I42_I188_XG_MP0 (XI1_I42_I188_XG_p1 I1_I42_P20_5n VDD VDD) gpdk090_pmos1v w=0.48u l=0.1u ad=0.1056p as=0.0936p pd=0.92u ps=0.92u
    I_MXI1_I42_I188_XG_MP1 (I1_I42_G20_0 I1_I42_G4_0n XI1_I42_I188_XG_p1 VDD) gpdk090_pmos1v w=0.48u l=0.1u ad=0.1632p as=0.1056p pd=1.64u ps=0.92u
    I_MXI1_I42_I80_XG_MP2 (VDD I1_I42_gn14 I1_I42_G14_13 VDD) gpdk090_pmos1v w=0.24u l=0.1u ad=0.0936p as=0.0816p pd=0.92u ps=1.16u
    I_MXI1_I42_I80_XG_MP0 (XI1_I42_I80_XG_p1 I1_I42_pn14 VDD VDD) gpdk090_pmos1v w=0.48u l=0.1u ad=0.1056p as=0.0936p pd=0.92u ps=0.92u
    I_MXI1_I42_I80_XG_MP1 (I1_I42_G14_13 I1_I42_gn13 XI1_I42_I80_XG_p1 VDD) gpdk090_pmos1v w=0.48u l=0.1u ad=0.1632p as=0.1056p pd=1.64u ps=0.92u
    I_MXI1_I42_I94_XG_MP2 (VDD I1_I42_gn28 I1_I42_G28_27 VDD) gpdk090_pmos1v w=0.24u l=0.1u ad=0.0936p as=0.0816p pd=0.92u ps=1.16u
    I_MXI1_I42_I94_XG_MP0 (XI1_I42_I94_XG_p1 I1_I42_pn28 VDD VDD) gpdk090_pmos1v w=0.48u l=0.1u ad=0.1056p as=0.0936p pd=0.92u ps=0.92u
    I_MXI1_I42_I94_XG_MP1 (I1_I42_G28_27 I1_I42_gn27 XI1_I42_I94_XG_p1 VDD) gpdk090_pmos1v w=0.48u l=0.1u ad=0.1632p as=0.1056p pd=1.64u ps=0.92u
    I_MXI1_I42_I155_XG_MP2 (VDD I1_I42_G30_27n I1_I42_G30_23 VDD) gpdk090_pmos1v w=0.24u l=0.1u ad=0.0936p as=0.0816p pd=0.92u ps=1.16u
    I_MXI1_I42_I155_XG_MP0 (XI1_I42_I155_XG_p1 I1_I42_P30_27n VDD VDD) gpdk090_pmos1v w=0.48u l=0.1u ad=0.1056p as=0.0936p pd=0.92u ps=0.92u
    I_MXI1_I42_I155_XG_MP1 (I1_I42_G30_23 I1_I42_G26_23n XI1_I42_I155_XG_p1 VDD) gpdk090_pmos1v w=0.48u l=0.1u ad=0.1632p as=0.1056p pd=1.64u ps=0.92u
    I_MXI1_I42_I201_XG_MP2 (VDD I1_I42_G30_15n CM VDD) gpdk090_pmos1v w=0.24u l=0.1u ad=0.0936p as=0.0816p pd=0.92u ps=1.16u
    I_MXI1_I42_I201_XG_MP0 (XI1_I42_I201_XG_p1 I1_I42_P30_15n VDD VDD) gpdk090_pmos1v w=0.48u l=0.1u ad=0.1056p as=0.0936p pd=0.92u ps=0.92u
    I_MXI1_I42_I201_XG_MP1 (CM I1_I42_G14_0n XI1_I42_I201_XG_p1 VDD) gpdk090_pmos1v w=0.48u l=0.1u ad=0.1632p as=0.1056p pd=1.64u ps=0.92u
    I_MXI1_I42_I153_XG_MP2 (VDD I1_I42_G28_25n I1_I42_G28_21 VDD) gpdk090_pmos1v w=0.24u l=0.1u ad=0.0936p as=0.0816p pd=0.92u ps=1.16u
    I_MXI1_I42_I153_XG_MP0 (XI1_I42_I153_XG_p1 I1_I42_P28_25n VDD VDD) gpdk090_pmos1v w=0.48u l=0.1u ad=0.1056p as=0.0936p pd=0.92u ps=0.92u
    I_MXI1_I42_I153_XG_MP1 (I1_I42_G28_21 I1_I42_G24_21n XI1_I42_I153_XG_p1 VDD) gpdk090_pmos1v w=0.48u l=0.1u ad=0.1632p as=0.1056p pd=1.64u ps=0.92u
    I_MXI1_I42_I192_XG_MP2 (VDD I1_I42_G22_7n I1_I42_G22_0 VDD) gpdk090_pmos1v w=0.24u l=0.1u ad=0.0936p as=0.0816p pd=0.92u ps=1.16u
    I_MXI1_I42_I192_XG_MP0 (XI1_I42_I192_XG_p1 I1_I42_P22_7n VDD VDD) gpdk090_pmos1v w=0.48u l=0.1u ad=0.1056p as=0.0936p pd=0.92u ps=0.92u
    I_MXI1_I42_I192_XG_MP1 (I1_I42_G22_0 I1_I42_G6_0n XI1_I42_I192_XG_p1 VDD) gpdk090_pmos1v w=0.48u l=0.1u ad=0.1632p as=0.1056p pd=1.64u ps=0.92u
    I_MXI1_I42_I197_XG_MP2 (VDD I1_I42_G26_11n I1_I42_G26_0 VDD) gpdk090_pmos1v w=0.24u l=0.1u ad=0.0936p as=0.0816p pd=0.92u ps=1.16u
    I_MXI1_I42_I197_XG_MP0 (XI1_I42_I197_XG_p1 I1_I42_P26_11n VDD VDD) gpdk090_pmos1v w=0.48u l=0.1u ad=0.1056p as=0.0936p pd=0.92u ps=0.92u
    I_MXI1_I42_I197_XG_MP1 (I1_I42_G26_0 I1_I42_G10_0n XI1_I42_I197_XG_p1 VDD) gpdk090_pmos1v w=0.48u l=0.1u ad=0.1632p as=0.1056p pd=1.64u ps=0.92u
    I_MXI1_I42_I143_XG_MP2 (VDD I1_I42_G18_15n I1_I42_G18_11 VDD) gpdk090_pmos1v w=0.24u l=0.1u ad=0.0936p as=0.0816p pd=0.92u ps=1.16u
    I_MXI1_I42_I143_XG_MP0 (XI1_I42_I143_XG_p1 I1_I42_P18_15n VDD VDD) gpdk090_pmos1v w=0.48u l=0.1u ad=0.1056p as=0.0936p pd=0.92u ps=0.92u
    I_MXI1_I42_I143_XG_MP1 (I1_I42_G18_11 I1_I42_G14_11n XI1_I42_I143_XG_p1 VDD) gpdk090_pmos1v w=0.48u l=0.1u ad=0.1632p as=0.1056p pd=1.64u ps=0.92u
    I_MXI1_I42_I149_XG_MP2 (VDD I1_I42_G24_21n I1_I42_G24_17 VDD) gpdk090_pmos1v w=0.24u l=0.1u ad=0.0936p as=0.0816p pd=0.92u ps=1.16u
    I_MXI1_I42_I149_XG_MP0 (XI1_I42_I149_XG_p1 I1_I42_P24_21n VDD VDD) gpdk090_pmos1v w=0.48u l=0.1u ad=0.1056p as=0.0936p pd=0.92u ps=0.92u
    I_MXI1_I42_I149_XG_MP1 (I1_I42_G24_17 I1_I42_G20_17n XI1_I42_I149_XG_p1 VDD) gpdk090_pmos1v w=0.48u l=0.1u ad=0.1632p as=0.1056p pd=1.64u ps=0.92u
    I_MXI1_I42_I145_XG_MP2 (VDD I1_I42_G20_17n I1_I42_G20_13 VDD) gpdk090_pmos1v w=0.24u l=0.1u ad=0.0936p as=0.0816p pd=0.92u ps=1.16u
    I_MXI1_I42_I145_XG_MP0 (XI1_I42_I145_XG_p1 I1_I42_P20_17n VDD VDD) gpdk090_pmos1v w=0.48u l=0.1u ad=0.1056p as=0.0936p pd=0.92u ps=0.92u
    I_MXI1_I42_I145_XG_MP1 (I1_I42_G20_13 I1_I42_G16_13n XI1_I42_I145_XG_p1 VDD) gpdk090_pmos1v w=0.48u l=0.1u ad=0.1632p as=0.1056p pd=1.64u ps=0.92u
    I_MXI1_I42_I81_XG_MP2 (VDD I1_I42_gn15 I1_I42_G15_14 VDD) gpdk090_pmos1v w=0.24u l=0.1u ad=0.0936p as=0.0816p pd=0.92u ps=1.16u
    I_MXI1_I42_I81_XG_MP0 (XI1_I42_I81_XG_p1 I1_I42_pn15 VDD VDD) gpdk090_pmos1v w=0.48u l=0.1u ad=0.1056p as=0.0936p pd=0.92u ps=0.92u
    I_MXI1_I42_I81_XG_MP1 (I1_I42_G15_14 I1_I42_gn14 XI1_I42_I81_XG_p1 VDD) gpdk090_pmos1v w=0.48u l=0.1u ad=0.1632p as=0.1056p pd=1.64u ps=0.92u
    I_MXI1_I42_I93_XG_MP2 (VDD I1_I42_gn27 I1_I42_G27_26 VDD) gpdk090_pmos1v w=0.24u l=0.1u ad=0.0936p as=0.0816p pd=0.92u ps=1.16u
    I_MXI1_I42_I93_XG_MP0 (XI1_I42_I93_XG_p1 I1_I42_pn27 VDD VDD) gpdk090_pmos1v w=0.48u l=0.1u ad=0.1056p as=0.0936p pd=0.92u ps=0.92u
    I_MXI1_I42_I93_XG_MP1 (I1_I42_G27_26 I1_I42_gn26 XI1_I42_I93_XG_p1 VDD) gpdk090_pmos1v w=0.48u l=0.1u ad=0.1632p as=0.1056p pd=1.64u ps=0.92u
    I_MXI1_I42_I151_XG_MP2 (VDD I1_I42_G26_23n I1_I42_G26_19 VDD) gpdk090_pmos1v w=0.24u l=0.1u ad=0.0936p as=0.0816p pd=0.92u ps=1.16u
    I_MXI1_I42_I151_XG_MP0 (XI1_I42_I151_XG_p1 I1_I42_P26_23n VDD VDD) gpdk090_pmos1v w=0.48u l=0.1u ad=0.1056p as=0.0936p pd=0.92u ps=0.92u
    I_MXI1_I42_I151_XG_MP1 (I1_I42_G26_19 I1_I42_G22_19n XI1_I42_I151_XG_p1 VDD) gpdk090_pmos1v w=0.48u l=0.1u ad=0.1632p as=0.1056p pd=1.64u ps=0.92u
    I_MXI1_I42_I147_XG_MP2 (VDD I1_I42_G22_19n I1_I42_G22_15 VDD) gpdk090_pmos1v w=0.24u l=0.1u ad=0.0936p as=0.0816p pd=0.92u ps=1.16u
    I_MXI1_I42_I147_XG_MP0 (XI1_I42_I147_XG_p1 I1_I42_P22_19n VDD VDD) gpdk090_pmos1v w=0.48u l=0.1u ad=0.1056p as=0.0936p pd=0.92u ps=0.92u
    I_MXI1_I42_I147_XG_MP1 (I1_I42_G22_15 I1_I42_G18_15n XI1_I42_I147_XG_p1 VDD) gpdk090_pmos1v w=0.48u l=0.1u ad=0.1632p as=0.1056p pd=1.64u ps=0.92u
    I_MXI1_I42_I83_XG_MP2 (VDD I1_I42_gn17 I1_I42_G17_16 VDD) gpdk090_pmos1v w=0.24u l=0.1u ad=0.0936p as=0.0816p pd=0.92u ps=1.16u
    I_MXI1_I42_I83_XG_MP0 (XI1_I42_I83_XG_p1 I1_I42_pn17 VDD VDD) gpdk090_pmos1v w=0.48u l=0.1u ad=0.1056p as=0.0936p pd=0.92u ps=0.92u
    I_MXI1_I42_I83_XG_MP1 (I1_I42_G17_16 I1_I42_gn16 XI1_I42_I83_XG_p1 VDD) gpdk090_pmos1v w=0.48u l=0.1u ad=0.1632p as=0.1056p pd=1.64u ps=0.92u
    I_MXI1_I42_I82_XG_MP2 (VDD I1_I42_gn16 I1_I42_G16_15 VDD) gpdk090_pmos1v w=0.24u l=0.1u ad=0.0936p as=0.0816p pd=0.92u ps=1.16u
    I_MXI1_I42_I82_XG_MP0 (XI1_I42_I82_XG_p1 I1_I42_pn16 VDD VDD) gpdk090_pmos1v w=0.48u l=0.1u ad=0.1056p as=0.0936p pd=0.92u ps=0.92u
    I_MXI1_I42_I82_XG_MP1 (I1_I42_G16_15 I1_I42_gn15 XI1_I42_I82_XG_p1 VDD) gpdk090_pmos1v w=0.48u l=0.1u ad=0.1632p as=0.1056p pd=1.64u ps=0.92u
    I_MXI1_I42_I92_XG_MP2 (VDD I1_I42_gn26 I1_I42_G26_25 VDD) gpdk090_pmos1v w=0.24u l=0.1u ad=0.0936p as=0.0816p pd=0.92u ps=1.16u
    I_MXI1_I42_I92_XG_MP0 (XI1_I42_I92_XG_p1 I1_I42_pn26 VDD VDD) gpdk090_pmos1v w=0.48u l=0.1u ad=0.1056p as=0.0936p pd=0.92u ps=0.92u
    I_MXI1_I42_I92_XG_MP1 (I1_I42_G26_25 I1_I42_gn25 XI1_I42_I92_XG_p1 VDD) gpdk090_pmos1v w=0.48u l=0.1u ad=0.1632p as=0.1056p pd=1.64u ps=0.92u
    I_MXI1_I42_I91_XG_MP2 (VDD I1_I42_gn25 I1_I42_G25_24 VDD) gpdk090_pmos1v w=0.24u l=0.1u ad=0.0936p as=0.0816p pd=0.92u ps=1.16u
    I_MXI1_I42_I91_XG_MP0 (XI1_I42_I91_XG_p1 I1_I42_pn25 VDD VDD) gpdk090_pmos1v w=0.48u l=0.1u ad=0.1056p as=0.0936p pd=0.92u ps=0.92u
    I_MXI1_I42_I91_XG_MP1 (I1_I42_G25_24 I1_I42_gn24 XI1_I42_I91_XG_p1 VDD) gpdk090_pmos1v w=0.48u l=0.1u ad=0.1632p as=0.1056p pd=1.64u ps=0.92u
    I_MXI1_I42_I90_XG_MP2 (VDD I1_I42_gn24 I1_I42_G24_23 VDD) gpdk090_pmos1v w=0.24u l=0.1u ad=0.0936p as=0.0816p pd=0.92u ps=1.16u
    I_MXI1_I42_I90_XG_MP0 (XI1_I42_I90_XG_p1 I1_I42_pn24 VDD VDD) gpdk090_pmos1v w=0.48u l=0.1u ad=0.1056p as=0.0936p pd=0.92u ps=0.92u
    I_MXI1_I42_I90_XG_MP1 (I1_I42_G24_23 I1_I42_gn23 XI1_I42_I90_XG_p1 VDD) gpdk090_pmos1v w=0.48u l=0.1u ad=0.1632p as=0.1056p pd=1.64u ps=0.92u
    I_MXI1_I42_I89_XG_MP2 (VDD I1_I42_gn23 I1_I42_G23_22 VDD) gpdk090_pmos1v w=0.24u l=0.1u ad=0.0936p as=0.0816p pd=0.92u ps=1.16u
    I_MXI1_I42_I89_XG_MP0 (XI1_I42_I89_XG_p1 I1_I42_pn23 VDD VDD) gpdk090_pmos1v w=0.48u l=0.1u ad=0.1056p as=0.0936p pd=0.92u ps=0.92u
    I_MXI1_I42_I89_XG_MP1 (I1_I42_G23_22 I1_I42_gn22 XI1_I42_I89_XG_p1 VDD) gpdk090_pmos1v w=0.48u l=0.1u ad=0.1632p as=0.1056p pd=1.64u ps=0.92u
    I_MXI1_I42_I88_XG_MP2 (VDD I1_I42_gn22 I1_I42_G22_21 VDD) gpdk090_pmos1v w=0.24u l=0.1u ad=0.0936p as=0.0816p pd=0.92u ps=1.16u
    I_MXI1_I42_I88_XG_MP0 (XI1_I42_I88_XG_p1 I1_I42_pn22 VDD VDD) gpdk090_pmos1v w=0.48u l=0.1u ad=0.1056p as=0.0936p pd=0.92u ps=0.92u
    I_MXI1_I42_I88_XG_MP1 (I1_I42_G22_21 I1_I42_gn21 XI1_I42_I88_XG_p1 VDD) gpdk090_pmos1v w=0.48u l=0.1u ad=0.1632p as=0.1056p pd=1.64u ps=0.92u
    I_MXI1_I42_I87_XG_MP2 (VDD I1_I42_gn21 I1_I42_G21_20 VDD) gpdk090_pmos1v w=0.24u l=0.1u ad=0.0936p as=0.0816p pd=0.92u ps=1.16u
    I_MXI1_I42_I87_XG_MP0 (XI1_I42_I87_XG_p1 I1_I42_pn21 VDD VDD) gpdk090_pmos1v w=0.48u l=0.1u ad=0.1056p as=0.0936p pd=0.92u ps=0.92u
    I_MXI1_I42_I87_XG_MP1 (I1_I42_G21_20 I1_I42_gn20 XI1_I42_I87_XG_p1 VDD) gpdk090_pmos1v w=0.48u l=0.1u ad=0.1632p as=0.1056p pd=1.64u ps=0.92u
    I_MXI1_I42_I86_XG_MP2 (VDD I1_I42_gn20 I1_I42_G20_19 VDD) gpdk090_pmos1v w=0.24u l=0.1u ad=0.0936p as=0.0816p pd=0.92u ps=1.16u
    I_MXI1_I42_I86_XG_MP0 (XI1_I42_I86_XG_p1 I1_I42_pn20 VDD VDD) gpdk090_pmos1v w=0.48u l=0.1u ad=0.1056p as=0.0936p pd=0.92u ps=0.92u
    I_MXI1_I42_I86_XG_MP1 (I1_I42_G20_19 I1_I42_gn19 XI1_I42_I86_XG_p1 VDD) gpdk090_pmos1v w=0.48u l=0.1u ad=0.1632p as=0.1056p pd=1.64u ps=0.92u
    I_MXI1_I42_I85_XG_MP2 (VDD I1_I42_gn19 I1_I42_G19_18 VDD) gpdk090_pmos1v w=0.24u l=0.1u ad=0.0936p as=0.0816p pd=0.92u ps=1.16u
    I_MXI1_I42_I85_XG_MP0 (XI1_I42_I85_XG_p1 I1_I42_pn19 VDD VDD) gpdk090_pmos1v w=0.48u l=0.1u ad=0.1056p as=0.0936p pd=0.92u ps=0.92u
    I_MXI1_I42_I85_XG_MP1 (I1_I42_G19_18 I1_I42_gn18 XI1_I42_I85_XG_p1 VDD) gpdk090_pmos1v w=0.48u l=0.1u ad=0.1632p as=0.1056p pd=1.64u ps=0.92u
    I_MXI1_I42_I84_XG_MP2 (VDD I1_I42_gn18 I1_I42_G18_17 VDD) gpdk090_pmos1v w=0.24u l=0.1u ad=0.0936p as=0.0816p pd=0.92u ps=1.16u
    I_MXI1_I42_I84_XG_MP0 (XI1_I42_I84_XG_p1 I1_I42_pn18 VDD VDD) gpdk090_pmos1v w=0.48u l=0.1u ad=0.1056p as=0.0936p pd=0.92u ps=0.92u
    I_MXI1_I42_I84_XG_MP1 (I1_I42_G18_17 I1_I42_gn17 XI1_I42_I84_XG_p1 VDD) gpdk090_pmos1v w=0.48u l=0.1u ad=0.1632p as=0.1056p pd=1.64u ps=0.92u
    I_MXI3_I533_MP1 (I3_hd54 DIVR_22 VDD VDD) gpdk090_pmos1v w=0.24u l=0.1u ad=0.0528p as=0.0816p pd=0.68u ps=1.16u
    I_MXI3_I533_MP0 (VDD I3_SEL_DIV_b3_9 I3_hd54 VDD) gpdk090_pmos1v w=0.24u l=0.1u ad=0.0816p as=0.0528p pd=1.16u ps=0.68u
    I_MXI3_I541_MP1 (I3_hm57 MULP_57 VDD VDD) gpdk090_pmos1v w=0.24u l=0.1u ad=0.0528p as=0.0816p pd=0.68u ps=1.16u
    I_MXI3_I541_MP0 (VDD I3_SEL_MUL_b3_9 I3_hm57 VDD) gpdk090_pmos1v w=0.24u l=0.1u ad=0.0816p as=0.0528p pd=1.16u ps=0.68u
    I_MXI3_I545_MP1 (I3_hd58 DIVR_26 VDD VDD) gpdk090_pmos1v w=0.24u l=0.1u ad=0.0528p as=0.0816p pd=0.68u ps=1.16u
    I_MXI3_I545_MP0 (VDD I3_SEL_DIV_b3_9 I3_hd58 VDD) gpdk090_pmos1v w=0.24u l=0.1u ad=0.0816p as=0.0528p pd=1.16u ps=0.68u
    I_MXI3_I546_MP1 (Y_58 I3_hd58 VDD VDD) gpdk090_pmos1v w=0.24u l=0.1u ad=0.0528p as=0.0816p pd=0.68u ps=1.16u
    I_MXI3_I546_MP0 (VDD I3_hm58 Y_58 VDD) gpdk090_pmos1v w=0.24u l=0.1u ad=0.0816p as=0.0528p pd=1.16u ps=0.68u
    I_MXI3_I544_MP1 (I3_hm58 MULP_58 VDD VDD) gpdk090_pmos1v w=0.24u l=0.1u ad=0.0528p as=0.0816p pd=0.68u ps=1.16u
    I_MXI3_I544_MP0 (VDD I3_SEL_MUL_b3_9 I3_hm58 VDD) gpdk090_pmos1v w=0.24u l=0.1u ad=0.0816p as=0.0528p pd=1.16u ps=0.68u
    I_MXI3_I549_MP1 (Y_59 I3_hd59 VDD VDD) gpdk090_pmos1v w=0.24u l=0.1u ad=0.0528p as=0.0816p pd=0.68u ps=1.16u
    I_MXI3_I549_MP0 (VDD I3_hm59 Y_59 VDD) gpdk090_pmos1v w=0.24u l=0.1u ad=0.0816p as=0.0528p pd=1.16u ps=0.68u
    I_MXI3_I548_MP1 (I3_hd59 DIVR_27 VDD VDD) gpdk090_pmos1v w=0.24u l=0.1u ad=0.0528p as=0.0816p pd=0.68u ps=1.16u
    I_MXI3_I548_MP0 (VDD I3_SEL_DIV_b3_10 I3_hd59 VDD) gpdk090_pmos1v w=0.24u l=0.1u ad=0.0816p as=0.0528p pd=1.16u ps=0.68u
    I_MXI3_I557_MP1 (I3_hd62 DIVR_30 VDD VDD) gpdk090_pmos1v w=0.24u l=0.1u ad=0.0528p as=0.0816p pd=0.68u ps=1.16u
    I_MXI3_I557_MP0 (VDD I3_SEL_DIV_b3_10 I3_hd62 VDD) gpdk090_pmos1v w=0.24u l=0.1u ad=0.0816p as=0.0528p pd=1.16u ps=0.68u
    I_MXI3_I552_MP1 (Y_60 I3_hd60 VDD VDD) gpdk090_pmos1v w=0.24u l=0.1u ad=0.0528p as=0.0816p pd=0.68u ps=1.16u
    I_MXI3_I552_MP0 (VDD I3_hm60 Y_60 VDD) gpdk090_pmos1v w=0.24u l=0.1u ad=0.0816p as=0.0528p pd=1.16u ps=0.68u
    I_MXI3_I551_MP1 (I3_hd60 DIVR_28 VDD VDD) gpdk090_pmos1v w=0.24u l=0.1u ad=0.0528p as=0.0816p pd=0.68u ps=1.16u
    I_MXI3_I551_MP0 (VDD I3_SEL_DIV_b3_10 I3_hd60 VDD) gpdk090_pmos1v w=0.24u l=0.1u ad=0.0816p as=0.0528p pd=1.16u ps=0.68u
    I_MXI3_I550_MP1 (I3_hm60 MULP_60 VDD VDD) gpdk090_pmos1v w=0.24u l=0.1u ad=0.0528p as=0.0816p pd=0.68u ps=1.16u
    I_MXI3_I550_MP0 (VDD I3_SEL_MUL_b3_10 I3_hm60 VDD) gpdk090_pmos1v w=0.24u l=0.1u ad=0.0816p as=0.0528p pd=1.16u ps=0.68u
    I_MXI4_I70_MP1 (I4_dzn DIVDZ VDD VDD) gpdk090_pmos1v w=0.24u l=0.1u ad=0.0528p as=0.0816p pd=0.68u ps=1.16u
    I_MXI4_I70_MP0 (VDD SEL_DIV I4_dzn VDD) gpdk090_pmos1v w=0.24u l=0.1u ad=0.0816p as=0.0528p pd=1.16u ps=0.68u
    I_MXI3_I206_MP1 (I3_n10_4 MULP_10 VDD VDD) gpdk090_pmos1v w=0.24u l=0.1u ad=0.0528p as=0.0816p pd=0.68u ps=1.16u
    I_MXI3_I206_MP0 (VDD I3_SEL_MUL_b3_1 I3_n10_4 VDD) gpdk090_pmos1v w=0.24u l=0.1u ad=0.0816p as=0.0528p pd=1.16u ps=0.68u
    I_MXI3_I210_MP1 (I3_o10_2 I3_n10_5 VDD VDD) gpdk090_pmos1v w=0.24u l=0.1u ad=0.0528p as=0.0816p pd=0.68u ps=1.16u
    I_MXI3_I210_MP0 (VDD I3_n10_4 I3_o10_2 VDD) gpdk090_pmos1v w=0.24u l=0.1u ad=0.0816p as=0.0528p pd=1.16u ps=0.68u
    I_MXI3_I207_MP1 (I3_n10_5 DIVQ_10 VDD VDD) gpdk090_pmos1v w=0.24u l=0.1u ad=0.0528p as=0.0816p pd=0.68u ps=1.16u
    I_MXI3_I207_MP0 (VDD I3_SEL_DIV_b3_1 I3_n10_5 VDD) gpdk090_pmos1v w=0.24u l=0.1u ad=0.0816p as=0.0528p pd=1.16u ps=0.68u
    I_MXI3_I195_MP1 (I3_n9_5 DIVQ_9 VDD VDD) gpdk090_pmos1v w=0.24u l=0.1u ad=0.0528p as=0.0816p pd=0.68u ps=1.16u
    I_MXI3_I195_MP0 (VDD I3_SEL_DIV_b3_1 I3_n9_5 VDD) gpdk090_pmos1v w=0.24u l=0.1u ad=0.0816p as=0.0528p pd=1.16u ps=0.68u
    I_MXI3_I171_MP1 (I3_n7_5 DIVQ_7 VDD VDD) gpdk090_pmos1v w=0.24u l=0.1u ad=0.0528p as=0.0816p pd=0.68u ps=1.16u
    I_MXI3_I171_MP0 (VDD I3_SEL_DIV_b3_1 I3_n7_5 VDD) gpdk090_pmos1v w=0.24u l=0.1u ad=0.0816p as=0.0528p pd=1.16u ps=0.68u
    I_MXI3_I158_MP1 (I3_n6_4 MULP_6 VDD VDD) gpdk090_pmos1v w=0.24u l=0.1u ad=0.0528p as=0.0816p pd=0.68u ps=1.16u
    I_MXI3_I158_MP0 (VDD I3_SEL_MUL_b3_1 I3_n6_4 VDD) gpdk090_pmos1v w=0.24u l=0.1u ad=0.0816p as=0.0528p pd=1.16u ps=0.68u
    I_MXI3_I190_MP1 (I3_n9_0 AND_9 VDD VDD) gpdk090_pmos1v w=0.24u l=0.1u ad=0.0528p as=0.0816p pd=0.68u ps=1.16u
    I_MXI3_I190_MP0 (VDD I3_SEL_AND_b3_1 I3_n9_0 VDD) gpdk090_pmos1v w=0.24u l=0.1u ad=0.0816p as=0.0528p pd=1.16u ps=0.68u
    I_MXI3_I154_MP1 (I3_n6_0 AND_6 VDD VDD) gpdk090_pmos1v w=0.24u l=0.1u ad=0.0528p as=0.0816p pd=0.68u ps=1.16u
    I_MXI3_I154_MP0 (VDD I3_SEL_AND_b3_1 I3_n6_0 VDD) gpdk090_pmos1v w=0.24u l=0.1u ad=0.0816p as=0.0528p pd=1.16u ps=0.68u
    I_MXI4_I33_MP1 (I4_z1_1 I4_z0_3 VDD VDD) gpdk090_pmos1v w=0.24u l=0.1u ad=0.0528p as=0.0816p pd=0.68u ps=1.16u
    I_MXI4_I33_MP0 (VDD I4_z0_2 I4_z1_1 VDD) gpdk090_pmos1v w=0.24u l=0.1u ad=0.0816p as=0.0528p pd=1.16u ps=0.68u
    I_MXI2_I0_MP1 (I2_nand0 B_0 VDD VDD) gpdk090_pmos1v w=0.24u l=0.1u ad=0.0528p as=0.0816p pd=0.68u ps=1.16u
    I_MXI2_I0_MP0 (VDD A_0 I2_nand0 VDD) gpdk090_pmos1v w=0.24u l=0.1u ad=0.0816p as=0.0528p pd=1.16u ps=0.68u
    I_MXI3_I83_MP1 (I3_n0_1 OR_0 VDD VDD) gpdk090_pmos1v w=0.24u l=0.1u ad=0.0528p as=0.0816p pd=0.68u ps=1.16u
    I_MXI3_I83_MP0 (VDD I3_SEL_OR_b3_0 I3_n0_1 VDD) gpdk090_pmos1v w=0.24u l=0.1u ad=0.0816p as=0.0528p pd=1.16u ps=0.68u
    I_MXI3_I141_MP1 (Y_4 I3_q4_2 VDD VDD) gpdk090_pmos1v w=0.24u l=0.1u ad=0.0528p as=0.0816p pd=0.68u ps=1.16u
    I_MXI3_I141_MP0 (VDD I3_q4_1 Y_4 VDD) gpdk090_pmos1v w=0.24u l=0.1u ad=0.0816p as=0.0528p pd=1.16u ps=0.68u
    I_MXI2_I6_MP1 (I2_nand1 B_1 VDD VDD) gpdk090_pmos1v w=0.24u l=0.1u ad=0.0528p as=0.0816p pd=0.68u ps=1.16u
    I_MXI2_I6_MP0 (VDD A_1 I2_nand1 VDD) gpdk090_pmos1v w=0.24u l=0.1u ad=0.0816p as=0.0528p pd=1.16u ps=0.68u
    I_MXI3_I136_MP1 (I3_o4_0 I3_n4_1 VDD VDD) gpdk090_pmos1v w=0.24u l=0.1u ad=0.0528p as=0.0816p pd=0.68u ps=1.16u
    I_MXI3_I136_MP0 (VDD I3_n4_0 I3_o4_0 VDD) gpdk090_pmos1v w=0.24u l=0.1u ad=0.0816p as=0.0528p pd=1.16u ps=0.68u
    I_MXI3_I131_MP1 (I3_n4_1 OR_4 VDD VDD) gpdk090_pmos1v w=0.24u l=0.1u ad=0.0528p as=0.0816p pd=0.68u ps=1.16u
    I_MXI3_I131_MP0 (VDD I3_SEL_OR_b3_0 I3_n4_1 VDD) gpdk090_pmos1v w=0.24u l=0.1u ad=0.0816p as=0.0528p pd=1.16u ps=0.68u
    I_MXI3_I532_MP1 (I3_hm54 MULP_54 VDD VDD) gpdk090_pmos1v w=0.24u l=0.1u ad=0.0528p as=0.0816p pd=0.68u ps=1.16u
    I_MXI3_I532_MP0 (VDD I3_SEL_MUL_b3_9 I3_hm54 VDD) gpdk090_pmos1v w=0.24u l=0.1u ad=0.0816p as=0.0528p pd=1.16u ps=0.68u
    I_MXI3_I534_MP1 (Y_54 I3_hd54 VDD VDD) gpdk090_pmos1v w=0.24u l=0.1u ad=0.0528p as=0.0816p pd=0.68u ps=1.16u
    I_MXI3_I534_MP0 (VDD I3_hm54 Y_54 VDD) gpdk090_pmos1v w=0.24u l=0.1u ad=0.0816p as=0.0528p pd=1.16u ps=0.68u
    I_MXI3_I535_MP1 (I3_hm55 MULP_55 VDD VDD) gpdk090_pmos1v w=0.24u l=0.1u ad=0.0528p as=0.0816p pd=0.68u ps=1.16u
    I_MXI3_I535_MP0 (VDD I3_SEL_MUL_b3_9 I3_hm55 VDD) gpdk090_pmos1v w=0.24u l=0.1u ad=0.0816p as=0.0528p pd=1.16u ps=0.68u
    I_MXI3_I542_MP1 (I3_hd57 DIVR_25 VDD VDD) gpdk090_pmos1v w=0.24u l=0.1u ad=0.0528p as=0.0816p pd=0.68u ps=1.16u
    I_MXI3_I542_MP0 (VDD I3_SEL_DIV_b3_9 I3_hd57 VDD) gpdk090_pmos1v w=0.24u l=0.1u ad=0.0816p as=0.0528p pd=1.16u ps=0.68u
    I_MXI3_I537_MP1 (Y_55 I3_hd55 VDD VDD) gpdk090_pmos1v w=0.24u l=0.1u ad=0.0528p as=0.0816p pd=0.68u ps=1.16u
    I_MXI3_I537_MP0 (VDD I3_hm55 Y_55 VDD) gpdk090_pmos1v w=0.24u l=0.1u ad=0.0816p as=0.0528p pd=1.16u ps=0.68u
    I_MXI3_I543_MP1 (Y_57 I3_hd57 VDD VDD) gpdk090_pmos1v w=0.24u l=0.1u ad=0.0528p as=0.0816p pd=0.68u ps=1.16u
    I_MXI3_I543_MP0 (VDD I3_hm57 Y_57 VDD) gpdk090_pmos1v w=0.24u l=0.1u ad=0.0816p as=0.0528p pd=1.16u ps=0.68u
    I_MXI3_I536_MP1 (I3_hd55 DIVR_23 VDD VDD) gpdk090_pmos1v w=0.24u l=0.1u ad=0.0528p as=0.0816p pd=0.68u ps=1.16u
    I_MXI3_I536_MP0 (VDD I3_SEL_DIV_b3_9 I3_hd55 VDD) gpdk090_pmos1v w=0.24u l=0.1u ad=0.0816p as=0.0528p pd=1.16u ps=0.68u
    I_MXI3_I539_MP1 (I3_hd56 DIVR_24 VDD VDD) gpdk090_pmos1v w=0.24u l=0.1u ad=0.0528p as=0.0816p pd=0.68u ps=1.16u
    I_MXI3_I539_MP0 (VDD I3_SEL_DIV_b3_9 I3_hd56 VDD) gpdk090_pmos1v w=0.24u l=0.1u ad=0.0816p as=0.0528p pd=1.16u ps=0.68u
    I_MXI3_I538_MP1 (I3_hm56 MULP_56 VDD VDD) gpdk090_pmos1v w=0.24u l=0.1u ad=0.0528p as=0.0816p pd=0.68u ps=1.16u
    I_MXI3_I538_MP0 (VDD I3_SEL_MUL_b3_9 I3_hm56 VDD) gpdk090_pmos1v w=0.24u l=0.1u ad=0.0816p as=0.0528p pd=1.16u ps=0.68u
    I_MXI3_I540_MP1 (Y_56 I3_hd56 VDD VDD) gpdk090_pmos1v w=0.24u l=0.1u ad=0.0528p as=0.0816p pd=0.68u ps=1.16u
    I_MXI3_I540_MP0 (VDD I3_hm56 Y_56 VDD) gpdk090_pmos1v w=0.24u l=0.1u ad=0.0816p as=0.0528p pd=1.16u ps=0.68u
    I_MXI4_I46_MP1 (I4_z1_14 I4_z0_29 VDD VDD) gpdk090_pmos1v w=0.24u l=0.1u ad=0.0528p as=0.0816p pd=0.68u ps=1.16u
    I_MXI4_I46_MP0 (VDD I4_z0_28 I4_z1_14 VDD) gpdk090_pmos1v w=0.24u l=0.1u ad=0.0816p as=0.0528p pd=1.16u ps=0.68u
    I_MXI4_I47_MP1 (I4_z1_15 I4_z0_31 VDD VDD) gpdk090_pmos1v w=0.24u l=0.1u ad=0.0528p as=0.0816p pd=0.68u ps=1.16u
    I_MXI4_I47_MP0 (VDD I4_z0_30 I4_z1_15 VDD) gpdk090_pmos1v w=0.24u l=0.1u ad=0.0816p as=0.0528p pd=1.16u ps=0.68u
    I_MXI3_I547_MP1 (I3_hm59 MULP_59 VDD VDD) gpdk090_pmos1v w=0.24u l=0.1u ad=0.0528p as=0.0816p pd=0.68u ps=1.16u
    I_MXI3_I547_MP0 (VDD I3_SEL_MUL_b3_10 I3_hm59 VDD) gpdk090_pmos1v w=0.24u l=0.1u ad=0.0816p as=0.0528p pd=1.16u ps=0.68u
    I_MXI3_I558_MP1 (Y_62 I3_hd62 VDD VDD) gpdk090_pmos1v w=0.24u l=0.1u ad=0.0528p as=0.0816p pd=0.68u ps=1.16u
    I_MXI3_I558_MP0 (VDD I3_hm62 Y_62 VDD) gpdk090_pmos1v w=0.24u l=0.1u ad=0.0816p as=0.0528p pd=1.16u ps=0.68u
    I_MXI3_I505_MP1 (I3_hm45 MULP_45 VDD VDD) gpdk090_pmos1v w=0.24u l=0.1u ad=0.0528p as=0.0816p pd=0.68u ps=1.16u
    I_MXI3_I505_MP0 (VDD I3_SEL_MUL_b3_7 I3_hm45 VDD) gpdk090_pmos1v w=0.24u l=0.1u ad=0.0816p as=0.0528p pd=1.16u ps=0.68u
    I_MXI3_I556_MP1 (I3_hm62 MULP_62 VDD VDD) gpdk090_pmos1v w=0.24u l=0.1u ad=0.0528p as=0.0816p pd=0.68u ps=1.16u
    I_MXI3_I556_MP0 (VDD I3_SEL_MUL_b3_10 I3_hm62 VDD) gpdk090_pmos1v w=0.24u l=0.1u ad=0.0816p as=0.0528p pd=1.16u ps=0.68u
    I_MXI3_I561_MP1 (Y_63 I3_hd63 VDD VDD) gpdk090_pmos1v w=0.24u l=0.1u ad=0.0528p as=0.0816p pd=0.68u ps=1.16u
    I_MXI3_I561_MP0 (VDD I3_hm63 Y_63 VDD) gpdk090_pmos1v w=0.24u l=0.1u ad=0.0816p as=0.0528p pd=1.16u ps=0.68u
    I_MXI3_I559_MP1 (I3_hm63 MULP_63 VDD VDD) gpdk090_pmos1v w=0.24u l=0.1u ad=0.0528p as=0.0816p pd=0.68u ps=1.16u
    I_MXI3_I559_MP0 (VDD I3_SEL_MUL_b3_10 I3_hm63 VDD) gpdk090_pmos1v w=0.24u l=0.1u ad=0.0816p as=0.0528p pd=1.16u ps=0.68u
    I_MXI3_I496_MP1 (I3_hm42 MULP_42 VDD VDD) gpdk090_pmos1v w=0.24u l=0.1u ad=0.0528p as=0.0816p pd=0.68u ps=1.16u
    I_MXI3_I496_MP0 (VDD I3_SEL_MUL_b3_7 I3_hm42 VDD) gpdk090_pmos1v w=0.24u l=0.1u ad=0.0816p as=0.0528p pd=1.16u ps=0.68u
    I_MXI3_I560_MP1 (I3_hd63 DIVR_31 VDD VDD) gpdk090_pmos1v w=0.24u l=0.1u ad=0.0528p as=0.0816p pd=0.68u ps=1.16u
    I_MXI3_I560_MP0 (VDD I3_SEL_DIV_b3_10 I3_hd63 VDD) gpdk090_pmos1v w=0.24u l=0.1u ad=0.0816p as=0.0528p pd=1.16u ps=0.68u
    I_MXI3_I555_MP1 (Y_61 I3_hd61 VDD VDD) gpdk090_pmos1v w=0.24u l=0.1u ad=0.0528p as=0.0816p pd=0.68u ps=1.16u
    I_MXI3_I555_MP0 (VDD I3_hm61 Y_61 VDD) gpdk090_pmos1v w=0.24u l=0.1u ad=0.0816p as=0.0528p pd=1.16u ps=0.68u
    I_MXI3_I554_MP1 (I3_hd61 DIVR_29 VDD VDD) gpdk090_pmos1v w=0.24u l=0.1u ad=0.0528p as=0.0816p pd=0.68u ps=1.16u
    I_MXI3_I554_MP0 (VDD I3_SEL_DIV_b3_10 I3_hd61 VDD) gpdk090_pmos1v w=0.24u l=0.1u ad=0.0816p as=0.0528p pd=1.16u ps=0.68u
    I_MXI3_I553_MP1 (I3_hm61 MULP_61 VDD VDD) gpdk090_pmos1v w=0.24u l=0.1u ad=0.0528p as=0.0816p pd=0.68u ps=1.16u
    I_MXI3_I553_MP0 (VDD I3_SEL_MUL_b3_10 I3_hm61 VDD) gpdk090_pmos1v w=0.24u l=0.1u ad=0.0816p as=0.0528p pd=1.16u ps=0.68u
    I_MXI3_I179_MP1 (I3_n8_1 OR_8 VDD VDD) gpdk090_pmos1v w=0.24u l=0.1u ad=0.0528p as=0.0816p pd=0.68u ps=1.16u
    I_MXI3_I179_MP0 (VDD I3_SEL_OR_b3_1 I3_n8_1 VDD) gpdk090_pmos1v w=0.24u l=0.1u ad=0.0816p as=0.0528p pd=1.16u ps=0.68u
    I_MXI2_I48_MP1 (I2_nand8 B_8 VDD VDD) gpdk090_pmos1v w=0.24u l=0.1u ad=0.0528p as=0.0816p pd=0.68u ps=1.16u
    I_MXI2_I48_MP0 (VDD A_8 I2_nand8 VDD) gpdk090_pmos1v w=0.24u l=0.1u ad=0.0816p as=0.0528p pd=1.16u ps=0.68u
    I_MXI3_I182_MP1 (I3_n8_4 MULP_8 VDD VDD) gpdk090_pmos1v w=0.24u l=0.1u ad=0.0528p as=0.0816p pd=0.68u ps=1.16u
    I_MXI3_I182_MP0 (VDD I3_SEL_MUL_b3_1 I3_n8_4 VDD) gpdk090_pmos1v w=0.24u l=0.1u ad=0.0816p as=0.0528p pd=1.16u ps=0.68u
    I_MXI3_I183_MP1 (I3_n8_5 DIVQ_8 VDD VDD) gpdk090_pmos1v w=0.24u l=0.1u ad=0.0528p as=0.0816p pd=0.68u ps=1.16u
    I_MXI3_I183_MP0 (VDD I3_SEL_DIV_b3_1 I3_n8_5 VDD) gpdk090_pmos1v w=0.24u l=0.1u ad=0.0816p as=0.0528p pd=1.16u ps=0.68u
    I_MXI3_I186_MP1 (I3_o8_2 I3_n8_5 VDD VDD) gpdk090_pmos1v w=0.24u l=0.1u ad=0.0528p as=0.0816p pd=0.68u ps=1.16u
    I_MXI3_I186_MP0 (VDD I3_n8_4 I3_o8_2 VDD) gpdk090_pmos1v w=0.24u l=0.1u ad=0.0816p as=0.0528p pd=1.16u ps=0.68u
    I_MXI3_I198_MP1 (I3_o9_2 I3_n9_5 VDD VDD) gpdk090_pmos1v w=0.24u l=0.1u ad=0.0528p as=0.0816p pd=0.68u ps=1.16u
    I_MXI3_I198_MP0 (VDD I3_n9_4 I3_o9_2 VDD) gpdk090_pmos1v w=0.24u l=0.1u ad=0.0816p as=0.0528p pd=1.16u ps=0.68u
    I_MXI3_I159_MP1 (I3_n6_5 DIVQ_6 VDD VDD) gpdk090_pmos1v w=0.24u l=0.1u ad=0.0528p as=0.0816p pd=0.68u ps=1.16u
    I_MXI3_I159_MP0 (VDD I3_SEL_DIV_b3_1 I3_n6_5 VDD) gpdk090_pmos1v w=0.24u l=0.1u ad=0.0816p as=0.0528p pd=1.16u ps=0.68u
    I_MXI3_I194_MP1 (I3_n9_4 MULP_9 VDD VDD) gpdk090_pmos1v w=0.24u l=0.1u ad=0.0528p as=0.0816p pd=0.68u ps=1.16u
    I_MXI3_I194_MP0 (VDD I3_SEL_MUL_b3_1 I3_n9_4 VDD) gpdk090_pmos1v w=0.24u l=0.1u ad=0.0816p as=0.0528p pd=1.16u ps=0.68u
    I_MXI3_I170_MP1 (I3_n7_4 MULP_7 VDD VDD) gpdk090_pmos1v w=0.24u l=0.1u ad=0.0528p as=0.0816p pd=0.68u ps=1.16u
    I_MXI3_I170_MP0 (VDD I3_SEL_MUL_b3_1 I3_n7_4 VDD) gpdk090_pmos1v w=0.24u l=0.1u ad=0.0816p as=0.0528p pd=1.16u ps=0.68u
    I_MXI3_I162_MP1 (I3_o6_2 I3_n6_5 VDD VDD) gpdk090_pmos1v w=0.24u l=0.1u ad=0.0528p as=0.0816p pd=0.68u ps=1.16u
    I_MXI3_I162_MP0 (VDD I3_n6_4 I3_o6_2 VDD) gpdk090_pmos1v w=0.24u l=0.1u ad=0.0816p as=0.0528p pd=1.16u ps=0.68u
    I_MXI3_I174_MP1 (I3_o7_2 I3_n7_5 VDD VDD) gpdk090_pmos1v w=0.24u l=0.1u ad=0.0528p as=0.0816p pd=0.68u ps=1.16u
    I_MXI3_I174_MP0 (VDD I3_n7_4 I3_o7_2 VDD) gpdk090_pmos1v w=0.24u l=0.1u ad=0.0816p as=0.0528p pd=1.16u ps=0.68u
    I_MXI2_I54_MP1 (I2_nand9 B_9 VDD VDD) gpdk090_pmos1v w=0.24u l=0.1u ad=0.0528p as=0.0816p pd=0.68u ps=1.16u
    I_MXI2_I54_MP0 (VDD A_9 I2_nand9 VDD) gpdk090_pmos1v w=0.24u l=0.1u ad=0.0816p as=0.0528p pd=1.16u ps=0.68u
    I_MXI3_I196_MP1 (I3_o9_0 I3_n9_1 VDD VDD) gpdk090_pmos1v w=0.24u l=0.1u ad=0.0528p as=0.0816p pd=0.68u ps=1.16u
    I_MXI3_I196_MP0 (VDD I3_n9_0 I3_o9_0 VDD) gpdk090_pmos1v w=0.24u l=0.1u ad=0.0816p as=0.0528p pd=1.16u ps=0.68u
    I_MXI3_I191_MP1 (I3_n9_1 OR_9 VDD VDD) gpdk090_pmos1v w=0.24u l=0.1u ad=0.0528p as=0.0816p pd=0.68u ps=1.16u
    I_MXI3_I191_MP0 (VDD I3_SEL_OR_b3_1 I3_n9_1 VDD) gpdk090_pmos1v w=0.24u l=0.1u ad=0.0816p as=0.0528p pd=1.16u ps=0.68u
    I_MXI3_I165_MP1 (Y_6 I3_q6_2 VDD VDD) gpdk090_pmos1v w=0.24u l=0.1u ad=0.0528p as=0.0816p pd=0.68u ps=1.16u
    I_MXI3_I165_MP0 (VDD I3_q6_1 Y_6 VDD) gpdk090_pmos1v w=0.24u l=0.1u ad=0.0816p as=0.0528p pd=1.16u ps=0.68u
    I_MXI3_I161_MP1 (I3_o6_1 I3_n6_3 VDD VDD) gpdk090_pmos1v w=0.24u l=0.1u ad=0.0528p as=0.0816p pd=0.68u ps=1.16u
    I_MXI3_I161_MP0 (VDD I3_n6_2 I3_o6_1 VDD) gpdk090_pmos1v w=0.24u l=0.1u ad=0.0816p as=0.0528p pd=1.16u ps=0.68u
    I_MXI3_I160_MP1 (I3_o6_0 I3_n6_1 VDD VDD) gpdk090_pmos1v w=0.24u l=0.1u ad=0.0528p as=0.0816p pd=0.68u ps=1.16u
    I_MXI3_I160_MP0 (VDD I3_n6_0 I3_o6_0 VDD) gpdk090_pmos1v w=0.24u l=0.1u ad=0.0816p as=0.0528p pd=1.16u ps=0.68u
    I_MXI3_I155_MP1 (I3_n6_1 OR_6 VDD VDD) gpdk090_pmos1v w=0.24u l=0.1u ad=0.0528p as=0.0816p pd=0.68u ps=1.16u
    I_MXI3_I155_MP0 (VDD I3_SEL_OR_b3_1 I3_n6_1 VDD) gpdk090_pmos1v w=0.24u l=0.1u ad=0.0816p as=0.0528p pd=1.16u ps=0.68u
    I_MXI2_I36_MP1 (I2_nand6 B_6 VDD VDD) gpdk090_pmos1v w=0.24u l=0.1u ad=0.0528p as=0.0816p pd=0.68u ps=1.16u
    I_MXI2_I36_MP0 (VDD A_6 I2_nand6 VDD) gpdk090_pmos1v w=0.24u l=0.1u ad=0.0816p as=0.0528p pd=1.16u ps=0.68u
    I_MXI3_I84_MP1 (I3_n0_2 XOR_0 VDD VDD) gpdk090_pmos1v w=0.24u l=0.1u ad=0.0528p as=0.0816p pd=0.68u ps=1.16u
    I_MXI3_I84_MP0 (VDD I3_SEL_XOR_b3_0 I3_n0_2 VDD) gpdk090_pmos1v w=0.24u l=0.1u ad=0.0816p as=0.0528p pd=1.16u ps=0.68u
    I_MXI3_I85_MP1 (I3_n0_3 NOT_0 VDD VDD) gpdk090_pmos1v w=0.24u l=0.1u ad=0.0528p as=0.0816p pd=0.68u ps=1.16u
    I_MXI3_I85_MP0 (VDD I3_SEL_NOT_b3_0 I3_n0_3 VDD) gpdk090_pmos1v w=0.24u l=0.1u ad=0.0816p as=0.0528p pd=1.16u ps=0.68u
    I_MXI3_I82_MP1 (I3_n0_0 AND_0 VDD VDD) gpdk090_pmos1v w=0.24u l=0.1u ad=0.0528p as=0.0816p pd=0.68u ps=1.16u
    I_MXI3_I82_MP0 (VDD I3_SEL_AND_b3_0 I3_n0_0 VDD) gpdk090_pmos1v w=0.24u l=0.1u ad=0.0816p as=0.0528p pd=1.16u ps=0.68u
    I_MXI3_I89_MP1 (I3_o0_1 I3_n0_3 VDD VDD) gpdk090_pmos1v w=0.24u l=0.1u ad=0.0528p as=0.0816p pd=0.68u ps=1.16u
    I_MXI3_I89_MP0 (VDD I3_n0_2 I3_o0_1 VDD) gpdk090_pmos1v w=0.24u l=0.1u ad=0.0816p as=0.0528p pd=1.16u ps=0.68u
    I_MXI3_I88_MP1 (I3_o0_0 I3_n0_1 VDD VDD) gpdk090_pmos1v w=0.24u l=0.1u ad=0.0528p as=0.0816p pd=0.68u ps=1.16u
    I_MXI3_I88_MP0 (VDD I3_n0_0 I3_o0_0 VDD) gpdk090_pmos1v w=0.24u l=0.1u ad=0.0816p as=0.0528p pd=1.16u ps=0.68u
    I_MXI4_I32_MP1 (I4_z1_0 I4_z0_1 VDD VDD) gpdk090_pmos1v w=0.24u l=0.1u ad=0.0528p as=0.0816p pd=0.68u ps=1.16u
    I_MXI4_I32_MP0 (VDD I4_z0_0 I4_z1_0 VDD) gpdk090_pmos1v w=0.24u l=0.1u ad=0.0816p as=0.0528p pd=1.16u ps=0.68u
    I_MXI3_I94_MP1 (I3_n1_0 AND_1 VDD VDD) gpdk090_pmos1v w=0.24u l=0.1u ad=0.0528p as=0.0816p pd=0.68u ps=1.16u
    I_MXI3_I94_MP0 (VDD I3_SEL_AND_b3_0 I3_n1_0 VDD) gpdk090_pmos1v w=0.24u l=0.1u ad=0.0816p as=0.0528p pd=1.16u ps=0.68u
    I_MXI3_I105_MP1 (Y_1 I3_q1_2 VDD VDD) gpdk090_pmos1v w=0.24u l=0.1u ad=0.0528p as=0.0816p pd=0.68u ps=1.16u
    I_MXI3_I105_MP0 (VDD I3_q1_1 Y_1 VDD) gpdk090_pmos1v w=0.24u l=0.1u ad=0.0816p as=0.0528p pd=1.16u ps=0.68u
    I_MXI3_I100_MP1 (I3_o1_0 I3_n1_1 VDD VDD) gpdk090_pmos1v w=0.24u l=0.1u ad=0.0528p as=0.0816p pd=0.68u ps=1.16u
    I_MXI3_I100_MP0 (VDD I3_n1_0 I3_o1_0 VDD) gpdk090_pmos1v w=0.24u l=0.1u ad=0.0816p as=0.0528p pd=1.16u ps=0.68u
    I_MXI3_I95_MP1 (I3_n1_1 OR_1 VDD VDD) gpdk090_pmos1v w=0.24u l=0.1u ad=0.0528p as=0.0816p pd=0.68u ps=1.16u
    I_MXI3_I95_MP0 (VDD I3_SEL_OR_b3_0 I3_n1_1 VDD) gpdk090_pmos1v w=0.24u l=0.1u ad=0.0816p as=0.0528p pd=1.16u ps=0.68u
    I_MXI3_I132_MP1 (I3_n4_2 XOR_4 VDD VDD) gpdk090_pmos1v w=0.24u l=0.1u ad=0.0528p as=0.0816p pd=0.68u ps=1.16u
    I_MXI3_I132_MP0 (VDD I3_SEL_XOR_b3_0 I3_n4_2 VDD) gpdk090_pmos1v w=0.24u l=0.1u ad=0.0816p as=0.0528p pd=1.16u ps=0.68u
    I_MXI3_I137_MP1 (I3_o4_1 I3_n4_3 VDD VDD) gpdk090_pmos1v w=0.24u l=0.1u ad=0.0528p as=0.0816p pd=0.68u ps=1.16u
    I_MXI3_I137_MP0 (VDD I3_n4_2 I3_o4_1 VDD) gpdk090_pmos1v w=0.24u l=0.1u ad=0.0816p as=0.0528p pd=1.16u ps=0.68u
    I_MXI3_I130_MP1 (I3_n4_0 AND_4 VDD VDD) gpdk090_pmos1v w=0.24u l=0.1u ad=0.0528p as=0.0816p pd=0.68u ps=1.16u
    I_MXI3_I130_MP0 (VDD I3_SEL_AND_b3_0 I3_n4_0 VDD) gpdk090_pmos1v w=0.24u l=0.1u ad=0.0816p as=0.0528p pd=1.16u ps=0.68u
    I_MXI2_I24_MP1 (I2_nand4 B_4 VDD VDD) gpdk090_pmos1v w=0.24u l=0.1u ad=0.0528p as=0.0816p pd=0.68u ps=1.16u
    I_MXI2_I24_MP0 (VDD A_4 I2_nand4 VDD) gpdk090_pmos1v w=0.24u l=0.1u ad=0.0816p as=0.0528p pd=1.16u ps=0.68u
    I_MXI3_I530_MP1 (I3_hd53 DIVR_21 VDD VDD) gpdk090_pmos1v w=0.24u l=0.1u ad=0.0528p as=0.0816p pd=0.68u ps=1.16u
    I_MXI3_I530_MP0 (VDD I3_SEL_DIV_b3_9 I3_hd53 VDD) gpdk090_pmos1v w=0.24u l=0.1u ad=0.0816p as=0.0528p pd=1.16u ps=0.68u
    I_MXI3_I529_MP1 (I3_hm53 MULP_53 VDD VDD) gpdk090_pmos1v w=0.24u l=0.1u ad=0.0528p as=0.0816p pd=0.68u ps=1.16u
    I_MXI3_I529_MP0 (VDD I3_SEL_MUL_b3_9 I3_hm53 VDD) gpdk090_pmos1v w=0.24u l=0.1u ad=0.0816p as=0.0528p pd=1.16u ps=0.68u
    I_MXI3_I528_MP1 (Y_52 I3_hd52 VDD VDD) gpdk090_pmos1v w=0.24u l=0.1u ad=0.0528p as=0.0816p pd=0.68u ps=1.16u
    I_MXI3_I528_MP0 (VDD I3_hm52 Y_52 VDD) gpdk090_pmos1v w=0.24u l=0.1u ad=0.0816p as=0.0528p pd=1.16u ps=0.68u
    I_MXI3_I531_MP1 (Y_53 I3_hd53 VDD VDD) gpdk090_pmos1v w=0.24u l=0.1u ad=0.0528p as=0.0816p pd=0.68u ps=1.16u
    I_MXI3_I531_MP0 (VDD I3_hm53 Y_53 VDD) gpdk090_pmos1v w=0.24u l=0.1u ad=0.0816p as=0.0528p pd=1.16u ps=0.68u
    I_MXI3_I512_MP1 (I3_hd47 DIVR_15 VDD VDD) gpdk090_pmos1v w=0.24u l=0.1u ad=0.0528p as=0.0816p pd=0.68u ps=1.16u
    I_MXI3_I512_MP0 (VDD I3_SEL_DIV_b3_8 I3_hd47 VDD) gpdk090_pmos1v w=0.24u l=0.1u ad=0.0816p as=0.0528p pd=1.16u ps=0.68u
    I_MXI4_I45_MP1 (I4_z1_13 I4_z0_27 VDD VDD) gpdk090_pmos1v w=0.24u l=0.1u ad=0.0528p as=0.0816p pd=0.68u ps=1.16u
    I_MXI4_I45_MP0 (VDD I4_z0_26 I4_z1_13 VDD) gpdk090_pmos1v w=0.24u l=0.1u ad=0.0816p as=0.0528p pd=1.16u ps=0.68u
    I_MXI4_I59_MP1 (I4_z3_3 I4_z2_7 VDD VDD) gpdk090_pmos1v w=0.24u l=0.1u ad=0.0528p as=0.0816p pd=0.68u ps=1.16u
    I_MXI4_I59_MP0 (VDD I4_z2_6 I4_z3_3 VDD) gpdk090_pmos1v w=0.24u l=0.1u ad=0.0816p as=0.0528p pd=1.16u ps=0.68u
    I_MXI3_I508_MP1 (I3_hm46 MULP_46 VDD VDD) gpdk090_pmos1v w=0.24u l=0.1u ad=0.0528p as=0.0816p pd=0.68u ps=1.16u
    I_MXI3_I508_MP0 (VDD I3_SEL_MUL_b3_7 I3_hm46 VDD) gpdk090_pmos1v w=0.24u l=0.1u ad=0.0816p as=0.0528p pd=1.16u ps=0.68u
    I_MXI3_I509_MP1 (I3_hd46 DIVR_14 VDD VDD) gpdk090_pmos1v w=0.24u l=0.1u ad=0.0528p as=0.0816p pd=0.68u ps=1.16u
    I_MXI3_I509_MP0 (VDD I3_SEL_DIV_b3_7 I3_hd46 VDD) gpdk090_pmos1v w=0.24u l=0.1u ad=0.0816p as=0.0528p pd=1.16u ps=0.68u
    I_MXI3_I507_MP1 (Y_45 I3_hd45 VDD VDD) gpdk090_pmos1v w=0.24u l=0.1u ad=0.0528p as=0.0816p pd=0.68u ps=1.16u
    I_MXI3_I507_MP0 (VDD I3_hm45 Y_45 VDD) gpdk090_pmos1v w=0.24u l=0.1u ad=0.0816p as=0.0528p pd=1.16u ps=0.68u
    I_MXI3_I506_MP1 (I3_hd45 DIVR_13 VDD VDD) gpdk090_pmos1v w=0.24u l=0.1u ad=0.0528p as=0.0816p pd=0.68u ps=1.16u
    I_MXI3_I506_MP0 (VDD I3_SEL_DIV_b3_7 I3_hd45 VDD) gpdk090_pmos1v w=0.24u l=0.1u ad=0.0816p as=0.0528p pd=1.16u ps=0.68u
    I_MXI3_I504_MP1 (Y_44 I3_hd44 VDD VDD) gpdk090_pmos1v w=0.24u l=0.1u ad=0.0528p as=0.0816p pd=0.68u ps=1.16u
    I_MXI3_I504_MP0 (VDD I3_hm44 Y_44 VDD) gpdk090_pmos1v w=0.24u l=0.1u ad=0.0816p as=0.0528p pd=1.16u ps=0.68u
    I_MXI3_I498_MP1 (Y_42 I3_hd42 VDD VDD) gpdk090_pmos1v w=0.24u l=0.1u ad=0.0528p as=0.0816p pd=0.68u ps=1.16u
    I_MXI3_I498_MP0 (VDD I3_hm42 Y_42 VDD) gpdk090_pmos1v w=0.24u l=0.1u ad=0.0816p as=0.0528p pd=1.16u ps=0.68u
    I_MXI3_I503_MP1 (I3_hd44 DIVR_12 VDD VDD) gpdk090_pmos1v w=0.24u l=0.1u ad=0.0528p as=0.0816p pd=0.68u ps=1.16u
    I_MXI3_I503_MP0 (VDD I3_SEL_DIV_b3_7 I3_hd44 VDD) gpdk090_pmos1v w=0.24u l=0.1u ad=0.0816p as=0.0528p pd=1.16u ps=0.68u
    I_MXI3_I497_MP1 (I3_hd42 DIVR_10 VDD VDD) gpdk090_pmos1v w=0.24u l=0.1u ad=0.0528p as=0.0816p pd=0.68u ps=1.16u
    I_MXI3_I497_MP0 (VDD I3_SEL_DIV_b3_7 I3_hd42 VDD) gpdk090_pmos1v w=0.24u l=0.1u ad=0.0816p as=0.0528p pd=1.16u ps=0.68u
    I_MXI4_I62_MP1 (I4_z5_0 I4_z4_1 VDD VDD) gpdk090_pmos1v w=0.24u l=0.1u ad=0.0528p as=0.0816p pd=0.68u ps=1.16u
    I_MXI4_I62_MP0 (VDD I4_z4_0 I4_z5_0 VDD) gpdk090_pmos1v w=0.24u l=0.1u ad=0.0816p as=0.0528p pd=1.16u ps=0.68u
    I_MXI3_I502_MP1 (I3_hm44 MULP_44 VDD VDD) gpdk090_pmos1v w=0.24u l=0.1u ad=0.0528p as=0.0816p pd=0.68u ps=1.16u
    I_MXI3_I502_MP0 (VDD I3_SEL_MUL_b3_7 I3_hm44 VDD) gpdk090_pmos1v w=0.24u l=0.1u ad=0.0816p as=0.0528p pd=1.16u ps=0.68u
    I_MXI3_I180_MP1 (I3_n8_2 XOR_8 VDD VDD) gpdk090_pmos1v w=0.24u l=0.1u ad=0.0528p as=0.0816p pd=0.68u ps=1.16u
    I_MXI3_I180_MP0 (VDD I3_SEL_XOR_b3_1 I3_n8_2 VDD) gpdk090_pmos1v w=0.24u l=0.1u ad=0.0816p as=0.0528p pd=1.16u ps=0.68u
    I_MXI3_I184_MP1 (I3_o8_0 I3_n8_1 VDD VDD) gpdk090_pmos1v w=0.24u l=0.1u ad=0.0528p as=0.0816p pd=0.68u ps=1.16u
    I_MXI3_I184_MP0 (VDD I3_n8_0 I3_o8_0 VDD) gpdk090_pmos1v w=0.24u l=0.1u ad=0.0816p as=0.0528p pd=1.16u ps=0.68u
    I_MXI3_I185_MP1 (I3_o8_1 I3_n8_3 VDD VDD) gpdk090_pmos1v w=0.24u l=0.1u ad=0.0528p as=0.0816p pd=0.68u ps=1.16u
    I_MXI3_I185_MP0 (VDD I3_n8_2 I3_o8_1 VDD) gpdk090_pmos1v w=0.24u l=0.1u ad=0.0816p as=0.0528p pd=1.16u ps=0.68u
    I_MXI3_I181_MP1 (I3_n8_3 NOT_8 VDD VDD) gpdk090_pmos1v w=0.24u l=0.1u ad=0.0528p as=0.0816p pd=0.68u ps=1.16u
    I_MXI3_I181_MP0 (VDD I3_SEL_NOT_b3_1 I3_n8_3 VDD) gpdk090_pmos1v w=0.24u l=0.1u ad=0.0816p as=0.0528p pd=1.16u ps=0.68u
    I_MXI3_I178_MP1 (I3_n8_0 AND_8 VDD VDD) gpdk090_pmos1v w=0.24u l=0.1u ad=0.0528p as=0.0816p pd=0.68u ps=1.16u
    I_MXI3_I178_MP0 (VDD I3_SEL_AND_b3_1 I3_n8_0 VDD) gpdk090_pmos1v w=0.24u l=0.1u ad=0.0816p as=0.0528p pd=1.16u ps=0.68u
    I_MXI3_I189_MP1 (Y_8 I3_q8_2 VDD VDD) gpdk090_pmos1v w=0.24u l=0.1u ad=0.0528p as=0.0816p pd=0.68u ps=1.16u
    I_MXI3_I189_MP0 (VDD I3_q8_1 Y_8 VDD) gpdk090_pmos1v w=0.24u l=0.1u ad=0.0816p as=0.0528p pd=1.16u ps=0.68u
    I_MXI3_I201_MP1 (Y_9 I3_q9_2 VDD VDD) gpdk090_pmos1v w=0.24u l=0.1u ad=0.0528p as=0.0816p pd=0.68u ps=1.16u
    I_MXI3_I201_MP0 (VDD I3_q9_1 Y_9 VDD) gpdk090_pmos1v w=0.24u l=0.1u ad=0.0816p as=0.0528p pd=1.16u ps=0.68u
    I_MXI3_I197_MP1 (I3_o9_1 I3_n9_3 VDD VDD) gpdk090_pmos1v w=0.24u l=0.1u ad=0.0528p as=0.0816p pd=0.68u ps=1.16u
    I_MXI3_I197_MP0 (VDD I3_n9_2 I3_o9_1 VDD) gpdk090_pmos1v w=0.24u l=0.1u ad=0.0816p as=0.0528p pd=1.16u ps=0.68u
    I_MXI3_I219_MP1 (I3_n11_5 DIVQ_11 VDD VDD) gpdk090_pmos1v w=0.24u l=0.1u ad=0.0528p as=0.0816p pd=0.68u ps=1.16u
    I_MXI3_I219_MP0 (VDD I3_SEL_DIV_b3_1 I3_n11_5 VDD) gpdk090_pmos1v w=0.24u l=0.1u ad=0.0816p as=0.0528p pd=1.16u ps=0.68u
    I_MXI3_I192_MP1 (I3_n9_2 XOR_9 VDD VDD) gpdk090_pmos1v w=0.24u l=0.1u ad=0.0528p as=0.0816p pd=0.68u ps=1.16u
    I_MXI3_I192_MP0 (VDD I3_SEL_XOR_b3_1 I3_n9_2 VDD) gpdk090_pmos1v w=0.24u l=0.1u ad=0.0816p as=0.0528p pd=1.16u ps=0.68u
    I_MXI3_I177_MP1 (Y_7 I3_q7_2 VDD VDD) gpdk090_pmos1v w=0.24u l=0.1u ad=0.0528p as=0.0816p pd=0.68u ps=1.16u
    I_MXI3_I177_MP0 (VDD I3_q7_1 Y_7 VDD) gpdk090_pmos1v w=0.24u l=0.1u ad=0.0816p as=0.0528p pd=1.16u ps=0.68u
    I_MXI3_I156_MP1 (I3_n6_2 XOR_6 VDD VDD) gpdk090_pmos1v w=0.24u l=0.1u ad=0.0528p as=0.0816p pd=0.68u ps=1.16u
    I_MXI3_I156_MP0 (VDD I3_SEL_XOR_b3_1 I3_n6_2 VDD) gpdk090_pmos1v w=0.24u l=0.1u ad=0.0816p as=0.0528p pd=1.16u ps=0.68u
    I_MXI3_I166_MP1 (I3_n7_0 AND_7 VDD VDD) gpdk090_pmos1v w=0.24u l=0.1u ad=0.0528p as=0.0816p pd=0.68u ps=1.16u
    I_MXI3_I166_MP0 (VDD I3_SEL_AND_b3_1 I3_n7_0 VDD) gpdk090_pmos1v w=0.24u l=0.1u ad=0.0816p as=0.0528p pd=1.16u ps=0.68u
    I_MXI3_I157_MP1 (I3_n6_3 NOT_6 VDD VDD) gpdk090_pmos1v w=0.24u l=0.1u ad=0.0528p as=0.0816p pd=0.68u ps=1.16u
    I_MXI3_I157_MP0 (VDD I3_SEL_NOT_b3_1 I3_n6_3 VDD) gpdk090_pmos1v w=0.24u l=0.1u ad=0.0816p as=0.0528p pd=1.16u ps=0.68u
    I_MXI2_I42_MP1 (I2_nand7 B_7 VDD VDD) gpdk090_pmos1v w=0.24u l=0.1u ad=0.0528p as=0.0816p pd=0.68u ps=1.16u
    I_MXI2_I42_MP0 (VDD A_7 I2_nand7 VDD) gpdk090_pmos1v w=0.24u l=0.1u ad=0.0816p as=0.0528p pd=1.16u ps=0.68u
    I_MXI1_I42_I0_MP1 (I1_I42_gn0 I1_bx0 VDD VDD) gpdk090_pmos1v w=0.24u l=0.1u ad=0.0528p as=0.0816p pd=0.68u ps=1.16u
    I_MXI1_I42_I0_MP0 (VDD A_0 I1_I42_gn0 VDD) gpdk090_pmos1v w=0.24u l=0.1u ad=0.0816p as=0.0528p pd=1.16u ps=0.68u
    I_MXI3_I145_MP1 (I3_n5_3 NOT_5 VDD VDD) gpdk090_pmos1v w=0.24u l=0.1u ad=0.0528p as=0.0816p pd=0.68u ps=1.16u
    I_MXI3_I145_MP0 (VDD I3_SEL_NOT_b3_0 I3_n5_3 VDD) gpdk090_pmos1v w=0.24u l=0.1u ad=0.0816p as=0.0528p pd=1.16u ps=0.68u
    I_MXI3_I93_MP1 (Y_0 I3_q0_2 VDD VDD) gpdk090_pmos1v w=0.24u l=0.1u ad=0.0528p as=0.0816p pd=0.68u ps=1.16u
    I_MXI3_I93_MP0 (VDD I3_q0_1 Y_0 VDD) gpdk090_pmos1v w=0.24u l=0.1u ad=0.0816p as=0.0528p pd=1.16u ps=0.68u
    I_MXI1_I42_I1_MP1 (I1_I42_gn1 I1_bx1 VDD VDD) gpdk090_pmos1v w=0.24u l=0.1u ad=0.0528p as=0.0816p pd=0.68u ps=1.16u
    I_MXI1_I42_I1_MP0 (VDD A_1 I1_I42_gn1 VDD) gpdk090_pmos1v w=0.24u l=0.1u ad=0.0816p as=0.0528p pd=1.16u ps=0.68u
    I_MXI3_I101_MP1 (I3_o1_1 I3_n1_3 VDD VDD) gpdk090_pmos1v w=0.24u l=0.1u ad=0.0528p as=0.0816p pd=0.68u ps=1.16u
    I_MXI3_I101_MP0 (VDD I3_n1_2 I3_o1_1 VDD) gpdk090_pmos1v w=0.24u l=0.1u ad=0.0816p as=0.0528p pd=1.16u ps=0.68u
    I_MXI3_I97_MP1 (I3_n1_3 NOT_1 VDD VDD) gpdk090_pmos1v w=0.24u l=0.1u ad=0.0528p as=0.0816p pd=0.68u ps=1.16u
    I_MXI3_I97_MP0 (VDD I3_SEL_NOT_b3_0 I3_n1_3 VDD) gpdk090_pmos1v w=0.24u l=0.1u ad=0.0816p as=0.0528p pd=1.16u ps=0.68u
    I_MXI3_I96_MP1 (I3_n1_2 XOR_1 VDD VDD) gpdk090_pmos1v w=0.24u l=0.1u ad=0.0528p as=0.0816p pd=0.68u ps=1.16u
    I_MXI3_I96_MP0 (VDD I3_SEL_XOR_b3_0 I3_n1_2 VDD) gpdk090_pmos1v w=0.24u l=0.1u ad=0.0816p as=0.0528p pd=1.16u ps=0.68u
    I_MXI3_I133_MP1 (I3_n4_3 NOT_4 VDD VDD) gpdk090_pmos1v w=0.24u l=0.1u ad=0.0528p as=0.0816p pd=0.68u ps=1.16u
    I_MXI3_I133_MP0 (VDD I3_SEL_NOT_b3_0 I3_n4_3 VDD) gpdk090_pmos1v w=0.24u l=0.1u ad=0.0816p as=0.0528p pd=1.16u ps=0.68u
    I_MXI3_I107_MP1 (I3_n2_1 OR_2 VDD VDD) gpdk090_pmos1v w=0.24u l=0.1u ad=0.0528p as=0.0816p pd=0.68u ps=1.16u
    I_MXI3_I107_MP0 (VDD I3_SEL_OR_b3_0 I3_n2_1 VDD) gpdk090_pmos1v w=0.24u l=0.1u ad=0.0816p as=0.0528p pd=1.16u ps=0.68u
    I_MXI3_I112_MP1 (I3_o2_0 I3_n2_1 VDD VDD) gpdk090_pmos1v w=0.24u l=0.1u ad=0.0528p as=0.0816p pd=0.68u ps=1.16u
    I_MXI3_I112_MP0 (VDD I3_n2_0 I3_o2_0 VDD) gpdk090_pmos1v w=0.24u l=0.1u ad=0.0816p as=0.0528p pd=1.16u ps=0.68u
    I_MXI2_I12_MP1 (I2_nand2 B_2 VDD VDD) gpdk090_pmos1v w=0.24u l=0.1u ad=0.0528p as=0.0816p pd=0.68u ps=1.16u
    I_MXI2_I12_MP0 (VDD A_2 I2_nand2 VDD) gpdk090_pmos1v w=0.24u l=0.1u ad=0.0816p as=0.0528p pd=1.16u ps=0.68u
    I_MXI3_I106_MP1 (I3_n2_0 AND_2 VDD VDD) gpdk090_pmos1v w=0.24u l=0.1u ad=0.0528p as=0.0816p pd=0.68u ps=1.16u
    I_MXI3_I106_MP0 (VDD I3_SEL_AND_b3_0 I3_n2_0 VDD) gpdk090_pmos1v w=0.24u l=0.1u ad=0.0816p as=0.0528p pd=1.16u ps=0.68u
    I_MXI3_I527_MP1 (I3_hd52 DIVR_20 VDD VDD) gpdk090_pmos1v w=0.24u l=0.1u ad=0.0528p as=0.0816p pd=0.68u ps=1.16u
    I_MXI3_I527_MP0 (VDD I3_SEL_DIV_b3_8 I3_hd52 VDD) gpdk090_pmos1v w=0.24u l=0.1u ad=0.0816p as=0.0528p pd=1.16u ps=0.68u
    I_MXI3_I516_MP1 (Y_48 I3_hd48 VDD VDD) gpdk090_pmos1v w=0.24u l=0.1u ad=0.0528p as=0.0816p pd=0.68u ps=1.16u
    I_MXI3_I516_MP0 (VDD I3_hm48 Y_48 VDD) gpdk090_pmos1v w=0.24u l=0.1u ad=0.0816p as=0.0528p pd=1.16u ps=0.68u
    I_MXI3_I511_MP1 (I3_hm47 MULP_47 VDD VDD) gpdk090_pmos1v w=0.24u l=0.1u ad=0.0528p as=0.0816p pd=0.68u ps=1.16u
    I_MXI3_I511_MP0 (VDD I3_SEL_MUL_b3_8 I3_hm47 VDD) gpdk090_pmos1v w=0.24u l=0.1u ad=0.0816p as=0.0528p pd=1.16u ps=0.68u
    I_MXI3_I526_MP1 (I3_hm52 MULP_52 VDD VDD) gpdk090_pmos1v w=0.24u l=0.1u ad=0.0528p as=0.0816p pd=0.68u ps=1.16u
    I_MXI3_I526_MP0 (VDD I3_SEL_MUL_b3_8 I3_hm52 VDD) gpdk090_pmos1v w=0.24u l=0.1u ad=0.0816p as=0.0528p pd=1.16u ps=0.68u
    I_MXI3_I520_MP1 (I3_hm50 MULP_50 VDD VDD) gpdk090_pmos1v w=0.24u l=0.1u ad=0.0528p as=0.0816p pd=0.68u ps=1.16u
    I_MXI3_I520_MP0 (VDD I3_SEL_MUL_b3_8 I3_hm50 VDD) gpdk090_pmos1v w=0.24u l=0.1u ad=0.0816p as=0.0528p pd=1.16u ps=0.68u
    I_MXI3_I513_MP1 (Y_47 I3_hd47 VDD VDD) gpdk090_pmos1v w=0.24u l=0.1u ad=0.0528p as=0.0816p pd=0.68u ps=1.16u
    I_MXI3_I513_MP0 (VDD I3_hm47 Y_47 VDD) gpdk090_pmos1v w=0.24u l=0.1u ad=0.0816p as=0.0528p pd=1.16u ps=0.68u
    I_MXI4_I44_MP1 (I4_z1_12 I4_z0_25 VDD VDD) gpdk090_pmos1v w=0.24u l=0.1u ad=0.0528p as=0.0816p pd=0.68u ps=1.16u
    I_MXI4_I44_MP0 (VDD I4_z0_24 I4_z1_12 VDD) gpdk090_pmos1v w=0.24u l=0.1u ad=0.0816p as=0.0528p pd=1.16u ps=0.68u
    I_MXI3_I522_MP1 (Y_50 I3_hd50 VDD VDD) gpdk090_pmos1v w=0.24u l=0.1u ad=0.0528p as=0.0816p pd=0.68u ps=1.16u
    I_MXI3_I522_MP0 (VDD I3_hm50 Y_50 VDD) gpdk090_pmos1v w=0.24u l=0.1u ad=0.0816p as=0.0528p pd=1.16u ps=0.68u
    I_MXI4_I58_MP1 (I4_z3_2 I4_z2_5 VDD VDD) gpdk090_pmos1v w=0.24u l=0.1u ad=0.0528p as=0.0816p pd=0.68u ps=1.16u
    I_MXI4_I58_MP0 (VDD I4_z2_4 I4_z3_2 VDD) gpdk090_pmos1v w=0.24u l=0.1u ad=0.0816p as=0.0528p pd=1.16u ps=0.68u
    I_MXI3_I510_MP1 (Y_46 I3_hd46 VDD VDD) gpdk090_pmos1v w=0.24u l=0.1u ad=0.0528p as=0.0816p pd=0.68u ps=1.16u
    I_MXI3_I510_MP0 (VDD I3_hm46 Y_46 VDD) gpdk090_pmos1v w=0.24u l=0.1u ad=0.0816p as=0.0528p pd=1.16u ps=0.68u
    I_MXI4_I43_MP1 (I4_z1_11 I4_z0_23 VDD VDD) gpdk090_pmos1v w=0.24u l=0.1u ad=0.0528p as=0.0816p pd=0.68u ps=1.16u
    I_MXI4_I43_MP0 (VDD I4_z0_22 I4_z1_11 VDD) gpdk090_pmos1v w=0.24u l=0.1u ad=0.0816p as=0.0528p pd=1.16u ps=0.68u
    I_MXI4_I42_MP1 (I4_z1_10 I4_z0_21 VDD VDD) gpdk090_pmos1v w=0.24u l=0.1u ad=0.0528p as=0.0816p pd=0.68u ps=1.16u
    I_MXI4_I42_MP0 (VDD I4_z0_20 I4_z1_10 VDD) gpdk090_pmos1v w=0.24u l=0.1u ad=0.0816p as=0.0528p pd=1.16u ps=0.68u
    I_MXI3_I501_MP1 (Y_43 I3_hd43 VDD VDD) gpdk090_pmos1v w=0.24u l=0.1u ad=0.0528p as=0.0816p pd=0.68u ps=1.16u
    I_MXI3_I501_MP0 (VDD I3_hm43 Y_43 VDD) gpdk090_pmos1v w=0.24u l=0.1u ad=0.0816p as=0.0528p pd=1.16u ps=0.68u
    I_MXI3_I499_MP1 (I3_hm43 MULP_43 VDD VDD) gpdk090_pmos1v w=0.24u l=0.1u ad=0.0528p as=0.0816p pd=0.68u ps=1.16u
    I_MXI3_I499_MP0 (VDD I3_SEL_MUL_b3_7 I3_hm43 VDD) gpdk090_pmos1v w=0.24u l=0.1u ad=0.0816p as=0.0528p pd=1.16u ps=0.68u
    I_MXI3_I500_MP1 (I3_hd43 DIVR_11 VDD VDD) gpdk090_pmos1v w=0.24u l=0.1u ad=0.0528p as=0.0816p pd=0.68u ps=1.16u
    I_MXI3_I500_MP0 (VDD I3_SEL_DIV_b3_7 I3_hd43 VDD) gpdk090_pmos1v w=0.24u l=0.1u ad=0.0816p as=0.0528p pd=1.16u ps=0.68u
    I_MXI3_I204_MP1 (I3_n10_2 XOR_10 VDD VDD) gpdk090_pmos1v w=0.24u l=0.1u ad=0.0528p as=0.0816p pd=0.68u ps=1.16u
    I_MXI3_I204_MP0 (VDD I3_SEL_XOR_b3_1 I3_n10_2 VDD) gpdk090_pmos1v w=0.24u l=0.1u ad=0.0816p as=0.0528p pd=1.16u ps=0.68u
    I_MXI3_I209_MP1 (I3_o10_1 I3_n10_3 VDD VDD) gpdk090_pmos1v w=0.24u l=0.1u ad=0.0528p as=0.0816p pd=0.68u ps=1.16u
    I_MXI3_I209_MP0 (VDD I3_n10_2 I3_o10_1 VDD) gpdk090_pmos1v w=0.24u l=0.1u ad=0.0816p as=0.0528p pd=1.16u ps=0.68u
    I_MXI3_I205_MP1 (I3_n10_3 NOT_10 VDD VDD) gpdk090_pmos1v w=0.24u l=0.1u ad=0.0528p as=0.0816p pd=0.68u ps=1.16u
    I_MXI3_I205_MP0 (VDD I3_SEL_NOT_b3_1 I3_n10_3 VDD) gpdk090_pmos1v w=0.24u l=0.1u ad=0.0816p as=0.0528p pd=1.16u ps=0.68u
    I_MXI3_I213_MP1 (Y_10 I3_q10_2 VDD VDD) gpdk090_pmos1v w=0.24u l=0.1u ad=0.0528p as=0.0816p pd=0.68u ps=1.16u
    I_MXI3_I213_MP0 (VDD I3_q10_1 Y_10 VDD) gpdk090_pmos1v w=0.24u l=0.1u ad=0.0816p as=0.0528p pd=1.16u ps=0.68u
    I_MXI3_I218_MP1 (I3_n11_4 MULP_11 VDD VDD) gpdk090_pmos1v w=0.24u l=0.1u ad=0.0528p as=0.0816p pd=0.68u ps=1.16u
    I_MXI3_I218_MP0 (VDD I3_SEL_MUL_b3_1 I3_n11_4 VDD) gpdk090_pmos1v w=0.24u l=0.1u ad=0.0816p as=0.0528p pd=1.16u ps=0.68u
    I_MXI3_I222_MP1 (I3_o11_2 I3_n11_5 VDD VDD) gpdk090_pmos1v w=0.24u l=0.1u ad=0.0528p as=0.0816p pd=0.68u ps=1.16u
    I_MXI3_I222_MP0 (VDD I3_n11_4 I3_o11_2 VDD) gpdk090_pmos1v w=0.24u l=0.1u ad=0.0816p as=0.0528p pd=1.16u ps=0.68u
    I_MXI3_I193_MP1 (I3_n9_3 NOT_9 VDD VDD) gpdk090_pmos1v w=0.24u l=0.1u ad=0.0528p as=0.0816p pd=0.68u ps=1.16u
    I_MXI3_I193_MP0 (VDD I3_SEL_NOT_b3_1 I3_n9_3 VDD) gpdk090_pmos1v w=0.24u l=0.1u ad=0.0816p as=0.0528p pd=1.16u ps=0.68u
    I_MXI4_I34_MP1 (I4_z1_2 I4_z0_5 VDD VDD) gpdk090_pmos1v w=0.24u l=0.1u ad=0.0528p as=0.0816p pd=0.68u ps=1.16u
    I_MXI4_I34_MP0 (VDD I4_z0_4 I4_z1_2 VDD) gpdk090_pmos1v w=0.24u l=0.1u ad=0.0816p as=0.0528p pd=1.16u ps=0.68u
    I_MXI3_I169_MP1 (I3_n7_3 NOT_7 VDD VDD) gpdk090_pmos1v w=0.24u l=0.1u ad=0.0528p as=0.0816p pd=0.68u ps=1.16u
    I_MXI3_I169_MP0 (VDD I3_SEL_NOT_b3_1 I3_n7_3 VDD) gpdk090_pmos1v w=0.24u l=0.1u ad=0.0816p as=0.0528p pd=1.16u ps=0.68u
    I_MXI3_I173_MP1 (I3_o7_1 I3_n7_3 VDD VDD) gpdk090_pmos1v w=0.24u l=0.1u ad=0.0528p as=0.0816p pd=0.68u ps=1.16u
    I_MXI3_I173_MP0 (VDD I3_n7_2 I3_o7_1 VDD) gpdk090_pmos1v w=0.24u l=0.1u ad=0.0816p as=0.0528p pd=1.16u ps=0.68u
    I_MXI3_I168_MP1 (I3_n7_2 XOR_7 VDD VDD) gpdk090_pmos1v w=0.24u l=0.1u ad=0.0528p as=0.0816p pd=0.68u ps=1.16u
    I_MXI3_I168_MP0 (VDD I3_SEL_XOR_b3_1 I3_n7_2 VDD) gpdk090_pmos1v w=0.24u l=0.1u ad=0.0816p as=0.0528p pd=1.16u ps=0.68u
    I_MXI3_I172_MP1 (I3_o7_0 I3_n7_1 VDD VDD) gpdk090_pmos1v w=0.24u l=0.1u ad=0.0528p as=0.0816p pd=0.68u ps=1.16u
    I_MXI3_I172_MP0 (VDD I3_n7_0 I3_o7_0 VDD) gpdk090_pmos1v w=0.24u l=0.1u ad=0.0816p as=0.0528p pd=1.16u ps=0.68u
    I_MXI3_I167_MP1 (I3_n7_1 OR_7 VDD VDD) gpdk090_pmos1v w=0.24u l=0.1u ad=0.0528p as=0.0816p pd=0.68u ps=1.16u
    I_MXI3_I167_MP0 (VDD I3_SEL_OR_b3_1 I3_n7_1 VDD) gpdk090_pmos1v w=0.24u l=0.1u ad=0.0816p as=0.0528p pd=1.16u ps=0.68u
    I_MXI4_I56_MP1 (I4_z3_0 I4_z2_1 VDD VDD) gpdk090_pmos1v w=0.24u l=0.1u ad=0.0528p as=0.0816p pd=0.68u ps=1.16u
    I_MXI4_I56_MP0 (VDD I4_z2_0 I4_z3_0 VDD) gpdk090_pmos1v w=0.24u l=0.1u ad=0.0816p as=0.0528p pd=1.16u ps=0.68u
    I_MXI3_I144_MP1 (I3_n5_2 XOR_5 VDD VDD) gpdk090_pmos1v w=0.24u l=0.1u ad=0.0528p as=0.0816p pd=0.68u ps=1.16u
    I_MXI3_I144_MP0 (VDD I3_SEL_XOR_b3_0 I3_n5_2 VDD) gpdk090_pmos1v w=0.24u l=0.1u ad=0.0816p as=0.0528p pd=1.16u ps=0.68u
    I_MXI3_I153_MP1 (Y_5 I3_q5_2 VDD VDD) gpdk090_pmos1v w=0.24u l=0.1u ad=0.0528p as=0.0816p pd=0.68u ps=1.16u
    I_MXI3_I153_MP0 (VDD I3_q5_1 Y_5 VDD) gpdk090_pmos1v w=0.24u l=0.1u ad=0.0816p as=0.0528p pd=1.16u ps=0.68u
    I_MXI3_I149_MP1 (I3_o5_1 I3_n5_3 VDD VDD) gpdk090_pmos1v w=0.24u l=0.1u ad=0.0528p as=0.0816p pd=0.68u ps=1.16u
    I_MXI3_I149_MP0 (VDD I3_n5_2 I3_o5_1 VDD) gpdk090_pmos1v w=0.24u l=0.1u ad=0.0816p as=0.0528p pd=1.16u ps=0.68u
    I_MXI3_I90_MP1 (I3_o0_2 I3_n0_5 VDD VDD) gpdk090_pmos1v w=0.24u l=0.1u ad=0.0528p as=0.0816p pd=0.68u ps=1.16u
    I_MXI3_I90_MP0 (VDD I3_n0_4 I3_o0_2 VDD) gpdk090_pmos1v w=0.24u l=0.1u ad=0.0816p as=0.0528p pd=1.16u ps=0.68u
    I_MXI3_I87_MP1 (I3_n0_5 DIVQ_0 VDD VDD) gpdk090_pmos1v w=0.24u l=0.1u ad=0.0528p as=0.0816p pd=0.68u ps=1.16u
    I_MXI3_I87_MP0 (VDD I3_SEL_DIV_b3_0 I3_n0_5 VDD) gpdk090_pmos1v w=0.24u l=0.1u ad=0.0816p as=0.0528p pd=1.16u ps=0.68u
    I_MXI3_I86_MP1 (I3_n0_4 MULP_0 VDD VDD) gpdk090_pmos1v w=0.24u l=0.1u ad=0.0528p as=0.0816p pd=0.68u ps=1.16u
    I_MXI3_I86_MP0 (VDD I3_SEL_MUL_b3_0 I3_n0_4 VDD) gpdk090_pmos1v w=0.24u l=0.1u ad=0.0816p as=0.0528p pd=1.16u ps=0.68u
    I_MXI1_I42_I4_MP1 (I1_I42_gn4 I1_bx4 VDD VDD) gpdk090_pmos1v w=0.24u l=0.1u ad=0.0528p as=0.0816p pd=0.68u ps=1.16u
    I_MXI1_I42_I4_MP0 (VDD A_4 I1_I42_gn4 VDD) gpdk090_pmos1v w=0.24u l=0.1u ad=0.0816p as=0.0528p pd=1.16u ps=0.68u
    I_MXI3_I102_MP1 (I3_o1_2 I3_n1_5 VDD VDD) gpdk090_pmos1v w=0.24u l=0.1u ad=0.0528p as=0.0816p pd=0.68u ps=1.16u
    I_MXI3_I102_MP0 (VDD I3_n1_4 I3_o1_2 VDD) gpdk090_pmos1v w=0.24u l=0.1u ad=0.0816p as=0.0528p pd=1.16u ps=0.68u
    I_MXI3_I109_MP1 (I3_n2_3 NOT_2 VDD VDD) gpdk090_pmos1v w=0.24u l=0.1u ad=0.0528p as=0.0816p pd=0.68u ps=1.16u
    I_MXI3_I109_MP0 (VDD I3_SEL_NOT_b3_0 I3_n2_3 VDD) gpdk090_pmos1v w=0.24u l=0.1u ad=0.0816p as=0.0528p pd=1.16u ps=0.68u
    I_MXI3_I99_MP1 (I3_n1_5 DIVQ_1 VDD VDD) gpdk090_pmos1v w=0.24u l=0.1u ad=0.0528p as=0.0816p pd=0.68u ps=1.16u
    I_MXI3_I99_MP0 (VDD I3_SEL_DIV_b3_0 I3_n1_5 VDD) gpdk090_pmos1v w=0.24u l=0.1u ad=0.0816p as=0.0528p pd=1.16u ps=0.68u
    I_MXI3_I113_MP1 (I3_o2_1 I3_n2_3 VDD VDD) gpdk090_pmos1v w=0.24u l=0.1u ad=0.0528p as=0.0816p pd=0.68u ps=1.16u
    I_MXI3_I113_MP0 (VDD I3_n2_2 I3_o2_1 VDD) gpdk090_pmos1v w=0.24u l=0.1u ad=0.0816p as=0.0528p pd=1.16u ps=0.68u
    I_MXI3_I98_MP1 (I3_n1_4 MULP_1 VDD VDD) gpdk090_pmos1v w=0.24u l=0.1u ad=0.0528p as=0.0816p pd=0.68u ps=1.16u
    I_MXI3_I98_MP0 (VDD I3_SEL_MUL_b3_0 I3_n1_4 VDD) gpdk090_pmos1v w=0.24u l=0.1u ad=0.0816p as=0.0528p pd=1.16u ps=0.68u
    I_MXI3_I117_MP1 (Y_2 I3_q2_2 VDD VDD) gpdk090_pmos1v w=0.24u l=0.1u ad=0.0528p as=0.0816p pd=0.68u ps=1.16u
    I_MXI3_I117_MP0 (VDD I3_q2_1 Y_2 VDD) gpdk090_pmos1v w=0.24u l=0.1u ad=0.0816p as=0.0528p pd=1.16u ps=0.68u
    I_MXI3_I108_MP1 (I3_n2_2 XOR_2 VDD VDD) gpdk090_pmos1v w=0.24u l=0.1u ad=0.0528p as=0.0816p pd=0.68u ps=1.16u
    I_MXI3_I108_MP0 (VDD I3_SEL_XOR_b3_0 I3_n2_2 VDD) gpdk090_pmos1v w=0.24u l=0.1u ad=0.0816p as=0.0528p pd=1.16u ps=0.68u
    I_MXI3_I515_MP1 (I3_hd48 DIVR_16 VDD VDD) gpdk090_pmos1v w=0.24u l=0.1u ad=0.0528p as=0.0816p pd=0.68u ps=1.16u
    I_MXI3_I515_MP0 (VDD I3_SEL_DIV_b3_8 I3_hd48 VDD) gpdk090_pmos1v w=0.24u l=0.1u ad=0.0816p as=0.0528p pd=1.16u ps=0.68u
    I_MXI3_I488_MP1 (I3_hd39 DIVR_7 VDD VDD) gpdk090_pmos1v w=0.24u l=0.1u ad=0.0528p as=0.0816p pd=0.68u ps=1.16u
    I_MXI3_I488_MP0 (VDD I3_SEL_DIV_b3_6 I3_hd39 VDD) gpdk090_pmos1v w=0.24u l=0.1u ad=0.0816p as=0.0528p pd=1.16u ps=0.68u
    I_MXI3_I517_MP1 (I3_hm49 MULP_49 VDD VDD) gpdk090_pmos1v w=0.24u l=0.1u ad=0.0528p as=0.0816p pd=0.68u ps=1.16u
    I_MXI3_I517_MP0 (VDD I3_SEL_MUL_b3_8 I3_hm49 VDD) gpdk090_pmos1v w=0.24u l=0.1u ad=0.0816p as=0.0528p pd=1.16u ps=0.68u
    I_MXI3_I514_MP1 (I3_hm48 MULP_48 VDD VDD) gpdk090_pmos1v w=0.24u l=0.1u ad=0.0528p as=0.0816p pd=0.68u ps=1.16u
    I_MXI3_I514_MP0 (VDD I3_SEL_MUL_b3_8 I3_hm48 VDD) gpdk090_pmos1v w=0.24u l=0.1u ad=0.0816p as=0.0528p pd=1.16u ps=0.68u
    I_MXI3_I492_MP1 (Y_40 I3_hd40 VDD VDD) gpdk090_pmos1v w=0.24u l=0.1u ad=0.0528p as=0.0816p pd=0.68u ps=1.16u
    I_MXI3_I492_MP0 (VDD I3_hm40 Y_40 VDD) gpdk090_pmos1v w=0.24u l=0.1u ad=0.0816p as=0.0528p pd=1.16u ps=0.68u
    I_MXI3_I519_MP1 (Y_49 I3_hd49 VDD VDD) gpdk090_pmos1v w=0.24u l=0.1u ad=0.0528p as=0.0816p pd=0.68u ps=1.16u
    I_MXI3_I519_MP0 (VDD I3_hm49 Y_49 VDD) gpdk090_pmos1v w=0.24u l=0.1u ad=0.0816p as=0.0528p pd=1.16u ps=0.68u
    I_MXI3_I523_MP1 (I3_hm51 MULP_51 VDD VDD) gpdk090_pmos1v w=0.24u l=0.1u ad=0.0528p as=0.0816p pd=0.68u ps=1.16u
    I_MXI3_I523_MP0 (VDD I3_SEL_MUL_b3_8 I3_hm51 VDD) gpdk090_pmos1v w=0.24u l=0.1u ad=0.0816p as=0.0528p pd=1.16u ps=0.68u
    I_MXI3_I518_MP1 (I3_hd49 DIVR_17 VDD VDD) gpdk090_pmos1v w=0.24u l=0.1u ad=0.0528p as=0.0816p pd=0.68u ps=1.16u
    I_MXI3_I518_MP0 (VDD I3_SEL_DIV_b3_8 I3_hd49 VDD) gpdk090_pmos1v w=0.24u l=0.1u ad=0.0816p as=0.0528p pd=1.16u ps=0.68u
    I_MXI3_I521_MP1 (I3_hd50 DIVR_18 VDD VDD) gpdk090_pmos1v w=0.24u l=0.1u ad=0.0528p as=0.0816p pd=0.68u ps=1.16u
    I_MXI3_I521_MP0 (VDD I3_SEL_DIV_b3_8 I3_hd50 VDD) gpdk090_pmos1v w=0.24u l=0.1u ad=0.0816p as=0.0528p pd=1.16u ps=0.68u
    I_MXI3_I525_MP1 (Y_51 I3_hd51 VDD VDD) gpdk090_pmos1v w=0.24u l=0.1u ad=0.0528p as=0.0816p pd=0.68u ps=1.16u
    I_MXI3_I525_MP0 (VDD I3_hm51 Y_51 VDD) gpdk090_pmos1v w=0.24u l=0.1u ad=0.0816p as=0.0528p pd=1.16u ps=0.68u
    I_MXI3_I524_MP1 (I3_hd51 DIVR_19 VDD VDD) gpdk090_pmos1v w=0.24u l=0.1u ad=0.0528p as=0.0816p pd=0.68u ps=1.16u
    I_MXI3_I524_MP0 (VDD I3_SEL_DIV_b3_8 I3_hd51 VDD) gpdk090_pmos1v w=0.24u l=0.1u ad=0.0816p as=0.0528p pd=1.16u ps=0.68u
    I_MXI3_I493_MP1 (I3_hm41 MULP_41 VDD VDD) gpdk090_pmos1v w=0.24u l=0.1u ad=0.0528p as=0.0816p pd=0.68u ps=1.16u
    I_MXI3_I493_MP0 (VDD I3_SEL_MUL_b3_7 I3_hm41 VDD) gpdk090_pmos1v w=0.24u l=0.1u ad=0.0816p as=0.0528p pd=1.16u ps=0.68u
    I_MXI3_I494_MP1 (I3_hd41 DIVR_9 VDD VDD) gpdk090_pmos1v w=0.24u l=0.1u ad=0.0528p as=0.0816p pd=0.68u ps=1.16u
    I_MXI3_I494_MP0 (VDD I3_SEL_DIV_b3_7 I3_hd41 VDD) gpdk090_pmos1v w=0.24u l=0.1u ad=0.0816p as=0.0528p pd=1.16u ps=0.68u
    I_MXI3_I495_MP1 (Y_41 I3_hd41 VDD VDD) gpdk090_pmos1v w=0.24u l=0.1u ad=0.0528p as=0.0816p pd=0.68u ps=1.16u
    I_MXI3_I495_MP0 (VDD I3_hm41 Y_41 VDD) gpdk090_pmos1v w=0.24u l=0.1u ad=0.0816p as=0.0528p pd=1.16u ps=0.68u
    I_MXI3_I202_MP1 (I3_n10_0 AND_10 VDD VDD) gpdk090_pmos1v w=0.24u l=0.1u ad=0.0528p as=0.0816p pd=0.68u ps=1.16u
    I_MXI3_I202_MP0 (VDD I3_SEL_AND_b3_1 I3_n10_0 VDD) gpdk090_pmos1v w=0.24u l=0.1u ad=0.0816p as=0.0528p pd=1.16u ps=0.68u
    I_MXI3_I203_MP1 (I3_n10_1 OR_10 VDD VDD) gpdk090_pmos1v w=0.24u l=0.1u ad=0.0528p as=0.0816p pd=0.68u ps=1.16u
    I_MXI3_I203_MP0 (VDD I3_SEL_OR_b3_1 I3_n10_1 VDD) gpdk090_pmos1v w=0.24u l=0.1u ad=0.0816p as=0.0528p pd=1.16u ps=0.68u
    I_MXI3_I208_MP1 (I3_o10_0 I3_n10_1 VDD VDD) gpdk090_pmos1v w=0.24u l=0.1u ad=0.0528p as=0.0816p pd=0.68u ps=1.16u
    I_MXI3_I208_MP0 (VDD I3_n10_0 I3_o10_0 VDD) gpdk090_pmos1v w=0.24u l=0.1u ad=0.0816p as=0.0528p pd=1.16u ps=0.68u
    I_MXI1_I42_I8_MP1 (I1_I42_gn8 I1_bx8 VDD VDD) gpdk090_pmos1v w=0.24u l=0.1u ad=0.0528p as=0.0816p pd=0.68u ps=1.16u
    I_MXI1_I42_I8_MP0 (VDD A_8 I1_I42_gn8 VDD) gpdk090_pmos1v w=0.24u l=0.1u ad=0.0816p as=0.0528p pd=1.16u ps=0.68u
    I_MXI1_I42_I9_MP1 (I1_I42_gn9 I1_bx9 VDD VDD) gpdk090_pmos1v w=0.24u l=0.1u ad=0.0528p as=0.0816p pd=0.68u ps=1.16u
    I_MXI1_I42_I9_MP0 (VDD A_9 I1_I42_gn9 VDD) gpdk090_pmos1v w=0.24u l=0.1u ad=0.0816p as=0.0528p pd=1.16u ps=0.68u
    I_MXI1_I42_I7_MP1 (I1_I42_gn7 I1_bx7 VDD VDD) gpdk090_pmos1v w=0.24u l=0.1u ad=0.0528p as=0.0816p pd=0.68u ps=1.16u
    I_MXI1_I42_I7_MP0 (VDD A_7 I1_I42_gn7 VDD) gpdk090_pmos1v w=0.24u l=0.1u ad=0.0816p as=0.0528p pd=1.16u ps=0.68u
    I_MXI1_I42_I6_MP1 (I1_I42_gn6 I1_bx6 VDD VDD) gpdk090_pmos1v w=0.24u l=0.1u ad=0.0528p as=0.0816p pd=0.68u ps=1.16u
    I_MXI1_I42_I6_MP0 (VDD A_6 I1_I42_gn6 VDD) gpdk090_pmos1v w=0.24u l=0.1u ad=0.0816p as=0.0528p pd=1.16u ps=0.68u
    I_MXI2_I30_MP1 (I2_nand5 B_5 VDD VDD) gpdk090_pmos1v w=0.24u l=0.1u ad=0.0528p as=0.0816p pd=0.68u ps=1.16u
    I_MXI2_I30_MP0 (VDD A_5 I2_nand5 VDD) gpdk090_pmos1v w=0.24u l=0.1u ad=0.0816p as=0.0528p pd=1.16u ps=0.68u
    I_MXI3_I143_MP1 (I3_n5_1 OR_5 VDD VDD) gpdk090_pmos1v w=0.24u l=0.1u ad=0.0528p as=0.0816p pd=0.68u ps=1.16u
    I_MXI3_I143_MP0 (VDD I3_SEL_OR_b3_0 I3_n5_1 VDD) gpdk090_pmos1v w=0.24u l=0.1u ad=0.0816p as=0.0528p pd=1.16u ps=0.68u
    I_MXI3_I142_MP1 (I3_n5_0 AND_5 VDD VDD) gpdk090_pmos1v w=0.24u l=0.1u ad=0.0528p as=0.0816p pd=0.68u ps=1.16u
    I_MXI3_I142_MP0 (VDD I3_SEL_AND_b3_0 I3_n5_0 VDD) gpdk090_pmos1v w=0.24u l=0.1u ad=0.0816p as=0.0528p pd=1.16u ps=0.68u
    I_MXI3_I148_MP1 (I3_o5_0 I3_n5_1 VDD VDD) gpdk090_pmos1v w=0.24u l=0.1u ad=0.0528p as=0.0816p pd=0.68u ps=1.16u
    I_MXI3_I148_MP0 (VDD I3_n5_0 I3_o5_0 VDD) gpdk090_pmos1v w=0.24u l=0.1u ad=0.0816p as=0.0528p pd=1.16u ps=0.68u
    I_MXI3_I146_MP1 (I3_n5_4 MULP_5 VDD VDD) gpdk090_pmos1v w=0.24u l=0.1u ad=0.0528p as=0.0816p pd=0.68u ps=1.16u
    I_MXI3_I146_MP0 (VDD I3_SEL_MUL_b3_0 I3_n5_4 VDD) gpdk090_pmos1v w=0.24u l=0.1u ad=0.0816p as=0.0528p pd=1.16u ps=0.68u
    I_MXI3_I114_MP1 (I3_o2_2 I3_n2_5 VDD VDD) gpdk090_pmos1v w=0.24u l=0.1u ad=0.0528p as=0.0816p pd=0.68u ps=1.16u
    I_MXI3_I114_MP0 (VDD I3_n2_4 I3_o2_2 VDD) gpdk090_pmos1v w=0.24u l=0.1u ad=0.0816p as=0.0528p pd=1.16u ps=0.68u
    I_MXI3_I126_MP1 (I3_o3_2 I3_n3_5 VDD VDD) gpdk090_pmos1v w=0.24u l=0.1u ad=0.0528p as=0.0816p pd=0.68u ps=1.16u
    I_MXI3_I126_MP0 (VDD I3_n3_4 I3_o3_2 VDD) gpdk090_pmos1v w=0.24u l=0.1u ad=0.0816p as=0.0528p pd=1.16u ps=0.68u
    I_MXI3_I110_MP1 (I3_n2_4 MULP_2 VDD VDD) gpdk090_pmos1v w=0.24u l=0.1u ad=0.0528p as=0.0816p pd=0.68u ps=1.16u
    I_MXI3_I110_MP0 (VDD I3_SEL_MUL_b3_0 I3_n2_4 VDD) gpdk090_pmos1v w=0.24u l=0.1u ad=0.0816p as=0.0528p pd=1.16u ps=0.68u
    I_MXI3_I122_MP1 (I3_n3_4 MULP_3 VDD VDD) gpdk090_pmos1v w=0.24u l=0.1u ad=0.0528p as=0.0816p pd=0.68u ps=1.16u
    I_MXI3_I122_MP0 (VDD I3_SEL_MUL_b3_0 I3_n3_4 VDD) gpdk090_pmos1v w=0.24u l=0.1u ad=0.0816p as=0.0528p pd=1.16u ps=0.68u
    I_MXI3_I111_MP1 (I3_n2_5 DIVQ_2 VDD VDD) gpdk090_pmos1v w=0.24u l=0.1u ad=0.0528p as=0.0816p pd=0.68u ps=1.16u
    I_MXI3_I111_MP0 (VDD I3_SEL_DIV_b3_0 I3_n2_5 VDD) gpdk090_pmos1v w=0.24u l=0.1u ad=0.0816p as=0.0528p pd=1.16u ps=0.68u
    I_MXI3_I123_MP1 (I3_n3_5 DIVQ_3 VDD VDD) gpdk090_pmos1v w=0.24u l=0.1u ad=0.0528p as=0.0816p pd=0.68u ps=1.16u
    I_MXI3_I123_MP0 (VDD I3_SEL_DIV_b3_0 I3_n3_5 VDD) gpdk090_pmos1v w=0.24u l=0.1u ad=0.0816p as=0.0528p pd=1.16u ps=0.68u
    I_MXI3_I121_MP1 (I3_n3_3 NOT_3 VDD VDD) gpdk090_pmos1v w=0.24u l=0.1u ad=0.0528p as=0.0816p pd=0.68u ps=1.16u
    I_MXI3_I121_MP0 (VDD I3_SEL_NOT_b3_0 I3_n3_3 VDD) gpdk090_pmos1v w=0.24u l=0.1u ad=0.0816p as=0.0528p pd=1.16u ps=0.68u
    I_MXI3_I129_MP1 (Y_3 I3_q3_2 VDD VDD) gpdk090_pmos1v w=0.24u l=0.1u ad=0.0528p as=0.0816p pd=0.68u ps=1.16u
    I_MXI3_I129_MP0 (VDD I3_q3_1 Y_3 VDD) gpdk090_pmos1v w=0.24u l=0.1u ad=0.0816p as=0.0528p pd=1.16u ps=0.68u
    I_MXI3_I125_MP1 (I3_o3_1 I3_n3_3 VDD VDD) gpdk090_pmos1v w=0.24u l=0.1u ad=0.0528p as=0.0816p pd=0.68u ps=1.16u
    I_MXI3_I125_MP0 (VDD I3_n3_2 I3_o3_1 VDD) gpdk090_pmos1v w=0.24u l=0.1u ad=0.0816p as=0.0528p pd=1.16u ps=0.68u
    I_MXI3_I120_MP1 (I3_n3_2 XOR_3 VDD VDD) gpdk090_pmos1v w=0.24u l=0.1u ad=0.0528p as=0.0816p pd=0.68u ps=1.16u
    I_MXI3_I120_MP0 (VDD I3_SEL_XOR_b3_0 I3_n3_2 VDD) gpdk090_pmos1v w=0.24u l=0.1u ad=0.0816p as=0.0528p pd=1.16u ps=0.68u
    I_MXI3_I487_MP1 (I3_hm39 MULP_39 VDD VDD) gpdk090_pmos1v w=0.24u l=0.1u ad=0.0528p as=0.0816p pd=0.68u ps=1.16u
    I_MXI3_I487_MP0 (VDD I3_SEL_MUL_b3_6 I3_hm39 VDD) gpdk090_pmos1v w=0.24u l=0.1u ad=0.0816p as=0.0528p pd=1.16u ps=0.68u
    I_MXI3_I489_MP1 (Y_39 I3_hd39 VDD VDD) gpdk090_pmos1v w=0.24u l=0.1u ad=0.0528p as=0.0816p pd=0.68u ps=1.16u
    I_MXI3_I489_MP0 (VDD I3_hm39 Y_39 VDD) gpdk090_pmos1v w=0.24u l=0.1u ad=0.0816p as=0.0528p pd=1.16u ps=0.68u
    I_MXI3_I478_MP1 (I3_hm36 MULP_36 VDD VDD) gpdk090_pmos1v w=0.24u l=0.1u ad=0.0528p as=0.0816p pd=0.68u ps=1.16u
    I_MXI3_I478_MP0 (VDD I3_SEL_MUL_b3_6 I3_hm36 VDD) gpdk090_pmos1v w=0.24u l=0.1u ad=0.0816p as=0.0528p pd=1.16u ps=0.68u
    I_MXI3_I491_MP1 (I3_hd40 DIVR_8 VDD VDD) gpdk090_pmos1v w=0.24u l=0.1u ad=0.0528p as=0.0816p pd=0.68u ps=1.16u
    I_MXI3_I491_MP0 (VDD I3_SEL_DIV_b3_6 I3_hd40 VDD) gpdk090_pmos1v w=0.24u l=0.1u ad=0.0816p as=0.0528p pd=1.16u ps=0.68u
    I_MXI3_I482_MP1 (I3_hd37 DIVR_5 VDD VDD) gpdk090_pmos1v w=0.24u l=0.1u ad=0.0528p as=0.0816p pd=0.68u ps=1.16u
    I_MXI3_I482_MP0 (VDD I3_SEL_DIV_b3_6 I3_hd37 VDD) gpdk090_pmos1v w=0.24u l=0.1u ad=0.0816p as=0.0528p pd=1.16u ps=0.68u
    I_MXI3_I484_MP1 (I3_hm38 MULP_38 VDD VDD) gpdk090_pmos1v w=0.24u l=0.1u ad=0.0528p as=0.0816p pd=0.68u ps=1.16u
    I_MXI3_I484_MP0 (VDD I3_SEL_MUL_b3_6 I3_hm38 VDD) gpdk090_pmos1v w=0.24u l=0.1u ad=0.0816p as=0.0528p pd=1.16u ps=0.68u
    I_MXI3_I490_MP1 (I3_hm40 MULP_40 VDD VDD) gpdk090_pmos1v w=0.24u l=0.1u ad=0.0528p as=0.0816p pd=0.68u ps=1.16u
    I_MXI3_I490_MP0 (VDD I3_SEL_MUL_b3_6 I3_hm40 VDD) gpdk090_pmos1v w=0.24u l=0.1u ad=0.0816p as=0.0528p pd=1.16u ps=0.68u
    I_MXI3_I485_MP1 (I3_hd38 DIVR_6 VDD VDD) gpdk090_pmos1v w=0.24u l=0.1u ad=0.0528p as=0.0816p pd=0.68u ps=1.16u
    I_MXI3_I485_MP0 (VDD I3_SEL_DIV_b3_6 I3_hd38 VDD) gpdk090_pmos1v w=0.24u l=0.1u ad=0.0816p as=0.0528p pd=1.16u ps=0.68u
    I_MXI3_I486_MP1 (Y_38 I3_hd38 VDD VDD) gpdk090_pmos1v w=0.24u l=0.1u ad=0.0528p as=0.0816p pd=0.68u ps=1.16u
    I_MXI3_I486_MP0 (VDD I3_hm38 Y_38 VDD) gpdk090_pmos1v w=0.24u l=0.1u ad=0.0816p as=0.0528p pd=1.16u ps=0.68u
    I_MXI3_I475_MP1 (I3_hm35 MULP_35 VDD VDD) gpdk090_pmos1v w=0.24u l=0.1u ad=0.0528p as=0.0816p pd=0.68u ps=1.16u
    I_MXI3_I475_MP0 (VDD I3_SEL_MUL_b3_6 I3_hm35 VDD) gpdk090_pmos1v w=0.24u l=0.1u ad=0.0816p as=0.0528p pd=1.16u ps=0.68u
    I_MXI4_I41_MP1 (I4_z1_9 I4_z0_19 VDD VDD) gpdk090_pmos1v w=0.24u l=0.1u ad=0.0528p as=0.0816p pd=0.68u ps=1.16u
    I_MXI4_I41_MP0 (VDD I4_z0_18 I4_z1_9 VDD) gpdk090_pmos1v w=0.24u l=0.1u ad=0.0816p as=0.0528p pd=1.16u ps=0.68u
    I_MXI0_I6_MP1 (I0_h10 I0_opn2 VDD VDD) gpdk090_pmos1v w=0.24u l=0.1u ad=0.0528p as=0.0816p pd=0.68u ps=1.16u
    I_MXI0_I6_MP0 (VDD OP_3 I0_h10 VDD) gpdk090_pmos1v w=0.24u l=0.1u ad=0.0816p as=0.0528p pd=1.16u ps=0.68u
    I_MXI0_I4_MP1 (I0_h00 I0_opn2 VDD VDD) gpdk090_pmos1v w=0.24u l=0.1u ad=0.0528p as=0.0816p pd=0.68u ps=1.16u
    I_MXI0_I4_MP0 (VDD I0_opn3 I0_h00 VDD) gpdk090_pmos1v w=0.24u l=0.1u ad=0.0816p as=0.0528p pd=1.16u ps=0.68u
    I_MXI0_I5_MP1 (I0_h01 OP_2 VDD VDD) gpdk090_pmos1v w=0.24u l=0.1u ad=0.0528p as=0.0816p pd=0.68u ps=1.16u
    I_MXI0_I5_MP0 (VDD I0_opn3 I0_h01 VDD) gpdk090_pmos1v w=0.24u l=0.1u ad=0.0816p as=0.0528p pd=1.16u ps=0.68u
    I_MXI0_I8_MP1 (I0_l01 OP_0 VDD VDD) gpdk090_pmos1v w=0.24u l=0.1u ad=0.0528p as=0.0816p pd=0.68u ps=1.16u
    I_MXI0_I8_MP0 (VDD I0_opn1 I0_l01 VDD) gpdk090_pmos1v w=0.24u l=0.1u ad=0.0816p as=0.0528p pd=1.16u ps=0.68u
    I_MXI2_I60_MP1 (I2_nand10 B_10 VDD VDD) gpdk090_pmos1v w=0.24u l=0.1u ad=0.0528p as=0.0816p pd=0.68u ps=1.16u
    I_MXI2_I60_MP0 (VDD A_10 I2_nand10 VDD) gpdk090_pmos1v w=0.24u l=0.1u ad=0.0816p as=0.0528p pd=1.16u ps=0.68u
    I_MXI1_I42_I10_MP1 (I1_I42_gn10 I1_bx10 VDD VDD) gpdk090_pmos1v w=0.24u l=0.1u ad=0.0528p as=0.0816p pd=0.68u ps=1.16u
    I_MXI1_I42_I10_MP0 (VDD A_10 I1_I42_gn10 VDD) gpdk090_pmos1v w=0.24u l=0.1u ad=0.0816p as=0.0528p pd=1.16u ps=0.68u
    I_MXI1_I42_I5_MP1 (I1_I42_gn5 I1_bx5 VDD VDD) gpdk090_pmos1v w=0.24u l=0.1u ad=0.0528p as=0.0816p pd=0.68u ps=1.16u
    I_MXI1_I42_I5_MP0 (VDD A_5 I1_I42_gn5 VDD) gpdk090_pmos1v w=0.24u l=0.1u ad=0.0816p as=0.0528p pd=1.16u ps=0.68u
    I_MXI3_I150_MP1 (I3_o5_2 I3_n5_5 VDD VDD) gpdk090_pmos1v w=0.24u l=0.1u ad=0.0528p as=0.0816p pd=0.68u ps=1.16u
    I_MXI3_I150_MP0 (VDD I3_n5_4 I3_o5_2 VDD) gpdk090_pmos1v w=0.24u l=0.1u ad=0.0816p as=0.0528p pd=1.16u ps=0.68u
    I_MXI1_I42_I2_MP1 (I1_I42_gn2 I1_bx2 VDD VDD) gpdk090_pmos1v w=0.24u l=0.1u ad=0.0528p as=0.0816p pd=0.68u ps=1.16u
    I_MXI1_I42_I2_MP0 (VDD A_2 I1_I42_gn2 VDD) gpdk090_pmos1v w=0.24u l=0.1u ad=0.0816p as=0.0528p pd=1.16u ps=0.68u
    I_MXI3_I147_MP1 (I3_n5_5 DIVQ_5 VDD VDD) gpdk090_pmos1v w=0.24u l=0.1u ad=0.0528p as=0.0816p pd=0.68u ps=1.16u
    I_MXI3_I147_MP0 (VDD I3_SEL_DIV_b3_0 I3_n5_5 VDD) gpdk090_pmos1v w=0.24u l=0.1u ad=0.0816p as=0.0528p pd=1.16u ps=0.68u
    I_MXI3_I138_MP1 (I3_o4_2 I3_n4_5 VDD VDD) gpdk090_pmos1v w=0.24u l=0.1u ad=0.0528p as=0.0816p pd=0.68u ps=1.16u
    I_MXI3_I138_MP0 (VDD I3_n4_4 I3_o4_2 VDD) gpdk090_pmos1v w=0.24u l=0.1u ad=0.0816p as=0.0528p pd=1.16u ps=0.68u
    I_MXI3_I134_MP1 (I3_n4_4 MULP_4 VDD VDD) gpdk090_pmos1v w=0.24u l=0.1u ad=0.0528p as=0.0816p pd=0.68u ps=1.16u
    I_MXI3_I134_MP0 (VDD I3_SEL_MUL_b3_0 I3_n4_4 VDD) gpdk090_pmos1v w=0.24u l=0.1u ad=0.0816p as=0.0528p pd=1.16u ps=0.68u
    I_MXI3_I135_MP1 (I3_n4_5 DIVQ_4 VDD VDD) gpdk090_pmos1v w=0.24u l=0.1u ad=0.0528p as=0.0816p pd=0.68u ps=1.16u
    I_MXI3_I135_MP0 (VDD I3_SEL_DIV_b3_0 I3_n4_5 VDD) gpdk090_pmos1v w=0.24u l=0.1u ad=0.0816p as=0.0528p pd=1.16u ps=0.68u
    I_MXI3_I119_MP1 (I3_n3_1 OR_3 VDD VDD) gpdk090_pmos1v w=0.24u l=0.1u ad=0.0528p as=0.0816p pd=0.68u ps=1.16u
    I_MXI3_I119_MP0 (VDD I3_SEL_OR_b3_0 I3_n3_1 VDD) gpdk090_pmos1v w=0.24u l=0.1u ad=0.0816p as=0.0528p pd=1.16u ps=0.68u
    I_MXI3_I124_MP1 (I3_o3_0 I3_n3_1 VDD VDD) gpdk090_pmos1v w=0.24u l=0.1u ad=0.0528p as=0.0816p pd=0.68u ps=1.16u
    I_MXI3_I124_MP0 (VDD I3_n3_0 I3_o3_0 VDD) gpdk090_pmos1v w=0.24u l=0.1u ad=0.0816p as=0.0528p pd=1.16u ps=0.68u
    I_MXI3_I118_MP1 (I3_n3_0 AND_3 VDD VDD) gpdk090_pmos1v w=0.24u l=0.1u ad=0.0528p as=0.0816p pd=0.68u ps=1.16u
    I_MXI3_I118_MP0 (VDD I3_SEL_AND_b3_0 I3_n3_0 VDD) gpdk090_pmos1v w=0.24u l=0.1u ad=0.0816p as=0.0528p pd=1.16u ps=0.68u
    I_MXI3_I479_MP1 (I3_hd36 DIVR_4 VDD VDD) gpdk090_pmos1v w=0.24u l=0.1u ad=0.0528p as=0.0816p pd=0.68u ps=1.16u
    I_MXI3_I479_MP0 (VDD I3_SEL_DIV_b3_6 I3_hd36 VDD) gpdk090_pmos1v w=0.24u l=0.1u ad=0.0816p as=0.0528p pd=1.16u ps=0.68u
    I_MXI3_I474_MP1 (Y_34 I3_hd34 VDD VDD) gpdk090_pmos1v w=0.24u l=0.1u ad=0.0528p as=0.0816p pd=0.68u ps=1.16u
    I_MXI3_I474_MP0 (VDD I3_hm34 Y_34 VDD) gpdk090_pmos1v w=0.24u l=0.1u ad=0.0816p as=0.0528p pd=1.16u ps=0.68u
    I_MXI3_I480_MP1 (Y_36 I3_hd36 VDD VDD) gpdk090_pmos1v w=0.24u l=0.1u ad=0.0528p as=0.0816p pd=0.68u ps=1.16u
    I_MXI3_I480_MP0 (VDD I3_hm36 Y_36 VDD) gpdk090_pmos1v w=0.24u l=0.1u ad=0.0816p as=0.0528p pd=1.16u ps=0.68u
    I_MXI3_I481_MP1 (I3_hm37 MULP_37 VDD VDD) gpdk090_pmos1v w=0.24u l=0.1u ad=0.0528p as=0.0816p pd=0.68u ps=1.16u
    I_MXI3_I481_MP0 (VDD I3_SEL_MUL_b3_6 I3_hm37 VDD) gpdk090_pmos1v w=0.24u l=0.1u ad=0.0816p as=0.0528p pd=1.16u ps=0.68u
    I_MXI3_I469_MP1 (I3_hm33 MULP_33 VDD VDD) gpdk090_pmos1v w=0.24u l=0.1u ad=0.0528p as=0.0816p pd=0.68u ps=1.16u
    I_MXI3_I469_MP0 (VDD I3_SEL_MUL_b3_5 I3_hm33 VDD) gpdk090_pmos1v w=0.24u l=0.1u ad=0.0816p as=0.0528p pd=1.16u ps=0.68u
    I_MXI3_I483_MP1 (Y_37 I3_hd37 VDD VDD) gpdk090_pmos1v w=0.24u l=0.1u ad=0.0528p as=0.0816p pd=0.68u ps=1.16u
    I_MXI3_I483_MP0 (VDD I3_hm37 Y_37 VDD) gpdk090_pmos1v w=0.24u l=0.1u ad=0.0816p as=0.0528p pd=1.16u ps=0.68u
    I_MXI3_I476_MP1 (I3_hd35 DIVR_3 VDD VDD) gpdk090_pmos1v w=0.24u l=0.1u ad=0.0528p as=0.0816p pd=0.68u ps=1.16u
    I_MXI3_I476_MP0 (VDD I3_SEL_DIV_b3_6 I3_hd35 VDD) gpdk090_pmos1v w=0.24u l=0.1u ad=0.0816p as=0.0528p pd=1.16u ps=0.68u
    I_MXI3_I471_MP1 (Y_33 I3_hd33 VDD VDD) gpdk090_pmos1v w=0.24u l=0.1u ad=0.0528p as=0.0816p pd=0.68u ps=1.16u
    I_MXI3_I471_MP0 (VDD I3_hm33 Y_33 VDD) gpdk090_pmos1v w=0.24u l=0.1u ad=0.0816p as=0.0528p pd=1.16u ps=0.68u
    I_MXI3_I466_MP1 (I3_hm32 MULP_32 VDD VDD) gpdk090_pmos1v w=0.24u l=0.1u ad=0.0528p as=0.0816p pd=0.68u ps=1.16u
    I_MXI3_I466_MP0 (VDD I3_SEL_MUL_b3_5 I3_hm32 VDD) gpdk090_pmos1v w=0.24u l=0.1u ad=0.0816p as=0.0528p pd=1.16u ps=0.68u
    I_MXI3_I477_MP1 (Y_35 I3_hd35 VDD VDD) gpdk090_pmos1v w=0.24u l=0.1u ad=0.0528p as=0.0816p pd=0.68u ps=1.16u
    I_MXI3_I477_MP0 (VDD I3_hm35 Y_35 VDD) gpdk090_pmos1v w=0.24u l=0.1u ad=0.0816p as=0.0528p pd=1.16u ps=0.68u
    I_MXI3_I468_MP1 (Y_32 I3_hd32 VDD VDD) gpdk090_pmos1v w=0.24u l=0.1u ad=0.0528p as=0.0816p pd=0.68u ps=1.16u
    I_MXI3_I468_MP0 (VDD I3_hm32 Y_32 VDD) gpdk090_pmos1v w=0.24u l=0.1u ad=0.0816p as=0.0528p pd=1.16u ps=0.68u
    I_MXI4_I40_MP1 (I4_z1_8 I4_z0_17 VDD VDD) gpdk090_pmos1v w=0.24u l=0.1u ad=0.0528p as=0.0816p pd=0.68u ps=1.16u
    I_MXI4_I40_MP0 (VDD I4_z0_16 I4_z1_8 VDD) gpdk090_pmos1v w=0.24u l=0.1u ad=0.0816p as=0.0528p pd=1.16u ps=0.68u
    I_MXI4_I68_MP1 (I4_v2 DIVV VDD VDD) gpdk090_pmos1v w=0.24u l=0.1u ad=0.0528p as=0.0816p pd=0.68u ps=1.16u
    I_MXI4_I68_MP0 (VDD SEL_DIV I4_v2 VDD) gpdk090_pmos1v w=0.24u l=0.1u ad=0.0816p as=0.0528p pd=1.16u ps=0.68u
    I_MXI0_I10_MP1 (I0_l11 OP_0 VDD VDD) gpdk090_pmos1v w=0.24u l=0.1u ad=0.0528p as=0.0816p pd=0.68u ps=1.16u
    I_MXI0_I10_MP0 (VDD OP_1 I0_l11 VDD) gpdk090_pmos1v w=0.24u l=0.1u ad=0.0816p as=0.0528p pd=1.16u ps=0.68u
    I_MXI0_I7_MP1 (I0_l00 I0_opn0 VDD VDD) gpdk090_pmos1v w=0.24u l=0.1u ad=0.0528p as=0.0816p pd=0.68u ps=1.16u
    I_MXI0_I7_MP0 (VDD I0_opn1 I0_l00 VDD) gpdk090_pmos1v w=0.24u l=0.1u ad=0.0816p as=0.0528p pd=1.16u ps=0.68u
    I_MXI0_I9_MP1 (I0_l10 I0_opn0 VDD VDD) gpdk090_pmos1v w=0.24u l=0.1u ad=0.0528p as=0.0816p pd=0.68u ps=1.16u
    I_MXI0_I9_MP0 (VDD OP_1 I0_l10 VDD) gpdk090_pmos1v w=0.24u l=0.1u ad=0.0816p as=0.0528p pd=1.16u ps=0.68u
    I_MXI1_I42_I105_XP_MP1 (I1_I42_P9_6n I1_I42_P7_6 VDD VDD) gpdk090_pmos1v w=0.24u l=0.1u ad=0.0528p as=0.0816p pd=0.68u ps=1.16u
    I_MXI1_I42_I105_XP_MP0 (VDD I1_I42_P9_8 I1_I42_P9_6n VDD) gpdk090_pmos1v w=0.24u l=0.1u ad=0.0816p as=0.0528p pd=1.16u ps=0.68u
    I_MXI1_I42_I103_XP_MP1 (I1_I42_P7_4n I1_I42_P5_4 VDD VDD) gpdk090_pmos1v w=0.24u l=0.1u ad=0.0528p as=0.0816p pd=0.68u ps=1.16u
    I_MXI1_I42_I103_XP_MP0 (VDD I1_I42_P7_6 I1_I42_P7_4n VDD) gpdk090_pmos1v w=0.24u l=0.1u ad=0.0816p as=0.0528p pd=1.16u ps=0.68u
    I_MXI1_I42_I101_XP_MP1 (I1_I42_P5_2n I1_I42_P3_2 VDD VDD) gpdk090_pmos1v w=0.24u l=0.1u ad=0.0528p as=0.0816p pd=0.68u ps=1.16u
    I_MXI1_I42_I101_XP_MP0 (VDD I1_I42_P5_4 I1_I42_P5_2n VDD) gpdk090_pmos1v w=0.24u l=0.1u ad=0.0816p as=0.0528p pd=1.16u ps=0.68u
    I_MXI1_I42_I3_MP1 (I1_I42_gn3 I1_bx3 VDD VDD) gpdk090_pmos1v w=0.24u l=0.1u ad=0.0528p as=0.0816p pd=0.68u ps=1.16u
    I_MXI1_I42_I3_MP0 (VDD A_3 I1_I42_gn3 VDD) gpdk090_pmos1v w=0.24u l=0.1u ad=0.0816p as=0.0528p pd=1.16u ps=0.68u
    I_MXI3_I216_MP1 (I3_n11_2 XOR_11 VDD VDD) gpdk090_pmos1v w=0.24u l=0.1u ad=0.0528p as=0.0816p pd=0.68u ps=1.16u
    I_MXI3_I216_MP0 (VDD I3_SEL_XOR_b3_2 I3_n11_2 VDD) gpdk090_pmos1v w=0.24u l=0.1u ad=0.0816p as=0.0528p pd=1.16u ps=0.68u
    I_MXI2_I18_MP1 (I2_nand3 B_3 VDD VDD) gpdk090_pmos1v w=0.24u l=0.1u ad=0.0528p as=0.0816p pd=0.68u ps=1.16u
    I_MXI2_I18_MP0 (VDD A_3 I2_nand3 VDD) gpdk090_pmos1v w=0.24u l=0.1u ad=0.0816p as=0.0528p pd=1.16u ps=0.68u
    I_MXI3_I473_MP1 (I3_hd34 DIVR_2 VDD VDD) gpdk090_pmos1v w=0.24u l=0.1u ad=0.0528p as=0.0816p pd=0.68u ps=1.16u
    I_MXI3_I473_MP0 (VDD I3_SEL_DIV_b3_5 I3_hd34 VDD) gpdk090_pmos1v w=0.24u l=0.1u ad=0.0816p as=0.0528p pd=1.16u ps=0.68u
    I_MXI3_I472_MP1 (I3_hm34 MULP_34 VDD VDD) gpdk090_pmos1v w=0.24u l=0.1u ad=0.0528p as=0.0816p pd=0.68u ps=1.16u
    I_MXI3_I472_MP0 (VDD I3_SEL_MUL_b3_5 I3_hm34 VDD) gpdk090_pmos1v w=0.24u l=0.1u ad=0.0816p as=0.0528p pd=1.16u ps=0.68u
    I_MXI3_I447_MP1 (I3_n30_5 DIVQ_30 VDD VDD) gpdk090_pmos1v w=0.24u l=0.1u ad=0.0528p as=0.0816p pd=0.68u ps=1.16u
    I_MXI3_I447_MP0 (VDD I3_SEL_DIV_b3_5 I3_n30_5 VDD) gpdk090_pmos1v w=0.24u l=0.1u ad=0.0816p as=0.0528p pd=1.16u ps=0.68u
    I_MXI3_I446_MP1 (I3_n30_4 MULP_30 VDD VDD) gpdk090_pmos1v w=0.24u l=0.1u ad=0.0528p as=0.0816p pd=0.68u ps=1.16u
    I_MXI3_I446_MP0 (VDD I3_SEL_MUL_b3_5 I3_n30_4 VDD) gpdk090_pmos1v w=0.24u l=0.1u ad=0.0816p as=0.0528p pd=1.16u ps=0.68u
    I_MXI3_I450_MP1 (I3_o30_2 I3_n30_5 VDD VDD) gpdk090_pmos1v w=0.24u l=0.1u ad=0.0528p as=0.0816p pd=0.68u ps=1.16u
    I_MXI3_I450_MP0 (VDD I3_n30_4 I3_o30_2 VDD) gpdk090_pmos1v w=0.24u l=0.1u ad=0.0816p as=0.0528p pd=1.16u ps=0.68u
    I_MXI3_I458_MP1 (I3_n31_4 MULP_31 VDD VDD) gpdk090_pmos1v w=0.24u l=0.1u ad=0.0528p as=0.0816p pd=0.68u ps=1.16u
    I_MXI3_I458_MP0 (VDD I3_SEL_MUL_b3_5 I3_n31_4 VDD) gpdk090_pmos1v w=0.24u l=0.1u ad=0.0816p as=0.0528p pd=1.16u ps=0.68u
    I_MXI3_I470_MP1 (I3_hd33 DIVR_1 VDD VDD) gpdk090_pmos1v w=0.24u l=0.1u ad=0.0528p as=0.0816p pd=0.68u ps=1.16u
    I_MXI3_I470_MP0 (VDD I3_SEL_DIV_b3_5 I3_hd33 VDD) gpdk090_pmos1v w=0.24u l=0.1u ad=0.0816p as=0.0528p pd=1.16u ps=0.68u
    I_MXI3_I459_MP1 (I3_n31_5 DIVQ_31 VDD VDD) gpdk090_pmos1v w=0.24u l=0.1u ad=0.0528p as=0.0816p pd=0.68u ps=1.16u
    I_MXI3_I459_MP0 (VDD I3_SEL_DIV_b3_5 I3_n31_5 VDD) gpdk090_pmos1v w=0.24u l=0.1u ad=0.0816p as=0.0528p pd=1.16u ps=0.68u
    I_MXI3_I462_MP1 (I3_o31_2 I3_n31_5 VDD VDD) gpdk090_pmos1v w=0.24u l=0.1u ad=0.0528p as=0.0816p pd=0.68u ps=1.16u
    I_MXI3_I462_MP0 (VDD I3_n31_4 I3_o31_2 VDD) gpdk090_pmos1v w=0.24u l=0.1u ad=0.0816p as=0.0528p pd=1.16u ps=0.68u
    I_MXI3_I467_MP1 (I3_hd32 DIVR_0 VDD VDD) gpdk090_pmos1v w=0.24u l=0.1u ad=0.0528p as=0.0816p pd=0.68u ps=1.16u
    I_MXI3_I467_MP0 (VDD I3_SEL_DIV_b3_5 I3_hd32 VDD) gpdk090_pmos1v w=0.24u l=0.1u ad=0.0816p as=0.0528p pd=1.16u ps=0.68u
    I_MXI3_I444_MP1 (I3_n30_2 XOR_30 VDD VDD) gpdk090_pmos1v w=0.24u l=0.1u ad=0.0528p as=0.0816p pd=0.68u ps=1.16u
    I_MXI3_I444_MP0 (VDD I3_SEL_XOR_b3_5 I3_n30_2 VDD) gpdk090_pmos1v w=0.24u l=0.1u ad=0.0816p as=0.0528p pd=1.16u ps=0.68u
    I_MXI4_I69_MP1 (V I4_v2 VDD VDD) gpdk090_pmos1v w=0.24u l=0.1u ad=0.0528p as=0.0816p pd=0.68u ps=1.16u
    I_MXI4_I69_MP0 (VDD I4_v1 V VDD) gpdk090_pmos1v w=0.24u l=0.1u ad=0.0816p as=0.0528p pd=1.16u ps=0.68u
    I_MXI4_I64_MP1 (I4_cn SEL_AS VDD VDD) gpdk090_pmos1v w=0.24u l=0.1u ad=0.0528p as=0.0816p pd=0.68u ps=1.16u
    I_MXI4_I64_MP0 (VDD CO I4_cn VDD) gpdk090_pmos1v w=0.24u l=0.1u ad=0.0816p as=0.0528p pd=1.16u ps=0.68u
    I_MXI4_I67_MP1 (I4_v1 I4_ovf VDD VDD) gpdk090_pmos1v w=0.24u l=0.1u ad=0.0528p as=0.0816p pd=0.68u ps=1.16u
    I_MXI4_I67_MP0 (VDD SEL_AS I4_v1 VDD) gpdk090_pmos1v w=0.24u l=0.1u ad=0.0816p as=0.0528p pd=1.16u ps=0.68u
    I_MXI1_I42_I168_XP_MP1 (I1_I42_P17_2n I1_I42_P9_2 VDD VDD) gpdk090_pmos1v w=0.24u l=0.1u ad=0.0528p as=0.0816p pd=0.68u ps=1.16u
    I_MXI1_I42_I168_XP_MP0 (VDD I1_I42_P17_10 I1_I42_P17_2n VDD) gpdk090_pmos1v w=0.24u l=0.1u ad=0.0816p as=0.0528p pd=1.16u ps=0.68u
    I_MXI1_I42_I107_XP_MP1 (I1_I42_P11_8n I1_I42_P9_8 VDD VDD) gpdk090_pmos1v w=0.24u l=0.1u ad=0.0528p as=0.0816p pd=0.68u ps=1.16u
    I_MXI1_I42_I107_XP_MP0 (VDD I1_I42_P11_10 I1_I42_P11_8n VDD) gpdk090_pmos1v w=0.24u l=0.1u ad=0.0816p as=0.0528p pd=1.16u ps=0.68u
    I_MXI3_I225_MP1 (Y_11 I3_q11_2 VDD VDD) gpdk090_pmos1v w=0.24u l=0.1u ad=0.0528p as=0.0816p pd=0.68u ps=1.16u
    I_MXI3_I225_MP0 (VDD I3_q11_1 Y_11 VDD) gpdk090_pmos1v w=0.24u l=0.1u ad=0.0816p as=0.0528p pd=1.16u ps=0.68u
    I_MXI1_I42_I106_XP_MP1 (I1_I42_P10_7n I1_I42_P8_7 VDD VDD) gpdk090_pmos1v w=0.24u l=0.1u ad=0.0528p as=0.0816p pd=0.68u ps=1.16u
    I_MXI1_I42_I106_XP_MP0 (VDD I1_I42_P10_9 I1_I42_P10_7n VDD) gpdk090_pmos1v w=0.24u l=0.1u ad=0.0816p as=0.0528p pd=1.16u ps=0.68u
    I_MXI1_I42_I104_XP_MP1 (I1_I42_P8_5n I1_I42_P6_5 VDD VDD) gpdk090_pmos1v w=0.24u l=0.1u ad=0.0528p as=0.0816p pd=0.68u ps=1.16u
    I_MXI1_I42_I104_XP_MP0 (VDD I1_I42_P8_7 I1_I42_P8_5n VDD) gpdk090_pmos1v w=0.24u l=0.1u ad=0.0816p as=0.0528p pd=1.16u ps=0.68u
    I_MXI1_I42_I102_XP_MP1 (I1_I42_P6_3n I1_I42_P4_3 VDD VDD) gpdk090_pmos1v w=0.24u l=0.1u ad=0.0528p as=0.0816p pd=0.68u ps=1.16u
    I_MXI1_I42_I102_XP_MP0 (VDD I1_I42_P6_5 I1_I42_P6_3n VDD) gpdk090_pmos1v w=0.24u l=0.1u ad=0.0816p as=0.0528p pd=1.16u ps=0.68u
    I_MXI1_I42_I100_XP_MP1 (I1_I42_P4_1n I1_I42_P2_1 VDD VDD) gpdk090_pmos1v w=0.24u l=0.1u ad=0.0528p as=0.0816p pd=0.68u ps=1.16u
    I_MXI1_I42_I100_XP_MP0 (VDD I1_I42_P4_3 I1_I42_P4_1n VDD) gpdk090_pmos1v w=0.24u l=0.1u ad=0.0816p as=0.0528p pd=1.16u ps=0.68u
    I_MXI3_I214_MP1 (I3_n11_0 AND_11 VDD VDD) gpdk090_pmos1v w=0.24u l=0.1u ad=0.0528p as=0.0816p pd=0.68u ps=1.16u
    I_MXI3_I214_MP0 (VDD I3_SEL_AND_b3_2 I3_n11_0 VDD) gpdk090_pmos1v w=0.24u l=0.1u ad=0.0816p as=0.0528p pd=1.16u ps=0.68u
    I_MXI3_I220_MP1 (I3_o11_0 I3_n11_1 VDD VDD) gpdk090_pmos1v w=0.24u l=0.1u ad=0.0528p as=0.0816p pd=0.68u ps=1.16u
    I_MXI3_I220_MP0 (VDD I3_n11_0 I3_o11_0 VDD) gpdk090_pmos1v w=0.24u l=0.1u ad=0.0816p as=0.0528p pd=1.16u ps=0.68u
    I_MXI2_I66_MP1 (I2_nand11 B_11 VDD VDD) gpdk090_pmos1v w=0.24u l=0.1u ad=0.0528p as=0.0816p pd=0.68u ps=1.16u
    I_MXI2_I66_MP0 (VDD A_11 I2_nand11 VDD) gpdk090_pmos1v w=0.24u l=0.1u ad=0.0816p as=0.0528p pd=1.16u ps=0.68u
    I_MXI3_I215_MP1 (I3_n11_1 OR_11 VDD VDD) gpdk090_pmos1v w=0.24u l=0.1u ad=0.0528p as=0.0816p pd=0.68u ps=1.16u
    I_MXI3_I215_MP0 (VDD I3_SEL_OR_b3_2 I3_n11_1 VDD) gpdk090_pmos1v w=0.24u l=0.1u ad=0.0816p as=0.0528p pd=1.16u ps=0.68u
    I_MXI3_I217_MP1 (I3_n11_3 NOT_11 VDD VDD) gpdk090_pmos1v w=0.24u l=0.1u ad=0.0528p as=0.0816p pd=0.68u ps=1.16u
    I_MXI3_I217_MP0 (VDD I3_SEL_NOT_b3_2 I3_n11_3 VDD) gpdk090_pmos1v w=0.24u l=0.1u ad=0.0816p as=0.0528p pd=1.16u ps=0.68u
    I_MXI3_I221_MP1 (I3_o11_1 I3_n11_3 VDD VDD) gpdk090_pmos1v w=0.24u l=0.1u ad=0.0528p as=0.0816p pd=0.68u ps=1.16u
    I_MXI3_I221_MP0 (VDD I3_n11_2 I3_o11_1 VDD) gpdk090_pmos1v w=0.24u l=0.1u ad=0.0816p as=0.0528p pd=1.16u ps=0.68u
    I_MXI3_I227_MP1 (I3_n12_1 OR_12 VDD VDD) gpdk090_pmos1v w=0.24u l=0.1u ad=0.0528p as=0.0816p pd=0.68u ps=1.16u
    I_MXI3_I227_MP0 (VDD I3_SEL_OR_b3_2 I3_n12_1 VDD) gpdk090_pmos1v w=0.24u l=0.1u ad=0.0816p as=0.0528p pd=1.16u ps=0.68u
    I_MXI2_I180_MP1 (I2_nand30 B_30 VDD VDD) gpdk090_pmos1v w=0.24u l=0.1u ad=0.0528p as=0.0816p pd=0.68u ps=1.16u
    I_MXI2_I180_MP0 (VDD A_30 I2_nand30 VDD) gpdk090_pmos1v w=0.24u l=0.1u ad=0.0816p as=0.0528p pd=1.16u ps=0.68u
    I_MXI3_I443_MP1 (I3_n30_1 OR_30 VDD VDD) gpdk090_pmos1v w=0.24u l=0.1u ad=0.0528p as=0.0816p pd=0.68u ps=1.16u
    I_MXI3_I443_MP0 (VDD I3_SEL_OR_b3_5 I3_n30_1 VDD) gpdk090_pmos1v w=0.24u l=0.1u ad=0.0816p as=0.0528p pd=1.16u ps=0.68u
    I_MXI3_I453_MP1 (Y_30 I3_q30_2 VDD VDD) gpdk090_pmos1v w=0.24u l=0.1u ad=0.0528p as=0.0816p pd=0.68u ps=1.16u
    I_MXI3_I453_MP0 (VDD I3_q30_1 Y_30 VDD) gpdk090_pmos1v w=0.24u l=0.1u ad=0.0816p as=0.0528p pd=1.16u ps=0.68u
    I_MXI3_I465_MP1 (Y_31 I3_q31_2 VDD VDD) gpdk090_pmos1v w=0.24u l=0.1u ad=0.0528p as=0.0816p pd=0.68u ps=1.16u
    I_MXI3_I465_MP0 (VDD I3_q31_1 Y_31 VDD) gpdk090_pmos1v w=0.24u l=0.1u ad=0.0816p as=0.0528p pd=1.16u ps=0.68u
    I_MXI3_I449_MP1 (I3_o30_1 I3_n30_3 VDD VDD) gpdk090_pmos1v w=0.24u l=0.1u ad=0.0528p as=0.0816p pd=0.68u ps=1.16u
    I_MXI3_I449_MP0 (VDD I3_n30_2 I3_o30_1 VDD) gpdk090_pmos1v w=0.24u l=0.1u ad=0.0816p as=0.0528p pd=1.16u ps=0.68u
    I_MXI3_I445_MP1 (I3_n30_3 NOT_30 VDD VDD) gpdk090_pmos1v w=0.24u l=0.1u ad=0.0528p as=0.0816p pd=0.68u ps=1.16u
    I_MXI3_I445_MP0 (VDD I3_SEL_NOT_b3_5 I3_n30_3 VDD) gpdk090_pmos1v w=0.24u l=0.1u ad=0.0816p as=0.0528p pd=1.16u ps=0.68u
    I_MXI3_I461_MP1 (I3_o31_1 I3_n31_3 VDD VDD) gpdk090_pmos1v w=0.24u l=0.1u ad=0.0528p as=0.0816p pd=0.68u ps=1.16u
    I_MXI3_I461_MP0 (VDD I3_n31_2 I3_o31_1 VDD) gpdk090_pmos1v w=0.24u l=0.1u ad=0.0816p as=0.0528p pd=1.16u ps=0.68u
    I_MXI3_I457_MP1 (I3_n31_3 NOT_31 VDD VDD) gpdk090_pmos1v w=0.24u l=0.1u ad=0.0528p as=0.0816p pd=0.68u ps=1.16u
    I_MXI3_I457_MP0 (VDD I3_SEL_NOT_b3_5 I3_n31_3 VDD) gpdk090_pmos1v w=0.24u l=0.1u ad=0.0816p as=0.0528p pd=1.16u ps=0.68u
    I_MXI3_I456_MP1 (I3_n31_2 XOR_31 VDD VDD) gpdk090_pmos1v w=0.24u l=0.1u ad=0.0528p as=0.0816p pd=0.68u ps=1.16u
    I_MXI3_I456_MP0 (VDD I3_SEL_XOR_b3_5 I3_n31_2 VDD) gpdk090_pmos1v w=0.24u l=0.1u ad=0.0816p as=0.0528p pd=1.16u ps=0.68u
    I_MXI1_I42_I30_MP1 (I1_I42_gn30 I1_bx30 VDD VDD) gpdk090_pmos1v w=0.24u l=0.1u ad=0.0528p as=0.0816p pd=0.68u ps=1.16u
    I_MXI1_I42_I30_MP0 (VDD A_30 I1_I42_gn30 VDD) gpdk090_pmos1v w=0.24u l=0.1u ad=0.0816p as=0.0528p pd=1.16u ps=0.68u
    I_MXI1_I42_I176_XP_MP1 (I1_I42_P25_10n I1_I42_P17_10 VDD VDD) gpdk090_pmos1v w=0.24u l=0.1u ad=0.0528p as=0.0816p pd=0.68u ps=1.16u
    I_MXI1_I42_I176_XP_MP0 (VDD I1_I42_P25_18 I1_I42_P25_10n VDD) gpdk090_pmos1v w=0.24u l=0.1u ad=0.0816p as=0.0528p pd=1.16u ps=0.68u
    I_MXI1_I42_I172_XP_MP1 (I1_I42_P21_6n I1_I42_P13_6 VDD VDD) gpdk090_pmos1v w=0.24u l=0.1u ad=0.0528p as=0.0816p pd=0.68u ps=1.16u
    I_MXI1_I42_I172_XP_MP0 (VDD I1_I42_P21_14 I1_I42_P21_6n VDD) gpdk090_pmos1v w=0.24u l=0.1u ad=0.0816p as=0.0528p pd=1.16u ps=0.68u
    I_MXI1_I42_I109_XP_MP1 (I1_I42_P13_10n I1_I42_P11_10 VDD VDD) gpdk090_pmos1v w=0.24u l=0.1u ad=0.0528p as=0.0816p pd=0.68u ps=1.16u
    I_MXI1_I42_I109_XP_MP0 (VDD I1_I42_P13_12 I1_I42_P13_10n VDD) gpdk090_pmos1v w=0.24u l=0.1u ad=0.0816p as=0.0528p pd=1.16u ps=0.68u
    I_MXI1_I42_I108_XP_MP1 (I1_I42_P12_9n I1_I42_P10_9 VDD VDD) gpdk090_pmos1v w=0.24u l=0.1u ad=0.0528p as=0.0816p pd=0.68u ps=1.16u
    I_MXI1_I42_I108_XP_MP0 (VDD I1_I42_P12_11 I1_I42_P12_9n VDD) gpdk090_pmos1v w=0.24u l=0.1u ad=0.0816p as=0.0528p pd=1.16u ps=0.68u
    I_MXI1_I42_I167_XP_MP1 (I1_I42_P16_1n I1_I42_P8_1 VDD VDD) gpdk090_pmos1v w=0.24u l=0.1u ad=0.0528p as=0.0816p pd=0.68u ps=1.16u
    I_MXI1_I42_I167_XP_MP0 (VDD I1_I42_P16_9 I1_I42_P16_1n VDD) gpdk090_pmos1v w=0.24u l=0.1u ad=0.0816p as=0.0528p pd=1.16u ps=0.68u
    I_MXI1_I42_I11_MP1 (I1_I42_gn11 I1_bx11 VDD VDD) gpdk090_pmos1v w=0.24u l=0.1u ad=0.0528p as=0.0816p pd=0.68u ps=1.16u
    I_MXI1_I42_I11_MP0 (VDD A_11 I1_I42_gn11 VDD) gpdk090_pmos1v w=0.24u l=0.1u ad=0.0816p as=0.0528p pd=1.16u ps=0.68u
    I_MXI3_I228_MP1 (I3_n12_2 XOR_12 VDD VDD) gpdk090_pmos1v w=0.24u l=0.1u ad=0.0528p as=0.0816p pd=0.68u ps=1.16u
    I_MXI3_I228_MP0 (VDD I3_SEL_XOR_b3_2 I3_n12_2 VDD) gpdk090_pmos1v w=0.24u l=0.1u ad=0.0816p as=0.0528p pd=1.16u ps=0.68u
    I_MXI3_I226_MP1 (I3_n12_0 AND_12 VDD VDD) gpdk090_pmos1v w=0.24u l=0.1u ad=0.0528p as=0.0816p pd=0.68u ps=1.16u
    I_MXI3_I226_MP0 (VDD I3_SEL_AND_b3_2 I3_n12_0 VDD) gpdk090_pmos1v w=0.24u l=0.1u ad=0.0816p as=0.0528p pd=1.16u ps=0.68u
    I_MXI3_I232_MP1 (I3_o12_0 I3_n12_1 VDD VDD) gpdk090_pmos1v w=0.24u l=0.1u ad=0.0528p as=0.0816p pd=0.68u ps=1.16u
    I_MXI3_I232_MP0 (VDD I3_n12_0 I3_o12_0 VDD) gpdk090_pmos1v w=0.24u l=0.1u ad=0.0816p as=0.0528p pd=1.16u ps=0.68u
    I_MXI2_I72_MP1 (I2_nand12 B_12 VDD VDD) gpdk090_pmos1v w=0.24u l=0.1u ad=0.0528p as=0.0816p pd=0.68u ps=1.16u
    I_MXI2_I72_MP0 (VDD A_12 I2_nand12 VDD) gpdk090_pmos1v w=0.24u l=0.1u ad=0.0816p as=0.0528p pd=1.16u ps=0.68u
    I_MXI3_I442_MP1 (I3_n30_0 AND_30 VDD VDD) gpdk090_pmos1v w=0.24u l=0.1u ad=0.0528p as=0.0816p pd=0.68u ps=1.16u
    I_MXI3_I442_MP0 (VDD I3_SEL_AND_b3_5 I3_n30_0 VDD) gpdk090_pmos1v w=0.24u l=0.1u ad=0.0816p as=0.0528p pd=1.16u ps=0.68u
    I_MXI3_I430_MP1 (I3_n29_0 AND_29 VDD VDD) gpdk090_pmos1v w=0.24u l=0.1u ad=0.0528p as=0.0816p pd=0.68u ps=1.16u
    I_MXI3_I430_MP0 (VDD I3_SEL_AND_b3_5 I3_n29_0 VDD) gpdk090_pmos1v w=0.24u l=0.1u ad=0.0816p as=0.0528p pd=1.16u ps=0.68u
    I_MXI3_I448_MP1 (I3_o30_0 I3_n30_1 VDD VDD) gpdk090_pmos1v w=0.24u l=0.1u ad=0.0528p as=0.0816p pd=0.68u ps=1.16u
    I_MXI3_I448_MP0 (VDD I3_n30_0 I3_o30_0 VDD) gpdk090_pmos1v w=0.24u l=0.1u ad=0.0816p as=0.0528p pd=1.16u ps=0.68u
    I_MXI3_I431_MP1 (I3_n29_1 OR_29 VDD VDD) gpdk090_pmos1v w=0.24u l=0.1u ad=0.0528p as=0.0816p pd=0.68u ps=1.16u
    I_MXI3_I431_MP0 (VDD I3_SEL_OR_b3_5 I3_n29_1 VDD) gpdk090_pmos1v w=0.24u l=0.1u ad=0.0816p as=0.0528p pd=1.16u ps=0.68u
    I_MXI3_I454_MP1 (I3_n31_0 AND_31 VDD VDD) gpdk090_pmos1v w=0.24u l=0.1u ad=0.0528p as=0.0816p pd=0.68u ps=1.16u
    I_MXI3_I454_MP0 (VDD I3_SEL_AND_b3_5 I3_n31_0 VDD) gpdk090_pmos1v w=0.24u l=0.1u ad=0.0816p as=0.0528p pd=1.16u ps=0.68u
    I_MXI3_I455_MP1 (I3_n31_1 OR_31 VDD VDD) gpdk090_pmos1v w=0.24u l=0.1u ad=0.0528p as=0.0816p pd=0.68u ps=1.16u
    I_MXI3_I455_MP0 (VDD I3_SEL_OR_b3_5 I3_n31_1 VDD) gpdk090_pmos1v w=0.24u l=0.1u ad=0.0816p as=0.0528p pd=1.16u ps=0.68u
    I_MXI3_I460_MP1 (I3_o31_0 I3_n31_1 VDD VDD) gpdk090_pmos1v w=0.24u l=0.1u ad=0.0528p as=0.0816p pd=0.68u ps=1.16u
    I_MXI3_I460_MP0 (VDD I3_n31_0 I3_o31_0 VDD) gpdk090_pmos1v w=0.24u l=0.1u ad=0.0816p as=0.0528p pd=1.16u ps=0.68u
    I_MXI2_I186_MP1 (I2_nand31 B_31 VDD VDD) gpdk090_pmos1v w=0.24u l=0.1u ad=0.0528p as=0.0816p pd=0.68u ps=1.16u
    I_MXI2_I186_MP0 (VDD A_31 I2_nand31 VDD) gpdk090_pmos1v w=0.24u l=0.1u ad=0.0816p as=0.0528p pd=1.16u ps=0.68u
    I_MXI1_I42_I31_MP1 (I1_I42_gn31 I1_bx31 VDD VDD) gpdk090_pmos1v w=0.24u l=0.1u ad=0.0528p as=0.0816p pd=0.68u ps=1.16u
    I_MXI1_I42_I31_MP0 (VDD A_31 I1_I42_gn31 VDD) gpdk090_pmos1v w=0.24u l=0.1u ad=0.0816p as=0.0528p pd=1.16u ps=0.68u
    I_MXI1_I42_I180_XP_MP1 (I1_I42_P29_14n I1_I42_P21_14 VDD VDD) gpdk090_pmos1v w=0.24u l=0.1u ad=0.0528p as=0.0816p pd=0.68u ps=1.16u
    I_MXI1_I42_I180_XP_MP0 (VDD I1_I42_P29_22 I1_I42_P29_14n VDD) gpdk090_pmos1v w=0.24u l=0.1u ad=0.0816p as=0.0528p pd=1.16u ps=0.68u
    I_MXI1_I42_I111_XP_MP1 (I1_I42_P15_12n I1_I42_P13_12 VDD VDD) gpdk090_pmos1v w=0.24u l=0.1u ad=0.0528p as=0.0816p pd=0.68u ps=1.16u
    I_MXI1_I42_I111_XP_MP0 (VDD I1_I42_P15_14 I1_I42_P15_12n VDD) gpdk090_pmos1v w=0.24u l=0.1u ad=0.0816p as=0.0528p pd=1.16u ps=0.68u
    I_MXI1_I42_I170_XP_MP1 (I1_I42_P19_4n I1_I42_P11_4 VDD VDD) gpdk090_pmos1v w=0.24u l=0.1u ad=0.0528p as=0.0816p pd=0.68u ps=1.16u
    I_MXI1_I42_I170_XP_MP0 (VDD I1_I42_P19_12 I1_I42_P19_4n VDD) gpdk090_pmos1v w=0.24u l=0.1u ad=0.0816p as=0.0528p pd=1.16u ps=0.68u
    I_MXI1_I42_I175_XP_MP1 (I1_I42_P24_9n I1_I42_P16_9 VDD VDD) gpdk090_pmos1v w=0.24u l=0.1u ad=0.0528p as=0.0816p pd=0.68u ps=1.16u
    I_MXI1_I42_I175_XP_MP0 (VDD I1_I42_P24_17 I1_I42_P24_9n VDD) gpdk090_pmos1v w=0.24u l=0.1u ad=0.0816p as=0.0528p pd=1.16u ps=0.68u
    I_MXI1_I42_I13_MP1 (I1_I42_gn13 I1_bx13 VDD VDD) gpdk090_pmos1v w=0.24u l=0.1u ad=0.0528p as=0.0816p pd=0.68u ps=1.16u
    I_MXI1_I42_I13_MP0 (VDD A_13 I1_I42_gn13 VDD) gpdk090_pmos1v w=0.24u l=0.1u ad=0.0816p as=0.0528p pd=1.16u ps=0.68u
    I_MXI1_I42_I12_MP1 (I1_I42_gn12 I1_bx12 VDD VDD) gpdk090_pmos1v w=0.24u l=0.1u ad=0.0528p as=0.0816p pd=0.68u ps=1.16u
    I_MXI1_I42_I12_MP0 (VDD A_12 I1_I42_gn12 VDD) gpdk090_pmos1v w=0.24u l=0.1u ad=0.0816p as=0.0528p pd=1.16u ps=0.68u
    I_MXI3_I241_MP1 (I3_n13_3 NOT_13 VDD VDD) gpdk090_pmos1v w=0.24u l=0.1u ad=0.0528p as=0.0816p pd=0.68u ps=1.16u
    I_MXI3_I241_MP0 (VDD I3_SEL_NOT_b3_2 I3_n13_3 VDD) gpdk090_pmos1v w=0.24u l=0.1u ad=0.0816p as=0.0528p pd=1.16u ps=0.68u
    I_MXI3_I229_MP1 (I3_n12_3 NOT_12 VDD VDD) gpdk090_pmos1v w=0.24u l=0.1u ad=0.0528p as=0.0816p pd=0.68u ps=1.16u
    I_MXI3_I229_MP0 (VDD I3_SEL_NOT_b3_2 I3_n12_3 VDD) gpdk090_pmos1v w=0.24u l=0.1u ad=0.0816p as=0.0528p pd=1.16u ps=0.68u
    I_MXI3_I233_MP1 (I3_o12_1 I3_n12_3 VDD VDD) gpdk090_pmos1v w=0.24u l=0.1u ad=0.0528p as=0.0816p pd=0.68u ps=1.16u
    I_MXI3_I233_MP0 (VDD I3_n12_2 I3_o12_1 VDD) gpdk090_pmos1v w=0.24u l=0.1u ad=0.0816p as=0.0528p pd=1.16u ps=0.68u
    I_MXI3_I239_MP1 (I3_n13_1 OR_13 VDD VDD) gpdk090_pmos1v w=0.24u l=0.1u ad=0.0528p as=0.0816p pd=0.68u ps=1.16u
    I_MXI3_I239_MP0 (VDD I3_SEL_OR_b3_2 I3_n13_1 VDD) gpdk090_pmos1v w=0.24u l=0.1u ad=0.0816p as=0.0528p pd=1.16u ps=0.68u
    I_MXI3_I237_MP1 (Y_12 I3_q12_2 VDD VDD) gpdk090_pmos1v w=0.24u l=0.1u ad=0.0528p as=0.0816p pd=0.68u ps=1.16u
    I_MXI3_I237_MP0 (VDD I3_q12_1 Y_12 VDD) gpdk090_pmos1v w=0.24u l=0.1u ad=0.0816p as=0.0528p pd=1.16u ps=0.68u
    I_MXI4_I35_MP1 (I4_z1_3 I4_z0_7 VDD VDD) gpdk090_pmos1v w=0.24u l=0.1u ad=0.0528p as=0.0816p pd=0.68u ps=1.16u
    I_MXI4_I35_MP0 (VDD I4_z0_6 I4_z1_3 VDD) gpdk090_pmos1v w=0.24u l=0.1u ad=0.0816p as=0.0528p pd=1.16u ps=0.68u
    I_MXI3_I435_MP1 (I3_n29_5 DIVQ_29 VDD VDD) gpdk090_pmos1v w=0.24u l=0.1u ad=0.0528p as=0.0816p pd=0.68u ps=1.16u
    I_MXI3_I435_MP0 (VDD I3_SEL_DIV_b3_4 I3_n29_5 VDD) gpdk090_pmos1v w=0.24u l=0.1u ad=0.0816p as=0.0528p pd=1.16u ps=0.68u
    I_MXI3_I434_MP1 (I3_n29_4 MULP_29 VDD VDD) gpdk090_pmos1v w=0.24u l=0.1u ad=0.0528p as=0.0816p pd=0.68u ps=1.16u
    I_MXI3_I434_MP0 (VDD I3_SEL_MUL_b3_4 I3_n29_4 VDD) gpdk090_pmos1v w=0.24u l=0.1u ad=0.0816p as=0.0528p pd=1.16u ps=0.68u
    I_MXI3_I438_MP1 (I3_o29_2 I3_n29_5 VDD VDD) gpdk090_pmos1v w=0.24u l=0.1u ad=0.0528p as=0.0816p pd=0.68u ps=1.16u
    I_MXI3_I438_MP0 (VDD I3_n29_4 I3_o29_2 VDD) gpdk090_pmos1v w=0.24u l=0.1u ad=0.0816p as=0.0528p pd=1.16u ps=0.68u
    I_MXI3_I436_MP1 (I3_o29_0 I3_n29_1 VDD VDD) gpdk090_pmos1v w=0.24u l=0.1u ad=0.0528p as=0.0816p pd=0.68u ps=1.16u
    I_MXI3_I436_MP0 (VDD I3_n29_0 I3_o29_0 VDD) gpdk090_pmos1v w=0.24u l=0.1u ad=0.0816p as=0.0528p pd=1.16u ps=0.68u
    I_MXI4_I39_MP1 (I4_z1_7 I4_z0_15 VDD VDD) gpdk090_pmos1v w=0.24u l=0.1u ad=0.0528p as=0.0816p pd=0.68u ps=1.16u
    I_MXI4_I39_MP0 (VDD I4_z0_14 I4_z1_7 VDD) gpdk090_pmos1v w=0.24u l=0.1u ad=0.0816p as=0.0528p pd=1.16u ps=0.68u
    I_MXI2_I174_MP1 (I2_nand29 B_29 VDD VDD) gpdk090_pmos1v w=0.24u l=0.1u ad=0.0528p as=0.0816p pd=0.68u ps=1.16u
    I_MXI2_I174_MP0 (VDD A_29 I2_nand29 VDD) gpdk090_pmos1v w=0.24u l=0.1u ad=0.0816p as=0.0528p pd=1.16u ps=0.68u
    I_MXI3_I441_MP1 (Y_29 I3_q29_2 VDD VDD) gpdk090_pmos1v w=0.24u l=0.1u ad=0.0528p as=0.0816p pd=0.68u ps=1.16u
    I_MXI3_I441_MP0 (VDD I3_q29_1 Y_29 VDD) gpdk090_pmos1v w=0.24u l=0.1u ad=0.0816p as=0.0528p pd=1.16u ps=0.68u
    I_MXI3_I437_MP1 (I3_o29_1 I3_n29_3 VDD VDD) gpdk090_pmos1v w=0.24u l=0.1u ad=0.0528p as=0.0816p pd=0.68u ps=1.16u
    I_MXI3_I437_MP0 (VDD I3_n29_2 I3_o29_1 VDD) gpdk090_pmos1v w=0.24u l=0.1u ad=0.0816p as=0.0528p pd=1.16u ps=0.68u
    I_MXI3_I433_MP1 (I3_n29_3 NOT_29 VDD VDD) gpdk090_pmos1v w=0.24u l=0.1u ad=0.0528p as=0.0816p pd=0.68u ps=1.16u
    I_MXI3_I433_MP0 (VDD I3_SEL_NOT_b3_5 I3_n29_3 VDD) gpdk090_pmos1v w=0.24u l=0.1u ad=0.0816p as=0.0528p pd=1.16u ps=0.68u
    I_MXI3_I432_MP1 (I3_n29_2 XOR_29 VDD VDD) gpdk090_pmos1v w=0.24u l=0.1u ad=0.0528p as=0.0816p pd=0.68u ps=1.16u
    I_MXI3_I432_MP0 (VDD I3_SEL_XOR_b3_5 I3_n29_2 VDD) gpdk090_pmos1v w=0.24u l=0.1u ad=0.0816p as=0.0528p pd=1.16u ps=0.68u
    I_MXI1_I42_I29_MP1 (I1_I42_gn29 I1_bx29 VDD VDD) gpdk090_pmos1v w=0.24u l=0.1u ad=0.0528p as=0.0816p pd=0.68u ps=1.16u
    I_MXI1_I42_I29_MP0 (VDD A_29 I1_I42_gn29 VDD) gpdk090_pmos1v w=0.24u l=0.1u ad=0.0816p as=0.0528p pd=1.16u ps=0.68u
    I_MXI1_I42_I127_XP_MP1 (I1_I42_P31_28n I1_I42_P29_28 VDD VDD) gpdk090_pmos1v w=0.24u l=0.1u ad=0.0528p as=0.0816p pd=0.68u ps=1.16u
    I_MXI1_I42_I127_XP_MP0 (VDD I1_I42_P31_30 I1_I42_P31_28n VDD) gpdk090_pmos1v w=0.24u l=0.1u ad=0.0816p as=0.0528p pd=1.16u ps=0.68u
    I_MXI1_I42_I182_XP_MP1 (I1_I42_P31_16n I1_I42_P23_16 VDD VDD) gpdk090_pmos1v w=0.24u l=0.1u ad=0.0528p as=0.0816p pd=0.68u ps=1.16u
    I_MXI1_I42_I182_XP_MP0 (VDD I1_I42_P31_24 I1_I42_P31_16n VDD) gpdk090_pmos1v w=0.24u l=0.1u ad=0.0816p as=0.0528p pd=1.16u ps=0.68u
    I_MXI1_I42_I174_XP_MP1 (I1_I42_P23_8n I1_I42_P15_8 VDD VDD) gpdk090_pmos1v w=0.24u l=0.1u ad=0.0528p as=0.0816p pd=0.68u ps=1.16u
    I_MXI1_I42_I174_XP_MP0 (VDD I1_I42_P23_16 I1_I42_P23_8n VDD) gpdk090_pmos1v w=0.24u l=0.1u ad=0.0816p as=0.0528p pd=1.16u ps=0.68u
    I_MXI1_I42_I178_XP_MP1 (I1_I42_P27_12n I1_I42_P19_12 VDD VDD) gpdk090_pmos1v w=0.24u l=0.1u ad=0.0528p as=0.0816p pd=0.68u ps=1.16u
    I_MXI1_I42_I178_XP_MP0 (VDD I1_I42_P27_20 I1_I42_P27_12n VDD) gpdk090_pmos1v w=0.24u l=0.1u ad=0.0816p as=0.0528p pd=1.16u ps=0.68u
    I_MXI1_I42_I113_XP_MP1 (I1_I42_P17_14n I1_I42_P15_14 VDD VDD) gpdk090_pmos1v w=0.24u l=0.1u ad=0.0528p as=0.0816p pd=0.68u ps=1.16u
    I_MXI1_I42_I113_XP_MP0 (VDD I1_I42_P17_16 I1_I42_P17_14n VDD) gpdk090_pmos1v w=0.24u l=0.1u ad=0.0816p as=0.0528p pd=1.16u ps=0.68u
    I_MXI1_I42_I169_XP_MP1 (I1_I42_P18_3n I1_I42_P10_3 VDD VDD) gpdk090_pmos1v w=0.24u l=0.1u ad=0.0528p as=0.0816p pd=0.68u ps=1.16u
    I_MXI1_I42_I169_XP_MP0 (VDD I1_I42_P18_11 I1_I42_P18_3n VDD) gpdk090_pmos1v w=0.24u l=0.1u ad=0.0816p as=0.0528p pd=1.16u ps=0.68u
    I_MXI3_I240_MP1 (I3_n13_2 XOR_13 VDD VDD) gpdk090_pmos1v w=0.24u l=0.1u ad=0.0528p as=0.0816p pd=0.68u ps=1.16u
    I_MXI3_I240_MP0 (VDD I3_SEL_XOR_b3_2 I3_n13_2 VDD) gpdk090_pmos1v w=0.24u l=0.1u ad=0.0816p as=0.0528p pd=1.16u ps=0.68u
    I_MXI3_I245_MP1 (I3_o13_1 I3_n13_3 VDD VDD) gpdk090_pmos1v w=0.24u l=0.1u ad=0.0528p as=0.0816p pd=0.68u ps=1.16u
    I_MXI3_I245_MP0 (VDD I3_n13_2 I3_o13_1 VDD) gpdk090_pmos1v w=0.24u l=0.1u ad=0.0816p as=0.0528p pd=1.16u ps=0.68u
    I_MXI2_I78_MP1 (I2_nand13 B_13 VDD VDD) gpdk090_pmos1v w=0.24u l=0.1u ad=0.0528p as=0.0816p pd=0.68u ps=1.16u
    I_MXI2_I78_MP0 (VDD A_13 I2_nand13 VDD) gpdk090_pmos1v w=0.24u l=0.1u ad=0.0816p as=0.0528p pd=1.16u ps=0.68u
    I_MXI3_I249_MP1 (Y_13 I3_q13_2 VDD VDD) gpdk090_pmos1v w=0.24u l=0.1u ad=0.0528p as=0.0816p pd=0.68u ps=1.16u
    I_MXI3_I249_MP0 (VDD I3_q13_1 Y_13 VDD) gpdk090_pmos1v w=0.24u l=0.1u ad=0.0816p as=0.0528p pd=1.16u ps=0.68u
    I_MXI3_I244_MP1 (I3_o13_0 I3_n13_1 VDD VDD) gpdk090_pmos1v w=0.24u l=0.1u ad=0.0528p as=0.0816p pd=0.68u ps=1.16u
    I_MXI3_I244_MP0 (VDD I3_n13_0 I3_o13_0 VDD) gpdk090_pmos1v w=0.24u l=0.1u ad=0.0816p as=0.0528p pd=1.16u ps=0.68u
    I_MXI3_I246_MP1 (I3_o13_2 I3_n13_5 VDD VDD) gpdk090_pmos1v w=0.24u l=0.1u ad=0.0528p as=0.0816p pd=0.68u ps=1.16u
    I_MXI3_I246_MP0 (VDD I3_n13_4 I3_o13_2 VDD) gpdk090_pmos1v w=0.24u l=0.1u ad=0.0816p as=0.0528p pd=1.16u ps=0.68u
    I_MXI3_I234_MP1 (I3_o12_2 I3_n12_5 VDD VDD) gpdk090_pmos1v w=0.24u l=0.1u ad=0.0528p as=0.0816p pd=0.68u ps=1.16u
    I_MXI3_I234_MP0 (VDD I3_n12_4 I3_o12_2 VDD) gpdk090_pmos1v w=0.24u l=0.1u ad=0.0816p as=0.0528p pd=1.16u ps=0.68u
    I_MXI3_I238_MP1 (I3_n13_0 AND_13 VDD VDD) gpdk090_pmos1v w=0.24u l=0.1u ad=0.0528p as=0.0816p pd=0.68u ps=1.16u
    I_MXI3_I238_MP0 (VDD I3_SEL_AND_b3_2 I3_n13_0 VDD) gpdk090_pmos1v w=0.24u l=0.1u ad=0.0816p as=0.0528p pd=1.16u ps=0.68u
    I_MXI3_I231_MP1 (I3_n12_5 DIVQ_12 VDD VDD) gpdk090_pmos1v w=0.24u l=0.1u ad=0.0528p as=0.0816p pd=0.68u ps=1.16u
    I_MXI3_I231_MP0 (VDD I3_SEL_DIV_b3_2 I3_n12_5 VDD) gpdk090_pmos1v w=0.24u l=0.1u ad=0.0816p as=0.0528p pd=1.16u ps=0.68u
    I_MXI3_I230_MP1 (I3_n12_4 MULP_12 VDD VDD) gpdk090_pmos1v w=0.24u l=0.1u ad=0.0528p as=0.0816p pd=0.68u ps=1.16u
    I_MXI3_I230_MP0 (VDD I3_SEL_MUL_b3_2 I3_n12_4 VDD) gpdk090_pmos1v w=0.24u l=0.1u ad=0.0816p as=0.0528p pd=1.16u ps=0.68u
    I_MXI3_I423_MP1 (I3_n28_5 DIVQ_28 VDD VDD) gpdk090_pmos1v w=0.24u l=0.1u ad=0.0528p as=0.0816p pd=0.68u ps=1.16u
    I_MXI3_I423_MP0 (VDD I3_SEL_DIV_b3_4 I3_n28_5 VDD) gpdk090_pmos1v w=0.24u l=0.1u ad=0.0816p as=0.0528p pd=1.16u ps=0.68u
    I_MXI3_I422_MP1 (I3_n28_4 MULP_28 VDD VDD) gpdk090_pmos1v w=0.24u l=0.1u ad=0.0528p as=0.0816p pd=0.68u ps=1.16u
    I_MXI3_I422_MP0 (VDD I3_SEL_MUL_b3_4 I3_n28_4 VDD) gpdk090_pmos1v w=0.24u l=0.1u ad=0.0816p as=0.0528p pd=1.16u ps=0.68u
    I_MXI3_I418_MP1 (I3_n28_0 AND_28 VDD VDD) gpdk090_pmos1v w=0.24u l=0.1u ad=0.0528p as=0.0816p pd=0.68u ps=1.16u
    I_MXI3_I418_MP0 (VDD I3_SEL_AND_b3_5 I3_n28_0 VDD) gpdk090_pmos1v w=0.24u l=0.1u ad=0.0816p as=0.0528p pd=1.16u ps=0.68u
    I_MXI3_I426_MP1 (I3_o28_2 I3_n28_5 VDD VDD) gpdk090_pmos1v w=0.24u l=0.1u ad=0.0528p as=0.0816p pd=0.68u ps=1.16u
    I_MXI3_I426_MP0 (VDD I3_n28_4 I3_o28_2 VDD) gpdk090_pmos1v w=0.24u l=0.1u ad=0.0816p as=0.0528p pd=1.16u ps=0.68u
    I_MXI3_I419_MP1 (I3_n28_1 OR_28 VDD VDD) gpdk090_pmos1v w=0.24u l=0.1u ad=0.0528p as=0.0816p pd=0.68u ps=1.16u
    I_MXI3_I419_MP0 (VDD I3_SEL_OR_b3_5 I3_n28_1 VDD) gpdk090_pmos1v w=0.24u l=0.1u ad=0.0816p as=0.0528p pd=1.16u ps=0.68u
    I_MXI3_I429_MP1 (Y_28 I3_q28_2 VDD VDD) gpdk090_pmos1v w=0.24u l=0.1u ad=0.0528p as=0.0816p pd=0.68u ps=1.16u
    I_MXI3_I429_MP0 (VDD I3_q28_1 Y_28 VDD) gpdk090_pmos1v w=0.24u l=0.1u ad=0.0816p as=0.0528p pd=1.16u ps=0.68u
    I_MXI3_I424_MP1 (I3_o28_0 I3_n28_1 VDD VDD) gpdk090_pmos1v w=0.24u l=0.1u ad=0.0528p as=0.0816p pd=0.68u ps=1.16u
    I_MXI3_I424_MP0 (VDD I3_n28_0 I3_o28_0 VDD) gpdk090_pmos1v w=0.24u l=0.1u ad=0.0816p as=0.0528p pd=1.16u ps=0.68u
    I_MXI3_I407_MP1 (I3_n27_1 OR_27 VDD VDD) gpdk090_pmos1v w=0.24u l=0.1u ad=0.0528p as=0.0816p pd=0.68u ps=1.16u
    I_MXI3_I407_MP0 (VDD I3_SEL_OR_b3_5 I3_n27_1 VDD) gpdk090_pmos1v w=0.24u l=0.1u ad=0.0816p as=0.0528p pd=1.16u ps=0.68u
    I_MXI3_I421_MP1 (I3_n28_3 NOT_28 VDD VDD) gpdk090_pmos1v w=0.24u l=0.1u ad=0.0528p as=0.0816p pd=0.68u ps=1.16u
    I_MXI3_I421_MP0 (VDD I3_SEL_NOT_b3_5 I3_n28_3 VDD) gpdk090_pmos1v w=0.24u l=0.1u ad=0.0816p as=0.0528p pd=1.16u ps=0.68u
    I_MXI3_I425_MP1 (I3_o28_1 I3_n28_3 VDD VDD) gpdk090_pmos1v w=0.24u l=0.1u ad=0.0528p as=0.0816p pd=0.68u ps=1.16u
    I_MXI3_I425_MP0 (VDD I3_n28_2 I3_o28_1 VDD) gpdk090_pmos1v w=0.24u l=0.1u ad=0.0816p as=0.0528p pd=1.16u ps=0.68u
    I_MXI3_I420_MP1 (I3_n28_2 XOR_28 VDD VDD) gpdk090_pmos1v w=0.24u l=0.1u ad=0.0528p as=0.0816p pd=0.68u ps=1.16u
    I_MXI3_I420_MP0 (VDD I3_SEL_XOR_b3_5 I3_n28_2 VDD) gpdk090_pmos1v w=0.24u l=0.1u ad=0.0816p as=0.0528p pd=1.16u ps=0.68u
    I_MXI1_I42_I28_MP1 (I1_I42_gn28 I1_bx28 VDD VDD) gpdk090_pmos1v w=0.24u l=0.1u ad=0.0528p as=0.0816p pd=0.68u ps=1.16u
    I_MXI1_I42_I28_MP0 (VDD A_28 I1_I42_gn28 VDD) gpdk090_pmos1v w=0.24u l=0.1u ad=0.0816p as=0.0528p pd=1.16u ps=0.68u
    I_MXI1_I42_I125_XP_MP1 (I1_I42_P29_26n I1_I42_P27_26 VDD VDD) gpdk090_pmos1v w=0.24u l=0.1u ad=0.0528p as=0.0816p pd=0.68u ps=1.16u
    I_MXI1_I42_I125_XP_MP0 (VDD I1_I42_P29_28 I1_I42_P29_26n VDD) gpdk090_pmos1v w=0.24u l=0.1u ad=0.0816p as=0.0528p pd=1.16u ps=0.68u
    I_MXI1_I42_I123_XP_MP1 (I1_I42_P27_24n I1_I42_P25_24 VDD VDD) gpdk090_pmos1v w=0.24u l=0.1u ad=0.0528p as=0.0816p pd=0.68u ps=1.16u
    I_MXI1_I42_I123_XP_MP0 (VDD I1_I42_P27_26 I1_I42_P27_24n VDD) gpdk090_pmos1v w=0.24u l=0.1u ad=0.0816p as=0.0528p pd=1.16u ps=0.68u
    I_MXI1_I42_I121_XP_MP1 (I1_I42_P25_22n I1_I42_P23_22 VDD VDD) gpdk090_pmos1v w=0.24u l=0.1u ad=0.0528p as=0.0816p pd=0.68u ps=1.16u
    I_MXI1_I42_I121_XP_MP0 (VDD I1_I42_P25_24 I1_I42_P25_22n VDD) gpdk090_pmos1v w=0.24u l=0.1u ad=0.0816p as=0.0528p pd=1.16u ps=0.68u
    I_MXI1_I42_I119_XP_MP1 (I1_I42_P23_20n I1_I42_P21_20 VDD VDD) gpdk090_pmos1v w=0.24u l=0.1u ad=0.0528p as=0.0816p pd=0.68u ps=1.16u
    I_MXI1_I42_I119_XP_MP0 (VDD I1_I42_P23_22 I1_I42_P23_20n VDD) gpdk090_pmos1v w=0.24u l=0.1u ad=0.0816p as=0.0528p pd=1.16u ps=0.68u
    I_MXI1_I42_I117_XP_MP1 (I1_I42_P21_18n I1_I42_P19_18 VDD VDD) gpdk090_pmos1v w=0.24u l=0.1u ad=0.0528p as=0.0816p pd=0.68u ps=1.16u
    I_MXI1_I42_I117_XP_MP0 (VDD I1_I42_P21_20 I1_I42_P21_18n VDD) gpdk090_pmos1v w=0.24u l=0.1u ad=0.0816p as=0.0528p pd=1.16u ps=0.68u
    I_MXI1_I42_I115_XP_MP1 (I1_I42_P19_16n I1_I42_P17_16 VDD VDD) gpdk090_pmos1v w=0.24u l=0.1u ad=0.0528p as=0.0816p pd=0.68u ps=1.16u
    I_MXI1_I42_I115_XP_MP0 (VDD I1_I42_P19_18 I1_I42_P19_16n VDD) gpdk090_pmos1v w=0.24u l=0.1u ad=0.0816p as=0.0528p pd=1.16u ps=0.68u
    I_MXI1_I42_I179_XP_MP1 (I1_I42_P28_13n I1_I42_P20_13 VDD VDD) gpdk090_pmos1v w=0.24u l=0.1u ad=0.0528p as=0.0816p pd=0.68u ps=1.16u
    I_MXI1_I42_I179_XP_MP0 (VDD I1_I42_P28_21 I1_I42_P28_13n VDD) gpdk090_pmos1v w=0.24u l=0.1u ad=0.0816p as=0.0528p pd=1.16u ps=0.68u
    I_MXI1_I42_I171_XP_MP1 (I1_I42_P20_5n I1_I42_P12_5 VDD VDD) gpdk090_pmos1v w=0.24u l=0.1u ad=0.0528p as=0.0816p pd=0.68u ps=1.16u
    I_MXI1_I42_I171_XP_MP0 (VDD I1_I42_P20_13 I1_I42_P20_5n VDD) gpdk090_pmos1v w=0.24u l=0.1u ad=0.0816p as=0.0528p pd=1.16u ps=0.68u
    I_MXI1_I42_I110_XP_MP1 (I1_I42_P14_11n I1_I42_P12_11 VDD VDD) gpdk090_pmos1v w=0.24u l=0.1u ad=0.0528p as=0.0816p pd=0.68u ps=1.16u
    I_MXI1_I42_I110_XP_MP0 (VDD I1_I42_P14_13 I1_I42_P14_11n VDD) gpdk090_pmos1v w=0.24u l=0.1u ad=0.0816p as=0.0528p pd=1.16u ps=0.68u
    I_MXI1_I42_I112_XP_MP1 (I1_I42_P16_13n I1_I42_P14_13 VDD VDD) gpdk090_pmos1v w=0.24u l=0.1u ad=0.0528p as=0.0816p pd=0.68u ps=1.16u
    I_MXI1_I42_I112_XP_MP0 (VDD I1_I42_P16_15 I1_I42_P16_13n VDD) gpdk090_pmos1v w=0.24u l=0.1u ad=0.0816p as=0.0528p pd=1.16u ps=0.68u
    I_MXI3_I252_MP1 (I3_n14_2 XOR_14 VDD VDD) gpdk090_pmos1v w=0.24u l=0.1u ad=0.0528p as=0.0816p pd=0.68u ps=1.16u
    I_MXI3_I252_MP0 (VDD I3_SEL_XOR_b3_2 I3_n14_2 VDD) gpdk090_pmos1v w=0.24u l=0.1u ad=0.0816p as=0.0528p pd=1.16u ps=0.68u
    I_MXI3_I253_MP1 (I3_n14_3 NOT_14 VDD VDD) gpdk090_pmos1v w=0.24u l=0.1u ad=0.0528p as=0.0816p pd=0.68u ps=1.16u
    I_MXI3_I253_MP0 (VDD I3_SEL_NOT_b3_2 I3_n14_3 VDD) gpdk090_pmos1v w=0.24u l=0.1u ad=0.0816p as=0.0528p pd=1.16u ps=0.68u
    I_MXI3_I257_MP1 (I3_o14_1 I3_n14_3 VDD VDD) gpdk090_pmos1v w=0.24u l=0.1u ad=0.0528p as=0.0816p pd=0.68u ps=1.16u
    I_MXI3_I257_MP0 (VDD I3_n14_2 I3_o14_1 VDD) gpdk090_pmos1v w=0.24u l=0.1u ad=0.0816p as=0.0528p pd=1.16u ps=0.68u
    I_MXI2_I84_MP1 (I2_nand14 B_14 VDD VDD) gpdk090_pmos1v w=0.24u l=0.1u ad=0.0528p as=0.0816p pd=0.68u ps=1.16u
    I_MXI2_I84_MP0 (VDD A_14 I2_nand14 VDD) gpdk090_pmos1v w=0.24u l=0.1u ad=0.0816p as=0.0528p pd=1.16u ps=0.68u
    I_MXI3_I261_MP1 (Y_14 I3_q14_2 VDD VDD) gpdk090_pmos1v w=0.24u l=0.1u ad=0.0528p as=0.0816p pd=0.68u ps=1.16u
    I_MXI3_I261_MP0 (VDD I3_q14_1 Y_14 VDD) gpdk090_pmos1v w=0.24u l=0.1u ad=0.0816p as=0.0528p pd=1.16u ps=0.68u
    I_MXI3_I256_MP1 (I3_o14_0 I3_n14_1 VDD VDD) gpdk090_pmos1v w=0.24u l=0.1u ad=0.0528p as=0.0816p pd=0.68u ps=1.16u
    I_MXI3_I256_MP0 (VDD I3_n14_0 I3_o14_0 VDD) gpdk090_pmos1v w=0.24u l=0.1u ad=0.0816p as=0.0528p pd=1.16u ps=0.68u
    I_MXI3_I243_MP1 (I3_n13_5 DIVQ_13 VDD VDD) gpdk090_pmos1v w=0.24u l=0.1u ad=0.0528p as=0.0816p pd=0.68u ps=1.16u
    I_MXI3_I243_MP0 (VDD I3_SEL_DIV_b3_2 I3_n13_5 VDD) gpdk090_pmos1v w=0.24u l=0.1u ad=0.0816p as=0.0528p pd=1.16u ps=0.68u
    I_MXI3_I250_MP1 (I3_n14_0 AND_14 VDD VDD) gpdk090_pmos1v w=0.24u l=0.1u ad=0.0528p as=0.0816p pd=0.68u ps=1.16u
    I_MXI3_I250_MP0 (VDD I3_SEL_AND_b3_2 I3_n14_0 VDD) gpdk090_pmos1v w=0.24u l=0.1u ad=0.0816p as=0.0528p pd=1.16u ps=0.68u
    I_MXI3_I242_MP1 (I3_n13_4 MULP_13 VDD VDD) gpdk090_pmos1v w=0.24u l=0.1u ad=0.0528p as=0.0816p pd=0.68u ps=1.16u
    I_MXI3_I242_MP0 (VDD I3_SEL_MUL_b3_2 I3_n13_4 VDD) gpdk090_pmos1v w=0.24u l=0.1u ad=0.0816p as=0.0528p pd=1.16u ps=0.68u
    I_MXI2_I168_MP1 (I2_nand28 B_28 VDD VDD) gpdk090_pmos1v w=0.24u l=0.1u ad=0.0528p as=0.0816p pd=0.68u ps=1.16u
    I_MXI2_I168_MP0 (VDD A_28 I2_nand28 VDD) gpdk090_pmos1v w=0.24u l=0.1u ad=0.0816p as=0.0528p pd=1.16u ps=0.68u
    I_MXI3_I411_MP1 (I3_n27_5 DIVQ_27 VDD VDD) gpdk090_pmos1v w=0.24u l=0.1u ad=0.0528p as=0.0816p pd=0.68u ps=1.16u
    I_MXI3_I411_MP0 (VDD I3_SEL_DIV_b3_4 I3_n27_5 VDD) gpdk090_pmos1v w=0.24u l=0.1u ad=0.0816p as=0.0528p pd=1.16u ps=0.68u
    I_MXI3_I410_MP1 (I3_n27_4 MULP_27 VDD VDD) gpdk090_pmos1v w=0.24u l=0.1u ad=0.0528p as=0.0816p pd=0.68u ps=1.16u
    I_MXI3_I410_MP0 (VDD I3_SEL_MUL_b3_4 I3_n27_4 VDD) gpdk090_pmos1v w=0.24u l=0.1u ad=0.0816p as=0.0528p pd=1.16u ps=0.68u
    I_MXI3_I414_MP1 (I3_o27_2 I3_n27_5 VDD VDD) gpdk090_pmos1v w=0.24u l=0.1u ad=0.0528p as=0.0816p pd=0.68u ps=1.16u
    I_MXI3_I414_MP0 (VDD I3_n27_4 I3_o27_2 VDD) gpdk090_pmos1v w=0.24u l=0.1u ad=0.0816p as=0.0528p pd=1.16u ps=0.68u
    I_MXI3_I417_MP1 (Y_27 I3_q27_2 VDD VDD) gpdk090_pmos1v w=0.24u l=0.1u ad=0.0528p as=0.0816p pd=0.68u ps=1.16u
    I_MXI3_I417_MP0 (VDD I3_q27_1 Y_27 VDD) gpdk090_pmos1v w=0.24u l=0.1u ad=0.0816p as=0.0528p pd=1.16u ps=0.68u
    I_MXI3_I412_MP1 (I3_o27_0 I3_n27_1 VDD VDD) gpdk090_pmos1v w=0.24u l=0.1u ad=0.0528p as=0.0816p pd=0.68u ps=1.16u
    I_MXI3_I412_MP0 (VDD I3_n27_0 I3_o27_0 VDD) gpdk090_pmos1v w=0.24u l=0.1u ad=0.0816p as=0.0528p pd=1.16u ps=0.68u
    I_MXI3_I406_MP1 (I3_n27_0 AND_27 VDD VDD) gpdk090_pmos1v w=0.24u l=0.1u ad=0.0528p as=0.0816p pd=0.68u ps=1.16u
    I_MXI3_I406_MP0 (VDD I3_SEL_AND_b3_5 I3_n27_0 VDD) gpdk090_pmos1v w=0.24u l=0.1u ad=0.0816p as=0.0528p pd=1.16u ps=0.68u
    I_MXI3_I413_MP1 (I3_o27_1 I3_n27_3 VDD VDD) gpdk090_pmos1v w=0.24u l=0.1u ad=0.0528p as=0.0816p pd=0.68u ps=1.16u
    I_MXI3_I413_MP0 (VDD I3_n27_2 I3_o27_1 VDD) gpdk090_pmos1v w=0.24u l=0.1u ad=0.0816p as=0.0528p pd=1.16u ps=0.68u
    I_MXI3_I409_MP1 (I3_n27_3 NOT_27 VDD VDD) gpdk090_pmos1v w=0.24u l=0.1u ad=0.0528p as=0.0816p pd=0.68u ps=1.16u
    I_MXI3_I409_MP0 (VDD I3_SEL_NOT_b3_5 I3_n27_3 VDD) gpdk090_pmos1v w=0.24u l=0.1u ad=0.0816p as=0.0528p pd=1.16u ps=0.68u
    I_MXI4_I57_MP1 (I4_z3_1 I4_z2_3 VDD VDD) gpdk090_pmos1v w=0.24u l=0.1u ad=0.0528p as=0.0816p pd=0.68u ps=1.16u
    I_MXI4_I57_MP0 (VDD I4_z2_2 I4_z3_1 VDD) gpdk090_pmos1v w=0.24u l=0.1u ad=0.0816p as=0.0528p pd=1.16u ps=0.68u
    I_MXI1_I42_I126_XP_MP1 (I1_I42_P30_27n I1_I42_P28_27 VDD VDD) gpdk090_pmos1v w=0.24u l=0.1u ad=0.0528p as=0.0816p pd=0.68u ps=1.16u
    I_MXI1_I42_I126_XP_MP0 (VDD I1_I42_P30_29 I1_I42_P30_27n VDD) gpdk090_pmos1v w=0.24u l=0.1u ad=0.0816p as=0.0528p pd=1.16u ps=0.68u
    I_MXI1_I42_I124_XP_MP1 (I1_I42_P28_25n I1_I42_P26_25 VDD VDD) gpdk090_pmos1v w=0.24u l=0.1u ad=0.0528p as=0.0816p pd=0.68u ps=1.16u
    I_MXI1_I42_I124_XP_MP0 (VDD I1_I42_P28_27 I1_I42_P28_25n VDD) gpdk090_pmos1v w=0.24u l=0.1u ad=0.0816p as=0.0528p pd=1.16u ps=0.68u
    I_MXI1_I42_I181_XP_MP1 (I1_I42_P30_15n I1_I42_P22_15 VDD VDD) gpdk090_pmos1v w=0.24u l=0.1u ad=0.0528p as=0.0816p pd=0.68u ps=1.16u
    I_MXI1_I42_I181_XP_MP0 (VDD I1_I42_P30_23 I1_I42_P30_15n VDD) gpdk090_pmos1v w=0.24u l=0.1u ad=0.0816p as=0.0528p pd=1.16u ps=0.68u
    I_MXI1_I42_I173_XP_MP1 (I1_I42_P22_7n I1_I42_P14_7 VDD VDD) gpdk090_pmos1v w=0.24u l=0.1u ad=0.0528p as=0.0816p pd=0.68u ps=1.16u
    I_MXI1_I42_I173_XP_MP0 (VDD I1_I42_P22_15 I1_I42_P22_7n VDD) gpdk090_pmos1v w=0.24u l=0.1u ad=0.0816p as=0.0528p pd=1.16u ps=0.68u
    I_MXI1_I42_I177_XP_MP1 (I1_I42_P26_11n I1_I42_P18_11 VDD VDD) gpdk090_pmos1v w=0.24u l=0.1u ad=0.0528p as=0.0816p pd=0.68u ps=1.16u
    I_MXI1_I42_I177_XP_MP0 (VDD I1_I42_P26_19 I1_I42_P26_11n VDD) gpdk090_pmos1v w=0.24u l=0.1u ad=0.0816p as=0.0528p pd=1.16u ps=0.68u
    I_MXI1_I42_I114_XP_MP1 (I1_I42_P18_15n I1_I42_P16_15 VDD VDD) gpdk090_pmos1v w=0.24u l=0.1u ad=0.0528p as=0.0816p pd=0.68u ps=1.16u
    I_MXI1_I42_I114_XP_MP0 (VDD I1_I42_P18_17 I1_I42_P18_15n VDD) gpdk090_pmos1v w=0.24u l=0.1u ad=0.0816p as=0.0528p pd=1.16u ps=0.68u
    I_MXI1_I42_I14_MP1 (I1_I42_gn14 I1_bx14 VDD VDD) gpdk090_pmos1v w=0.24u l=0.1u ad=0.0528p as=0.0816p pd=0.68u ps=1.16u
    I_MXI1_I42_I14_MP0 (VDD A_14 I1_I42_gn14 VDD) gpdk090_pmos1v w=0.24u l=0.1u ad=0.0816p as=0.0528p pd=1.16u ps=0.68u
    I_MXI3_I265_MP1 (I3_n15_3 NOT_15 VDD VDD) gpdk090_pmos1v w=0.24u l=0.1u ad=0.0528p as=0.0816p pd=0.68u ps=1.16u
    I_MXI3_I265_MP0 (VDD I3_SEL_NOT_b3_2 I3_n15_3 VDD) gpdk090_pmos1v w=0.24u l=0.1u ad=0.0816p as=0.0528p pd=1.16u ps=0.68u
    I_MXI3_I269_MP1 (I3_o15_1 I3_n15_3 VDD VDD) gpdk090_pmos1v w=0.24u l=0.1u ad=0.0528p as=0.0816p pd=0.68u ps=1.16u
    I_MXI3_I269_MP0 (VDD I3_n15_2 I3_o15_1 VDD) gpdk090_pmos1v w=0.24u l=0.1u ad=0.0816p as=0.0528p pd=1.16u ps=0.68u
    I_MXI3_I251_MP1 (I3_n14_1 OR_14 VDD VDD) gpdk090_pmos1v w=0.24u l=0.1u ad=0.0528p as=0.0816p pd=0.68u ps=1.16u
    I_MXI3_I251_MP0 (VDD I3_SEL_OR_b3_2 I3_n14_1 VDD) gpdk090_pmos1v w=0.24u l=0.1u ad=0.0816p as=0.0528p pd=1.16u ps=0.68u
    I_MXI3_I273_MP1 (Y_15 I3_q15_2 VDD VDD) gpdk090_pmos1v w=0.24u l=0.1u ad=0.0528p as=0.0816p pd=0.68u ps=1.16u
    I_MXI3_I273_MP0 (VDD I3_q15_1 Y_15 VDD) gpdk090_pmos1v w=0.24u l=0.1u ad=0.0816p as=0.0528p pd=1.16u ps=0.68u
    I_MXI3_I258_MP1 (I3_o14_2 I3_n14_5 VDD VDD) gpdk090_pmos1v w=0.24u l=0.1u ad=0.0528p as=0.0816p pd=0.68u ps=1.16u
    I_MXI3_I258_MP0 (VDD I3_n14_4 I3_o14_2 VDD) gpdk090_pmos1v w=0.24u l=0.1u ad=0.0816p as=0.0528p pd=1.16u ps=0.68u
    I_MXI3_I255_MP1 (I3_n14_5 DIVQ_14 VDD VDD) gpdk090_pmos1v w=0.24u l=0.1u ad=0.0528p as=0.0816p pd=0.68u ps=1.16u
    I_MXI3_I255_MP0 (VDD I3_SEL_DIV_b3_2 I3_n14_5 VDD) gpdk090_pmos1v w=0.24u l=0.1u ad=0.0816p as=0.0528p pd=1.16u ps=0.68u
    I_MXI3_I270_MP1 (I3_o15_2 I3_n15_5 VDD VDD) gpdk090_pmos1v w=0.24u l=0.1u ad=0.0528p as=0.0816p pd=0.68u ps=1.16u
    I_MXI3_I270_MP0 (VDD I3_n15_4 I3_o15_2 VDD) gpdk090_pmos1v w=0.24u l=0.1u ad=0.0816p as=0.0528p pd=1.16u ps=0.68u
    I_MXI3_I254_MP1 (I3_n14_4 MULP_14 VDD VDD) gpdk090_pmos1v w=0.24u l=0.1u ad=0.0528p as=0.0816p pd=0.68u ps=1.16u
    I_MXI3_I254_MP0 (VDD I3_SEL_MUL_b3_2 I3_n14_4 VDD) gpdk090_pmos1v w=0.24u l=0.1u ad=0.0816p as=0.0528p pd=1.16u ps=0.68u
    I_MXI3_I387_MP1 (I3_n25_5 DIVQ_25 VDD VDD) gpdk090_pmos1v w=0.24u l=0.1u ad=0.0528p as=0.0816p pd=0.68u ps=1.16u
    I_MXI3_I387_MP0 (VDD I3_SEL_DIV_b3_4 I3_n25_5 VDD) gpdk090_pmos1v w=0.24u l=0.1u ad=0.0816p as=0.0528p pd=1.16u ps=0.68u
    I_MXI3_I398_MP1 (I3_n26_4 MULP_26 VDD VDD) gpdk090_pmos1v w=0.24u l=0.1u ad=0.0528p as=0.0816p pd=0.68u ps=1.16u
    I_MXI3_I398_MP0 (VDD I3_SEL_MUL_b3_4 I3_n26_4 VDD) gpdk090_pmos1v w=0.24u l=0.1u ad=0.0816p as=0.0528p pd=1.16u ps=0.68u
    I_MXI3_I375_MP1 (I3_n24_5 DIVQ_24 VDD VDD) gpdk090_pmos1v w=0.24u l=0.1u ad=0.0528p as=0.0816p pd=0.68u ps=1.16u
    I_MXI3_I375_MP0 (VDD I3_SEL_DIV_b3_4 I3_n24_5 VDD) gpdk090_pmos1v w=0.24u l=0.1u ad=0.0816p as=0.0528p pd=1.16u ps=0.68u
    I_MXI3_I399_MP1 (I3_n26_5 DIVQ_26 VDD VDD) gpdk090_pmos1v w=0.24u l=0.1u ad=0.0528p as=0.0816p pd=0.68u ps=1.16u
    I_MXI3_I399_MP0 (VDD I3_SEL_DIV_b3_4 I3_n26_5 VDD) gpdk090_pmos1v w=0.24u l=0.1u ad=0.0816p as=0.0528p pd=1.16u ps=0.68u
    I_MXI3_I402_MP1 (I3_o26_2 I3_n26_5 VDD VDD) gpdk090_pmos1v w=0.24u l=0.1u ad=0.0528p as=0.0816p pd=0.68u ps=1.16u
    I_MXI3_I402_MP0 (VDD I3_n26_4 I3_o26_2 VDD) gpdk090_pmos1v w=0.24u l=0.1u ad=0.0816p as=0.0528p pd=1.16u ps=0.68u
    I_MXI2_I162_MP1 (I2_nand27 B_27 VDD VDD) gpdk090_pmos1v w=0.24u l=0.1u ad=0.0528p as=0.0816p pd=0.68u ps=1.16u
    I_MXI2_I162_MP0 (VDD A_27 I2_nand27 VDD) gpdk090_pmos1v w=0.24u l=0.1u ad=0.0816p as=0.0528p pd=1.16u ps=0.68u
    I_MXI3_I408_MP1 (I3_n27_2 XOR_27 VDD VDD) gpdk090_pmos1v w=0.24u l=0.1u ad=0.0528p as=0.0816p pd=0.68u ps=1.16u
    I_MXI3_I408_MP0 (VDD I3_SEL_XOR_b3_5 I3_n27_2 VDD) gpdk090_pmos1v w=0.24u l=0.1u ad=0.0816p as=0.0528p pd=1.16u ps=0.68u
    I_MXI1_I42_I27_MP1 (I1_I42_gn27 I1_bx27 VDD VDD) gpdk090_pmos1v w=0.24u l=0.1u ad=0.0528p as=0.0816p pd=0.68u ps=1.16u
    I_MXI1_I42_I27_MP0 (VDD A_27 I1_I42_gn27 VDD) gpdk090_pmos1v w=0.24u l=0.1u ad=0.0816p as=0.0528p pd=1.16u ps=0.68u
    I_MXI1_I42_I122_XP_MP1 (I1_I42_P26_23n I1_I42_P24_23 VDD VDD) gpdk090_pmos1v w=0.24u l=0.1u ad=0.0528p as=0.0816p pd=0.68u ps=1.16u
    I_MXI1_I42_I122_XP_MP0 (VDD I1_I42_P26_25 I1_I42_P26_23n VDD) gpdk090_pmos1v w=0.24u l=0.1u ad=0.0816p as=0.0528p pd=1.16u ps=0.68u
    I_MXI1_I42_I120_XP_MP1 (I1_I42_P24_21n I1_I42_P22_21 VDD VDD) gpdk090_pmos1v w=0.24u l=0.1u ad=0.0528p as=0.0816p pd=0.68u ps=1.16u
    I_MXI1_I42_I120_XP_MP0 (VDD I1_I42_P24_23 I1_I42_P24_21n VDD) gpdk090_pmos1v w=0.24u l=0.1u ad=0.0816p as=0.0528p pd=1.16u ps=0.68u
    I_MXI1_I42_I118_XP_MP1 (I1_I42_P22_19n I1_I42_P20_19 VDD VDD) gpdk090_pmos1v w=0.24u l=0.1u ad=0.0528p as=0.0816p pd=0.68u ps=1.16u
    I_MXI1_I42_I118_XP_MP0 (VDD I1_I42_P22_21 I1_I42_P22_19n VDD) gpdk090_pmos1v w=0.24u l=0.1u ad=0.0816p as=0.0528p pd=1.16u ps=0.68u
    I_MXI1_I42_I116_XP_MP1 (I1_I42_P20_17n I1_I42_P18_17 VDD VDD) gpdk090_pmos1v w=0.24u l=0.1u ad=0.0528p as=0.0816p pd=0.68u ps=1.16u
    I_MXI1_I42_I116_XP_MP0 (VDD I1_I42_P20_19 I1_I42_P20_17n VDD) gpdk090_pmos1v w=0.24u l=0.1u ad=0.0816p as=0.0528p pd=1.16u ps=0.68u
    I_MXI1_I42_I15_MP1 (I1_I42_gn15 I1_bx15 VDD VDD) gpdk090_pmos1v w=0.24u l=0.1u ad=0.0528p as=0.0816p pd=0.68u ps=1.16u
    I_MXI1_I42_I15_MP0 (VDD A_15 I1_I42_gn15 VDD) gpdk090_pmos1v w=0.24u l=0.1u ad=0.0816p as=0.0528p pd=1.16u ps=0.68u
    I_MXI3_I264_MP1 (I3_n15_2 XOR_15 VDD VDD) gpdk090_pmos1v w=0.24u l=0.1u ad=0.0528p as=0.0816p pd=0.68u ps=1.16u
    I_MXI3_I264_MP0 (VDD I3_SEL_XOR_b3_2 I3_n15_2 VDD) gpdk090_pmos1v w=0.24u l=0.1u ad=0.0816p as=0.0528p pd=1.16u ps=0.68u
    I_MXI3_I263_MP1 (I3_n15_1 OR_15 VDD VDD) gpdk090_pmos1v w=0.24u l=0.1u ad=0.0528p as=0.0816p pd=0.68u ps=1.16u
    I_MXI3_I263_MP0 (VDD I3_SEL_OR_b3_2 I3_n15_1 VDD) gpdk090_pmos1v w=0.24u l=0.1u ad=0.0816p as=0.0528p pd=1.16u ps=0.68u
    I_MXI3_I268_MP1 (I3_o15_0 I3_n15_1 VDD VDD) gpdk090_pmos1v w=0.24u l=0.1u ad=0.0528p as=0.0816p pd=0.68u ps=1.16u
    I_MXI3_I268_MP0 (VDD I3_n15_0 I3_o15_0 VDD) gpdk090_pmos1v w=0.24u l=0.1u ad=0.0816p as=0.0528p pd=1.16u ps=0.68u
    I_MXI2_I90_MP1 (I2_nand15 B_15 VDD VDD) gpdk090_pmos1v w=0.24u l=0.1u ad=0.0528p as=0.0816p pd=0.68u ps=1.16u
    I_MXI2_I90_MP0 (VDD A_15 I2_nand15 VDD) gpdk090_pmos1v w=0.24u l=0.1u ad=0.0816p as=0.0528p pd=1.16u ps=0.68u
    I_MXI3_I266_MP1 (I3_n15_4 MULP_15 VDD VDD) gpdk090_pmos1v w=0.24u l=0.1u ad=0.0528p as=0.0816p pd=0.68u ps=1.16u
    I_MXI3_I266_MP0 (VDD I3_SEL_MUL_b3_2 I3_n15_4 VDD) gpdk090_pmos1v w=0.24u l=0.1u ad=0.0816p as=0.0528p pd=1.16u ps=0.68u
    I_MXI3_I262_MP1 (I3_n15_0 AND_15 VDD VDD) gpdk090_pmos1v w=0.24u l=0.1u ad=0.0528p as=0.0816p pd=0.68u ps=1.16u
    I_MXI3_I262_MP0 (VDD I3_SEL_AND_b3_2 I3_n15_0 VDD) gpdk090_pmos1v w=0.24u l=0.1u ad=0.0816p as=0.0528p pd=1.16u ps=0.68u
    I_MXI3_I267_MP1 (I3_n15_5 DIVQ_15 VDD VDD) gpdk090_pmos1v w=0.24u l=0.1u ad=0.0528p as=0.0816p pd=0.68u ps=1.16u
    I_MXI3_I267_MP0 (VDD I3_SEL_DIV_b3_2 I3_n15_5 VDD) gpdk090_pmos1v w=0.24u l=0.1u ad=0.0816p as=0.0528p pd=1.16u ps=0.68u
    I_MXI3_I386_MP1 (I3_n25_4 MULP_25 VDD VDD) gpdk090_pmos1v w=0.24u l=0.1u ad=0.0528p as=0.0816p pd=0.68u ps=1.16u
    I_MXI3_I386_MP0 (VDD I3_SEL_MUL_b3_4 I3_n25_4 VDD) gpdk090_pmos1v w=0.24u l=0.1u ad=0.0816p as=0.0528p pd=1.16u ps=0.68u
    I_MXI3_I390_MP1 (I3_o25_2 I3_n25_5 VDD VDD) gpdk090_pmos1v w=0.24u l=0.1u ad=0.0528p as=0.0816p pd=0.68u ps=1.16u
    I_MXI3_I390_MP0 (VDD I3_n25_4 I3_o25_2 VDD) gpdk090_pmos1v w=0.24u l=0.1u ad=0.0816p as=0.0528p pd=1.16u ps=0.68u
    I_MXI4_I38_MP1 (I4_z1_6 I4_z0_13 VDD VDD) gpdk090_pmos1v w=0.24u l=0.1u ad=0.0528p as=0.0816p pd=0.68u ps=1.16u
    I_MXI4_I38_MP0 (VDD I4_z0_12 I4_z1_6 VDD) gpdk090_pmos1v w=0.24u l=0.1u ad=0.0816p as=0.0528p pd=1.16u ps=0.68u
    I_MXI3_I374_MP1 (I3_n24_4 MULP_24 VDD VDD) gpdk090_pmos1v w=0.24u l=0.1u ad=0.0528p as=0.0816p pd=0.68u ps=1.16u
    I_MXI3_I374_MP0 (VDD I3_SEL_MUL_b3_4 I3_n24_4 VDD) gpdk090_pmos1v w=0.24u l=0.1u ad=0.0816p as=0.0528p pd=1.16u ps=0.68u
    I_MXI3_I378_MP1 (I3_o24_2 I3_n24_5 VDD VDD) gpdk090_pmos1v w=0.24u l=0.1u ad=0.0528p as=0.0816p pd=0.68u ps=1.16u
    I_MXI3_I378_MP0 (VDD I3_n24_4 I3_o24_2 VDD) gpdk090_pmos1v w=0.24u l=0.1u ad=0.0816p as=0.0528p pd=1.16u ps=0.68u
    I_MXI3_I405_MP1 (Y_26 I3_q26_2 VDD VDD) gpdk090_pmos1v w=0.24u l=0.1u ad=0.0528p as=0.0816p pd=0.68u ps=1.16u
    I_MXI3_I405_MP0 (VDD I3_q26_1 Y_26 VDD) gpdk090_pmos1v w=0.24u l=0.1u ad=0.0816p as=0.0528p pd=1.16u ps=0.68u
    I_MXI1_I42_I26_MP1 (I1_I42_gn26 I1_bx26 VDD VDD) gpdk090_pmos1v w=0.24u l=0.1u ad=0.0528p as=0.0816p pd=0.68u ps=1.16u
    I_MXI1_I42_I26_MP0 (VDD A_26 I1_I42_gn26 VDD) gpdk090_pmos1v w=0.24u l=0.1u ad=0.0816p as=0.0528p pd=1.16u ps=0.68u
    I_MXI1_I42_I25_MP1 (I1_I42_gn25 I1_bx25 VDD VDD) gpdk090_pmos1v w=0.24u l=0.1u ad=0.0528p as=0.0816p pd=0.68u ps=1.16u
    I_MXI1_I42_I25_MP0 (VDD A_25 I1_I42_gn25 VDD) gpdk090_pmos1v w=0.24u l=0.1u ad=0.0816p as=0.0528p pd=1.16u ps=0.68u
    I_MXI1_I42_I23_MP1 (I1_I42_gn23 I1_bx23 VDD VDD) gpdk090_pmos1v w=0.24u l=0.1u ad=0.0528p as=0.0816p pd=0.68u ps=1.16u
    I_MXI1_I42_I23_MP0 (VDD A_23 I1_I42_gn23 VDD) gpdk090_pmos1v w=0.24u l=0.1u ad=0.0816p as=0.0528p pd=1.16u ps=0.68u
    I_MXI1_I42_I20_MP1 (I1_I42_gn20 I1_bx20 VDD VDD) gpdk090_pmos1v w=0.24u l=0.1u ad=0.0528p as=0.0816p pd=0.68u ps=1.16u
    I_MXI1_I42_I20_MP0 (VDD A_20 I1_I42_gn20 VDD) gpdk090_pmos1v w=0.24u l=0.1u ad=0.0816p as=0.0528p pd=1.16u ps=0.68u
    I_MXI1_I42_I19_MP1 (I1_I42_gn19 I1_bx19 VDD VDD) gpdk090_pmos1v w=0.24u l=0.1u ad=0.0528p as=0.0816p pd=0.68u ps=1.16u
    I_MXI1_I42_I19_MP0 (VDD A_19 I1_I42_gn19 VDD) gpdk090_pmos1v w=0.24u l=0.1u ad=0.0816p as=0.0528p pd=1.16u ps=0.68u
    I_MXI1_I42_I17_MP1 (I1_I42_gn17 I1_bx17 VDD VDD) gpdk090_pmos1v w=0.24u l=0.1u ad=0.0528p as=0.0816p pd=0.68u ps=1.16u
    I_MXI1_I42_I17_MP0 (VDD A_17 I1_I42_gn17 VDD) gpdk090_pmos1v w=0.24u l=0.1u ad=0.0816p as=0.0528p pd=1.16u ps=0.68u
    I_MXI1_I42_I16_MP1 (I1_I42_gn16 I1_bx16 VDD VDD) gpdk090_pmos1v w=0.24u l=0.1u ad=0.0528p as=0.0816p pd=0.68u ps=1.16u
    I_MXI1_I42_I16_MP0 (VDD A_16 I1_I42_gn16 VDD) gpdk090_pmos1v w=0.24u l=0.1u ad=0.0816p as=0.0528p pd=1.16u ps=0.68u
    I_MXI3_I282_MP1 (I3_o16_2 I3_n16_5 VDD VDD) gpdk090_pmos1v w=0.24u l=0.1u ad=0.0528p as=0.0816p pd=0.68u ps=1.16u
    I_MXI3_I282_MP0 (VDD I3_n16_4 I3_o16_2 VDD) gpdk090_pmos1v w=0.24u l=0.1u ad=0.0816p as=0.0528p pd=1.16u ps=0.68u
    I_MXI3_I279_MP1 (I3_n16_5 DIVQ_16 VDD VDD) gpdk090_pmos1v w=0.24u l=0.1u ad=0.0528p as=0.0816p pd=0.68u ps=1.16u
    I_MXI3_I279_MP0 (VDD I3_SEL_DIV_b3_2 I3_n16_5 VDD) gpdk090_pmos1v w=0.24u l=0.1u ad=0.0816p as=0.0528p pd=1.16u ps=0.68u
    I_MXI3_I278_MP1 (I3_n16_4 MULP_16 VDD VDD) gpdk090_pmos1v w=0.24u l=0.1u ad=0.0528p as=0.0816p pd=0.68u ps=1.16u
    I_MXI3_I278_MP0 (VDD I3_SEL_MUL_b3_2 I3_n16_4 VDD) gpdk090_pmos1v w=0.24u l=0.1u ad=0.0816p as=0.0528p pd=1.16u ps=0.68u
    I_MXI3_I291_MP1 (I3_n17_5 DIVQ_17 VDD VDD) gpdk090_pmos1v w=0.24u l=0.1u ad=0.0528p as=0.0816p pd=0.68u ps=1.16u
    I_MXI3_I291_MP0 (VDD I3_SEL_DIV_b3_2 I3_n17_5 VDD) gpdk090_pmos1v w=0.24u l=0.1u ad=0.0816p as=0.0528p pd=1.16u ps=0.68u
    I_MXI3_I290_MP1 (I3_n17_4 MULP_17 VDD VDD) gpdk090_pmos1v w=0.24u l=0.1u ad=0.0528p as=0.0816p pd=0.68u ps=1.16u
    I_MXI3_I290_MP0 (VDD I3_SEL_MUL_b3_2 I3_n17_4 VDD) gpdk090_pmos1v w=0.24u l=0.1u ad=0.0816p as=0.0528p pd=1.16u ps=0.68u
    I_MXI3_I394_MP1 (I3_n26_0 AND_26 VDD VDD) gpdk090_pmos1v w=0.24u l=0.1u ad=0.0528p as=0.0816p pd=0.68u ps=1.16u
    I_MXI3_I394_MP0 (VDD I3_SEL_AND_b3_4 I3_n26_0 VDD) gpdk090_pmos1v w=0.24u l=0.1u ad=0.0816p as=0.0528p pd=1.16u ps=0.68u
    I_MXI2_I156_MP1 (I2_nand26 B_26 VDD VDD) gpdk090_pmos1v w=0.24u l=0.1u ad=0.0528p as=0.0816p pd=0.68u ps=1.16u
    I_MXI2_I156_MP0 (VDD A_26 I2_nand26 VDD) gpdk090_pmos1v w=0.24u l=0.1u ad=0.0816p as=0.0528p pd=1.16u ps=0.68u
    I_MXI3_I400_MP1 (I3_o26_0 I3_n26_1 VDD VDD) gpdk090_pmos1v w=0.24u l=0.1u ad=0.0528p as=0.0816p pd=0.68u ps=1.16u
    I_MXI3_I400_MP0 (VDD I3_n26_0 I3_o26_0 VDD) gpdk090_pmos1v w=0.24u l=0.1u ad=0.0816p as=0.0528p pd=1.16u ps=0.68u
    I_MXI3_I393_MP1 (Y_25 I3_q25_2 VDD VDD) gpdk090_pmos1v w=0.24u l=0.1u ad=0.0528p as=0.0816p pd=0.68u ps=1.16u
    I_MXI3_I393_MP0 (VDD I3_q25_1 Y_25 VDD) gpdk090_pmos1v w=0.24u l=0.1u ad=0.0816p as=0.0528p pd=1.16u ps=0.68u
    I_MXI3_I401_MP1 (I3_o26_1 I3_n26_3 VDD VDD) gpdk090_pmos1v w=0.24u l=0.1u ad=0.0528p as=0.0816p pd=0.68u ps=1.16u
    I_MXI3_I401_MP0 (VDD I3_n26_2 I3_o26_1 VDD) gpdk090_pmos1v w=0.24u l=0.1u ad=0.0816p as=0.0528p pd=1.16u ps=0.68u
    I_MXI3_I396_MP1 (I3_n26_2 XOR_26 VDD VDD) gpdk090_pmos1v w=0.24u l=0.1u ad=0.0528p as=0.0816p pd=0.68u ps=1.16u
    I_MXI3_I396_MP0 (VDD I3_SEL_XOR_b3_4 I3_n26_2 VDD) gpdk090_pmos1v w=0.24u l=0.1u ad=0.0816p as=0.0528p pd=1.16u ps=0.68u
    I_MXI3_I373_MP1 (I3_n24_3 NOT_24 VDD VDD) gpdk090_pmos1v w=0.24u l=0.1u ad=0.0528p as=0.0816p pd=0.68u ps=1.16u
    I_MXI3_I373_MP0 (VDD I3_SEL_NOT_b3_4 I3_n24_3 VDD) gpdk090_pmos1v w=0.24u l=0.1u ad=0.0816p as=0.0528p pd=1.16u ps=0.68u
    I_MXI1_I42_I24_MP1 (I1_I42_gn24 I1_bx24 VDD VDD) gpdk090_pmos1v w=0.24u l=0.1u ad=0.0528p as=0.0816p pd=0.68u ps=1.16u
    I_MXI1_I42_I24_MP0 (VDD A_24 I1_I42_gn24 VDD) gpdk090_pmos1v w=0.24u l=0.1u ad=0.0816p as=0.0528p pd=1.16u ps=0.68u
    I_MXI1_I42_I22_MP1 (I1_I42_gn22 I1_bx22 VDD VDD) gpdk090_pmos1v w=0.24u l=0.1u ad=0.0528p as=0.0816p pd=0.68u ps=1.16u
    I_MXI1_I42_I22_MP0 (VDD A_22 I1_I42_gn22 VDD) gpdk090_pmos1v w=0.24u l=0.1u ad=0.0816p as=0.0528p pd=1.16u ps=0.68u
    I_MXI1_I42_I21_MP1 (I1_I42_gn21 I1_bx21 VDD VDD) gpdk090_pmos1v w=0.24u l=0.1u ad=0.0528p as=0.0816p pd=0.68u ps=1.16u
    I_MXI1_I42_I21_MP0 (VDD A_21 I1_I42_gn21 VDD) gpdk090_pmos1v w=0.24u l=0.1u ad=0.0816p as=0.0528p pd=1.16u ps=0.68u
    I_MXI3_I354_MP1 (I3_o22_2 I3_n22_5 VDD VDD) gpdk090_pmos1v w=0.24u l=0.1u ad=0.0528p as=0.0816p pd=0.68u ps=1.16u
    I_MXI3_I354_MP0 (VDD I3_n22_4 I3_o22_2 VDD) gpdk090_pmos1v w=0.24u l=0.1u ad=0.0816p as=0.0528p pd=1.16u ps=0.68u
    I_MXI3_I324_MP1 (I3_n20_2 XOR_20 VDD VDD) gpdk090_pmos1v w=0.24u l=0.1u ad=0.0528p as=0.0816p pd=0.68u ps=1.16u
    I_MXI3_I324_MP0 (VDD I3_SEL_XOR_b3_3 I3_n20_2 VDD) gpdk090_pmos1v w=0.24u l=0.1u ad=0.0816p as=0.0528p pd=1.16u ps=0.68u
    I_MXI3_I306_MP1 (I3_o18_2 I3_n18_5 VDD VDD) gpdk090_pmos1v w=0.24u l=0.1u ad=0.0528p as=0.0816p pd=0.68u ps=1.16u
    I_MXI3_I306_MP0 (VDD I3_n18_4 I3_o18_2 VDD) gpdk090_pmos1v w=0.24u l=0.1u ad=0.0816p as=0.0528p pd=1.16u ps=0.68u
    I_MXI1_I42_I18_MP1 (I1_I42_gn18 I1_bx18 VDD VDD) gpdk090_pmos1v w=0.24u l=0.1u ad=0.0528p as=0.0816p pd=0.68u ps=1.16u
    I_MXI1_I42_I18_MP0 (VDD A_18 I1_I42_gn18 VDD) gpdk090_pmos1v w=0.24u l=0.1u ad=0.0816p as=0.0528p pd=1.16u ps=0.68u
    I_MXI3_I277_MP1 (I3_n16_3 NOT_16 VDD VDD) gpdk090_pmos1v w=0.24u l=0.1u ad=0.0528p as=0.0816p pd=0.68u ps=1.16u
    I_MXI3_I277_MP0 (VDD I3_SEL_NOT_b3_3 I3_n16_3 VDD) gpdk090_pmos1v w=0.24u l=0.1u ad=0.0816p as=0.0528p pd=1.16u ps=0.68u
    I_MXI3_I281_MP1 (I3_o16_1 I3_n16_3 VDD VDD) gpdk090_pmos1v w=0.24u l=0.1u ad=0.0528p as=0.0816p pd=0.68u ps=1.16u
    I_MXI3_I281_MP0 (VDD I3_n16_2 I3_o16_1 VDD) gpdk090_pmos1v w=0.24u l=0.1u ad=0.0816p as=0.0528p pd=1.16u ps=0.68u
    I_MXI3_I276_MP1 (I3_n16_2 XOR_16 VDD VDD) gpdk090_pmos1v w=0.24u l=0.1u ad=0.0528p as=0.0816p pd=0.68u ps=1.16u
    I_MXI3_I276_MP0 (VDD I3_SEL_XOR_b3_3 I3_n16_2 VDD) gpdk090_pmos1v w=0.24u l=0.1u ad=0.0816p as=0.0528p pd=1.16u ps=0.68u
    I_MXI2_I96_MP1 (I2_nand16 B_16 VDD VDD) gpdk090_pmos1v w=0.24u l=0.1u ad=0.0528p as=0.0816p pd=0.68u ps=1.16u
    I_MXI2_I96_MP0 (VDD A_16 I2_nand16 VDD) gpdk090_pmos1v w=0.24u l=0.1u ad=0.0816p as=0.0528p pd=1.16u ps=0.68u
    I_MXI3_I294_MP1 (I3_o17_2 I3_n17_5 VDD VDD) gpdk090_pmos1v w=0.24u l=0.1u ad=0.0528p as=0.0816p pd=0.68u ps=1.16u
    I_MXI3_I294_MP0 (VDD I3_n17_4 I3_o17_2 VDD) gpdk090_pmos1v w=0.24u l=0.1u ad=0.0816p as=0.0528p pd=1.16u ps=0.68u
    I_MXI3_I388_MP1 (I3_o25_0 I3_n25_1 VDD VDD) gpdk090_pmos1v w=0.24u l=0.1u ad=0.0528p as=0.0816p pd=0.68u ps=1.16u
    I_MXI3_I388_MP0 (VDD I3_n25_0 I3_o25_0 VDD) gpdk090_pmos1v w=0.24u l=0.1u ad=0.0816p as=0.0528p pd=1.16u ps=0.68u
    I_MXI3_I395_MP1 (I3_n26_1 OR_26 VDD VDD) gpdk090_pmos1v w=0.24u l=0.1u ad=0.0528p as=0.0816p pd=0.68u ps=1.16u
    I_MXI3_I395_MP0 (VDD I3_SEL_OR_b3_4 I3_n26_1 VDD) gpdk090_pmos1v w=0.24u l=0.1u ad=0.0816p as=0.0528p pd=1.16u ps=0.68u
    I_MXI3_I389_MP1 (I3_o25_1 I3_n25_3 VDD VDD) gpdk090_pmos1v w=0.24u l=0.1u ad=0.0528p as=0.0816p pd=0.68u ps=1.16u
    I_MXI3_I389_MP0 (VDD I3_n25_2 I3_o25_1 VDD) gpdk090_pmos1v w=0.24u l=0.1u ad=0.0816p as=0.0528p pd=1.16u ps=0.68u
    I_MXI3_I385_MP1 (I3_n25_3 NOT_25 VDD VDD) gpdk090_pmos1v w=0.24u l=0.1u ad=0.0528p as=0.0816p pd=0.68u ps=1.16u
    I_MXI3_I385_MP0 (VDD I3_SEL_NOT_b3_4 I3_n25_3 VDD) gpdk090_pmos1v w=0.24u l=0.1u ad=0.0816p as=0.0528p pd=1.16u ps=0.68u
    I_MXI3_I397_MP1 (I3_n26_3 NOT_26 VDD VDD) gpdk090_pmos1v w=0.24u l=0.1u ad=0.0528p as=0.0816p pd=0.68u ps=1.16u
    I_MXI3_I397_MP0 (VDD I3_SEL_NOT_b3_4 I3_n26_3 VDD) gpdk090_pmos1v w=0.24u l=0.1u ad=0.0816p as=0.0528p pd=1.16u ps=0.68u
    I_MXI3_I384_MP1 (I3_n25_2 XOR_25 VDD VDD) gpdk090_pmos1v w=0.24u l=0.1u ad=0.0528p as=0.0816p pd=0.68u ps=1.16u
    I_MXI3_I384_MP0 (VDD I3_SEL_XOR_b3_4 I3_n25_2 VDD) gpdk090_pmos1v w=0.24u l=0.1u ad=0.0816p as=0.0528p pd=1.16u ps=0.68u
    I_MXI3_I381_MP1 (Y_24 I3_q24_2 VDD VDD) gpdk090_pmos1v w=0.24u l=0.1u ad=0.0528p as=0.0816p pd=0.68u ps=1.16u
    I_MXI3_I381_MP0 (VDD I3_q24_1 Y_24 VDD) gpdk090_pmos1v w=0.24u l=0.1u ad=0.0816p as=0.0528p pd=1.16u ps=0.68u
    I_MXI3_I376_MP1 (I3_o24_0 I3_n24_1 VDD VDD) gpdk090_pmos1v w=0.24u l=0.1u ad=0.0528p as=0.0816p pd=0.68u ps=1.16u
    I_MXI3_I376_MP0 (VDD I3_n24_0 I3_o24_0 VDD) gpdk090_pmos1v w=0.24u l=0.1u ad=0.0816p as=0.0528p pd=1.16u ps=0.68u
    I_MXI3_I377_MP1 (I3_o24_1 I3_n24_3 VDD VDD) gpdk090_pmos1v w=0.24u l=0.1u ad=0.0528p as=0.0816p pd=0.68u ps=1.16u
    I_MXI3_I377_MP0 (VDD I3_n24_2 I3_o24_1 VDD) gpdk090_pmos1v w=0.24u l=0.1u ad=0.0816p as=0.0528p pd=1.16u ps=0.68u
    I_MXI3_I372_MP1 (I3_n24_2 XOR_24 VDD VDD) gpdk090_pmos1v w=0.24u l=0.1u ad=0.0528p as=0.0816p pd=0.68u ps=1.16u
    I_MXI3_I372_MP0 (VDD I3_SEL_XOR_b3_4 I3_n24_2 VDD) gpdk090_pmos1v w=0.24u l=0.1u ad=0.0816p as=0.0528p pd=1.16u ps=0.68u
    I_MXI3_I360_MP1 (I3_n23_2 XOR_23 VDD VDD) gpdk090_pmos1v w=0.24u l=0.1u ad=0.0528p as=0.0816p pd=0.68u ps=1.16u
    I_MXI3_I360_MP0 (VDD I3_SEL_XOR_b3_4 I3_n23_2 VDD) gpdk090_pmos1v w=0.24u l=0.1u ad=0.0816p as=0.0528p pd=1.16u ps=0.68u
    I_MXI3_I364_MP1 (I3_o23_0 I3_n23_1 VDD VDD) gpdk090_pmos1v w=0.24u l=0.1u ad=0.0528p as=0.0816p pd=0.68u ps=1.16u
    I_MXI3_I364_MP0 (VDD I3_n23_0 I3_o23_0 VDD) gpdk090_pmos1v w=0.24u l=0.1u ad=0.0816p as=0.0528p pd=1.16u ps=0.68u
    I_MXI3_I365_MP1 (I3_o23_1 I3_n23_3 VDD VDD) gpdk090_pmos1v w=0.24u l=0.1u ad=0.0528p as=0.0816p pd=0.68u ps=1.16u
    I_MXI3_I365_MP0 (VDD I3_n23_2 I3_o23_1 VDD) gpdk090_pmos1v w=0.24u l=0.1u ad=0.0816p as=0.0528p pd=1.16u ps=0.68u
    I_MXI3_I361_MP1 (I3_n23_3 NOT_23 VDD VDD) gpdk090_pmos1v w=0.24u l=0.1u ad=0.0528p as=0.0816p pd=0.68u ps=1.16u
    I_MXI3_I361_MP0 (VDD I3_SEL_NOT_b3_4 I3_n23_3 VDD) gpdk090_pmos1v w=0.24u l=0.1u ad=0.0816p as=0.0528p pd=1.16u ps=0.68u
    I_MXI3_I349_MP1 (I3_n22_3 NOT_22 VDD VDD) gpdk090_pmos1v w=0.24u l=0.1u ad=0.0528p as=0.0816p pd=0.68u ps=1.16u
    I_MXI3_I349_MP0 (VDD I3_SEL_NOT_b3_4 I3_n22_3 VDD) gpdk090_pmos1v w=0.24u l=0.1u ad=0.0816p as=0.0528p pd=1.16u ps=0.68u
    I_MXI3_I353_MP1 (I3_o22_1 I3_n22_3 VDD VDD) gpdk090_pmos1v w=0.24u l=0.1u ad=0.0528p as=0.0816p pd=0.68u ps=1.16u
    I_MXI3_I353_MP0 (VDD I3_n22_2 I3_o22_1 VDD) gpdk090_pmos1v w=0.24u l=0.1u ad=0.0816p as=0.0528p pd=1.16u ps=0.68u
    I_MXI3_I348_MP1 (I3_n22_2 XOR_22 VDD VDD) gpdk090_pmos1v w=0.24u l=0.1u ad=0.0528p as=0.0816p pd=0.68u ps=1.16u
    I_MXI3_I348_MP0 (VDD I3_SEL_XOR_b3_4 I3_n22_2 VDD) gpdk090_pmos1v w=0.24u l=0.1u ad=0.0816p as=0.0528p pd=1.16u ps=0.68u
    I_MXI3_I369_MP1 (Y_23 I3_q23_2 VDD VDD) gpdk090_pmos1v w=0.24u l=0.1u ad=0.0528p as=0.0816p pd=0.68u ps=1.16u
    I_MXI3_I369_MP0 (VDD I3_q23_1 Y_23 VDD) gpdk090_pmos1v w=0.24u l=0.1u ad=0.0816p as=0.0528p pd=1.16u ps=0.68u
    I_MXI3_I335_MP1 (I3_n21_1 OR_21 VDD VDD) gpdk090_pmos1v w=0.24u l=0.1u ad=0.0528p as=0.0816p pd=0.68u ps=1.16u
    I_MXI3_I335_MP0 (VDD I3_SEL_OR_b3_3 I3_n21_1 VDD) gpdk090_pmos1v w=0.24u l=0.1u ad=0.0816p as=0.0528p pd=1.16u ps=0.68u
    I_MXI3_I337_MP1 (I3_n21_3 NOT_21 VDD VDD) gpdk090_pmos1v w=0.24u l=0.1u ad=0.0528p as=0.0816p pd=0.68u ps=1.16u
    I_MXI3_I337_MP0 (VDD I3_SEL_NOT_b3_3 I3_n21_3 VDD) gpdk090_pmos1v w=0.24u l=0.1u ad=0.0816p as=0.0528p pd=1.16u ps=0.68u
    I_MXI3_I341_MP1 (I3_o21_1 I3_n21_3 VDD VDD) gpdk090_pmos1v w=0.24u l=0.1u ad=0.0528p as=0.0816p pd=0.68u ps=1.16u
    I_MXI3_I341_MP0 (VDD I3_n21_2 I3_o21_1 VDD) gpdk090_pmos1v w=0.24u l=0.1u ad=0.0816p as=0.0528p pd=1.16u ps=0.68u
    I_MXI3_I351_MP1 (I3_n22_5 DIVQ_22 VDD VDD) gpdk090_pmos1v w=0.24u l=0.1u ad=0.0528p as=0.0816p pd=0.68u ps=1.16u
    I_MXI3_I351_MP0 (VDD I3_SEL_DIV_b3_3 I3_n22_5 VDD) gpdk090_pmos1v w=0.24u l=0.1u ad=0.0816p as=0.0528p pd=1.16u ps=0.68u
    I_MXI3_I366_MP1 (I3_o23_2 I3_n23_5 VDD VDD) gpdk090_pmos1v w=0.24u l=0.1u ad=0.0528p as=0.0816p pd=0.68u ps=1.16u
    I_MXI3_I366_MP0 (VDD I3_n23_4 I3_o23_2 VDD) gpdk090_pmos1v w=0.24u l=0.1u ad=0.0816p as=0.0528p pd=1.16u ps=0.68u
    I_MXI3_I362_MP1 (I3_n23_4 MULP_23 VDD VDD) gpdk090_pmos1v w=0.24u l=0.1u ad=0.0528p as=0.0816p pd=0.68u ps=1.16u
    I_MXI3_I362_MP0 (VDD I3_SEL_MUL_b3_3 I3_n23_4 VDD) gpdk090_pmos1v w=0.24u l=0.1u ad=0.0816p as=0.0528p pd=1.16u ps=0.68u
    I_MXI3_I350_MP1 (I3_n22_4 MULP_22 VDD VDD) gpdk090_pmos1v w=0.24u l=0.1u ad=0.0528p as=0.0816p pd=0.68u ps=1.16u
    I_MXI3_I350_MP0 (VDD I3_SEL_MUL_b3_3 I3_n22_4 VDD) gpdk090_pmos1v w=0.24u l=0.1u ad=0.0816p as=0.0528p pd=1.16u ps=0.68u
    I_MXI3_I338_MP1 (I3_n21_4 MULP_21 VDD VDD) gpdk090_pmos1v w=0.24u l=0.1u ad=0.0528p as=0.0816p pd=0.68u ps=1.16u
    I_MXI3_I338_MP0 (VDD I3_SEL_MUL_b3_3 I3_n21_4 VDD) gpdk090_pmos1v w=0.24u l=0.1u ad=0.0816p as=0.0528p pd=1.16u ps=0.68u
    I_MXI3_I342_MP1 (I3_o21_2 I3_n21_5 VDD VDD) gpdk090_pmos1v w=0.24u l=0.1u ad=0.0528p as=0.0816p pd=0.68u ps=1.16u
    I_MXI3_I342_MP0 (VDD I3_n21_4 I3_o21_2 VDD) gpdk090_pmos1v w=0.24u l=0.1u ad=0.0816p as=0.0528p pd=1.16u ps=0.68u
    I_MXI3_I339_MP1 (I3_n21_5 DIVQ_21 VDD VDD) gpdk090_pmos1v w=0.24u l=0.1u ad=0.0528p as=0.0816p pd=0.68u ps=1.16u
    I_MXI3_I339_MP0 (VDD I3_SEL_DIV_b3_3 I3_n21_5 VDD) gpdk090_pmos1v w=0.24u l=0.1u ad=0.0816p as=0.0528p pd=1.16u ps=0.68u
    I_MXI3_I330_MP1 (I3_o20_2 I3_n20_5 VDD VDD) gpdk090_pmos1v w=0.24u l=0.1u ad=0.0528p as=0.0816p pd=0.68u ps=1.16u
    I_MXI3_I330_MP0 (VDD I3_n20_4 I3_o20_2 VDD) gpdk090_pmos1v w=0.24u l=0.1u ad=0.0816p as=0.0528p pd=1.16u ps=0.68u
    I_MXI3_I327_MP1 (I3_n20_5 DIVQ_20 VDD VDD) gpdk090_pmos1v w=0.24u l=0.1u ad=0.0528p as=0.0816p pd=0.68u ps=1.16u
    I_MXI3_I327_MP0 (VDD I3_SEL_DIV_b3_3 I3_n20_5 VDD) gpdk090_pmos1v w=0.24u l=0.1u ad=0.0816p as=0.0528p pd=1.16u ps=0.68u
    I_MXI3_I326_MP1 (I3_n20_4 MULP_20 VDD VDD) gpdk090_pmos1v w=0.24u l=0.1u ad=0.0528p as=0.0816p pd=0.68u ps=1.16u
    I_MXI3_I326_MP0 (VDD I3_SEL_MUL_b3_3 I3_n20_4 VDD) gpdk090_pmos1v w=0.24u l=0.1u ad=0.0816p as=0.0528p pd=1.16u ps=0.68u
    I_MXI3_I329_MP1 (I3_o20_1 I3_n20_3 VDD VDD) gpdk090_pmos1v w=0.24u l=0.1u ad=0.0528p as=0.0816p pd=0.68u ps=1.16u
    I_MXI3_I329_MP0 (VDD I3_n20_2 I3_o20_1 VDD) gpdk090_pmos1v w=0.24u l=0.1u ad=0.0816p as=0.0528p pd=1.16u ps=0.68u
    I_MXI3_I325_MP1 (I3_n20_3 NOT_20 VDD VDD) gpdk090_pmos1v w=0.24u l=0.1u ad=0.0528p as=0.0816p pd=0.68u ps=1.16u
    I_MXI3_I325_MP0 (VDD I3_SEL_NOT_b3_3 I3_n20_3 VDD) gpdk090_pmos1v w=0.24u l=0.1u ad=0.0816p as=0.0528p pd=1.16u ps=0.68u
    I_MXI3_I318_MP1 (I3_o19_2 I3_n19_5 VDD VDD) gpdk090_pmos1v w=0.24u l=0.1u ad=0.0528p as=0.0816p pd=0.68u ps=1.16u
    I_MXI3_I318_MP0 (VDD I3_n19_4 I3_o19_2 VDD) gpdk090_pmos1v w=0.24u l=0.1u ad=0.0816p as=0.0528p pd=1.16u ps=0.68u
    I_MXI3_I314_MP1 (I3_n19_4 MULP_19 VDD VDD) gpdk090_pmos1v w=0.24u l=0.1u ad=0.0528p as=0.0816p pd=0.68u ps=1.16u
    I_MXI3_I314_MP0 (VDD I3_SEL_MUL_b3_3 I3_n19_4 VDD) gpdk090_pmos1v w=0.24u l=0.1u ad=0.0816p as=0.0528p pd=1.16u ps=0.68u
    I_MXI3_I303_MP1 (I3_n18_5 DIVQ_18 VDD VDD) gpdk090_pmos1v w=0.24u l=0.1u ad=0.0528p as=0.0816p pd=0.68u ps=1.16u
    I_MXI3_I303_MP0 (VDD I3_SEL_DIV_b3_3 I3_n18_5 VDD) gpdk090_pmos1v w=0.24u l=0.1u ad=0.0816p as=0.0528p pd=1.16u ps=0.68u
    I_MXI3_I321_MP1 (Y_19 I3_q19_2 VDD VDD) gpdk090_pmos1v w=0.24u l=0.1u ad=0.0528p as=0.0816p pd=0.68u ps=1.16u
    I_MXI3_I321_MP0 (VDD I3_q19_1 Y_19 VDD) gpdk090_pmos1v w=0.24u l=0.1u ad=0.0816p as=0.0528p pd=1.16u ps=0.68u
    I_MXI3_I302_MP1 (I3_n18_4 MULP_18 VDD VDD) gpdk090_pmos1v w=0.24u l=0.1u ad=0.0528p as=0.0816p pd=0.68u ps=1.16u
    I_MXI3_I302_MP0 (VDD I3_SEL_MUL_b3_3 I3_n18_4 VDD) gpdk090_pmos1v w=0.24u l=0.1u ad=0.0816p as=0.0528p pd=1.16u ps=0.68u
    I_MXI3_I317_MP1 (I3_o19_1 I3_n19_3 VDD VDD) gpdk090_pmos1v w=0.24u l=0.1u ad=0.0528p as=0.0816p pd=0.68u ps=1.16u
    I_MXI3_I317_MP0 (VDD I3_n19_2 I3_o19_1 VDD) gpdk090_pmos1v w=0.24u l=0.1u ad=0.0816p as=0.0528p pd=1.16u ps=0.68u
    I_MXI3_I313_MP1 (I3_n19_3 NOT_19 VDD VDD) gpdk090_pmos1v w=0.24u l=0.1u ad=0.0528p as=0.0816p pd=0.68u ps=1.16u
    I_MXI3_I313_MP0 (VDD I3_SEL_NOT_b3_3 I3_n19_3 VDD) gpdk090_pmos1v w=0.24u l=0.1u ad=0.0816p as=0.0528p pd=1.16u ps=0.68u
    I_MXI3_I312_MP1 (I3_n19_2 XOR_19 VDD VDD) gpdk090_pmos1v w=0.24u l=0.1u ad=0.0528p as=0.0816p pd=0.68u ps=1.16u
    I_MXI3_I312_MP0 (VDD I3_SEL_XOR_b3_3 I3_n19_2 VDD) gpdk090_pmos1v w=0.24u l=0.1u ad=0.0816p as=0.0528p pd=1.16u ps=0.68u
    I_MXI3_I309_MP1 (Y_18 I3_q18_2 VDD VDD) gpdk090_pmos1v w=0.24u l=0.1u ad=0.0528p as=0.0816p pd=0.68u ps=1.16u
    I_MXI3_I309_MP0 (VDD I3_q18_1 Y_18 VDD) gpdk090_pmos1v w=0.24u l=0.1u ad=0.0816p as=0.0528p pd=1.16u ps=0.68u
    I_MXI3_I301_MP1 (I3_n18_3 NOT_18 VDD VDD) gpdk090_pmos1v w=0.24u l=0.1u ad=0.0528p as=0.0816p pd=0.68u ps=1.16u
    I_MXI3_I301_MP0 (VDD I3_SEL_NOT_b3_3 I3_n18_3 VDD) gpdk090_pmos1v w=0.24u l=0.1u ad=0.0816p as=0.0528p pd=1.16u ps=0.68u
    I_MXI2_I108_MP1 (I2_nand18 B_18 VDD VDD) gpdk090_pmos1v w=0.24u l=0.1u ad=0.0528p as=0.0816p pd=0.68u ps=1.16u
    I_MXI2_I108_MP0 (VDD A_18 I2_nand18 VDD) gpdk090_pmos1v w=0.24u l=0.1u ad=0.0816p as=0.0528p pd=1.16u ps=0.68u
    I_MXI3_I305_MP1 (I3_o18_1 I3_n18_3 VDD VDD) gpdk090_pmos1v w=0.24u l=0.1u ad=0.0528p as=0.0816p pd=0.68u ps=1.16u
    I_MXI3_I305_MP0 (VDD I3_n18_2 I3_o18_1 VDD) gpdk090_pmos1v w=0.24u l=0.1u ad=0.0816p as=0.0528p pd=1.16u ps=0.68u
    I_MXI3_I300_MP1 (I3_n18_2 XOR_18 VDD VDD) gpdk090_pmos1v w=0.24u l=0.1u ad=0.0528p as=0.0816p pd=0.68u ps=1.16u
    I_MXI3_I300_MP0 (VDD I3_SEL_XOR_b3_3 I3_n18_2 VDD) gpdk090_pmos1v w=0.24u l=0.1u ad=0.0816p as=0.0528p pd=1.16u ps=0.68u
    I_MXI3_I297_MP1 (Y_17 I3_q17_2 VDD VDD) gpdk090_pmos1v w=0.24u l=0.1u ad=0.0528p as=0.0816p pd=0.68u ps=1.16u
    I_MXI3_I297_MP0 (VDD I3_q17_1 Y_17 VDD) gpdk090_pmos1v w=0.24u l=0.1u ad=0.0816p as=0.0528p pd=1.16u ps=0.68u
    I_MXI3_I289_MP1 (I3_n17_3 NOT_17 VDD VDD) gpdk090_pmos1v w=0.24u l=0.1u ad=0.0528p as=0.0816p pd=0.68u ps=1.16u
    I_MXI3_I289_MP0 (VDD I3_SEL_NOT_b3_3 I3_n17_3 VDD) gpdk090_pmos1v w=0.24u l=0.1u ad=0.0816p as=0.0528p pd=1.16u ps=0.68u
    I_MXI3_I285_MP1 (Y_16 I3_q16_2 VDD VDD) gpdk090_pmos1v w=0.24u l=0.1u ad=0.0528p as=0.0816p pd=0.68u ps=1.16u
    I_MXI3_I285_MP0 (VDD I3_q16_1 Y_16 VDD) gpdk090_pmos1v w=0.24u l=0.1u ad=0.0816p as=0.0528p pd=1.16u ps=0.68u
    I_MXI3_I293_MP1 (I3_o17_1 I3_n17_3 VDD VDD) gpdk090_pmos1v w=0.24u l=0.1u ad=0.0528p as=0.0816p pd=0.68u ps=1.16u
    I_MXI3_I293_MP0 (VDD I3_n17_2 I3_o17_1 VDD) gpdk090_pmos1v w=0.24u l=0.1u ad=0.0816p as=0.0528p pd=1.16u ps=0.68u
    I_MXI3_I274_MP1 (I3_n16_0 AND_16 VDD VDD) gpdk090_pmos1v w=0.24u l=0.1u ad=0.0528p as=0.0816p pd=0.68u ps=1.16u
    I_MXI3_I274_MP0 (VDD I3_SEL_AND_b3_3 I3_n16_0 VDD) gpdk090_pmos1v w=0.24u l=0.1u ad=0.0816p as=0.0528p pd=1.16u ps=0.68u
    I_MXI3_I292_MP1 (I3_o17_0 I3_n17_1 VDD VDD) gpdk090_pmos1v w=0.24u l=0.1u ad=0.0528p as=0.0816p pd=0.68u ps=1.16u
    I_MXI3_I292_MP0 (VDD I3_n17_0 I3_o17_0 VDD) gpdk090_pmos1v w=0.24u l=0.1u ad=0.0816p as=0.0528p pd=1.16u ps=0.68u
    I_MXI3_I280_MP1 (I3_o16_0 I3_n16_1 VDD VDD) gpdk090_pmos1v w=0.24u l=0.1u ad=0.0528p as=0.0816p pd=0.68u ps=1.16u
    I_MXI3_I280_MP0 (VDD I3_n16_0 I3_o16_0 VDD) gpdk090_pmos1v w=0.24u l=0.1u ad=0.0816p as=0.0528p pd=1.16u ps=0.68u
    I_MXI3_I287_MP1 (I3_n17_1 OR_17 VDD VDD) gpdk090_pmos1v w=0.24u l=0.1u ad=0.0528p as=0.0816p pd=0.68u ps=1.16u
    I_MXI3_I287_MP0 (VDD I3_SEL_OR_b3_3 I3_n17_1 VDD) gpdk090_pmos1v w=0.24u l=0.1u ad=0.0816p as=0.0528p pd=1.16u ps=0.68u
    I_MXI3_I275_MP1 (I3_n16_1 OR_16 VDD VDD) gpdk090_pmos1v w=0.24u l=0.1u ad=0.0528p as=0.0816p pd=0.68u ps=1.16u
    I_MXI3_I275_MP0 (VDD I3_SEL_OR_b3_3 I3_n16_1 VDD) gpdk090_pmos1v w=0.24u l=0.1u ad=0.0816p as=0.0528p pd=1.16u ps=0.68u
    I_MXI3_I383_MP1 (I3_n25_1 OR_25 VDD VDD) gpdk090_pmos1v w=0.24u l=0.1u ad=0.0528p as=0.0816p pd=0.68u ps=1.16u
    I_MXI3_I383_MP0 (VDD I3_SEL_OR_b3_4 I3_n25_1 VDD) gpdk090_pmos1v w=0.24u l=0.1u ad=0.0816p as=0.0528p pd=1.16u ps=0.68u
    I_MXI3_I382_MP1 (I3_n25_0 AND_25 VDD VDD) gpdk090_pmos1v w=0.24u l=0.1u ad=0.0528p as=0.0816p pd=0.68u ps=1.16u
    I_MXI3_I382_MP0 (VDD I3_SEL_AND_b3_4 I3_n25_0 VDD) gpdk090_pmos1v w=0.24u l=0.1u ad=0.0816p as=0.0528p pd=1.16u ps=0.68u
    I_MXI2_I150_MP1 (I2_nand25 B_25 VDD VDD) gpdk090_pmos1v w=0.24u l=0.1u ad=0.0528p as=0.0816p pd=0.68u ps=1.16u
    I_MXI2_I150_MP0 (VDD A_25 I2_nand25 VDD) gpdk090_pmos1v w=0.24u l=0.1u ad=0.0816p as=0.0528p pd=1.16u ps=0.68u
    I_MXI3_I370_MP1 (I3_n24_0 AND_24 VDD VDD) gpdk090_pmos1v w=0.24u l=0.1u ad=0.0528p as=0.0816p pd=0.68u ps=1.16u
    I_MXI3_I370_MP0 (VDD I3_SEL_AND_b3_4 I3_n24_0 VDD) gpdk090_pmos1v w=0.24u l=0.1u ad=0.0816p as=0.0528p pd=1.16u ps=0.68u
    I_MXI3_I371_MP1 (I3_n24_1 OR_24 VDD VDD) gpdk090_pmos1v w=0.24u l=0.1u ad=0.0528p as=0.0816p pd=0.68u ps=1.16u
    I_MXI3_I371_MP0 (VDD I3_SEL_OR_b3_4 I3_n24_1 VDD) gpdk090_pmos1v w=0.24u l=0.1u ad=0.0816p as=0.0528p pd=1.16u ps=0.68u
    I_MXI2_I144_MP1 (I2_nand24 B_24 VDD VDD) gpdk090_pmos1v w=0.24u l=0.1u ad=0.0528p as=0.0816p pd=0.68u ps=1.16u
    I_MXI2_I144_MP0 (VDD A_24 I2_nand24 VDD) gpdk090_pmos1v w=0.24u l=0.1u ad=0.0816p as=0.0528p pd=1.16u ps=0.68u
    I_MXI3_I359_MP1 (I3_n23_1 OR_23 VDD VDD) gpdk090_pmos1v w=0.24u l=0.1u ad=0.0528p as=0.0816p pd=0.68u ps=1.16u
    I_MXI3_I359_MP0 (VDD I3_SEL_OR_b3_4 I3_n23_1 VDD) gpdk090_pmos1v w=0.24u l=0.1u ad=0.0816p as=0.0528p pd=1.16u ps=0.68u
    I_MXI3_I358_MP1 (I3_n23_0 AND_23 VDD VDD) gpdk090_pmos1v w=0.24u l=0.1u ad=0.0528p as=0.0816p pd=0.68u ps=1.16u
    I_MXI3_I358_MP0 (VDD I3_SEL_AND_b3_4 I3_n23_0 VDD) gpdk090_pmos1v w=0.24u l=0.1u ad=0.0816p as=0.0528p pd=1.16u ps=0.68u
    I_MXI3_I347_MP1 (I3_n22_1 OR_22 VDD VDD) gpdk090_pmos1v w=0.24u l=0.1u ad=0.0528p as=0.0816p pd=0.68u ps=1.16u
    I_MXI3_I347_MP0 (VDD I3_SEL_OR_b3_4 I3_n22_1 VDD) gpdk090_pmos1v w=0.24u l=0.1u ad=0.0816p as=0.0528p pd=1.16u ps=0.68u
    I_MXI2_I138_MP1 (I2_nand23 B_23 VDD VDD) gpdk090_pmos1v w=0.24u l=0.1u ad=0.0528p as=0.0816p pd=0.68u ps=1.16u
    I_MXI2_I138_MP0 (VDD A_23 I2_nand23 VDD) gpdk090_pmos1v w=0.24u l=0.1u ad=0.0816p as=0.0528p pd=1.16u ps=0.68u
    I_MXI3_I352_MP1 (I3_o22_0 I3_n22_1 VDD VDD) gpdk090_pmos1v w=0.24u l=0.1u ad=0.0528p as=0.0816p pd=0.68u ps=1.16u
    I_MXI3_I352_MP0 (VDD I3_n22_0 I3_o22_0 VDD) gpdk090_pmos1v w=0.24u l=0.1u ad=0.0816p as=0.0528p pd=1.16u ps=0.68u
    I_MXI3_I346_MP1 (I3_n22_0 AND_22 VDD VDD) gpdk090_pmos1v w=0.24u l=0.1u ad=0.0528p as=0.0816p pd=0.68u ps=1.16u
    I_MXI3_I346_MP0 (VDD I3_SEL_AND_b3_4 I3_n22_0 VDD) gpdk090_pmos1v w=0.24u l=0.1u ad=0.0816p as=0.0528p pd=1.16u ps=0.68u
    I_MXI2_I132_MP1 (I2_nand22 B_22 VDD VDD) gpdk090_pmos1v w=0.24u l=0.1u ad=0.0528p as=0.0816p pd=0.68u ps=1.16u
    I_MXI2_I132_MP0 (VDD A_22 I2_nand22 VDD) gpdk090_pmos1v w=0.24u l=0.1u ad=0.0816p as=0.0528p pd=1.16u ps=0.68u
    I_MXI3_I357_MP1 (Y_22 I3_q22_2 VDD VDD) gpdk090_pmos1v w=0.24u l=0.1u ad=0.0528p as=0.0816p pd=0.68u ps=1.16u
    I_MXI3_I357_MP0 (VDD I3_q22_1 Y_22 VDD) gpdk090_pmos1v w=0.24u l=0.1u ad=0.0816p as=0.0528p pd=1.16u ps=0.68u
    I_MXI4_I37_MP1 (I4_z1_5 I4_z0_11 VDD VDD) gpdk090_pmos1v w=0.24u l=0.1u ad=0.0528p as=0.0816p pd=0.68u ps=1.16u
    I_MXI4_I37_MP0 (VDD I4_z0_10 I4_z1_5 VDD) gpdk090_pmos1v w=0.24u l=0.1u ad=0.0816p as=0.0528p pd=1.16u ps=0.68u
    I_MXI3_I334_MP1 (I3_n21_0 AND_21 VDD VDD) gpdk090_pmos1v w=0.24u l=0.1u ad=0.0528p as=0.0816p pd=0.68u ps=1.16u
    I_MXI3_I334_MP0 (VDD I3_SEL_AND_b3_3 I3_n21_0 VDD) gpdk090_pmos1v w=0.24u l=0.1u ad=0.0816p as=0.0528p pd=1.16u ps=0.68u
    I_MXI3_I340_MP1 (I3_o21_0 I3_n21_1 VDD VDD) gpdk090_pmos1v w=0.24u l=0.1u ad=0.0528p as=0.0816p pd=0.68u ps=1.16u
    I_MXI3_I340_MP0 (VDD I3_n21_0 I3_o21_0 VDD) gpdk090_pmos1v w=0.24u l=0.1u ad=0.0816p as=0.0528p pd=1.16u ps=0.68u
    I_MXI2_I126_MP1 (I2_nand21 B_21 VDD VDD) gpdk090_pmos1v w=0.24u l=0.1u ad=0.0528p as=0.0816p pd=0.68u ps=1.16u
    I_MXI2_I126_MP0 (VDD A_21 I2_nand21 VDD) gpdk090_pmos1v w=0.24u l=0.1u ad=0.0816p as=0.0528p pd=1.16u ps=0.68u
    I_MXI3_I336_MP1 (I3_n21_2 XOR_21 VDD VDD) gpdk090_pmos1v w=0.24u l=0.1u ad=0.0528p as=0.0816p pd=0.68u ps=1.16u
    I_MXI3_I336_MP0 (VDD I3_SEL_XOR_b3_3 I3_n21_2 VDD) gpdk090_pmos1v w=0.24u l=0.1u ad=0.0816p as=0.0528p pd=1.16u ps=0.68u
    I_MXI3_I363_MP1 (I3_n23_5 DIVQ_23 VDD VDD) gpdk090_pmos1v w=0.24u l=0.1u ad=0.0528p as=0.0816p pd=0.68u ps=1.16u
    I_MXI3_I363_MP0 (VDD I3_SEL_DIV_b3_3 I3_n23_5 VDD) gpdk090_pmos1v w=0.24u l=0.1u ad=0.0816p as=0.0528p pd=1.16u ps=0.68u
    I_MXI3_I345_MP1 (Y_21 I3_q21_2 VDD VDD) gpdk090_pmos1v w=0.24u l=0.1u ad=0.0528p as=0.0816p pd=0.68u ps=1.16u
    I_MXI3_I345_MP0 (VDD I3_q21_1 Y_21 VDD) gpdk090_pmos1v w=0.24u l=0.1u ad=0.0816p as=0.0528p pd=1.16u ps=0.68u
    I_MXI3_I333_MP1 (Y_20 I3_q20_2 VDD VDD) gpdk090_pmos1v w=0.24u l=0.1u ad=0.0528p as=0.0816p pd=0.68u ps=1.16u
    I_MXI3_I333_MP0 (VDD I3_q20_1 Y_20 VDD) gpdk090_pmos1v w=0.24u l=0.1u ad=0.0816p as=0.0528p pd=1.16u ps=0.68u
    I_MXI3_I322_MP1 (I3_n20_0 AND_20 VDD VDD) gpdk090_pmos1v w=0.24u l=0.1u ad=0.0528p as=0.0816p pd=0.68u ps=1.16u
    I_MXI3_I322_MP0 (VDD I3_SEL_AND_b3_3 I3_n20_0 VDD) gpdk090_pmos1v w=0.24u l=0.1u ad=0.0816p as=0.0528p pd=1.16u ps=0.68u
    I_MXI2_I120_MP1 (I2_nand20 B_20 VDD VDD) gpdk090_pmos1v w=0.24u l=0.1u ad=0.0528p as=0.0816p pd=0.68u ps=1.16u
    I_MXI2_I120_MP0 (VDD A_20 I2_nand20 VDD) gpdk090_pmos1v w=0.24u l=0.1u ad=0.0816p as=0.0528p pd=1.16u ps=0.68u
    I_MXI3_I328_MP1 (I3_o20_0 I3_n20_1 VDD VDD) gpdk090_pmos1v w=0.24u l=0.1u ad=0.0528p as=0.0816p pd=0.68u ps=1.16u
    I_MXI3_I328_MP0 (VDD I3_n20_0 I3_o20_0 VDD) gpdk090_pmos1v w=0.24u l=0.1u ad=0.0816p as=0.0528p pd=1.16u ps=0.68u
    I_MXI3_I323_MP1 (I3_n20_1 OR_20 VDD VDD) gpdk090_pmos1v w=0.24u l=0.1u ad=0.0528p as=0.0816p pd=0.68u ps=1.16u
    I_MXI3_I323_MP0 (VDD I3_SEL_OR_b3_3 I3_n20_1 VDD) gpdk090_pmos1v w=0.24u l=0.1u ad=0.0816p as=0.0528p pd=1.16u ps=0.68u
    I_MXI2_I114_MP1 (I2_nand19 B_19 VDD VDD) gpdk090_pmos1v w=0.24u l=0.1u ad=0.0528p as=0.0816p pd=0.68u ps=1.16u
    I_MXI2_I114_MP0 (VDD A_19 I2_nand19 VDD) gpdk090_pmos1v w=0.24u l=0.1u ad=0.0816p as=0.0528p pd=1.16u ps=0.68u
    I_MXI3_I315_MP1 (I3_n19_5 DIVQ_19 VDD VDD) gpdk090_pmos1v w=0.24u l=0.1u ad=0.0528p as=0.0816p pd=0.68u ps=1.16u
    I_MXI3_I315_MP0 (VDD I3_SEL_DIV_b3_3 I3_n19_5 VDD) gpdk090_pmos1v w=0.24u l=0.1u ad=0.0816p as=0.0528p pd=1.16u ps=0.68u
    I_MXI3_I310_MP1 (I3_n19_0 AND_19 VDD VDD) gpdk090_pmos1v w=0.24u l=0.1u ad=0.0528p as=0.0816p pd=0.68u ps=1.16u
    I_MXI3_I310_MP0 (VDD I3_SEL_AND_b3_3 I3_n19_0 VDD) gpdk090_pmos1v w=0.24u l=0.1u ad=0.0816p as=0.0528p pd=1.16u ps=0.68u
    I_MXI3_I311_MP1 (I3_n19_1 OR_19 VDD VDD) gpdk090_pmos1v w=0.24u l=0.1u ad=0.0528p as=0.0816p pd=0.68u ps=1.16u
    I_MXI3_I311_MP0 (VDD I3_SEL_OR_b3_3 I3_n19_1 VDD) gpdk090_pmos1v w=0.24u l=0.1u ad=0.0816p as=0.0528p pd=1.16u ps=0.68u
    I_MXI3_I316_MP1 (I3_o19_0 I3_n19_1 VDD VDD) gpdk090_pmos1v w=0.24u l=0.1u ad=0.0528p as=0.0816p pd=0.68u ps=1.16u
    I_MXI3_I316_MP0 (VDD I3_n19_0 I3_o19_0 VDD) gpdk090_pmos1v w=0.24u l=0.1u ad=0.0816p as=0.0528p pd=1.16u ps=0.68u
    I_MXI4_I36_MP1 (I4_z1_4 I4_z0_9 VDD VDD) gpdk090_pmos1v w=0.24u l=0.1u ad=0.0528p as=0.0816p pd=0.68u ps=1.16u
    I_MXI4_I36_MP0 (VDD I4_z0_8 I4_z1_4 VDD) gpdk090_pmos1v w=0.24u l=0.1u ad=0.0816p as=0.0528p pd=1.16u ps=0.68u
    I_MXI3_I304_MP1 (I3_o18_0 I3_n18_1 VDD VDD) gpdk090_pmos1v w=0.24u l=0.1u ad=0.0528p as=0.0816p pd=0.68u ps=1.16u
    I_MXI3_I304_MP0 (VDD I3_n18_0 I3_o18_0 VDD) gpdk090_pmos1v w=0.24u l=0.1u ad=0.0816p as=0.0528p pd=1.16u ps=0.68u
    I_MXI3_I298_MP1 (I3_n18_0 AND_18 VDD VDD) gpdk090_pmos1v w=0.24u l=0.1u ad=0.0528p as=0.0816p pd=0.68u ps=1.16u
    I_MXI3_I298_MP0 (VDD I3_SEL_AND_b3_3 I3_n18_0 VDD) gpdk090_pmos1v w=0.24u l=0.1u ad=0.0816p as=0.0528p pd=1.16u ps=0.68u
    I_MXI3_I299_MP1 (I3_n18_1 OR_18 VDD VDD) gpdk090_pmos1v w=0.24u l=0.1u ad=0.0528p as=0.0816p pd=0.68u ps=1.16u
    I_MXI3_I299_MP0 (VDD I3_SEL_OR_b3_3 I3_n18_1 VDD) gpdk090_pmos1v w=0.24u l=0.1u ad=0.0816p as=0.0528p pd=1.16u ps=0.68u
    I_MXI3_I288_MP1 (I3_n17_2 XOR_17 VDD VDD) gpdk090_pmos1v w=0.24u l=0.1u ad=0.0528p as=0.0816p pd=0.68u ps=1.16u
    I_MXI3_I288_MP0 (VDD I3_SEL_XOR_b3_3 I3_n17_2 VDD) gpdk090_pmos1v w=0.24u l=0.1u ad=0.0816p as=0.0528p pd=1.16u ps=0.68u
    I_MXI2_I102_MP1 (I2_nand17 B_17 VDD VDD) gpdk090_pmos1v w=0.24u l=0.1u ad=0.0528p as=0.0816p pd=0.68u ps=1.16u
    I_MXI2_I102_MP0 (VDD A_17 I2_nand17 VDD) gpdk090_pmos1v w=0.24u l=0.1u ad=0.0816p as=0.0528p pd=1.16u ps=0.68u
    I_MXI3_I286_MP1 (I3_n17_0 AND_17 VDD VDD) gpdk090_pmos1v w=0.24u l=0.1u ad=0.0528p as=0.0816p pd=0.68u ps=1.16u
    I_MXI3_I286_MP0 (VDD I3_SEL_AND_b3_3 I3_n17_0 VDD) gpdk090_pmos1v w=0.24u l=0.1u ad=0.0816p as=0.0528p pd=1.16u ps=0.68u
    I_MXI4_I29_MP0 (XI4_I29_p1 Y_58 VDD VDD) gpdk090_pmos1v w=0.48u l=0.1u ad=0.1056p as=0.1632p pd=0.92u ps=1.64u
    I_MXI4_I29_MP1 (I4_z0_29 Y_59 XI4_I29_p1 VDD) gpdk090_pmos1v w=0.48u l=0.1u ad=0.1632p as=0.1056p pd=1.64u ps=0.92u
    I_MXI4_I30_MP0 (XI4_I30_p1 Y_60 VDD VDD) gpdk090_pmos1v w=0.48u l=0.1u ad=0.1056p as=0.1632p pd=0.92u ps=1.64u
    I_MXI4_I30_MP1 (I4_z0_30 Y_61 XI4_I30_p1 VDD) gpdk090_pmos1v w=0.48u l=0.1u ad=0.1632p as=0.1056p pd=1.64u ps=0.92u
    I_MXI4_I3_MP0 (XI4_I3_p1 Y_6 VDD VDD) gpdk090_pmos1v w=0.48u l=0.1u ad=0.1056p as=0.1632p pd=0.92u ps=1.64u
    I_MXI4_I3_MP1 (I4_z0_3 Y_7 XI4_I3_p1 VDD) gpdk090_pmos1v w=0.48u l=0.1u ad=0.1632p as=0.1056p pd=1.64u ps=0.92u
    I_MXI2_I2_MP0 (XI2_I2_p1 A_0 VDD VDD) gpdk090_pmos1v w=0.48u l=0.1u ad=0.1056p as=0.1632p pd=0.92u ps=1.64u
    I_MXI2_I2_MP1 (I2_nor0 B_0 XI2_I2_p1 VDD) gpdk090_pmos1v w=0.48u l=0.1u ad=0.1632p as=0.1056p pd=1.64u ps=0.92u
    I_MXI4_I2_MP0 (XI4_I2_p1 Y_4 VDD VDD) gpdk090_pmos1v w=0.48u l=0.1u ad=0.1056p as=0.1632p pd=0.92u ps=1.64u
    I_MXI4_I2_MP1 (I4_z0_2 Y_5 XI4_I2_p1 VDD) gpdk090_pmos1v w=0.48u l=0.1u ad=0.1632p as=0.1056p pd=1.64u ps=0.92u
    I_MXI2_I8_MP0 (XI2_I8_p1 A_1 VDD VDD) gpdk090_pmos1v w=0.48u l=0.1u ad=0.1056p as=0.1632p pd=0.92u ps=1.64u
    I_MXI2_I8_MP1 (I2_nor1 B_1 XI2_I8_p1 VDD) gpdk090_pmos1v w=0.48u l=0.1u ad=0.1632p as=0.1056p pd=1.64u ps=0.92u
    I_MXI3_I139_MP0 (XI3_I139_p1 I3_o4_0 VDD VDD) gpdk090_pmos1v w=0.48u l=0.1u ad=0.1056p as=0.1632p pd=0.92u ps=1.64u
    I_MXI3_I139_MP1 (I3_q4_1 I3_o4_1 XI3_I139_p1 VDD) gpdk090_pmos1v w=0.48u l=0.1u ad=0.1632p as=0.1056p pd=1.64u ps=0.92u
    I_MXI4_I28_MP0 (XI4_I28_p1 Y_56 VDD VDD) gpdk090_pmos1v w=0.48u l=0.1u ad=0.1056p as=0.1632p pd=0.92u ps=1.64u
    I_MXI4_I28_MP1 (I4_z0_28 Y_57 XI4_I28_p1 VDD) gpdk090_pmos1v w=0.48u l=0.1u ad=0.1632p as=0.1056p pd=1.64u ps=0.92u
    I_MXI4_I55_MP0 (XI4_I55_p1 I4_z1_14 VDD VDD) gpdk090_pmos1v w=0.48u l=0.1u ad=0.1056p as=0.1632p pd=0.92u ps=1.64u
    I_MXI4_I55_MP1 (I4_z2_7 I4_z1_15 XI4_I55_p1 VDD) gpdk090_pmos1v w=0.48u l=0.1u ad=0.1632p as=0.1056p pd=1.64u ps=0.92u
    I_MXI4_I31_MP0 (XI4_I31_p1 Y_62 VDD VDD) gpdk090_pmos1v w=0.48u l=0.1u ad=0.1056p as=0.1632p pd=0.92u ps=1.64u
    I_MXI4_I31_MP1 (I4_z0_31 Y_63 XI4_I31_p1 VDD) gpdk090_pmos1v w=0.48u l=0.1u ad=0.1632p as=0.1056p pd=1.64u ps=0.92u
    I_MXI2_I50_MP0 (XI2_I50_p1 A_8 VDD VDD) gpdk090_pmos1v w=0.48u l=0.1u ad=0.1056p as=0.1632p pd=0.92u ps=1.64u
    I_MXI2_I50_MP1 (I2_nor8 B_8 XI2_I50_p1 VDD) gpdk090_pmos1v w=0.48u l=0.1u ad=0.1632p as=0.1056p pd=1.64u ps=0.92u
    I_MXI2_I56_MP0 (XI2_I56_p1 A_9 VDD VDD) gpdk090_pmos1v w=0.48u l=0.1u ad=0.1056p as=0.1632p pd=0.92u ps=1.64u
    I_MXI2_I56_MP1 (I2_nor9 B_9 XI2_I56_p1 VDD) gpdk090_pmos1v w=0.48u l=0.1u ad=0.1632p as=0.1056p pd=1.64u ps=0.92u
    I_MXI3_I163_MP0 (XI3_I163_p1 I3_o6_0 VDD VDD) gpdk090_pmos1v w=0.48u l=0.1u ad=0.1056p as=0.1632p pd=0.92u ps=1.64u
    I_MXI3_I163_MP1 (I3_q6_1 I3_o6_1 XI3_I163_p1 VDD) gpdk090_pmos1v w=0.48u l=0.1u ad=0.1632p as=0.1056p pd=1.64u ps=0.92u
    I_MXI2_I38_MP0 (XI2_I38_p1 A_6 VDD VDD) gpdk090_pmos1v w=0.48u l=0.1u ad=0.1056p as=0.1632p pd=0.92u ps=1.64u
    I_MXI2_I38_MP1 (I2_nor6 B_6 XI2_I38_p1 VDD) gpdk090_pmos1v w=0.48u l=0.1u ad=0.1632p as=0.1056p pd=1.64u ps=0.92u
    I_MXI4_I48_MP0 (XI4_I48_p1 I4_z1_0 VDD VDD) gpdk090_pmos1v w=0.48u l=0.1u ad=0.1056p as=0.1632p pd=0.92u ps=1.64u
    I_MXI4_I48_MP1 (I4_z2_0 I4_z1_1 XI4_I48_p1 VDD) gpdk090_pmos1v w=0.48u l=0.1u ad=0.1632p as=0.1056p pd=1.64u ps=0.92u
    I_MXI3_I91_MP0 (XI3_I91_p1 I3_o0_0 VDD VDD) gpdk090_pmos1v w=0.48u l=0.1u ad=0.1056p as=0.1632p pd=0.92u ps=1.64u
    I_MXI3_I91_MP1 (I3_q0_1 I3_o0_1 XI3_I91_p1 VDD) gpdk090_pmos1v w=0.48u l=0.1u ad=0.1632p as=0.1056p pd=1.64u ps=0.92u
    I_MXI4_I0_MP0 (XI4_I0_p1 Y_0 VDD VDD) gpdk090_pmos1v w=0.48u l=0.1u ad=0.1056p as=0.1632p pd=0.92u ps=1.64u
    I_MXI4_I0_MP1 (I4_z0_0 Y_1 XI4_I0_p1 VDD) gpdk090_pmos1v w=0.48u l=0.1u ad=0.1632p as=0.1056p pd=1.64u ps=0.92u
    I_MXI3_I103_MP0 (XI3_I103_p1 I3_o1_0 VDD VDD) gpdk090_pmos1v w=0.48u l=0.1u ad=0.1056p as=0.1632p pd=0.92u ps=1.64u
    I_MXI3_I103_MP1 (I3_q1_1 I3_o1_1 XI3_I103_p1 VDD) gpdk090_pmos1v w=0.48u l=0.1u ad=0.1632p as=0.1056p pd=1.64u ps=0.92u
    I_MXI2_I26_MP0 (XI2_I26_p1 A_4 VDD VDD) gpdk090_pmos1v w=0.48u l=0.1u ad=0.1056p as=0.1632p pd=0.92u ps=1.64u
    I_MXI2_I26_MP1 (I2_nor4 B_4 XI2_I26_p1 VDD) gpdk090_pmos1v w=0.48u l=0.1u ad=0.1632p as=0.1056p pd=1.64u ps=0.92u
    I_MXI4_I26_MP0 (XI4_I26_p1 Y_52 VDD VDD) gpdk090_pmos1v w=0.48u l=0.1u ad=0.1056p as=0.1632p pd=0.92u ps=1.64u
    I_MXI4_I26_MP1 (I4_z0_26 Y_53 XI4_I26_p1 VDD) gpdk090_pmos1v w=0.48u l=0.1u ad=0.1632p as=0.1056p pd=1.64u ps=0.92u
    I_MXI4_I27_MP0 (XI4_I27_p1 Y_54 VDD VDD) gpdk090_pmos1v w=0.48u l=0.1u ad=0.1056p as=0.1632p pd=0.92u ps=1.64u
    I_MXI4_I27_MP1 (I4_z0_27 Y_55 XI4_I27_p1 VDD) gpdk090_pmos1v w=0.48u l=0.1u ad=0.1632p as=0.1056p pd=1.64u ps=0.92u
    I_MXI4_I54_MP0 (XI4_I54_p1 I4_z1_12 VDD VDD) gpdk090_pmos1v w=0.48u l=0.1u ad=0.1056p as=0.1632p pd=0.92u ps=1.64u
    I_MXI4_I54_MP1 (I4_z2_6 I4_z1_13 XI4_I54_p1 VDD) gpdk090_pmos1v w=0.48u l=0.1u ad=0.1632p as=0.1056p pd=1.64u ps=0.92u
    I_MXI4_I61_MP0 (XI4_I61_p1 I4_z3_2 VDD VDD) gpdk090_pmos1v w=0.48u l=0.1u ad=0.1056p as=0.1632p pd=0.92u ps=1.64u
    I_MXI4_I61_MP1 (I4_z4_1 I4_z3_3 XI4_I61_p1 VDD) gpdk090_pmos1v w=0.48u l=0.1u ad=0.1632p as=0.1056p pd=1.64u ps=0.92u
    I_MXI4_I22_MP0 (XI4_I22_p1 Y_44 VDD VDD) gpdk090_pmos1v w=0.48u l=0.1u ad=0.1056p as=0.1632p pd=0.92u ps=1.64u
    I_MXI4_I22_MP1 (I4_z0_22 Y_45 XI4_I22_p1 VDD) gpdk090_pmos1v w=0.48u l=0.1u ad=0.1632p as=0.1056p pd=1.64u ps=0.92u
    I_MXI3_I187_MP0 (XI3_I187_p1 I3_o8_0 VDD VDD) gpdk090_pmos1v w=0.48u l=0.1u ad=0.1056p as=0.1632p pd=0.92u ps=1.64u
    I_MXI3_I187_MP1 (I3_q8_1 I3_o8_1 XI3_I187_p1 VDD) gpdk090_pmos1v w=0.48u l=0.1u ad=0.1632p as=0.1056p pd=1.64u ps=0.92u
    I_MXI4_I4_MP0 (XI4_I4_p1 Y_8 VDD VDD) gpdk090_pmos1v w=0.48u l=0.1u ad=0.1056p as=0.1632p pd=0.92u ps=1.64u
    I_MXI4_I4_MP1 (I4_z0_4 Y_9 XI4_I4_p1 VDD) gpdk090_pmos1v w=0.48u l=0.1u ad=0.1632p as=0.1056p pd=1.64u ps=0.92u
    I_MXI3_I199_MP0 (XI3_I199_p1 I3_o9_0 VDD VDD) gpdk090_pmos1v w=0.48u l=0.1u ad=0.1056p as=0.1632p pd=0.92u ps=1.64u
    I_MXI3_I199_MP1 (I3_q9_1 I3_o9_1 XI3_I199_p1 VDD) gpdk090_pmos1v w=0.48u l=0.1u ad=0.1632p as=0.1056p pd=1.64u ps=0.92u
    I_MXI2_I44_MP0 (XI2_I44_p1 A_7 VDD VDD) gpdk090_pmos1v w=0.48u l=0.1u ad=0.1056p as=0.1632p pd=0.92u ps=1.64u
    I_MXI2_I44_MP1 (I2_nor7 B_7 XI2_I44_p1 VDD) gpdk090_pmos1v w=0.48u l=0.1u ad=0.1632p as=0.1056p pd=1.64u ps=0.92u
    I_MXI2_I14_MP0 (XI2_I14_p1 A_2 VDD VDD) gpdk090_pmos1v w=0.48u l=0.1u ad=0.1056p as=0.1632p pd=0.92u ps=1.64u
    I_MXI2_I14_MP1 (I2_nor2 B_2 XI2_I14_p1 VDD) gpdk090_pmos1v w=0.48u l=0.1u ad=0.1632p as=0.1056p pd=1.64u ps=0.92u
    I_MXI4_I24_MP0 (XI4_I24_p1 Y_48 VDD VDD) gpdk090_pmos1v w=0.48u l=0.1u ad=0.1056p as=0.1632p pd=0.92u ps=1.64u
    I_MXI4_I24_MP1 (I4_z0_24 Y_49 XI4_I24_p1 VDD) gpdk090_pmos1v w=0.48u l=0.1u ad=0.1632p as=0.1056p pd=1.64u ps=0.92u
    I_MXI4_I25_MP0 (XI4_I25_p1 Y_50 VDD VDD) gpdk090_pmos1v w=0.48u l=0.1u ad=0.1056p as=0.1632p pd=0.92u ps=1.64u
    I_MXI4_I25_MP1 (I4_z0_25 Y_51 XI4_I25_p1 VDD) gpdk090_pmos1v w=0.48u l=0.1u ad=0.1632p as=0.1056p pd=1.64u ps=0.92u
    I_MXI4_I23_MP0 (XI4_I23_p1 Y_46 VDD VDD) gpdk090_pmos1v w=0.48u l=0.1u ad=0.1056p as=0.1632p pd=0.92u ps=1.64u
    I_MXI4_I23_MP1 (I4_z0_23 Y_47 XI4_I23_p1 VDD) gpdk090_pmos1v w=0.48u l=0.1u ad=0.1632p as=0.1056p pd=1.64u ps=0.92u
    I_MXI4_I53_MP0 (XI4_I53_p1 I4_z1_10 VDD VDD) gpdk090_pmos1v w=0.48u l=0.1u ad=0.1056p as=0.1632p pd=0.92u ps=1.64u
    I_MXI4_I53_MP1 (I4_z2_5 I4_z1_11 XI4_I53_p1 VDD) gpdk090_pmos1v w=0.48u l=0.1u ad=0.1632p as=0.1056p pd=1.64u ps=0.92u
    I_MXI4_I21_MP0 (XI4_I21_p1 Y_42 VDD VDD) gpdk090_pmos1v w=0.48u l=0.1u ad=0.1056p as=0.1632p pd=0.92u ps=1.64u
    I_MXI4_I21_MP1 (I4_z0_21 Y_43 XI4_I21_p1 VDD) gpdk090_pmos1v w=0.48u l=0.1u ad=0.1632p as=0.1056p pd=1.64u ps=0.92u
    I_MXI4_I60_MP0 (XI4_I60_p1 I4_z3_0 VDD VDD) gpdk090_pmos1v w=0.48u l=0.1u ad=0.1056p as=0.1632p pd=0.92u ps=1.64u
    I_MXI4_I60_MP1 (I4_z4_0 I4_z3_1 XI4_I60_p1 VDD) gpdk090_pmos1v w=0.48u l=0.1u ad=0.1632p as=0.1056p pd=1.64u ps=0.92u
    I_MXI3_I211_MP0 (XI3_I211_p1 I3_o10_0 VDD VDD) gpdk090_pmos1v w=0.48u l=0.1u ad=0.1056p as=0.1632p pd=0.92u ps=1.64u
    I_MXI3_I211_MP1 (I3_q10_1 I3_o10_1 XI3_I211_p1 VDD) gpdk090_pmos1v w=0.48u l=0.1u ad=0.1632p as=0.1056p pd=1.64u ps=0.92u
    I_MXI4_I5_MP0 (XI4_I5_p1 Y_10 VDD VDD) gpdk090_pmos1v w=0.48u l=0.1u ad=0.1056p as=0.1632p pd=0.92u ps=1.64u
    I_MXI4_I5_MP1 (I4_z0_5 Y_11 XI4_I5_p1 VDD) gpdk090_pmos1v w=0.48u l=0.1u ad=0.1632p as=0.1056p pd=1.64u ps=0.92u
    I_MXI3_I175_MP0 (XI3_I175_p1 I3_o7_0 VDD VDD) gpdk090_pmos1v w=0.48u l=0.1u ad=0.1056p as=0.1632p pd=0.92u ps=1.64u
    I_MXI3_I175_MP1 (I3_q7_1 I3_o7_1 XI3_I175_p1 VDD) gpdk090_pmos1v w=0.48u l=0.1u ad=0.1632p as=0.1056p pd=1.64u ps=0.92u
    I_MXI4_I49_MP0 (XI4_I49_p1 I4_z1_2 VDD VDD) gpdk090_pmos1v w=0.48u l=0.1u ad=0.1056p as=0.1632p pd=0.92u ps=1.64u
    I_MXI4_I49_MP1 (I4_z2_1 I4_z1_3 XI4_I49_p1 VDD) gpdk090_pmos1v w=0.48u l=0.1u ad=0.1632p as=0.1056p pd=1.64u ps=0.92u
    I_MXI3_I151_MP0 (XI3_I151_p1 I3_o5_0 VDD VDD) gpdk090_pmos1v w=0.48u l=0.1u ad=0.1056p as=0.1632p pd=0.92u ps=1.64u
    I_MXI3_I151_MP1 (I3_q5_1 I3_o5_1 XI3_I151_p1 VDD) gpdk090_pmos1v w=0.48u l=0.1u ad=0.1632p as=0.1056p pd=1.64u ps=0.92u
    I_MXI3_I115_MP0 (XI3_I115_p1 I3_o2_0 VDD VDD) gpdk090_pmos1v w=0.48u l=0.1u ad=0.1056p as=0.1632p pd=0.92u ps=1.64u
    I_MXI3_I115_MP1 (I3_q2_1 I3_o2_1 XI3_I115_p1 VDD) gpdk090_pmos1v w=0.48u l=0.1u ad=0.1632p as=0.1056p pd=1.64u ps=0.92u
    I_MXI4_I20_MP0 (XI4_I20_p1 Y_40 VDD VDD) gpdk090_pmos1v w=0.48u l=0.1u ad=0.1056p as=0.1632p pd=0.92u ps=1.64u
    I_MXI4_I20_MP1 (I4_z0_20 Y_41 XI4_I20_p1 VDD) gpdk090_pmos1v w=0.48u l=0.1u ad=0.1632p as=0.1056p pd=1.64u ps=0.92u
    I_MXI2_I62_MP0 (XI2_I62_p1 A_10 VDD VDD) gpdk090_pmos1v w=0.48u l=0.1u ad=0.1056p as=0.1632p pd=0.92u ps=1.64u
    I_MXI2_I62_MP1 (I2_nor10 B_10 XI2_I62_p1 VDD) gpdk090_pmos1v w=0.48u l=0.1u ad=0.1632p as=0.1056p pd=1.64u ps=0.92u
    I_MXI2_I32_MP0 (XI2_I32_p1 A_5 VDD VDD) gpdk090_pmos1v w=0.48u l=0.1u ad=0.1056p as=0.1632p pd=0.92u ps=1.64u
    I_MXI2_I32_MP1 (I2_nor5 B_5 XI2_I32_p1 VDD) gpdk090_pmos1v w=0.48u l=0.1u ad=0.1632p as=0.1056p pd=1.64u ps=0.92u
    I_MXI4_I1_MP0 (XI4_I1_p1 Y_2 VDD VDD) gpdk090_pmos1v w=0.48u l=0.1u ad=0.1056p as=0.1632p pd=0.92u ps=1.64u
    I_MXI4_I1_MP1 (I4_z0_1 Y_3 XI4_I1_p1 VDD) gpdk090_pmos1v w=0.48u l=0.1u ad=0.1632p as=0.1056p pd=1.64u ps=0.92u
    I_MXI3_I127_MP0 (XI3_I127_p1 I3_o3_0 VDD VDD) gpdk090_pmos1v w=0.48u l=0.1u ad=0.1056p as=0.1632p pd=0.92u ps=1.64u
    I_MXI3_I127_MP1 (I3_q3_1 I3_o3_1 XI3_I127_p1 VDD) gpdk090_pmos1v w=0.48u l=0.1u ad=0.1632p as=0.1056p pd=1.64u ps=0.92u
    I_MXI4_I19_MP0 (XI4_I19_p1 Y_38 VDD VDD) gpdk090_pmos1v w=0.48u l=0.1u ad=0.1056p as=0.1632p pd=0.92u ps=1.64u
    I_MXI4_I19_MP1 (I4_z0_19 Y_39 XI4_I19_p1 VDD) gpdk090_pmos1v w=0.48u l=0.1u ad=0.1632p as=0.1056p pd=1.64u ps=0.92u
    I_MXI4_I52_MP0 (XI4_I52_p1 I4_z1_8 VDD VDD) gpdk090_pmos1v w=0.48u l=0.1u ad=0.1056p as=0.1632p pd=0.92u ps=1.64u
    I_MXI4_I52_MP1 (I4_z2_4 I4_z1_9 XI4_I52_p1 VDD) gpdk090_pmos1v w=0.48u l=0.1u ad=0.1632p as=0.1056p pd=1.64u ps=0.92u
    I_MXI0_I16_MP0 (XI0_I16_p1 I0_h10 VDD VDD) gpdk090_pmos1v w=0.48u l=0.1u ad=0.1056p as=0.1632p pd=0.92u ps=1.64u
    I_MXI0_I16_MP1 (SEL_MUL I0_l01 XI0_I16_p1 VDD) gpdk090_pmos1v w=0.48u l=0.1u ad=0.1632p as=0.1056p pd=1.64u ps=0.92u
    I_MXI0_I15_MP0 (XI0_I15_p1 I0_h01 VDD VDD) gpdk090_pmos1v w=0.48u l=0.1u ad=0.1056p as=0.1632p pd=0.92u ps=1.64u
    I_MXI0_I15_MP1 (SEL_NOT I0_l01 XI0_I15_p1 VDD) gpdk090_pmos1v w=0.48u l=0.1u ad=0.1632p as=0.1056p pd=1.64u ps=0.92u
    I_MXI1_I42_I71_XP_MP0 (XI1_I42_I71_XP_p1 I1_I42_pn5 VDD VDD) gpdk090_pmos1v w=0.48u l=0.1u ad=0.1056p as=0.1632p pd=0.92u ps=1.64u
    I_MXI1_I42_I71_XP_MP1 (I1_I42_P5_4 I1_I42_pn4 XI1_I42_I71_XP_p1 VDD) gpdk090_pmos1v w=0.48u l=0.1u ad=0.1632p as=0.1056p pd=1.64u ps=0.92u
    I_MXI4_I18_MP0 (XI4_I18_p1 Y_36 VDD VDD) gpdk090_pmos1v w=0.48u l=0.1u ad=0.1056p as=0.1632p pd=0.92u ps=1.64u
    I_MXI4_I18_MP1 (I4_z0_18 Y_37 XI4_I18_p1 VDD) gpdk090_pmos1v w=0.48u l=0.1u ad=0.1632p as=0.1056p pd=1.64u ps=0.92u
    I_MXI4_I17_MP0 (XI4_I17_p1 Y_34 VDD VDD) gpdk090_pmos1v w=0.48u l=0.1u ad=0.1056p as=0.1632p pd=0.92u ps=1.64u
    I_MXI4_I17_MP1 (I4_z0_17 Y_35 XI4_I17_p1 VDD) gpdk090_pmos1v w=0.48u l=0.1u ad=0.1632p as=0.1056p pd=1.64u ps=0.92u
    I_MXI4_I16_MP0 (XI4_I16_p1 Y_32 VDD VDD) gpdk090_pmos1v w=0.48u l=0.1u ad=0.1056p as=0.1632p pd=0.92u ps=1.64u
    I_MXI4_I16_MP1 (I4_z0_16 Y_33 XI4_I16_p1 VDD) gpdk090_pmos1v w=0.48u l=0.1u ad=0.1632p as=0.1056p pd=1.64u ps=0.92u
    I_MXI0_I17_MP0 (XI0_I17_p1 I0_h10 VDD VDD) gpdk090_pmos1v w=0.48u l=0.1u ad=0.1056p as=0.1632p pd=0.92u ps=1.64u
    I_MXI0_I17_MP1 (SEL_DIV I0_l11 XI0_I17_p1 VDD) gpdk090_pmos1v w=0.48u l=0.1u ad=0.1632p as=0.1056p pd=1.64u ps=0.92u
    I_MXI0_I13_MP0 (XI0_I13_p1 I0_h00 VDD VDD) gpdk090_pmos1v w=0.48u l=0.1u ad=0.1056p as=0.1632p pd=0.92u ps=1.64u
    I_MXI0_I13_MP1 (SEL_OR I0_l11 XI0_I13_p1 VDD) gpdk090_pmos1v w=0.48u l=0.1u ad=0.1632p as=0.1056p pd=1.64u ps=0.92u
    I_MXI0_I14_MP0 (XI0_I14_p1 I0_h01 VDD VDD) gpdk090_pmos1v w=0.48u l=0.1u ad=0.1056p as=0.1632p pd=0.92u ps=1.64u
    I_MXI0_I14_MP1 (SEL_XOR I0_l00 XI0_I14_p1 VDD) gpdk090_pmos1v w=0.48u l=0.1u ad=0.1632p as=0.1056p pd=1.64u ps=0.92u
    I_MXI1_I42_I134_XP_MP0 (XI1_I42_I134_XP_p1 I1_I42_P9_6n VDD VDD) gpdk090_pmos1v w=0.48u l=0.1u ad=0.1056p as=0.1632p pd=0.92u ps=1.64u
    I_MXI1_I42_I134_XP_MP1 (I1_I42_P9_2 I1_I42_P5_2n XI1_I42_I134_XP_p1 VDD) gpdk090_pmos1v w=0.48u l=0.1u ad=0.1632p as=0.1056p pd=1.64u ps=0.92u
    I_MXI1_I42_I75_XP_MP0 (XI1_I42_I75_XP_p1 I1_I42_pn9 VDD VDD) gpdk090_pmos1v w=0.48u l=0.1u ad=0.1056p as=0.1632p pd=0.92u ps=1.64u
    I_MXI1_I42_I75_XP_MP1 (I1_I42_P9_8 I1_I42_pn8 XI1_I42_I75_XP_p1 VDD) gpdk090_pmos1v w=0.48u l=0.1u ad=0.1632p as=0.1056p pd=1.64u ps=0.92u
    I_MXI1_I42_I76_XP_MP0 (XI1_I42_I76_XP_p1 I1_I42_pn10 VDD VDD) gpdk090_pmos1v w=0.48u l=0.1u ad=0.1056p as=0.1632p pd=0.92u ps=1.64u
    I_MXI1_I42_I76_XP_MP1 (I1_I42_P10_9 I1_I42_pn9 XI1_I42_I76_XP_p1 VDD) gpdk090_pmos1v w=0.48u l=0.1u ad=0.1632p as=0.1056p pd=1.64u ps=0.92u
    I_MXI1_I42_I73_XP_MP0 (XI1_I42_I73_XP_p1 I1_I42_pn7 VDD VDD) gpdk090_pmos1v w=0.48u l=0.1u ad=0.1056p as=0.1632p pd=0.92u ps=1.64u
    I_MXI1_I42_I73_XP_MP1 (I1_I42_P7_6 I1_I42_pn6 XI1_I42_I73_XP_p1 VDD) gpdk090_pmos1v w=0.48u l=0.1u ad=0.1632p as=0.1056p pd=1.64u ps=0.92u
    I_MXI1_I42_I74_XP_MP0 (XI1_I42_I74_XP_p1 I1_I42_pn8 VDD VDD) gpdk090_pmos1v w=0.48u l=0.1u ad=0.1056p as=0.1632p pd=0.92u ps=1.64u
    I_MXI1_I42_I74_XP_MP1 (I1_I42_P8_7 I1_I42_pn7 XI1_I42_I74_XP_p1 VDD) gpdk090_pmos1v w=0.48u l=0.1u ad=0.1632p as=0.1056p pd=1.64u ps=0.92u
    I_MXI1_I42_I72_XP_MP0 (XI1_I42_I72_XP_p1 I1_I42_pn6 VDD VDD) gpdk090_pmos1v w=0.48u l=0.1u ad=0.1056p as=0.1632p pd=0.92u ps=1.64u
    I_MXI1_I42_I72_XP_MP1 (I1_I42_P6_5 I1_I42_pn5 XI1_I42_I72_XP_p1 VDD) gpdk090_pmos1v w=0.48u l=0.1u ad=0.1632p as=0.1056p pd=1.64u ps=0.92u
    I_MXI1_I42_I70_XP_MP0 (XI1_I42_I70_XP_p1 I1_I42_pn4 VDD VDD) gpdk090_pmos1v w=0.48u l=0.1u ad=0.1056p as=0.1632p pd=0.92u ps=1.64u
    I_MXI1_I42_I70_XP_MP1 (I1_I42_P4_3 I1_I42_pn3 XI1_I42_I70_XP_p1 VDD) gpdk090_pmos1v w=0.48u l=0.1u ad=0.1632p as=0.1056p pd=1.64u ps=0.92u
    I_MXI1_I42_I69_XP_MP0 (XI1_I42_I69_XP_p1 I1_I42_pn3 VDD VDD) gpdk090_pmos1v w=0.48u l=0.1u ad=0.1056p as=0.1632p pd=0.92u ps=1.64u
    I_MXI1_I42_I69_XP_MP1 (I1_I42_P3_2 I1_I42_pn2 XI1_I42_I69_XP_p1 VDD) gpdk090_pmos1v w=0.48u l=0.1u ad=0.1632p as=0.1056p pd=1.64u ps=0.92u
    I_MXI1_I42_I68_XP_MP0 (XI1_I42_I68_XP_p1 I1_I42_pn2 VDD VDD) gpdk090_pmos1v w=0.48u l=0.1u ad=0.1056p as=0.1632p pd=0.92u ps=1.64u
    I_MXI1_I42_I68_XP_MP1 (I1_I42_P2_1 I1_I42_pn1 XI1_I42_I68_XP_p1 VDD) gpdk090_pmos1v w=0.48u l=0.1u ad=0.1632p as=0.1056p pd=1.64u ps=0.92u
    I_MXI2_I20_MP0 (XI2_I20_p1 A_3 VDD VDD) gpdk090_pmos1v w=0.48u l=0.1u ad=0.1056p as=0.1632p pd=0.92u ps=1.64u
    I_MXI2_I20_MP1 (I2_nor3 B_3 XI2_I20_p1 VDD) gpdk090_pmos1v w=0.48u l=0.1u ad=0.1632p as=0.1056p pd=1.64u ps=0.92u
    I_MXI0_I11_MP0 (XI0_I11_p1 I0_h00 VDD VDD) gpdk090_pmos1v w=0.48u l=0.1u ad=0.1056p as=0.1632p pd=0.92u ps=1.64u
    I_MXI0_I11_MP1 (SEL_AS OP_1 XI0_I11_p1 VDD) gpdk090_pmos1v w=0.48u l=0.1u ad=0.1632p as=0.1056p pd=1.64u ps=0.92u
    I_MXI0_I12_MP0 (XI0_I12_p1 I0_h00 VDD VDD) gpdk090_pmos1v w=0.48u l=0.1u ad=0.1056p as=0.1632p pd=0.92u ps=1.64u
    I_MXI0_I12_MP1 (SEL_AND I0_l10 XI0_I12_p1 VDD) gpdk090_pmos1v w=0.48u l=0.1u ad=0.1632p as=0.1056p pd=1.64u ps=0.92u
    I_MXI1_I42_I77_XP_MP0 (XI1_I42_I77_XP_p1 I1_I42_pn11 VDD VDD) gpdk090_pmos1v w=0.48u l=0.1u ad=0.1056p as=0.1632p pd=0.92u ps=1.64u
    I_MXI1_I42_I77_XP_MP1 (I1_I42_P11_10 I1_I42_pn10 XI1_I42_I77_XP_p1 VDD) gpdk090_pmos1v w=0.48u l=0.1u ad=0.1632p as=0.1056p pd=1.64u ps=0.92u
    I_MXI1_I42_I136_XP_MP0 (XI1_I42_I136_XP_p1 I1_I42_P11_8n VDD VDD) gpdk090_pmos1v w=0.48u l=0.1u ad=0.1056p as=0.1632p pd=0.92u ps=1.64u
    I_MXI1_I42_I136_XP_MP1 (I1_I42_P11_4 I1_I42_P7_4n XI1_I42_I136_XP_p1 VDD) gpdk090_pmos1v w=0.48u l=0.1u ad=0.1632p as=0.1056p pd=1.64u ps=0.92u
    I_MXI1_I42_I133_XP_MP0 (XI1_I42_I133_XP_p1 I1_I42_P8_5n VDD VDD) gpdk090_pmos1v w=0.48u l=0.1u ad=0.1056p as=0.1632p pd=0.92u ps=1.64u
    I_MXI1_I42_I133_XP_MP1 (I1_I42_P8_1 I1_I42_P4_1n XI1_I42_I133_XP_p1 VDD) gpdk090_pmos1v w=0.48u l=0.1u ad=0.1632p as=0.1056p pd=1.64u ps=0.92u
    I_MXI3_I223_MP0 (XI3_I223_p1 I3_o11_0 VDD VDD) gpdk090_pmos1v w=0.48u l=0.1u ad=0.1056p as=0.1632p pd=0.92u ps=1.64u
    I_MXI3_I223_MP1 (I3_q11_1 I3_o11_1 XI3_I223_p1 VDD) gpdk090_pmos1v w=0.48u l=0.1u ad=0.1632p as=0.1056p pd=1.64u ps=0.92u
    I_MXI2_I68_MP0 (XI2_I68_p1 A_11 VDD VDD) gpdk090_pmos1v w=0.48u l=0.1u ad=0.1056p as=0.1632p pd=0.92u ps=1.64u
    I_MXI2_I68_MP1 (I2_nor11 B_11 XI2_I68_p1 VDD) gpdk090_pmos1v w=0.48u l=0.1u ad=0.1632p as=0.1056p pd=1.64u ps=0.92u
    I_MXI2_I182_MP0 (XI2_I182_p1 A_30 VDD VDD) gpdk090_pmos1v w=0.48u l=0.1u ad=0.1056p as=0.1632p pd=0.92u ps=1.64u
    I_MXI2_I182_MP1 (I2_nor30 B_30 XI2_I182_p1 VDD) gpdk090_pmos1v w=0.48u l=0.1u ad=0.1632p as=0.1056p pd=1.64u ps=0.92u
    I_MXI3_I451_MP0 (XI3_I451_p1 I3_o30_0 VDD VDD) gpdk090_pmos1v w=0.48u l=0.1u ad=0.1056p as=0.1632p pd=0.92u ps=1.64u
    I_MXI3_I451_MP1 (I3_q30_1 I3_o30_1 XI3_I451_p1 VDD) gpdk090_pmos1v w=0.48u l=0.1u ad=0.1632p as=0.1056p pd=1.64u ps=0.92u
    I_MXI3_I463_MP0 (XI3_I463_p1 I3_o31_0 VDD VDD) gpdk090_pmos1v w=0.48u l=0.1u ad=0.1056p as=0.1632p pd=0.92u ps=1.64u
    I_MXI3_I463_MP1 (I3_q31_1 I3_o31_1 XI3_I463_p1 VDD) gpdk090_pmos1v w=0.48u l=0.1u ad=0.1632p as=0.1056p pd=1.64u ps=0.92u
    I_MXI1_I42_I142_XP_MP0 (XI1_I42_I142_XP_p1 I1_I42_P17_14n VDD VDD) gpdk090_pmos1v w=0.48u l=0.1u ad=0.1056p as=0.1632p pd=0.92u ps=1.64u
    I_MXI1_I42_I142_XP_MP1 (I1_I42_P17_10 I1_I42_P13_10n XI1_I42_I142_XP_p1 VDD) gpdk090_pmos1v w=0.48u l=0.1u ad=0.1632p as=0.1056p pd=1.64u ps=0.92u
    I_MXI1_I42_I138_XP_MP0 (XI1_I42_I138_XP_p1 I1_I42_P13_10n VDD VDD) gpdk090_pmos1v w=0.48u l=0.1u ad=0.1056p as=0.1632p pd=0.92u ps=1.64u
    I_MXI1_I42_I138_XP_MP1 (I1_I42_P13_6 I1_I42_P9_6n XI1_I42_I138_XP_p1 VDD) gpdk090_pmos1v w=0.48u l=0.1u ad=0.1632p as=0.1056p pd=1.64u ps=0.92u
    I_MXI1_I42_I135_XP_MP0 (XI1_I42_I135_XP_p1 I1_I42_P10_7n VDD VDD) gpdk090_pmos1v w=0.48u l=0.1u ad=0.1056p as=0.1632p pd=0.92u ps=1.64u
    I_MXI1_I42_I135_XP_MP1 (I1_I42_P10_3 I1_I42_P6_3n XI1_I42_I135_XP_p1 VDD) gpdk090_pmos1v w=0.48u l=0.1u ad=0.1632p as=0.1056p pd=1.64u ps=0.92u
    I_MXI1_I42_I78_XP_MP0 (XI1_I42_I78_XP_p1 I1_I42_pn12 VDD VDD) gpdk090_pmos1v w=0.48u l=0.1u ad=0.1056p as=0.1632p pd=0.92u ps=1.64u
    I_MXI1_I42_I78_XP_MP1 (I1_I42_P12_11 I1_I42_pn11 XI1_I42_I78_XP_p1 VDD) gpdk090_pmos1v w=0.48u l=0.1u ad=0.1632p as=0.1056p pd=1.64u ps=0.92u
    I_MXI2_I74_MP0 (XI2_I74_p1 A_12 VDD VDD) gpdk090_pmos1v w=0.48u l=0.1u ad=0.1056p as=0.1632p pd=0.92u ps=1.64u
    I_MXI2_I74_MP1 (I2_nor12 B_12 XI2_I74_p1 VDD) gpdk090_pmos1v w=0.48u l=0.1u ad=0.1632p as=0.1056p pd=1.64u ps=0.92u
    I_MXI4_I15_MP0 (XI4_I15_p1 Y_30 VDD VDD) gpdk090_pmos1v w=0.48u l=0.1u ad=0.1056p as=0.1632p pd=0.92u ps=1.64u
    I_MXI4_I15_MP1 (I4_z0_15 Y_31 XI4_I15_p1 VDD) gpdk090_pmos1v w=0.48u l=0.1u ad=0.1632p as=0.1056p pd=1.64u ps=0.92u
    I_MXI2_I188_MP0 (XI2_I188_p1 A_31 VDD VDD) gpdk090_pmos1v w=0.48u l=0.1u ad=0.1056p as=0.1632p pd=0.92u ps=1.64u
    I_MXI2_I188_MP1 (I2_nor31 B_31 XI2_I188_p1 VDD) gpdk090_pmos1v w=0.48u l=0.1u ad=0.1632p as=0.1056p pd=1.64u ps=0.92u
    I_MXI1_I42_I97_XP_MP0 (XI1_I42_I97_XP_p1 I1_I42_pn31 VDD VDD) gpdk090_pmos1v w=0.48u l=0.1u ad=0.1056p as=0.1632p pd=0.92u ps=1.64u
    I_MXI1_I42_I97_XP_MP1 (I1_I42_P31_30 I1_I42_pn30 XI1_I42_I97_XP_p1 VDD) gpdk090_pmos1v w=0.48u l=0.1u ad=0.1632p as=0.1056p pd=1.64u ps=0.92u
    I_MXI1_I42_I154_XP_MP0 (XI1_I42_I154_XP_p1 I1_I42_P29_26n VDD VDD) gpdk090_pmos1v w=0.48u l=0.1u ad=0.1056p as=0.1632p pd=0.92u ps=1.64u
    I_MXI1_I42_I154_XP_MP1 (I1_I42_P29_22 I1_I42_P25_22n XI1_I42_I154_XP_p1 VDD) gpdk090_pmos1v w=0.48u l=0.1u ad=0.1632p as=0.1056p pd=1.64u ps=0.92u
    I_MXI1_I42_I150_XP_MP0 (XI1_I42_I150_XP_p1 I1_I42_P25_22n VDD VDD) gpdk090_pmos1v w=0.48u l=0.1u ad=0.1056p as=0.1632p pd=0.92u ps=1.64u
    I_MXI1_I42_I150_XP_MP1 (I1_I42_P25_18 I1_I42_P21_18n XI1_I42_I150_XP_p1 VDD) gpdk090_pmos1v w=0.48u l=0.1u ad=0.1632p as=0.1056p pd=1.64u ps=0.92u
    I_MXI1_I42_I146_XP_MP0 (XI1_I42_I146_XP_p1 I1_I42_P21_18n VDD VDD) gpdk090_pmos1v w=0.48u l=0.1u ad=0.1056p as=0.1632p pd=0.92u ps=1.64u
    I_MXI1_I42_I146_XP_MP1 (I1_I42_P21_14 I1_I42_P17_14n XI1_I42_I146_XP_p1 VDD) gpdk090_pmos1v w=0.48u l=0.1u ad=0.1632p as=0.1056p pd=1.64u ps=0.92u
    I_MXI1_I42_I140_XP_MP0 (XI1_I42_I140_XP_p1 I1_I42_P15_12n VDD VDD) gpdk090_pmos1v w=0.48u l=0.1u ad=0.1056p as=0.1632p pd=0.92u ps=1.64u
    I_MXI1_I42_I140_XP_MP1 (I1_I42_P15_8 I1_I42_P11_8n XI1_I42_I140_XP_p1 VDD) gpdk090_pmos1v w=0.48u l=0.1u ad=0.1632p as=0.1056p pd=1.64u ps=0.92u
    I_MXI1_I42_I137_XP_MP0 (XI1_I42_I137_XP_p1 I1_I42_P12_9n VDD VDD) gpdk090_pmos1v w=0.48u l=0.1u ad=0.1056p as=0.1632p pd=0.92u ps=1.64u
    I_MXI1_I42_I137_XP_MP1 (I1_I42_P12_5 I1_I42_P8_5n XI1_I42_I137_XP_p1 VDD) gpdk090_pmos1v w=0.48u l=0.1u ad=0.1632p as=0.1056p pd=1.64u ps=0.92u
    I_MXI1_I42_I141_XP_MP0 (XI1_I42_I141_XP_p1 I1_I42_P16_13n VDD VDD) gpdk090_pmos1v w=0.48u l=0.1u ad=0.1056p as=0.1632p pd=0.92u ps=1.64u
    I_MXI1_I42_I141_XP_MP1 (I1_I42_P16_9 I1_I42_P12_9n XI1_I42_I141_XP_p1 VDD) gpdk090_pmos1v w=0.48u l=0.1u ad=0.1632p as=0.1056p pd=1.64u ps=0.92u
    I_MXI1_I42_I79_XP_MP0 (XI1_I42_I79_XP_p1 I1_I42_pn13 VDD VDD) gpdk090_pmos1v w=0.48u l=0.1u ad=0.1056p as=0.1632p pd=0.92u ps=1.64u
    I_MXI1_I42_I79_XP_MP1 (I1_I42_P13_12 I1_I42_pn12 XI1_I42_I79_XP_p1 VDD) gpdk090_pmos1v w=0.48u l=0.1u ad=0.1632p as=0.1056p pd=1.64u ps=0.92u
    I_MXI2_I80_MP0 (XI2_I80_p1 A_13 VDD VDD) gpdk090_pmos1v w=0.48u l=0.1u ad=0.1056p as=0.1632p pd=0.92u ps=1.64u
    I_MXI2_I80_MP1 (I2_nor13 B_13 XI2_I80_p1 VDD) gpdk090_pmos1v w=0.48u l=0.1u ad=0.1632p as=0.1056p pd=1.64u ps=0.92u
    I_MXI3_I235_MP0 (XI3_I235_p1 I3_o12_0 VDD VDD) gpdk090_pmos1v w=0.48u l=0.1u ad=0.1056p as=0.1632p pd=0.92u ps=1.64u
    I_MXI3_I235_MP1 (I3_q12_1 I3_o12_1 XI3_I235_p1 VDD) gpdk090_pmos1v w=0.48u l=0.1u ad=0.1632p as=0.1056p pd=1.64u ps=0.92u
    I_MXI4_I6_MP0 (XI4_I6_p1 Y_12 VDD VDD) gpdk090_pmos1v w=0.48u l=0.1u ad=0.1056p as=0.1632p pd=0.92u ps=1.64u
    I_MXI4_I6_MP1 (I4_z0_6 Y_13 XI4_I6_p1 VDD) gpdk090_pmos1v w=0.48u l=0.1u ad=0.1632p as=0.1056p pd=1.64u ps=0.92u
    I_MXI4_I14_MP0 (XI4_I14_p1 Y_28 VDD VDD) gpdk090_pmos1v w=0.48u l=0.1u ad=0.1056p as=0.1632p pd=0.92u ps=1.64u
    I_MXI4_I14_MP1 (I4_z0_14 Y_29 XI4_I14_p1 VDD) gpdk090_pmos1v w=0.48u l=0.1u ad=0.1632p as=0.1056p pd=1.64u ps=0.92u
    I_MXI3_I439_MP0 (XI3_I439_p1 I3_o29_0 VDD VDD) gpdk090_pmos1v w=0.48u l=0.1u ad=0.1056p as=0.1632p pd=0.92u ps=1.64u
    I_MXI3_I439_MP1 (I3_q29_1 I3_o29_1 XI3_I439_p1 VDD) gpdk090_pmos1v w=0.48u l=0.1u ad=0.1632p as=0.1056p pd=1.64u ps=0.92u
    I_MXI2_I176_MP0 (XI2_I176_p1 A_29 VDD VDD) gpdk090_pmos1v w=0.48u l=0.1u ad=0.1056p as=0.1632p pd=0.92u ps=1.64u
    I_MXI2_I176_MP1 (I2_nor29 B_29 XI2_I176_p1 VDD) gpdk090_pmos1v w=0.48u l=0.1u ad=0.1632p as=0.1056p pd=1.64u ps=0.92u
    I_MXI1_I42_I156_XP_MP0 (XI1_I42_I156_XP_p1 I1_I42_P31_28n VDD VDD) gpdk090_pmos1v w=0.48u l=0.1u ad=0.1056p as=0.1632p pd=0.92u ps=1.64u
    I_MXI1_I42_I156_XP_MP1 (I1_I42_P31_24 I1_I42_P27_24n XI1_I42_I156_XP_p1 VDD) gpdk090_pmos1v w=0.48u l=0.1u ad=0.1632p as=0.1056p pd=1.64u ps=0.92u
    I_MXI1_I42_I144_XP_MP0 (XI1_I42_I144_XP_p1 I1_I42_P19_16n VDD VDD) gpdk090_pmos1v w=0.48u l=0.1u ad=0.1056p as=0.1632p pd=0.92u ps=1.64u
    I_MXI1_I42_I144_XP_MP1 (I1_I42_P19_12 I1_I42_P15_12n XI1_I42_I144_XP_p1 VDD) gpdk090_pmos1v w=0.48u l=0.1u ad=0.1632p as=0.1056p pd=1.64u ps=0.92u
    I_MXI1_I42_I81_XP_MP0 (XI1_I42_I81_XP_p1 I1_I42_pn15 VDD VDD) gpdk090_pmos1v w=0.48u l=0.1u ad=0.1056p as=0.1632p pd=0.92u ps=1.64u
    I_MXI1_I42_I81_XP_MP1 (I1_I42_P15_14 I1_I42_pn14 XI1_I42_I81_XP_p1 VDD) gpdk090_pmos1v w=0.48u l=0.1u ad=0.1632p as=0.1056p pd=1.64u ps=0.92u
    I_MXI3_I247_MP0 (XI3_I247_p1 I3_o13_0 VDD VDD) gpdk090_pmos1v w=0.48u l=0.1u ad=0.1056p as=0.1632p pd=0.92u ps=1.64u
    I_MXI3_I247_MP1 (I3_q13_1 I3_o13_1 XI3_I247_p1 VDD) gpdk090_pmos1v w=0.48u l=0.1u ad=0.1632p as=0.1056p pd=1.64u ps=0.92u
    I_MXI3_I427_MP0 (XI3_I427_p1 I3_o28_0 VDD VDD) gpdk090_pmos1v w=0.48u l=0.1u ad=0.1056p as=0.1632p pd=0.92u ps=1.64u
    I_MXI3_I427_MP1 (I3_q28_1 I3_o28_1 XI3_I427_p1 VDD) gpdk090_pmos1v w=0.48u l=0.1u ad=0.1632p as=0.1056p pd=1.64u ps=0.92u
    I_MXI1_I42_I96_XP_MP0 (XI1_I42_I96_XP_p1 I1_I42_pn30 VDD VDD) gpdk090_pmos1v w=0.48u l=0.1u ad=0.1056p as=0.1632p pd=0.92u ps=1.64u
    I_MXI1_I42_I96_XP_MP1 (I1_I42_P30_29 I1_I42_pn29 XI1_I42_I96_XP_p1 VDD) gpdk090_pmos1v w=0.48u l=0.1u ad=0.1632p as=0.1056p pd=1.64u ps=0.92u
    I_MXI1_I42_I95_XP_MP0 (XI1_I42_I95_XP_p1 I1_I42_pn29 VDD VDD) gpdk090_pmos1v w=0.48u l=0.1u ad=0.1056p as=0.1632p pd=0.92u ps=1.64u
    I_MXI1_I42_I95_XP_MP1 (I1_I42_P29_28 I1_I42_pn28 XI1_I42_I95_XP_p1 VDD) gpdk090_pmos1v w=0.48u l=0.1u ad=0.1632p as=0.1056p pd=1.64u ps=0.92u
    I_MXI1_I42_I152_XP_MP0 (XI1_I42_I152_XP_p1 I1_I42_P27_24n VDD VDD) gpdk090_pmos1v w=0.48u l=0.1u ad=0.1056p as=0.1632p pd=0.92u ps=1.64u
    I_MXI1_I42_I152_XP_MP1 (I1_I42_P27_20 I1_I42_P23_20n XI1_I42_I152_XP_p1 VDD) gpdk090_pmos1v w=0.48u l=0.1u ad=0.1632p as=0.1056p pd=1.64u ps=0.92u
    I_MXI1_I42_I148_XP_MP0 (XI1_I42_I148_XP_p1 I1_I42_P23_20n VDD VDD) gpdk090_pmos1v w=0.48u l=0.1u ad=0.1056p as=0.1632p pd=0.92u ps=1.64u
    I_MXI1_I42_I148_XP_MP1 (I1_I42_P23_16 I1_I42_P19_16n XI1_I42_I148_XP_p1 VDD) gpdk090_pmos1v w=0.48u l=0.1u ad=0.1632p as=0.1056p pd=1.64u ps=0.92u
    I_MXI1_I42_I139_XP_MP0 (XI1_I42_I139_XP_p1 I1_I42_P14_11n VDD VDD) gpdk090_pmos1v w=0.48u l=0.1u ad=0.1056p as=0.1632p pd=0.92u ps=1.64u
    I_MXI1_I42_I139_XP_MP1 (I1_I42_P14_7 I1_I42_P10_7n XI1_I42_I139_XP_p1 VDD) gpdk090_pmos1v w=0.48u l=0.1u ad=0.1632p as=0.1056p pd=1.64u ps=0.92u
    I_MXI1_I42_I145_XP_MP0 (XI1_I42_I145_XP_p1 I1_I42_P20_17n VDD VDD) gpdk090_pmos1v w=0.48u l=0.1u ad=0.1056p as=0.1632p pd=0.92u ps=1.64u
    I_MXI1_I42_I145_XP_MP1 (I1_I42_P20_13 I1_I42_P16_13n XI1_I42_I145_XP_p1 VDD) gpdk090_pmos1v w=0.48u l=0.1u ad=0.1632p as=0.1056p pd=1.64u ps=0.92u
    I_MXI1_I42_I80_XP_MP0 (XI1_I42_I80_XP_p1 I1_I42_pn14 VDD VDD) gpdk090_pmos1v w=0.48u l=0.1u ad=0.1056p as=0.1632p pd=0.92u ps=1.64u
    I_MXI1_I42_I80_XP_MP1 (I1_I42_P14_13 I1_I42_pn13 XI1_I42_I80_XP_p1 VDD) gpdk090_pmos1v w=0.48u l=0.1u ad=0.1632p as=0.1056p pd=1.64u ps=0.92u
    I_MXI3_I259_MP0 (XI3_I259_p1 I3_o14_0 VDD VDD) gpdk090_pmos1v w=0.48u l=0.1u ad=0.1056p as=0.1632p pd=0.92u ps=1.64u
    I_MXI3_I259_MP1 (I3_q14_1 I3_o14_1 XI3_I259_p1 VDD) gpdk090_pmos1v w=0.48u l=0.1u ad=0.1632p as=0.1056p pd=1.64u ps=0.92u
    I_MXI4_I7_MP0 (XI4_I7_p1 Y_14 VDD VDD) gpdk090_pmos1v w=0.48u l=0.1u ad=0.1056p as=0.1632p pd=0.92u ps=1.64u
    I_MXI4_I7_MP1 (I4_z0_7 Y_15 XI4_I7_p1 VDD) gpdk090_pmos1v w=0.48u l=0.1u ad=0.1632p as=0.1056p pd=1.64u ps=0.92u
    I_MXI2_I170_MP0 (XI2_I170_p1 A_28 VDD VDD) gpdk090_pmos1v w=0.48u l=0.1u ad=0.1056p as=0.1632p pd=0.92u ps=1.64u
    I_MXI2_I170_MP1 (I2_nor28 B_28 XI2_I170_p1 VDD) gpdk090_pmos1v w=0.48u l=0.1u ad=0.1632p as=0.1056p pd=1.64u ps=0.92u
    I_MXI4_I51_MP0 (XI4_I51_p1 I4_z1_6 VDD VDD) gpdk090_pmos1v w=0.48u l=0.1u ad=0.1056p as=0.1632p pd=0.92u ps=1.64u
    I_MXI4_I51_MP1 (I4_z2_3 I4_z1_7 XI4_I51_p1 VDD) gpdk090_pmos1v w=0.48u l=0.1u ad=0.1632p as=0.1056p pd=1.64u ps=0.92u
    I_MXI3_I415_MP0 (XI3_I415_p1 I3_o27_0 VDD VDD) gpdk090_pmos1v w=0.48u l=0.1u ad=0.1056p as=0.1632p pd=0.92u ps=1.64u
    I_MXI3_I415_MP1 (I3_q27_1 I3_o27_1 XI3_I415_p1 VDD) gpdk090_pmos1v w=0.48u l=0.1u ad=0.1632p as=0.1056p pd=1.64u ps=0.92u
    I_MXI1_I42_I94_XP_MP0 (XI1_I42_I94_XP_p1 I1_I42_pn28 VDD VDD) gpdk090_pmos1v w=0.48u l=0.1u ad=0.1056p as=0.1632p pd=0.92u ps=1.64u
    I_MXI1_I42_I94_XP_MP1 (I1_I42_P28_27 I1_I42_pn27 XI1_I42_I94_XP_p1 VDD) gpdk090_pmos1v w=0.48u l=0.1u ad=0.1632p as=0.1056p pd=1.64u ps=0.92u
    I_MXI1_I42_I155_XP_MP0 (XI1_I42_I155_XP_p1 I1_I42_P30_27n VDD VDD) gpdk090_pmos1v w=0.48u l=0.1u ad=0.1056p as=0.1632p pd=0.92u ps=1.64u
    I_MXI1_I42_I155_XP_MP1 (I1_I42_P30_23 I1_I42_P26_23n XI1_I42_I155_XP_p1 VDD) gpdk090_pmos1v w=0.48u l=0.1u ad=0.1632p as=0.1056p pd=1.64u ps=0.92u
    I_MXI1_I42_I153_XP_MP0 (XI1_I42_I153_XP_p1 I1_I42_P28_25n VDD VDD) gpdk090_pmos1v w=0.48u l=0.1u ad=0.1056p as=0.1632p pd=0.92u ps=1.64u
    I_MXI1_I42_I153_XP_MP1 (I1_I42_P28_21 I1_I42_P24_21n XI1_I42_I153_XP_p1 VDD) gpdk090_pmos1v w=0.48u l=0.1u ad=0.1632p as=0.1056p pd=1.64u ps=0.92u
    I_MXI1_I42_I151_XP_MP0 (XI1_I42_I151_XP_p1 I1_I42_P26_23n VDD VDD) gpdk090_pmos1v w=0.48u l=0.1u ad=0.1056p as=0.1632p pd=0.92u ps=1.64u
    I_MXI1_I42_I151_XP_MP1 (I1_I42_P26_19 I1_I42_P22_19n XI1_I42_I151_XP_p1 VDD) gpdk090_pmos1v w=0.48u l=0.1u ad=0.1632p as=0.1056p pd=1.64u ps=0.92u
    I_MXI1_I42_I147_XP_MP0 (XI1_I42_I147_XP_p1 I1_I42_P22_19n VDD VDD) gpdk090_pmos1v w=0.48u l=0.1u ad=0.1056p as=0.1632p pd=0.92u ps=1.64u
    I_MXI1_I42_I147_XP_MP1 (I1_I42_P22_15 I1_I42_P18_15n XI1_I42_I147_XP_p1 VDD) gpdk090_pmos1v w=0.48u l=0.1u ad=0.1632p as=0.1056p pd=1.64u ps=0.92u
    I_MXI1_I42_I143_XP_MP0 (XI1_I42_I143_XP_p1 I1_I42_P18_15n VDD VDD) gpdk090_pmos1v w=0.48u l=0.1u ad=0.1056p as=0.1632p pd=0.92u ps=1.64u
    I_MXI1_I42_I143_XP_MP1 (I1_I42_P18_11 I1_I42_P14_11n XI1_I42_I143_XP_p1 VDD) gpdk090_pmos1v w=0.48u l=0.1u ad=0.1632p as=0.1056p pd=1.64u ps=0.92u
    I_MXI1_I42_I149_XP_MP0 (XI1_I42_I149_XP_p1 I1_I42_P24_21n VDD VDD) gpdk090_pmos1v w=0.48u l=0.1u ad=0.1056p as=0.1632p pd=0.92u ps=1.64u
    I_MXI1_I42_I149_XP_MP1 (I1_I42_P24_17 I1_I42_P20_17n XI1_I42_I149_XP_p1 VDD) gpdk090_pmos1v w=0.48u l=0.1u ad=0.1632p as=0.1056p pd=1.64u ps=0.92u
    I_MXI1_I42_I83_XP_MP0 (XI1_I42_I83_XP_p1 I1_I42_pn17 VDD VDD) gpdk090_pmos1v w=0.48u l=0.1u ad=0.1056p as=0.1632p pd=0.92u ps=1.64u
    I_MXI1_I42_I83_XP_MP1 (I1_I42_P17_16 I1_I42_pn16 XI1_I42_I83_XP_p1 VDD) gpdk090_pmos1v w=0.48u l=0.1u ad=0.1632p as=0.1056p pd=1.64u ps=0.92u
    I_MXI1_I42_I82_XP_MP0 (XI1_I42_I82_XP_p1 I1_I42_pn16 VDD VDD) gpdk090_pmos1v w=0.48u l=0.1u ad=0.1056p as=0.1632p pd=0.92u ps=1.64u
    I_MXI1_I42_I82_XP_MP1 (I1_I42_P16_15 I1_I42_pn15 XI1_I42_I82_XP_p1 VDD) gpdk090_pmos1v w=0.48u l=0.1u ad=0.1632p as=0.1056p pd=1.64u ps=0.92u
    I_MXI2_I86_MP0 (XI2_I86_p1 A_14 VDD VDD) gpdk090_pmos1v w=0.48u l=0.1u ad=0.1056p as=0.1632p pd=0.92u ps=1.64u
    I_MXI2_I86_MP1 (I2_nor14 B_14 XI2_I86_p1 VDD) gpdk090_pmos1v w=0.48u l=0.1u ad=0.1632p as=0.1056p pd=1.64u ps=0.92u
    I_MXI3_I271_MP0 (XI3_I271_p1 I3_o15_0 VDD VDD) gpdk090_pmos1v w=0.48u l=0.1u ad=0.1056p as=0.1632p pd=0.92u ps=1.64u
    I_MXI3_I271_MP1 (I3_q15_1 I3_o15_1 XI3_I271_p1 VDD) gpdk090_pmos1v w=0.48u l=0.1u ad=0.1632p as=0.1056p pd=1.64u ps=0.92u
    I_MXI2_I164_MP0 (XI2_I164_p1 A_27 VDD VDD) gpdk090_pmos1v w=0.48u l=0.1u ad=0.1056p as=0.1632p pd=0.92u ps=1.64u
    I_MXI2_I164_MP1 (I2_nor27 B_27 XI2_I164_p1 VDD) gpdk090_pmos1v w=0.48u l=0.1u ad=0.1632p as=0.1056p pd=1.64u ps=0.92u
    I_MXI1_I42_I93_XP_MP0 (XI1_I42_I93_XP_p1 I1_I42_pn27 VDD VDD) gpdk090_pmos1v w=0.48u l=0.1u ad=0.1056p as=0.1632p pd=0.92u ps=1.64u
    I_MXI1_I42_I93_XP_MP1 (I1_I42_P27_26 I1_I42_pn26 XI1_I42_I93_XP_p1 VDD) gpdk090_pmos1v w=0.48u l=0.1u ad=0.1632p as=0.1056p pd=1.64u ps=0.92u
    I_MXI1_I42_I92_XP_MP0 (XI1_I42_I92_XP_p1 I1_I42_pn26 VDD VDD) gpdk090_pmos1v w=0.48u l=0.1u ad=0.1056p as=0.1632p pd=0.92u ps=1.64u
    I_MXI1_I42_I92_XP_MP1 (I1_I42_P26_25 I1_I42_pn25 XI1_I42_I92_XP_p1 VDD) gpdk090_pmos1v w=0.48u l=0.1u ad=0.1632p as=0.1056p pd=1.64u ps=0.92u
    I_MXI1_I42_I91_XP_MP0 (XI1_I42_I91_XP_p1 I1_I42_pn25 VDD VDD) gpdk090_pmos1v w=0.48u l=0.1u ad=0.1056p as=0.1632p pd=0.92u ps=1.64u
    I_MXI1_I42_I91_XP_MP1 (I1_I42_P25_24 I1_I42_pn24 XI1_I42_I91_XP_p1 VDD) gpdk090_pmos1v w=0.48u l=0.1u ad=0.1632p as=0.1056p pd=1.64u ps=0.92u
    I_MXI1_I42_I90_XP_MP0 (XI1_I42_I90_XP_p1 I1_I42_pn24 VDD VDD) gpdk090_pmos1v w=0.48u l=0.1u ad=0.1056p as=0.1632p pd=0.92u ps=1.64u
    I_MXI1_I42_I90_XP_MP1 (I1_I42_P24_23 I1_I42_pn23 XI1_I42_I90_XP_p1 VDD) gpdk090_pmos1v w=0.48u l=0.1u ad=0.1632p as=0.1056p pd=1.64u ps=0.92u
    I_MXI1_I42_I89_XP_MP0 (XI1_I42_I89_XP_p1 I1_I42_pn23 VDD VDD) gpdk090_pmos1v w=0.48u l=0.1u ad=0.1056p as=0.1632p pd=0.92u ps=1.64u
    I_MXI1_I42_I89_XP_MP1 (I1_I42_P23_22 I1_I42_pn22 XI1_I42_I89_XP_p1 VDD) gpdk090_pmos1v w=0.48u l=0.1u ad=0.1632p as=0.1056p pd=1.64u ps=0.92u
    I_MXI1_I42_I88_XP_MP0 (XI1_I42_I88_XP_p1 I1_I42_pn22 VDD VDD) gpdk090_pmos1v w=0.48u l=0.1u ad=0.1056p as=0.1632p pd=0.92u ps=1.64u
    I_MXI1_I42_I88_XP_MP1 (I1_I42_P22_21 I1_I42_pn21 XI1_I42_I88_XP_p1 VDD) gpdk090_pmos1v w=0.48u l=0.1u ad=0.1632p as=0.1056p pd=1.64u ps=0.92u
    I_MXI1_I42_I87_XP_MP0 (XI1_I42_I87_XP_p1 I1_I42_pn21 VDD VDD) gpdk090_pmos1v w=0.48u l=0.1u ad=0.1056p as=0.1632p pd=0.92u ps=1.64u
    I_MXI1_I42_I87_XP_MP1 (I1_I42_P21_20 I1_I42_pn20 XI1_I42_I87_XP_p1 VDD) gpdk090_pmos1v w=0.48u l=0.1u ad=0.1632p as=0.1056p pd=1.64u ps=0.92u
    I_MXI1_I42_I86_XP_MP0 (XI1_I42_I86_XP_p1 I1_I42_pn20 VDD VDD) gpdk090_pmos1v w=0.48u l=0.1u ad=0.1056p as=0.1632p pd=0.92u ps=1.64u
    I_MXI1_I42_I86_XP_MP1 (I1_I42_P20_19 I1_I42_pn19 XI1_I42_I86_XP_p1 VDD) gpdk090_pmos1v w=0.48u l=0.1u ad=0.1632p as=0.1056p pd=1.64u ps=0.92u
    I_MXI1_I42_I85_XP_MP0 (XI1_I42_I85_XP_p1 I1_I42_pn19 VDD VDD) gpdk090_pmos1v w=0.48u l=0.1u ad=0.1056p as=0.1632p pd=0.92u ps=1.64u
    I_MXI1_I42_I85_XP_MP1 (I1_I42_P19_18 I1_I42_pn18 XI1_I42_I85_XP_p1 VDD) gpdk090_pmos1v w=0.48u l=0.1u ad=0.1632p as=0.1056p pd=1.64u ps=0.92u
    I_MXI1_I42_I84_XP_MP0 (XI1_I42_I84_XP_p1 I1_I42_pn18 VDD VDD) gpdk090_pmos1v w=0.48u l=0.1u ad=0.1056p as=0.1632p pd=0.92u ps=1.64u
    I_MXI1_I42_I84_XP_MP1 (I1_I42_P18_17 I1_I42_pn17 XI1_I42_I84_XP_p1 VDD) gpdk090_pmos1v w=0.48u l=0.1u ad=0.1632p as=0.1056p pd=1.64u ps=0.92u
    I_MXI2_I92_MP0 (XI2_I92_p1 A_15 VDD VDD) gpdk090_pmos1v w=0.48u l=0.1u ad=0.1056p as=0.1632p pd=0.92u ps=1.64u
    I_MXI2_I92_MP1 (I2_nor15 B_15 XI2_I92_p1 VDD) gpdk090_pmos1v w=0.48u l=0.1u ad=0.1632p as=0.1056p pd=1.64u ps=0.92u
    I_MXI4_I13_MP0 (XI4_I13_p1 Y_26 VDD VDD) gpdk090_pmos1v w=0.48u l=0.1u ad=0.1056p as=0.1632p pd=0.92u ps=1.64u
    I_MXI4_I13_MP1 (I4_z0_13 Y_27 XI4_I13_p1 VDD) gpdk090_pmos1v w=0.48u l=0.1u ad=0.1632p as=0.1056p pd=1.64u ps=0.92u
    I_MXI2_I158_MP0 (XI2_I158_p1 A_26 VDD VDD) gpdk090_pmos1v w=0.48u l=0.1u ad=0.1056p as=0.1632p pd=0.92u ps=1.64u
    I_MXI2_I158_MP1 (I2_nor26 B_26 XI2_I158_p1 VDD) gpdk090_pmos1v w=0.48u l=0.1u ad=0.1632p as=0.1056p pd=1.64u ps=0.92u
    I_MXI4_I12_MP0 (XI4_I12_p1 Y_24 VDD VDD) gpdk090_pmos1v w=0.48u l=0.1u ad=0.1056p as=0.1632p pd=0.92u ps=1.64u
    I_MXI4_I12_MP1 (I4_z0_12 Y_25 XI4_I12_p1 VDD) gpdk090_pmos1v w=0.48u l=0.1u ad=0.1632p as=0.1056p pd=1.64u ps=0.92u
    I_MXI3_I403_MP0 (XI3_I403_p1 I3_o26_0 VDD VDD) gpdk090_pmos1v w=0.48u l=0.1u ad=0.1056p as=0.1632p pd=0.92u ps=1.64u
    I_MXI3_I403_MP1 (I3_q26_1 I3_o26_1 XI3_I403_p1 VDD) gpdk090_pmos1v w=0.48u l=0.1u ad=0.1632p as=0.1056p pd=1.64u ps=0.92u
    I_MXI2_I128_MP0 (XI2_I128_p1 A_21 VDD VDD) gpdk090_pmos1v w=0.48u l=0.1u ad=0.1056p as=0.1632p pd=0.92u ps=1.64u
    I_MXI2_I128_MP1 (I2_nor21 B_21 XI2_I128_p1 VDD) gpdk090_pmos1v w=0.48u l=0.1u ad=0.1632p as=0.1056p pd=1.64u ps=0.92u
    I_MXI2_I98_MP0 (XI2_I98_p1 A_16 VDD VDD) gpdk090_pmos1v w=0.48u l=0.1u ad=0.1056p as=0.1632p pd=0.92u ps=1.64u
    I_MXI2_I98_MP1 (I2_nor16 B_16 XI2_I98_p1 VDD) gpdk090_pmos1v w=0.48u l=0.1u ad=0.1632p as=0.1056p pd=1.64u ps=0.92u
    I_MXI3_I391_MP0 (XI3_I391_p1 I3_o25_0 VDD VDD) gpdk090_pmos1v w=0.48u l=0.1u ad=0.1056p as=0.1632p pd=0.92u ps=1.64u
    I_MXI3_I391_MP1 (I3_q25_1 I3_o25_1 XI3_I391_p1 VDD) gpdk090_pmos1v w=0.48u l=0.1u ad=0.1632p as=0.1056p pd=1.64u ps=0.92u
    I_MXI3_I379_MP0 (XI3_I379_p1 I3_o24_0 VDD VDD) gpdk090_pmos1v w=0.48u l=0.1u ad=0.1056p as=0.1632p pd=0.92u ps=1.64u
    I_MXI3_I379_MP1 (I3_q24_1 I3_o24_1 XI3_I379_p1 VDD) gpdk090_pmos1v w=0.48u l=0.1u ad=0.1632p as=0.1056p pd=1.64u ps=0.92u
    I_MXI3_I367_MP0 (XI3_I367_p1 I3_o23_0 VDD VDD) gpdk090_pmos1v w=0.48u l=0.1u ad=0.1056p as=0.1632p pd=0.92u ps=1.64u
    I_MXI3_I367_MP1 (I3_q23_1 I3_o23_1 XI3_I367_p1 VDD) gpdk090_pmos1v w=0.48u l=0.1u ad=0.1632p as=0.1056p pd=1.64u ps=0.92u
    I_MXI3_I319_MP0 (XI3_I319_p1 I3_o19_0 VDD VDD) gpdk090_pmos1v w=0.48u l=0.1u ad=0.1056p as=0.1632p pd=0.92u ps=1.64u
    I_MXI3_I319_MP1 (I3_q19_1 I3_o19_1 XI3_I319_p1 VDD) gpdk090_pmos1v w=0.48u l=0.1u ad=0.1632p as=0.1056p pd=1.64u ps=0.92u
    I_MXI3_I307_MP0 (XI3_I307_p1 I3_o18_0 VDD VDD) gpdk090_pmos1v w=0.48u l=0.1u ad=0.1056p as=0.1632p pd=0.92u ps=1.64u
    I_MXI3_I307_MP1 (I3_q18_1 I3_o18_1 XI3_I307_p1 VDD) gpdk090_pmos1v w=0.48u l=0.1u ad=0.1632p as=0.1056p pd=1.64u ps=0.92u
    I_MXI2_I110_MP0 (XI2_I110_p1 A_18 VDD VDD) gpdk090_pmos1v w=0.48u l=0.1u ad=0.1056p as=0.1632p pd=0.92u ps=1.64u
    I_MXI2_I110_MP1 (I2_nor18 B_18 XI2_I110_p1 VDD) gpdk090_pmos1v w=0.48u l=0.1u ad=0.1632p as=0.1056p pd=1.64u ps=0.92u
    I_MXI3_I283_MP0 (XI3_I283_p1 I3_o16_0 VDD VDD) gpdk090_pmos1v w=0.48u l=0.1u ad=0.1056p as=0.1632p pd=0.92u ps=1.64u
    I_MXI3_I283_MP1 (I3_q16_1 I3_o16_1 XI3_I283_p1 VDD) gpdk090_pmos1v w=0.48u l=0.1u ad=0.1632p as=0.1056p pd=1.64u ps=0.92u
    I_MXI3_I295_MP0 (XI3_I295_p1 I3_o17_0 VDD VDD) gpdk090_pmos1v w=0.48u l=0.1u ad=0.1056p as=0.1632p pd=0.92u ps=1.64u
    I_MXI3_I295_MP1 (I3_q17_1 I3_o17_1 XI3_I295_p1 VDD) gpdk090_pmos1v w=0.48u l=0.1u ad=0.1632p as=0.1056p pd=1.64u ps=0.92u
    I_MXI2_I152_MP0 (XI2_I152_p1 A_25 VDD VDD) gpdk090_pmos1v w=0.48u l=0.1u ad=0.1056p as=0.1632p pd=0.92u ps=1.64u
    I_MXI2_I152_MP1 (I2_nor25 B_25 XI2_I152_p1 VDD) gpdk090_pmos1v w=0.48u l=0.1u ad=0.1632p as=0.1056p pd=1.64u ps=0.92u
    I_MXI2_I146_MP0 (XI2_I146_p1 A_24 VDD VDD) gpdk090_pmos1v w=0.48u l=0.1u ad=0.1056p as=0.1632p pd=0.92u ps=1.64u
    I_MXI2_I146_MP1 (I2_nor24 B_24 XI2_I146_p1 VDD) gpdk090_pmos1v w=0.48u l=0.1u ad=0.1632p as=0.1056p pd=1.64u ps=0.92u
    I_MXI2_I140_MP0 (XI2_I140_p1 A_23 VDD VDD) gpdk090_pmos1v w=0.48u l=0.1u ad=0.1056p as=0.1632p pd=0.92u ps=1.64u
    I_MXI2_I140_MP1 (I2_nor23 B_23 XI2_I140_p1 VDD) gpdk090_pmos1v w=0.48u l=0.1u ad=0.1632p as=0.1056p pd=1.64u ps=0.92u
    I_MXI3_I355_MP0 (XI3_I355_p1 I3_o22_0 VDD VDD) gpdk090_pmos1v w=0.48u l=0.1u ad=0.1056p as=0.1632p pd=0.92u ps=1.64u
    I_MXI3_I355_MP1 (I3_q22_1 I3_o22_1 XI3_I355_p1 VDD) gpdk090_pmos1v w=0.48u l=0.1u ad=0.1632p as=0.1056p pd=1.64u ps=0.92u
    I_MXI2_I134_MP0 (XI2_I134_p1 A_22 VDD VDD) gpdk090_pmos1v w=0.48u l=0.1u ad=0.1056p as=0.1632p pd=0.92u ps=1.64u
    I_MXI2_I134_MP1 (I2_nor22 B_22 XI2_I134_p1 VDD) gpdk090_pmos1v w=0.48u l=0.1u ad=0.1632p as=0.1056p pd=1.64u ps=0.92u
    I_MXI4_I50_MP0 (XI4_I50_p1 I4_z1_4 VDD VDD) gpdk090_pmos1v w=0.48u l=0.1u ad=0.1056p as=0.1632p pd=0.92u ps=1.64u
    I_MXI4_I50_MP1 (I4_z2_2 I4_z1_5 XI4_I50_p1 VDD) gpdk090_pmos1v w=0.48u l=0.1u ad=0.1632p as=0.1056p pd=1.64u ps=0.92u
    I_MXI4_I11_MP0 (XI4_I11_p1 Y_22 VDD VDD) gpdk090_pmos1v w=0.48u l=0.1u ad=0.1056p as=0.1632p pd=0.92u ps=1.64u
    I_MXI4_I11_MP1 (I4_z0_11 Y_23 XI4_I11_p1 VDD) gpdk090_pmos1v w=0.48u l=0.1u ad=0.1632p as=0.1056p pd=1.64u ps=0.92u
    I_MXI3_I343_MP0 (XI3_I343_p1 I3_o21_0 VDD VDD) gpdk090_pmos1v w=0.48u l=0.1u ad=0.1056p as=0.1632p pd=0.92u ps=1.64u
    I_MXI3_I343_MP1 (I3_q21_1 I3_o21_1 XI3_I343_p1 VDD) gpdk090_pmos1v w=0.48u l=0.1u ad=0.1632p as=0.1056p pd=1.64u ps=0.92u
    I_MXI4_I10_MP0 (XI4_I10_p1 Y_20 VDD VDD) gpdk090_pmos1v w=0.48u l=0.1u ad=0.1056p as=0.1632p pd=0.92u ps=1.64u
    I_MXI4_I10_MP1 (I4_z0_10 Y_21 XI4_I10_p1 VDD) gpdk090_pmos1v w=0.48u l=0.1u ad=0.1632p as=0.1056p pd=1.64u ps=0.92u
    I_MXI2_I122_MP0 (XI2_I122_p1 A_20 VDD VDD) gpdk090_pmos1v w=0.48u l=0.1u ad=0.1056p as=0.1632p pd=0.92u ps=1.64u
    I_MXI2_I122_MP1 (I2_nor20 B_20 XI2_I122_p1 VDD) gpdk090_pmos1v w=0.48u l=0.1u ad=0.1632p as=0.1056p pd=1.64u ps=0.92u
    I_MXI3_I331_MP0 (XI3_I331_p1 I3_o20_0 VDD VDD) gpdk090_pmos1v w=0.48u l=0.1u ad=0.1056p as=0.1632p pd=0.92u ps=1.64u
    I_MXI3_I331_MP1 (I3_q20_1 I3_o20_1 XI3_I331_p1 VDD) gpdk090_pmos1v w=0.48u l=0.1u ad=0.1632p as=0.1056p pd=1.64u ps=0.92u
    I_MXI2_I116_MP0 (XI2_I116_p1 A_19 VDD VDD) gpdk090_pmos1v w=0.48u l=0.1u ad=0.1056p as=0.1632p pd=0.92u ps=1.64u
    I_MXI2_I116_MP1 (I2_nor19 B_19 XI2_I116_p1 VDD) gpdk090_pmos1v w=0.48u l=0.1u ad=0.1632p as=0.1056p pd=1.64u ps=0.92u
    I_MXI4_I9_MP0 (XI4_I9_p1 Y_18 VDD VDD) gpdk090_pmos1v w=0.48u l=0.1u ad=0.1056p as=0.1632p pd=0.92u ps=1.64u
    I_MXI4_I9_MP1 (I4_z0_9 Y_19 XI4_I9_p1 VDD) gpdk090_pmos1v w=0.48u l=0.1u ad=0.1632p as=0.1056p pd=1.64u ps=0.92u
    I_MXI4_I8_MP0 (XI4_I8_p1 Y_16 VDD VDD) gpdk090_pmos1v w=0.48u l=0.1u ad=0.1056p as=0.1632p pd=0.92u ps=1.64u
    I_MXI4_I8_MP1 (I4_z0_8 Y_17 XI4_I8_p1 VDD) gpdk090_pmos1v w=0.48u l=0.1u ad=0.1632p as=0.1056p pd=1.64u ps=0.92u
    I_MXI2_I104_MP0 (XI2_I104_p1 A_17 VDD VDD) gpdk090_pmos1v w=0.48u l=0.1u ad=0.1056p as=0.1632p pd=0.92u ps=1.64u
    I_MXI2_I104_MP1 (I2_nor17 B_17 XI2_I104_p1 VDD) gpdk090_pmos1v w=0.48u l=0.1u ad=0.1632p as=0.1056p pd=1.64u ps=0.92u
    I_MXI4_I71_MP0 (DZ I4_dzn VDD VDD) gpdk090_pmos1v w=0.24u l=0.1u ad=0.0816p as=0.0816p pd=1.16u ps=1.16u
    I_MXI2_I55_MP0 (AND_9 I2_nand9 VDD VDD) gpdk090_pmos1v w=0.24u l=0.1u ad=0.0816p as=0.0816p pd=1.16u ps=1.16u
    I_MXI2_I37_MP0 (AND_6 I2_nand6 VDD VDD) gpdk090_pmos1v w=0.24u l=0.1u ad=0.0816p as=0.0816p pd=1.16u ps=1.16u
    I_MXI2_I1_MP0 (AND_0 I2_nand0 VDD VDD) gpdk090_pmos1v w=0.24u l=0.1u ad=0.0816p as=0.0816p pd=1.16u ps=1.16u
    I_MXI2_I3_MP0 (OR_0 I2_nor0 VDD VDD) gpdk090_pmos1v w=0.24u l=0.1u ad=0.0816p as=0.0816p pd=1.16u ps=1.16u
    I_MXI2_I51_MP0 (OR_8 I2_nor8 VDD VDD) gpdk090_pmos1v w=0.24u l=0.1u ad=0.0816p as=0.0816p pd=1.16u ps=1.16u
    I_MXI2_I49_MP0 (AND_8 I2_nand8 VDD VDD) gpdk090_pmos1v w=0.24u l=0.1u ad=0.0816p as=0.0816p pd=1.16u ps=1.16u
    I_MXI2_I57_MP0 (OR_9 I2_nor9 VDD VDD) gpdk090_pmos1v w=0.24u l=0.1u ad=0.0816p as=0.0816p pd=1.16u ps=1.16u
    I_MXI2_I39_MP0 (OR_6 I2_nor6 VDD VDD) gpdk090_pmos1v w=0.24u l=0.1u ad=0.0816p as=0.0816p pd=1.16u ps=1.16u
    I_MXI2_I5_MP0 (NOT_0 A_0 VDD VDD) gpdk090_pmos1v w=0.24u l=0.1u ad=0.0816p as=0.0816p pd=1.16u ps=1.16u
    I_MXI2_I7_MP0 (AND_1 I2_nand1 VDD VDD) gpdk090_pmos1v w=0.24u l=0.1u ad=0.0816p as=0.0816p pd=1.16u ps=1.16u
    I_MXI2_I9_MP0 (OR_1 I2_nor1 VDD VDD) gpdk090_pmos1v w=0.24u l=0.1u ad=0.0816p as=0.0816p pd=1.16u ps=1.16u
    I_MXI2_I27_MP0 (OR_4 I2_nor4 VDD VDD) gpdk090_pmos1v w=0.24u l=0.1u ad=0.0816p as=0.0816p pd=1.16u ps=1.16u
    I_MXI2_I25_MP0 (AND_4 I2_nand4 VDD VDD) gpdk090_pmos1v w=0.24u l=0.1u ad=0.0816p as=0.0816p pd=1.16u ps=1.16u
    I_MXI4_I63_MP0 (Z I4_z5_0 VDD VDD) gpdk090_pmos1v w=0.24u l=0.1u ad=0.0816p as=0.0816p pd=1.16u ps=1.16u
    I_MXI2_I53_MP0 (NOT_8 A_8 VDD VDD) gpdk090_pmos1v w=0.24u l=0.1u ad=0.0816p as=0.0816p pd=1.16u ps=1.16u
    I_MXI2_I43_MP0 (AND_7 I2_nand7 VDD VDD) gpdk090_pmos1v w=0.24u l=0.1u ad=0.0816p as=0.0816p pd=1.16u ps=1.16u
    I_MXI2_I41_MP0 (NOT_6 A_6 VDD VDD) gpdk090_pmos1v w=0.24u l=0.1u ad=0.0816p as=0.0816p pd=1.16u ps=1.16u
    I_MXI2_I45_MP0 (OR_7 I2_nor7 VDD VDD) gpdk090_pmos1v w=0.24u l=0.1u ad=0.0816p as=0.0816p pd=1.16u ps=1.16u
    I_MXI2_I35_MP0 (NOT_5 A_5 VDD VDD) gpdk090_pmos1v w=0.24u l=0.1u ad=0.0816p as=0.0816p pd=1.16u ps=1.16u
    I_MXI2_I11_MP0 (NOT_1 A_1 VDD VDD) gpdk090_pmos1v w=0.24u l=0.1u ad=0.0816p as=0.0816p pd=1.16u ps=1.16u
    I_MXI2_I29_MP0 (NOT_4 A_4 VDD VDD) gpdk090_pmos1v w=0.24u l=0.1u ad=0.0816p as=0.0816p pd=1.16u ps=1.16u
    I_MXI2_I15_MP0 (OR_2 I2_nor2 VDD VDD) gpdk090_pmos1v w=0.24u l=0.1u ad=0.0816p as=0.0816p pd=1.16u ps=1.16u
    I_MXI2_I13_MP0 (AND_2 I2_nand2 VDD VDD) gpdk090_pmos1v w=0.24u l=0.1u ad=0.0816p as=0.0816p pd=1.16u ps=1.16u
    I_MXI2_I65_MP0 (NOT_10 A_10 VDD VDD) gpdk090_pmos1v w=0.24u l=0.1u ad=0.0816p as=0.0816p pd=1.16u ps=1.16u
    I_MXI2_I59_MP0 (NOT_9 A_9 VDD VDD) gpdk090_pmos1v w=0.24u l=0.1u ad=0.0816p as=0.0816p pd=1.16u ps=1.16u
    I_MXI2_I47_MP0 (NOT_7 A_7 VDD VDD) gpdk090_pmos1v w=0.24u l=0.1u ad=0.0816p as=0.0816p pd=1.16u ps=1.16u
    I_MXI1_I42_I64_MP0 (I1_I42_cinn I1_SUB_b3_5 VDD VDD) gpdk090_pmos1v w=0.24u l=0.1u ad=0.0816p as=0.0816p pd=1.16u ps=1.16u
    I_MXI2_I17_MP0 (NOT_2 A_2 VDD VDD) gpdk090_pmos1v w=0.24u l=0.1u ad=0.0816p as=0.0816p pd=1.16u ps=1.16u
    I_MXI3_I56_MP0 (I3_SEL_DIV_b0 SEL_DIV VDD VDD) gpdk090_pmos1v w=0.24u l=0.1u ad=0.0816p as=0.0816p pd=1.16u ps=1.16u
    I_MXI2_I61_MP0 (AND_10 I2_nand10 VDD VDD) gpdk090_pmos1v w=0.24u l=0.1u ad=0.0816p as=0.0816p pd=1.16u ps=1.16u
    I_MXI2_I63_MP0 (OR_10 I2_nor10 VDD VDD) gpdk090_pmos1v w=0.24u l=0.1u ad=0.0816p as=0.0816p pd=1.16u ps=1.16u
    I_MXI2_I33_MP0 (OR_5 I2_nor5 VDD VDD) gpdk090_pmos1v w=0.24u l=0.1u ad=0.0816p as=0.0816p pd=1.16u ps=1.16u
    I_MXI2_I31_MP0 (AND_5 I2_nand5 VDD VDD) gpdk090_pmos1v w=0.24u l=0.1u ad=0.0816p as=0.0816p pd=1.16u ps=1.16u
    I_MXI0_I2_MP0 (I0_opn2 OP_2 VDD VDD) gpdk090_pmos1v w=0.24u l=0.1u ad=0.0816p as=0.0816p pd=1.16u ps=1.16u
    I_MXI0_I3_MP0 (I0_opn3 OP_3 VDD VDD) gpdk090_pmos1v w=0.24u l=0.1u ad=0.0816p as=0.0816p pd=1.16u ps=1.16u
    I_MXI3_I40_MP0 (I3_SEL_MUL_b0 SEL_MUL VDD VDD) gpdk090_pmos1v w=0.24u l=0.1u ad=0.0816p as=0.0816p pd=1.16u ps=1.16u
    I_MXI3_I30_MP0 (I3_SEL_NOT_b0 SEL_NOT VDD VDD) gpdk090_pmos1v w=0.24u l=0.1u ad=0.0816p as=0.0816p pd=1.16u ps=1.16u
    I_MXI2_I23_MP0 (NOT_3 A_3 VDD VDD) gpdk090_pmos1v w=0.24u l=0.1u ad=0.0816p as=0.0816p pd=1.16u ps=1.16u
    I_MXI0_I0_MP0 (I0_opn0 OP_0 VDD VDD) gpdk090_pmos1v w=0.24u l=0.1u ad=0.0816p as=0.0816p pd=1.16u ps=1.16u
    I_MXI0_I1_MP0 (I0_opn1 OP_1 VDD VDD) gpdk090_pmos1v w=0.24u l=0.1u ad=0.0816p as=0.0816p pd=1.16u ps=1.16u
    I_MXI3_I10_MP0 (I3_SEL_OR_b0 SEL_OR VDD VDD) gpdk090_pmos1v w=0.24u l=0.1u ad=0.0816p as=0.0816p pd=1.16u ps=1.16u
    I_MXI3_I20_MP0 (I3_SEL_XOR_b0 SEL_XOR VDD VDD) gpdk090_pmos1v w=0.24u l=0.1u ad=0.0816p as=0.0816p pd=1.16u ps=1.16u
    I_MXI1_I0_MP0 (I1_SUB_b0 OP_0 VDD VDD) gpdk090_pmos1v w=0.24u l=0.1u ad=0.0816p as=0.0816p pd=1.16u ps=1.16u
    I_MXI1_I42_I129_MP0 (I1_I42_G1_0n I1_I42_G1_0 VDD VDD) gpdk090_pmos1v w=0.24u l=0.1u ad=0.0816p as=0.0816p pd=1.16u ps=1.16u
    I_MXI2_I19_MP0 (AND_3 I2_nand3 VDD VDD) gpdk090_pmos1v w=0.24u l=0.1u ad=0.0816p as=0.0816p pd=1.16u ps=1.16u
    I_MXI2_I21_MP0 (OR_3 I2_nor3 VDD VDD) gpdk090_pmos1v w=0.24u l=0.1u ad=0.0816p as=0.0816p pd=1.16u ps=1.16u
    I_MXI3_I72_MP0 (I3_SEL_AS_b0 SEL_AS VDD VDD) gpdk090_pmos1v w=0.24u l=0.1u ad=0.0816p as=0.0816p pd=1.16u ps=1.16u
    I_MXI3_I0_MP0 (I3_SEL_AND_b0 SEL_AND VDD VDD) gpdk090_pmos1v w=0.24u l=0.1u ad=0.0816p as=0.0816p pd=1.16u ps=1.16u
    I_MXI1_I42_I66_MP0 (I1_I42_G0_0n I1_I42_G0_0 VDD VDD) gpdk090_pmos1v w=0.24u l=0.1u ad=0.0816p as=0.0816p pd=1.16u ps=1.16u
    I_MXI2_I67_MP0 (AND_11 I2_nand11 VDD VDD) gpdk090_pmos1v w=0.24u l=0.1u ad=0.0816p as=0.0816p pd=1.16u ps=1.16u
    I_MXI2_I69_MP0 (OR_11 I2_nor11 VDD VDD) gpdk090_pmos1v w=0.24u l=0.1u ad=0.0816p as=0.0816p pd=1.16u ps=1.16u
    I_MXI2_I71_MP0 (NOT_11 A_11 VDD VDD) gpdk090_pmos1v w=0.24u l=0.1u ad=0.0816p as=0.0816p pd=1.16u ps=1.16u
    I_MXI2_I75_MP0 (OR_12 I2_nor12 VDD VDD) gpdk090_pmos1v w=0.24u l=0.1u ad=0.0816p as=0.0816p pd=1.16u ps=1.16u
    I_MXI2_I183_MP0 (OR_30 I2_nor30 VDD VDD) gpdk090_pmos1v w=0.24u l=0.1u ad=0.0816p as=0.0816p pd=1.16u ps=1.16u
    I_MXI2_I185_MP0 (NOT_30 A_30 VDD VDD) gpdk090_pmos1v w=0.24u l=0.1u ad=0.0816p as=0.0816p pd=1.16u ps=1.16u
    I_MXI2_I191_MP0 (NOT_31 A_31 VDD VDD) gpdk090_pmos1v w=0.24u l=0.1u ad=0.0816p as=0.0816p pd=1.16u ps=1.16u
    I_MXI4_I65_MP0 (C I4_cn VDD VDD) gpdk090_pmos1v w=0.24u l=0.1u ad=0.0816p as=0.0816p pd=1.16u ps=1.16u
    I_MXI1_I42_I189_MP0 (I1_I42_G5_0n I1_I42_G5_0 VDD VDD) gpdk090_pmos1v w=0.24u l=0.1u ad=0.0816p as=0.0816p pd=1.16u ps=1.16u
    I_MXI2_I73_MP0 (AND_12 I2_nand12 VDD VDD) gpdk090_pmos1v w=0.24u l=0.1u ad=0.0816p as=0.0816p pd=1.16u ps=1.16u
    I_MXI2_I181_MP0 (AND_30 I2_nand30 VDD VDD) gpdk090_pmos1v w=0.24u l=0.1u ad=0.0816p as=0.0816p pd=1.16u ps=1.16u
    I_MXI2_I175_MP0 (AND_29 I2_nand29 VDD VDD) gpdk090_pmos1v w=0.24u l=0.1u ad=0.0816p as=0.0816p pd=1.16u ps=1.16u
    I_MXI2_I177_MP0 (OR_29 I2_nor29 VDD VDD) gpdk090_pmos1v w=0.24u l=0.1u ad=0.0816p as=0.0816p pd=1.16u ps=1.16u
    I_MXI2_I187_MP0 (AND_31 I2_nand31 VDD VDD) gpdk090_pmos1v w=0.24u l=0.1u ad=0.0816p as=0.0816p pd=1.16u ps=1.16u
    I_MXI2_I189_MP0 (OR_31 I2_nor31 VDD VDD) gpdk090_pmos1v w=0.24u l=0.1u ad=0.0816p as=0.0816p pd=1.16u ps=1.16u
    I_MXI1_I42_I161_MP0 (I1_I42_G3_0np I1_I42_G3_0n VDD VDD) gpdk090_pmos1v w=0.24u l=0.1u ad=0.0816p as=0.0816p pd=1.16u ps=1.16u
    I_MXI1_I42_I159_MP0 (I1_I42_G2_0np I1_I42_G2_0n VDD VDD) gpdk090_pmos1v w=0.24u l=0.1u ad=0.0816p as=0.0816p pd=1.16u ps=1.16u
    I_MXI2_I83_MP0 (NOT_13 A_13 VDD VDD) gpdk090_pmos1v w=0.24u l=0.1u ad=0.0816p as=0.0816p pd=1.16u ps=1.16u
    I_MXI2_I77_MP0 (NOT_12 A_12 VDD VDD) gpdk090_pmos1v w=0.24u l=0.1u ad=0.0816p as=0.0816p pd=1.16u ps=1.16u
    I_MXI2_I81_MP0 (OR_13 I2_nor13 VDD VDD) gpdk090_pmos1v w=0.24u l=0.1u ad=0.0816p as=0.0816p pd=1.16u ps=1.16u
    I_MXI2_I179_MP0 (NOT_29 A_29 VDD VDD) gpdk090_pmos1v w=0.24u l=0.1u ad=0.0816p as=0.0816p pd=1.16u ps=1.16u
    I_MXI1_I42_I193_MP0 (I1_I42_G7_0n I1_I42_G7_0 VDD VDD) gpdk090_pmos1v w=0.24u l=0.1u ad=0.0816p as=0.0816p pd=1.16u ps=1.16u
    I_MXI1_I42_I187_MP0 (I1_I42_G4_0n I1_I42_G4_0 VDD VDD) gpdk090_pmos1v w=0.24u l=0.1u ad=0.0816p as=0.0816p pd=1.16u ps=1.16u
    I_MXI2_I79_MP0 (AND_13 I2_nand13 VDD VDD) gpdk090_pmos1v w=0.24u l=0.1u ad=0.0816p as=0.0816p pd=1.16u ps=1.16u
    I_MXI2_I169_MP0 (AND_28 I2_nand28 VDD VDD) gpdk090_pmos1v w=0.24u l=0.1u ad=0.0816p as=0.0816p pd=1.16u ps=1.16u
    I_MXI2_I171_MP0 (OR_28 I2_nor28 VDD VDD) gpdk090_pmos1v w=0.24u l=0.1u ad=0.0816p as=0.0816p pd=1.16u ps=1.16u
    I_MXI2_I173_MP0 (NOT_28 A_28 VDD VDD) gpdk090_pmos1v w=0.24u l=0.1u ad=0.0816p as=0.0816p pd=1.16u ps=1.16u
    I_MXI2_I89_MP0 (NOT_14 A_14 VDD VDD) gpdk090_pmos1v w=0.24u l=0.1u ad=0.0816p as=0.0816p pd=1.16u ps=1.16u
    I_MXI2_I85_MP0 (AND_14 I2_nand14 VDD VDD) gpdk090_pmos1v w=0.24u l=0.1u ad=0.0816p as=0.0816p pd=1.16u ps=1.16u
    I_MXI1_I42_I191_MP0 (I1_I42_G6_0n I1_I42_G6_0 VDD VDD) gpdk090_pmos1v w=0.24u l=0.1u ad=0.0816p as=0.0816p pd=1.16u ps=1.16u
    I_MXI2_I87_MP0 (OR_14 I2_nor14 VDD VDD) gpdk090_pmos1v w=0.24u l=0.1u ad=0.0816p as=0.0816p pd=1.16u ps=1.16u
    I_MXI2_I165_MP0 (OR_27 I2_nor27 VDD VDD) gpdk090_pmos1v w=0.24u l=0.1u ad=0.0816p as=0.0816p pd=1.16u ps=1.16u
    I_MXI2_I163_MP0 (AND_27 I2_nand27 VDD VDD) gpdk090_pmos1v w=0.24u l=0.1u ad=0.0816p as=0.0816p pd=1.16u ps=1.16u
    I_MXI2_I167_MP0 (NOT_27 A_27 VDD VDD) gpdk090_pmos1v w=0.24u l=0.1u ad=0.0816p as=0.0816p pd=1.16u ps=1.16u
    I_MXI2_I95_MP0 (NOT_15 A_15 VDD VDD) gpdk090_pmos1v w=0.24u l=0.1u ad=0.0816p as=0.0816p pd=1.16u ps=1.16u
    I_MXI2_I93_MP0 (OR_15 I2_nor15 VDD VDD) gpdk090_pmos1v w=0.24u l=0.1u ad=0.0816p as=0.0816p pd=1.16u ps=1.16u
    I_MXI2_I91_MP0 (AND_15 I2_nand15 VDD VDD) gpdk090_pmos1v w=0.24u l=0.1u ad=0.0816p as=0.0816p pd=1.16u ps=1.16u
    I_MXI2_I157_MP0 (AND_26 I2_nand26 VDD VDD) gpdk090_pmos1v w=0.24u l=0.1u ad=0.0816p as=0.0816p pd=1.16u ps=1.16u
    I_MXI2_I161_MP0 (NOT_26 A_26 VDD VDD) gpdk090_pmos1v w=0.24u l=0.1u ad=0.0816p as=0.0816p pd=1.16u ps=1.16u
    I_MXI2_I149_MP0 (NOT_24 A_24 VDD VDD) gpdk090_pmos1v w=0.24u l=0.1u ad=0.0816p as=0.0816p pd=1.16u ps=1.16u
    I_MXI2_I119_MP0 (NOT_19 A_19 VDD VDD) gpdk090_pmos1v w=0.24u l=0.1u ad=0.0816p as=0.0816p pd=1.16u ps=1.16u
    I_MXI2_I101_MP0 (NOT_16 A_16 VDD VDD) gpdk090_pmos1v w=0.24u l=0.1u ad=0.0816p as=0.0816p pd=1.16u ps=1.16u
    I_MXI2_I97_MP0 (AND_16 I2_nand16 VDD VDD) gpdk090_pmos1v w=0.24u l=0.1u ad=0.0816p as=0.0816p pd=1.16u ps=1.16u
    I_MXI2_I159_MP0 (OR_26 I2_nor26 VDD VDD) gpdk090_pmos1v w=0.24u l=0.1u ad=0.0816p as=0.0816p pd=1.16u ps=1.16u
    I_MXI2_I155_MP0 (NOT_25 A_25 VDD VDD) gpdk090_pmos1v w=0.24u l=0.1u ad=0.0816p as=0.0816p pd=1.16u ps=1.16u
    I_MXI2_I143_MP0 (NOT_23 A_23 VDD VDD) gpdk090_pmos1v w=0.24u l=0.1u ad=0.0816p as=0.0816p pd=1.16u ps=1.16u
    I_MXI2_I137_MP0 (NOT_22 A_22 VDD VDD) gpdk090_pmos1v w=0.24u l=0.1u ad=0.0816p as=0.0816p pd=1.16u ps=1.16u
    I_MXI2_I129_MP0 (OR_21 I2_nor21 VDD VDD) gpdk090_pmos1v w=0.24u l=0.1u ad=0.0816p as=0.0816p pd=1.16u ps=1.16u
    I_MXI2_I131_MP0 (NOT_21 A_21 VDD VDD) gpdk090_pmos1v w=0.24u l=0.1u ad=0.0816p as=0.0816p pd=1.16u ps=1.16u
    I_MXI2_I125_MP0 (NOT_20 A_20 VDD VDD) gpdk090_pmos1v w=0.24u l=0.1u ad=0.0816p as=0.0816p pd=1.16u ps=1.16u
    I_MXI2_I113_MP0 (NOT_18 A_18 VDD VDD) gpdk090_pmos1v w=0.24u l=0.1u ad=0.0816p as=0.0816p pd=1.16u ps=1.16u
    I_MXI2_I107_MP0 (NOT_17 A_17 VDD VDD) gpdk090_pmos1v w=0.24u l=0.1u ad=0.0816p as=0.0816p pd=1.16u ps=1.16u
    I_MXI2_I99_MP0 (OR_16 I2_nor16 VDD VDD) gpdk090_pmos1v w=0.24u l=0.1u ad=0.0816p as=0.0816p pd=1.16u ps=1.16u
    I_MXI2_I151_MP0 (AND_25 I2_nand25 VDD VDD) gpdk090_pmos1v w=0.24u l=0.1u ad=0.0816p as=0.0816p pd=1.16u ps=1.16u
    I_MXI2_I153_MP0 (OR_25 I2_nor25 VDD VDD) gpdk090_pmos1v w=0.24u l=0.1u ad=0.0816p as=0.0816p pd=1.16u ps=1.16u
    I_MXI2_I145_MP0 (AND_24 I2_nand24 VDD VDD) gpdk090_pmos1v w=0.24u l=0.1u ad=0.0816p as=0.0816p pd=1.16u ps=1.16u
    I_MXI2_I147_MP0 (OR_24 I2_nor24 VDD VDD) gpdk090_pmos1v w=0.24u l=0.1u ad=0.0816p as=0.0816p pd=1.16u ps=1.16u
    I_MXI2_I141_MP0 (OR_23 I2_nor23 VDD VDD) gpdk090_pmos1v w=0.24u l=0.1u ad=0.0816p as=0.0816p pd=1.16u ps=1.16u
    I_MXI2_I139_MP0 (AND_23 I2_nand23 VDD VDD) gpdk090_pmos1v w=0.24u l=0.1u ad=0.0816p as=0.0816p pd=1.16u ps=1.16u
    I_MXI2_I133_MP0 (AND_22 I2_nand22 VDD VDD) gpdk090_pmos1v w=0.24u l=0.1u ad=0.0816p as=0.0816p pd=1.16u ps=1.16u
    I_MXI2_I135_MP0 (OR_22 I2_nor22 VDD VDD) gpdk090_pmos1v w=0.24u l=0.1u ad=0.0816p as=0.0816p pd=1.16u ps=1.16u
    I_MXI2_I127_MP0 (AND_21 I2_nand21 VDD VDD) gpdk090_pmos1v w=0.24u l=0.1u ad=0.0816p as=0.0816p pd=1.16u ps=1.16u
    I_MXI2_I121_MP0 (AND_20 I2_nand20 VDD VDD) gpdk090_pmos1v w=0.24u l=0.1u ad=0.0816p as=0.0816p pd=1.16u ps=1.16u
    I_MXI2_I123_MP0 (OR_20 I2_nor20 VDD VDD) gpdk090_pmos1v w=0.24u l=0.1u ad=0.0816p as=0.0816p pd=1.16u ps=1.16u
    I_MXI2_I115_MP0 (AND_19 I2_nand19 VDD VDD) gpdk090_pmos1v w=0.24u l=0.1u ad=0.0816p as=0.0816p pd=1.16u ps=1.16u
    I_MXI2_I117_MP0 (OR_19 I2_nor19 VDD VDD) gpdk090_pmos1v w=0.24u l=0.1u ad=0.0816p as=0.0816p pd=1.16u ps=1.16u
    I_MXI2_I109_MP0 (AND_18 I2_nand18 VDD VDD) gpdk090_pmos1v w=0.24u l=0.1u ad=0.0816p as=0.0816p pd=1.16u ps=1.16u
    I_MXI2_I111_MP0 (OR_18 I2_nor18 VDD VDD) gpdk090_pmos1v w=0.24u l=0.1u ad=0.0816p as=0.0816p pd=1.16u ps=1.16u
    I_MXI2_I103_MP0 (AND_17 I2_nand17 VDD VDD) gpdk090_pmos1v w=0.24u l=0.1u ad=0.0816p as=0.0816p pd=1.16u ps=1.16u
    I_MXI2_I105_MP0 (OR_17 I2_nor17 VDD VDD) gpdk090_pmos1v w=0.24u l=0.1u ad=0.0816p as=0.0816p pd=1.16u ps=1.16u
    I_MXI1_I10_MP1 (VDD I1_SUB_b3_0 XI1_I10_Bn VDD) gpdk090_pmos1v w=0.24u l=0.1u ad=0.0816p as=0.0816p pd=1.16u ps=1.16u
    I_MXI1_I10_MP5 (I1_bx0 XI1_I10_Bn XI1_I10_p1 VDD) gpdk090_pmos1v w=0.48u l=0.1u ad=0.1056p as=0.1632p pd=0.92u ps=1.64u
    I_MXI1_I10_MP4 (XI1_I10_p1 XI1_I10_An I1_bx0 VDD) gpdk090_pmos1v w=0.48u l=0.1u ad=0.1056p as=0.1056p pd=0.92u ps=0.92u
    I_MXI1_I10_MP2 (VDD B_0 XI1_I10_p1 VDD) gpdk090_pmos1v w=0.48u l=0.1u ad=0.1056p as=0.1056p pd=0.92u ps=0.92u
    I_MXI1_I10_MP3 (XI1_I10_p1 I1_SUB_b3_0 VDD VDD) gpdk090_pmos1v w=0.48u l=0.1u ad=0.1632p as=0.1056p pd=1.64u ps=0.92u
    I_MXI1_I10_MP0 (VDD B_0 XI1_I10_An VDD) gpdk090_pmos1v w=0.24u l=0.1u ad=0.0816p as=0.0816p pd=1.16u ps=1.16u
    I_MXI2_I4_MP1 (VDD B_0 XI2_I4_Bn VDD) gpdk090_pmos1v w=0.24u l=0.1u ad=0.0816p as=0.0816p pd=1.16u ps=1.16u
    I_MXI2_I4_MP5 (XOR_0 XI2_I4_Bn XI2_I4_p1 VDD) gpdk090_pmos1v w=0.48u l=0.1u ad=0.1056p as=0.1632p pd=0.92u ps=1.64u
    I_MXI2_I4_MP4 (XI2_I4_p1 XI2_I4_An XOR_0 VDD) gpdk090_pmos1v w=0.48u l=0.1u ad=0.1056p as=0.1056p pd=0.92u ps=0.92u
    I_MXI2_I4_MP2 (VDD A_0 XI2_I4_p1 VDD) gpdk090_pmos1v w=0.48u l=0.1u ad=0.1056p as=0.1056p pd=0.92u ps=0.92u
    I_MXI2_I4_MP3 (XI2_I4_p1 B_0 VDD VDD) gpdk090_pmos1v w=0.48u l=0.1u ad=0.1632p as=0.1056p pd=1.64u ps=0.92u
    I_MXI2_I4_MP0 (VDD A_0 XI2_I4_An VDD) gpdk090_pmos1v w=0.24u l=0.1u ad=0.0816p as=0.0816p pd=1.16u ps=1.16u
    I_MXI2_I10_MP1 (VDD B_1 XI2_I10_Bn VDD) gpdk090_pmos1v w=0.24u l=0.1u ad=0.0816p as=0.0816p pd=1.16u ps=1.16u
    I_MXI2_I10_MP5 (XOR_1 XI2_I10_Bn XI2_I10_p1 VDD) gpdk090_pmos1v w=0.48u l=0.1u ad=0.1056p as=0.1632p pd=0.92u ps=1.64u
    I_MXI2_I10_MP4 (XI2_I10_p1 XI2_I10_An XOR_1 VDD) gpdk090_pmos1v w=0.48u l=0.1u ad=0.1056p as=0.1056p pd=0.92u ps=0.92u
    I_MXI2_I10_MP2 (VDD A_1 XI2_I10_p1 VDD) gpdk090_pmos1v w=0.48u l=0.1u ad=0.1056p as=0.1056p pd=0.92u ps=0.92u
    I_MXI2_I10_MP3 (XI2_I10_p1 B_1 VDD VDD) gpdk090_pmos1v w=0.48u l=0.1u ad=0.1632p as=0.1056p pd=1.64u ps=0.92u
    I_MXI2_I10_MP0 (VDD A_1 XI2_I10_An VDD) gpdk090_pmos1v w=0.24u l=0.1u ad=0.0816p as=0.0816p pd=1.16u ps=1.16u
    I_MXI2_I28_MP1 (VDD B_4 XI2_I28_Bn VDD) gpdk090_pmos1v w=0.24u l=0.1u ad=0.0816p as=0.0816p pd=1.16u ps=1.16u
    I_MXI2_I28_MP5 (XOR_4 XI2_I28_Bn XI2_I28_p1 VDD) gpdk090_pmos1v w=0.48u l=0.1u ad=0.1056p as=0.1632p pd=0.92u ps=1.64u
    I_MXI2_I28_MP4 (XI2_I28_p1 XI2_I28_An XOR_4 VDD) gpdk090_pmos1v w=0.48u l=0.1u ad=0.1056p as=0.1056p pd=0.92u ps=0.92u
    I_MXI2_I28_MP2 (VDD A_4 XI2_I28_p1 VDD) gpdk090_pmos1v w=0.48u l=0.1u ad=0.1056p as=0.1056p pd=0.92u ps=0.92u
    I_MXI2_I28_MP3 (XI2_I28_p1 B_4 VDD VDD) gpdk090_pmos1v w=0.48u l=0.1u ad=0.1632p as=0.1056p pd=1.64u ps=0.92u
    I_MXI2_I28_MP0 (VDD A_4 XI2_I28_An VDD) gpdk090_pmos1v w=0.24u l=0.1u ad=0.0816p as=0.0816p pd=1.16u ps=1.16u
    I_MXI2_I52_MP1 (VDD B_8 XI2_I52_Bn VDD) gpdk090_pmos1v w=0.24u l=0.1u ad=0.0816p as=0.0816p pd=1.16u ps=1.16u
    I_MXI2_I52_MP5 (XOR_8 XI2_I52_Bn XI2_I52_p1 VDD) gpdk090_pmos1v w=0.48u l=0.1u ad=0.1056p as=0.1632p pd=0.92u ps=1.64u
    I_MXI2_I52_MP4 (XI2_I52_p1 XI2_I52_An XOR_8 VDD) gpdk090_pmos1v w=0.48u l=0.1u ad=0.1056p as=0.1056p pd=0.92u ps=0.92u
    I_MXI2_I52_MP2 (VDD A_8 XI2_I52_p1 VDD) gpdk090_pmos1v w=0.48u l=0.1u ad=0.1056p as=0.1056p pd=0.92u ps=0.92u
    I_MXI2_I52_MP3 (XI2_I52_p1 B_8 VDD VDD) gpdk090_pmos1v w=0.48u l=0.1u ad=0.1632p as=0.1056p pd=1.64u ps=0.92u
    I_MXI2_I52_MP0 (VDD A_8 XI2_I52_An VDD) gpdk090_pmos1v w=0.24u l=0.1u ad=0.0816p as=0.0816p pd=1.16u ps=1.16u
    I_MXI2_I58_MP1 (VDD B_9 XI2_I58_Bn VDD) gpdk090_pmos1v w=0.24u l=0.1u ad=0.0816p as=0.0816p pd=1.16u ps=1.16u
    I_MXI2_I58_MP5 (XOR_9 XI2_I58_Bn XI2_I58_p1 VDD) gpdk090_pmos1v w=0.48u l=0.1u ad=0.1056p as=0.1632p pd=0.92u ps=1.64u
    I_MXI2_I58_MP4 (XI2_I58_p1 XI2_I58_An XOR_9 VDD) gpdk090_pmos1v w=0.48u l=0.1u ad=0.1056p as=0.1056p pd=0.92u ps=0.92u
    I_MXI2_I58_MP2 (VDD A_9 XI2_I58_p1 VDD) gpdk090_pmos1v w=0.48u l=0.1u ad=0.1056p as=0.1056p pd=0.92u ps=0.92u
    I_MXI2_I58_MP3 (XI2_I58_p1 B_9 VDD VDD) gpdk090_pmos1v w=0.48u l=0.1u ad=0.1632p as=0.1056p pd=1.64u ps=0.92u
    I_MXI2_I58_MP0 (VDD A_9 XI2_I58_An VDD) gpdk090_pmos1v w=0.24u l=0.1u ad=0.0816p as=0.0816p pd=1.16u ps=1.16u
    I_MXI2_I40_MP1 (VDD B_6 XI2_I40_Bn VDD) gpdk090_pmos1v w=0.24u l=0.1u ad=0.0816p as=0.0816p pd=1.16u ps=1.16u
    I_MXI2_I40_MP5 (XOR_6 XI2_I40_Bn XI2_I40_p1 VDD) gpdk090_pmos1v w=0.48u l=0.1u ad=0.1056p as=0.1632p pd=0.92u ps=1.64u
    I_MXI2_I40_MP4 (XI2_I40_p1 XI2_I40_An XOR_6 VDD) gpdk090_pmos1v w=0.48u l=0.1u ad=0.1056p as=0.1056p pd=0.92u ps=0.92u
    I_MXI2_I40_MP2 (VDD A_6 XI2_I40_p1 VDD) gpdk090_pmos1v w=0.48u l=0.1u ad=0.1056p as=0.1056p pd=0.92u ps=0.92u
    I_MXI2_I40_MP3 (XI2_I40_p1 B_6 VDD VDD) gpdk090_pmos1v w=0.48u l=0.1u ad=0.1632p as=0.1056p pd=1.64u ps=0.92u
    I_MXI2_I40_MP0 (VDD A_6 XI2_I40_An VDD) gpdk090_pmos1v w=0.24u l=0.1u ad=0.0816p as=0.0816p pd=1.16u ps=1.16u
    I_MXI1_I11_MP1 (VDD I1_SUB_b3_0 XI1_I11_Bn VDD) gpdk090_pmos1v w=0.24u l=0.1u ad=0.0816p as=0.0816p pd=1.16u ps=1.16u
    I_MXI1_I11_MP5 (I1_bx1 XI1_I11_Bn XI1_I11_p1 VDD) gpdk090_pmos1v w=0.48u l=0.1u ad=0.1056p as=0.1632p pd=0.92u ps=1.64u
    I_MXI1_I11_MP4 (XI1_I11_p1 XI1_I11_An I1_bx1 VDD) gpdk090_pmos1v w=0.48u l=0.1u ad=0.1056p as=0.1056p pd=0.92u ps=0.92u
    I_MXI1_I11_MP2 (VDD B_1 XI1_I11_p1 VDD) gpdk090_pmos1v w=0.48u l=0.1u ad=0.1056p as=0.1056p pd=0.92u ps=0.92u
    I_MXI1_I11_MP3 (XI1_I11_p1 I1_SUB_b3_0 VDD VDD) gpdk090_pmos1v w=0.48u l=0.1u ad=0.1632p as=0.1056p pd=1.64u ps=0.92u
    I_MXI1_I11_MP0 (VDD B_1 XI1_I11_An VDD) gpdk090_pmos1v w=0.24u l=0.1u ad=0.0816p as=0.0816p pd=1.16u ps=1.16u
    I_MXI1_I14_MP1 (VDD I1_SUB_b3_0 XI1_I14_Bn VDD) gpdk090_pmos1v w=0.24u l=0.1u ad=0.0816p as=0.0816p pd=1.16u ps=1.16u
    I_MXI1_I14_MP5 (I1_bx4 XI1_I14_Bn XI1_I14_p1 VDD) gpdk090_pmos1v w=0.48u l=0.1u ad=0.1056p as=0.1632p pd=0.92u ps=1.64u
    I_MXI1_I14_MP4 (XI1_I14_p1 XI1_I14_An I1_bx4 VDD) gpdk090_pmos1v w=0.48u l=0.1u ad=0.1056p as=0.1056p pd=0.92u ps=0.92u
    I_MXI1_I14_MP2 (VDD B_4 XI1_I14_p1 VDD) gpdk090_pmos1v w=0.48u l=0.1u ad=0.1056p as=0.1056p pd=0.92u ps=0.92u
    I_MXI1_I14_MP3 (XI1_I14_p1 I1_SUB_b3_0 VDD VDD) gpdk090_pmos1v w=0.48u l=0.1u ad=0.1632p as=0.1056p pd=1.64u ps=0.92u
    I_MXI1_I14_MP0 (VDD B_4 XI1_I14_An VDD) gpdk090_pmos1v w=0.24u l=0.1u ad=0.0816p as=0.0816p pd=1.16u ps=1.16u
    I_MXI2_I64_MP1 (VDD B_10 XI2_I64_Bn VDD) gpdk090_pmos1v w=0.24u l=0.1u ad=0.0816p as=0.0816p pd=1.16u ps=1.16u
    I_MXI2_I64_MP5 (XOR_10 XI2_I64_Bn XI2_I64_p1 VDD) gpdk090_pmos1v w=0.48u l=0.1u ad=0.1056p as=0.1632p pd=0.92u ps=1.64u
    I_MXI2_I64_MP4 (XI2_I64_p1 XI2_I64_An XOR_10 VDD) gpdk090_pmos1v w=0.48u l=0.1u ad=0.1056p as=0.1056p pd=0.92u ps=0.92u
    I_MXI2_I64_MP2 (VDD A_10 XI2_I64_p1 VDD) gpdk090_pmos1v w=0.48u l=0.1u ad=0.1056p as=0.1056p pd=0.92u ps=0.92u
    I_MXI2_I64_MP3 (XI2_I64_p1 B_10 VDD VDD) gpdk090_pmos1v w=0.48u l=0.1u ad=0.1632p as=0.1056p pd=1.64u ps=0.92u
    I_MXI2_I64_MP0 (VDD A_10 XI2_I64_An VDD) gpdk090_pmos1v w=0.24u l=0.1u ad=0.0816p as=0.0816p pd=1.16u ps=1.16u
    I_MXI2_I46_MP1 (VDD B_7 XI2_I46_Bn VDD) gpdk090_pmos1v w=0.24u l=0.1u ad=0.0816p as=0.0816p pd=1.16u ps=1.16u
    I_MXI2_I46_MP5 (XOR_7 XI2_I46_Bn XI2_I46_p1 VDD) gpdk090_pmos1v w=0.48u l=0.1u ad=0.1056p as=0.1632p pd=0.92u ps=1.64u
    I_MXI2_I46_MP4 (XI2_I46_p1 XI2_I46_An XOR_7 VDD) gpdk090_pmos1v w=0.48u l=0.1u ad=0.1056p as=0.1056p pd=0.92u ps=0.92u
    I_MXI2_I46_MP2 (VDD A_7 XI2_I46_p1 VDD) gpdk090_pmos1v w=0.48u l=0.1u ad=0.1056p as=0.1056p pd=0.92u ps=0.92u
    I_MXI2_I46_MP3 (XI2_I46_p1 B_7 VDD VDD) gpdk090_pmos1v w=0.48u l=0.1u ad=0.1632p as=0.1056p pd=1.64u ps=0.92u
    I_MXI2_I46_MP0 (VDD A_7 XI2_I46_An VDD) gpdk090_pmos1v w=0.24u l=0.1u ad=0.0816p as=0.0816p pd=1.16u ps=1.16u
    I_MXI2_I34_MP1 (VDD B_5 XI2_I34_Bn VDD) gpdk090_pmos1v w=0.24u l=0.1u ad=0.0816p as=0.0816p pd=1.16u ps=1.16u
    I_MXI2_I34_MP5 (XOR_5 XI2_I34_Bn XI2_I34_p1 VDD) gpdk090_pmos1v w=0.48u l=0.1u ad=0.1056p as=0.1632p pd=0.92u ps=1.64u
    I_MXI2_I34_MP4 (XI2_I34_p1 XI2_I34_An XOR_5 VDD) gpdk090_pmos1v w=0.48u l=0.1u ad=0.1056p as=0.1056p pd=0.92u ps=0.92u
    I_MXI2_I34_MP2 (VDD A_5 XI2_I34_p1 VDD) gpdk090_pmos1v w=0.48u l=0.1u ad=0.1056p as=0.1056p pd=0.92u ps=0.92u
    I_MXI2_I34_MP3 (XI2_I34_p1 B_5 VDD VDD) gpdk090_pmos1v w=0.48u l=0.1u ad=0.1632p as=0.1056p pd=1.64u ps=0.92u
    I_MXI2_I34_MP0 (VDD A_5 XI2_I34_An VDD) gpdk090_pmos1v w=0.24u l=0.1u ad=0.0816p as=0.0816p pd=1.16u ps=1.16u
    I_MXI2_I16_MP1 (VDD B_2 XI2_I16_Bn VDD) gpdk090_pmos1v w=0.24u l=0.1u ad=0.0816p as=0.0816p pd=1.16u ps=1.16u
    I_MXI2_I16_MP5 (XOR_2 XI2_I16_Bn XI2_I16_p1 VDD) gpdk090_pmos1v w=0.48u l=0.1u ad=0.1056p as=0.1632p pd=0.92u ps=1.64u
    I_MXI2_I16_MP4 (XI2_I16_p1 XI2_I16_An XOR_2 VDD) gpdk090_pmos1v w=0.48u l=0.1u ad=0.1056p as=0.1056p pd=0.92u ps=0.92u
    I_MXI2_I16_MP2 (VDD A_2 XI2_I16_p1 VDD) gpdk090_pmos1v w=0.48u l=0.1u ad=0.1056p as=0.1056p pd=0.92u ps=0.92u
    I_MXI2_I16_MP3 (XI2_I16_p1 B_2 VDD VDD) gpdk090_pmos1v w=0.48u l=0.1u ad=0.1632p as=0.1056p pd=1.64u ps=0.92u
    I_MXI2_I16_MP0 (VDD A_2 XI2_I16_An VDD) gpdk090_pmos1v w=0.24u l=0.1u ad=0.0816p as=0.0816p pd=1.16u ps=1.16u
    I_MXI1_I18_MP1 (VDD I1_SUB_b3_1 XI1_I18_Bn VDD) gpdk090_pmos1v w=0.24u l=0.1u ad=0.0816p as=0.0816p pd=1.16u ps=1.16u
    I_MXI1_I18_MP5 (I1_bx8 XI1_I18_Bn XI1_I18_p1 VDD) gpdk090_pmos1v w=0.48u l=0.1u ad=0.1056p as=0.1632p pd=0.92u ps=1.64u
    I_MXI1_I18_MP4 (XI1_I18_p1 XI1_I18_An I1_bx8 VDD) gpdk090_pmos1v w=0.48u l=0.1u ad=0.1056p as=0.1056p pd=0.92u ps=0.92u
    I_MXI1_I18_MP2 (VDD B_8 XI1_I18_p1 VDD) gpdk090_pmos1v w=0.48u l=0.1u ad=0.1056p as=0.1056p pd=0.92u ps=0.92u
    I_MXI1_I18_MP3 (XI1_I18_p1 I1_SUB_b3_1 VDD VDD) gpdk090_pmos1v w=0.48u l=0.1u ad=0.1632p as=0.1056p pd=1.64u ps=0.92u
    I_MXI1_I18_MP0 (VDD B_8 XI1_I18_An VDD) gpdk090_pmos1v w=0.24u l=0.1u ad=0.0816p as=0.0816p pd=1.16u ps=1.16u
    I_MXI1_I19_MP1 (VDD I1_SUB_b3_1 XI1_I19_Bn VDD) gpdk090_pmos1v w=0.24u l=0.1u ad=0.0816p as=0.0816p pd=1.16u ps=1.16u
    I_MXI1_I19_MP5 (I1_bx9 XI1_I19_Bn XI1_I19_p1 VDD) gpdk090_pmos1v w=0.48u l=0.1u ad=0.1056p as=0.1632p pd=0.92u ps=1.64u
    I_MXI1_I19_MP4 (XI1_I19_p1 XI1_I19_An I1_bx9 VDD) gpdk090_pmos1v w=0.48u l=0.1u ad=0.1056p as=0.1056p pd=0.92u ps=0.92u
    I_MXI1_I19_MP2 (VDD B_9 XI1_I19_p1 VDD) gpdk090_pmos1v w=0.48u l=0.1u ad=0.1056p as=0.1056p pd=0.92u ps=0.92u
    I_MXI1_I19_MP3 (XI1_I19_p1 I1_SUB_b3_1 VDD VDD) gpdk090_pmos1v w=0.48u l=0.1u ad=0.1632p as=0.1056p pd=1.64u ps=0.92u
    I_MXI1_I19_MP0 (VDD B_9 XI1_I19_An VDD) gpdk090_pmos1v w=0.24u l=0.1u ad=0.0816p as=0.0816p pd=1.16u ps=1.16u
    I_MXI1_I17_MP1 (VDD I1_SUB_b3_1 XI1_I17_Bn VDD) gpdk090_pmos1v w=0.24u l=0.1u ad=0.0816p as=0.0816p pd=1.16u ps=1.16u
    I_MXI1_I17_MP5 (I1_bx7 XI1_I17_Bn XI1_I17_p1 VDD) gpdk090_pmos1v w=0.48u l=0.1u ad=0.1056p as=0.1632p pd=0.92u ps=1.64u
    I_MXI1_I17_MP4 (XI1_I17_p1 XI1_I17_An I1_bx7 VDD) gpdk090_pmos1v w=0.48u l=0.1u ad=0.1056p as=0.1056p pd=0.92u ps=0.92u
    I_MXI1_I17_MP2 (VDD B_7 XI1_I17_p1 VDD) gpdk090_pmos1v w=0.48u l=0.1u ad=0.1056p as=0.1056p pd=0.92u ps=0.92u
    I_MXI1_I17_MP3 (XI1_I17_p1 I1_SUB_b3_1 VDD VDD) gpdk090_pmos1v w=0.48u l=0.1u ad=0.1632p as=0.1056p pd=1.64u ps=0.92u
    I_MXI1_I17_MP0 (VDD B_7 XI1_I17_An VDD) gpdk090_pmos1v w=0.24u l=0.1u ad=0.0816p as=0.0816p pd=1.16u ps=1.16u
    I_MXI1_I16_MP1 (VDD I1_SUB_b3_1 XI1_I16_Bn VDD) gpdk090_pmos1v w=0.24u l=0.1u ad=0.0816p as=0.0816p pd=1.16u ps=1.16u
    I_MXI1_I16_MP5 (I1_bx6 XI1_I16_Bn XI1_I16_p1 VDD) gpdk090_pmos1v w=0.48u l=0.1u ad=0.1056p as=0.1632p pd=0.92u ps=1.64u
    I_MXI1_I16_MP4 (XI1_I16_p1 XI1_I16_An I1_bx6 VDD) gpdk090_pmos1v w=0.48u l=0.1u ad=0.1056p as=0.1056p pd=0.92u ps=0.92u
    I_MXI1_I16_MP2 (VDD B_6 XI1_I16_p1 VDD) gpdk090_pmos1v w=0.48u l=0.1u ad=0.1056p as=0.1056p pd=0.92u ps=0.92u
    I_MXI1_I16_MP3 (XI1_I16_p1 I1_SUB_b3_1 VDD VDD) gpdk090_pmos1v w=0.48u l=0.1u ad=0.1632p as=0.1056p pd=1.64u ps=0.92u
    I_MXI1_I16_MP0 (VDD B_6 XI1_I16_An VDD) gpdk090_pmos1v w=0.24u l=0.1u ad=0.0816p as=0.0816p pd=1.16u ps=1.16u
    I_MXI1_I15_MP1 (VDD I1_SUB_b3_0 XI1_I15_Bn VDD) gpdk090_pmos1v w=0.24u l=0.1u ad=0.0816p as=0.0816p pd=1.16u ps=1.16u
    I_MXI1_I15_MP5 (I1_bx5 XI1_I15_Bn XI1_I15_p1 VDD) gpdk090_pmos1v w=0.48u l=0.1u ad=0.1056p as=0.1632p pd=0.92u ps=1.64u
    I_MXI1_I15_MP4 (XI1_I15_p1 XI1_I15_An I1_bx5 VDD) gpdk090_pmos1v w=0.48u l=0.1u ad=0.1056p as=0.1056p pd=0.92u ps=0.92u
    I_MXI1_I15_MP2 (VDD B_5 XI1_I15_p1 VDD) gpdk090_pmos1v w=0.48u l=0.1u ad=0.1056p as=0.1056p pd=0.92u ps=0.92u
    I_MXI1_I15_MP3 (XI1_I15_p1 I1_SUB_b3_0 VDD VDD) gpdk090_pmos1v w=0.48u l=0.1u ad=0.1632p as=0.1056p pd=1.64u ps=0.92u
    I_MXI1_I15_MP0 (VDD B_5 XI1_I15_An VDD) gpdk090_pmos1v w=0.24u l=0.1u ad=0.0816p as=0.0816p pd=1.16u ps=1.16u
    I_MXI1_I20_MP1 (VDD I1_SUB_b3_1 XI1_I20_Bn VDD) gpdk090_pmos1v w=0.24u l=0.1u ad=0.0816p as=0.0816p pd=1.16u ps=1.16u
    I_MXI1_I20_MP5 (I1_bx10 XI1_I20_Bn XI1_I20_p1 VDD) gpdk090_pmos1v w=0.48u l=0.1u ad=0.1056p as=0.1632p pd=0.92u ps=1.64u
    I_MXI1_I20_MP4 (XI1_I20_p1 XI1_I20_An I1_bx10 VDD) gpdk090_pmos1v w=0.48u l=0.1u ad=0.1056p as=0.1056p pd=0.92u ps=0.92u
    I_MXI1_I20_MP2 (VDD B_10 XI1_I20_p1 VDD) gpdk090_pmos1v w=0.48u l=0.1u ad=0.1056p as=0.1056p pd=0.92u ps=0.92u
    I_MXI1_I20_MP3 (XI1_I20_p1 I1_SUB_b3_1 VDD VDD) gpdk090_pmos1v w=0.48u l=0.1u ad=0.1632p as=0.1056p pd=1.64u ps=0.92u
    I_MXI1_I20_MP0 (VDD B_10 XI1_I20_An VDD) gpdk090_pmos1v w=0.24u l=0.1u ad=0.0816p as=0.0816p pd=1.16u ps=1.16u
    I_MXI1_I42_I212_MP1 (VDD I1_I42_G8_0n XI1_I42_I212_Bn VDD) gpdk090_pmos1v w=0.24u l=0.1u ad=0.0816p as=0.0816p pd=1.16u ps=1.16u
    I_MXI1_I42_I212_MP5 (S_9 XI1_I42_I212_Bn XI1_I42_I212_p1 VDD) gpdk090_pmos1v w=0.48u l=0.1u ad=0.1056p as=0.1632p pd=0.92u ps=1.64u
    I_MXI1_I42_I212_MP4 (XI1_I42_I212_p1 XI1_I42_I212_An S_9 VDD) gpdk090_pmos1v w=0.48u l=0.1u ad=0.1056p as=0.1056p pd=0.92u ps=0.92u
    I_MXI1_I42_I212_MP2 (VDD I1_I42_pn9 XI1_I42_I212_p1 VDD) gpdk090_pmos1v w=0.48u l=0.1u ad=0.1056p as=0.1056p pd=0.92u ps=0.92u
    I_MXI1_I42_I212_MP3 (XI1_I42_I212_p1 I1_I42_G8_0n VDD VDD) gpdk090_pmos1v w=0.48u l=0.1u ad=0.1632p as=0.1056p pd=1.64u ps=0.92u
    I_MXI1_I42_I212_MP0 (VDD I1_I42_pn9 XI1_I42_I212_An VDD) gpdk090_pmos1v w=0.24u l=0.1u ad=0.0816p as=0.0816p pd=1.16u ps=1.16u
    I_MXI1_I42_I207_MP1 (VDD I1_I42_G3_0n XI1_I42_I207_Bn VDD) gpdk090_pmos1v w=0.24u l=0.1u ad=0.0816p as=0.0816p pd=1.16u ps=1.16u
    I_MXI1_I42_I207_MP5 (S_4 XI1_I42_I207_Bn XI1_I42_I207_p1 VDD) gpdk090_pmos1v w=0.48u l=0.1u ad=0.1056p as=0.1632p pd=0.92u ps=1.64u
    I_MXI1_I42_I207_MP4 (XI1_I42_I207_p1 XI1_I42_I207_An S_4 VDD) gpdk090_pmos1v w=0.48u l=0.1u ad=0.1056p as=0.1056p pd=0.92u ps=0.92u
    I_MXI1_I42_I207_MP2 (VDD I1_I42_pn4 XI1_I42_I207_p1 VDD) gpdk090_pmos1v w=0.48u l=0.1u ad=0.1056p as=0.1056p pd=0.92u ps=0.92u
    I_MXI1_I42_I207_MP3 (XI1_I42_I207_p1 I1_I42_G3_0n VDD VDD) gpdk090_pmos1v w=0.48u l=0.1u ad=0.1632p as=0.1056p pd=1.64u ps=0.92u
    I_MXI1_I42_I207_MP0 (VDD I1_I42_pn4 XI1_I42_I207_An VDD) gpdk090_pmos1v w=0.24u l=0.1u ad=0.0816p as=0.0816p pd=1.16u ps=1.16u
    I_MXI1_I12_MP1 (VDD I1_SUB_b3_0 XI1_I12_Bn VDD) gpdk090_pmos1v w=0.24u l=0.1u ad=0.0816p as=0.0816p pd=1.16u ps=1.16u
    I_MXI1_I12_MP5 (I1_bx2 XI1_I12_Bn XI1_I12_p1 VDD) gpdk090_pmos1v w=0.48u l=0.1u ad=0.1056p as=0.1632p pd=0.92u ps=1.64u
    I_MXI1_I12_MP4 (XI1_I12_p1 XI1_I12_An I1_bx2 VDD) gpdk090_pmos1v w=0.48u l=0.1u ad=0.1056p as=0.1056p pd=0.92u ps=0.92u
    I_MXI1_I12_MP2 (VDD B_2 XI1_I12_p1 VDD) gpdk090_pmos1v w=0.48u l=0.1u ad=0.1056p as=0.1056p pd=0.92u ps=0.92u
    I_MXI1_I12_MP3 (XI1_I12_p1 I1_SUB_b3_0 VDD VDD) gpdk090_pmos1v w=0.48u l=0.1u ad=0.1632p as=0.1056p pd=1.64u ps=0.92u
    I_MXI1_I12_MP0 (VDD B_2 XI1_I12_An VDD) gpdk090_pmos1v w=0.24u l=0.1u ad=0.0816p as=0.0816p pd=1.16u ps=1.16u
    I_MXI2_I22_MP1 (VDD B_3 XI2_I22_Bn VDD) gpdk090_pmos1v w=0.24u l=0.1u ad=0.0816p as=0.0816p pd=1.16u ps=1.16u
    I_MXI2_I22_MP5 (XOR_3 XI2_I22_Bn XI2_I22_p1 VDD) gpdk090_pmos1v w=0.48u l=0.1u ad=0.1056p as=0.1632p pd=0.92u ps=1.64u
    I_MXI2_I22_MP4 (XI2_I22_p1 XI2_I22_An XOR_3 VDD) gpdk090_pmos1v w=0.48u l=0.1u ad=0.1056p as=0.1056p pd=0.92u ps=0.92u
    I_MXI2_I22_MP2 (VDD A_3 XI2_I22_p1 VDD) gpdk090_pmos1v w=0.48u l=0.1u ad=0.1056p as=0.1056p pd=0.92u ps=0.92u
    I_MXI2_I22_MP3 (XI2_I22_p1 B_3 VDD VDD) gpdk090_pmos1v w=0.48u l=0.1u ad=0.1632p as=0.1056p pd=1.64u ps=0.92u
    I_MXI2_I22_MP0 (VDD A_3 XI2_I22_An VDD) gpdk090_pmos1v w=0.24u l=0.1u ad=0.0816p as=0.0816p pd=1.16u ps=1.16u
    I_MXI1_I42_I213_MP1 (VDD I1_I42_G9_0n XI1_I42_I213_Bn VDD) gpdk090_pmos1v w=0.24u l=0.1u ad=0.0816p as=0.0816p pd=1.16u ps=1.16u
    I_MXI1_I42_I213_MP5 (S_10 XI1_I42_I213_Bn XI1_I42_I213_p1 VDD) gpdk090_pmos1v w=0.48u l=0.1u ad=0.1056p as=0.1632p pd=0.92u ps=1.64u
    I_MXI1_I42_I213_MP4 (XI1_I42_I213_p1 XI1_I42_I213_An S_10 VDD) gpdk090_pmos1v w=0.48u l=0.1u ad=0.1056p as=0.1056p pd=0.92u ps=0.92u
    I_MXI1_I42_I213_MP2 (VDD I1_I42_pn10 XI1_I42_I213_p1 VDD) gpdk090_pmos1v w=0.48u l=0.1u ad=0.1056p as=0.1056p pd=0.92u ps=0.92u
    I_MXI1_I42_I213_MP3 (XI1_I42_I213_p1 I1_I42_G9_0n VDD VDD) gpdk090_pmos1v w=0.48u l=0.1u ad=0.1632p as=0.1056p pd=1.64u ps=0.92u
    I_MXI1_I42_I213_MP0 (VDD I1_I42_pn10 XI1_I42_I213_An VDD) gpdk090_pmos1v w=0.24u l=0.1u ad=0.0816p as=0.0816p pd=1.16u ps=1.16u
    I_MXI1_I42_I206_MP1 (VDD I1_I42_G2_0n XI1_I42_I206_Bn VDD) gpdk090_pmos1v w=0.24u l=0.1u ad=0.0816p as=0.0816p pd=1.16u ps=1.16u
    I_MXI1_I42_I206_MP5 (S_3 XI1_I42_I206_Bn XI1_I42_I206_p1 VDD) gpdk090_pmos1v w=0.48u l=0.1u ad=0.1056p as=0.1632p pd=0.92u ps=1.64u
    I_MXI1_I42_I206_MP4 (XI1_I42_I206_p1 XI1_I42_I206_An S_3 VDD) gpdk090_pmos1v w=0.48u l=0.1u ad=0.1056p as=0.1056p pd=0.92u ps=0.92u
    I_MXI1_I42_I206_MP2 (VDD I1_I42_pn3 XI1_I42_I206_p1 VDD) gpdk090_pmos1v w=0.48u l=0.1u ad=0.1056p as=0.1056p pd=0.92u ps=0.92u
    I_MXI1_I42_I206_MP3 (XI1_I42_I206_p1 I1_I42_G2_0n VDD VDD) gpdk090_pmos1v w=0.48u l=0.1u ad=0.1632p as=0.1056p pd=1.64u ps=0.92u
    I_MXI1_I42_I206_MP0 (VDD I1_I42_pn3 XI1_I42_I206_An VDD) gpdk090_pmos1v w=0.24u l=0.1u ad=0.0816p as=0.0816p pd=1.16u ps=1.16u
    I_MXI1_I13_MP1 (VDD I1_SUB_b3_0 XI1_I13_Bn VDD) gpdk090_pmos1v w=0.24u l=0.1u ad=0.0816p as=0.0816p pd=1.16u ps=1.16u
    I_MXI1_I13_MP5 (I1_bx3 XI1_I13_Bn XI1_I13_p1 VDD) gpdk090_pmos1v w=0.48u l=0.1u ad=0.1056p as=0.1632p pd=0.92u ps=1.64u
    I_MXI1_I13_MP4 (XI1_I13_p1 XI1_I13_An I1_bx3 VDD) gpdk090_pmos1v w=0.48u l=0.1u ad=0.1056p as=0.1056p pd=0.92u ps=0.92u
    I_MXI1_I13_MP2 (VDD B_3 XI1_I13_p1 VDD) gpdk090_pmos1v w=0.48u l=0.1u ad=0.1056p as=0.1056p pd=0.92u ps=0.92u
    I_MXI1_I13_MP3 (XI1_I13_p1 I1_SUB_b3_0 VDD VDD) gpdk090_pmos1v w=0.48u l=0.1u ad=0.1632p as=0.1056p pd=1.64u ps=0.92u
    I_MXI1_I13_MP0 (VDD B_3 XI1_I13_An VDD) gpdk090_pmos1v w=0.24u l=0.1u ad=0.0816p as=0.0816p pd=1.16u ps=1.16u
    I_MXI2_I184_MP1 (VDD B_30 XI2_I184_Bn VDD) gpdk090_pmos1v w=0.24u l=0.1u ad=0.0816p as=0.0816p pd=1.16u ps=1.16u
    I_MXI2_I184_MP5 (XOR_30 XI2_I184_Bn XI2_I184_p1 VDD) gpdk090_pmos1v w=0.48u l=0.1u ad=0.1056p as=0.1632p pd=0.92u ps=1.64u
    I_MXI2_I184_MP4 (XI2_I184_p1 XI2_I184_An XOR_30 VDD) gpdk090_pmos1v w=0.48u l=0.1u ad=0.1056p as=0.1056p pd=0.92u ps=0.92u
    I_MXI2_I184_MP2 (VDD A_30 XI2_I184_p1 VDD) gpdk090_pmos1v w=0.48u l=0.1u ad=0.1056p as=0.1056p pd=0.92u ps=0.92u
    I_MXI2_I184_MP3 (XI2_I184_p1 B_30 VDD VDD) gpdk090_pmos1v w=0.48u l=0.1u ad=0.1632p as=0.1056p pd=1.64u ps=0.92u
    I_MXI2_I184_MP0 (VDD A_30 XI2_I184_An VDD) gpdk090_pmos1v w=0.24u l=0.1u ad=0.0816p as=0.0816p pd=1.16u ps=1.16u
    I_MXI1_I40_MP1 (VDD I1_SUB_b3_5 XI1_I40_Bn VDD) gpdk090_pmos1v w=0.24u l=0.1u ad=0.0816p as=0.0816p pd=1.16u ps=1.16u
    I_MXI1_I40_MP5 (I1_bx30 XI1_I40_Bn XI1_I40_p1 VDD) gpdk090_pmos1v w=0.48u l=0.1u ad=0.1056p as=0.1632p pd=0.92u ps=1.64u
    I_MXI1_I40_MP4 (XI1_I40_p1 XI1_I40_An I1_bx30 VDD) gpdk090_pmos1v w=0.48u l=0.1u ad=0.1056p as=0.1056p pd=0.92u ps=0.92u
    I_MXI1_I40_MP2 (VDD B_30 XI1_I40_p1 VDD) gpdk090_pmos1v w=0.48u l=0.1u ad=0.1056p as=0.1056p pd=0.92u ps=0.92u
    I_MXI1_I40_MP3 (XI1_I40_p1 I1_SUB_b3_5 VDD VDD) gpdk090_pmos1v w=0.48u l=0.1u ad=0.1632p as=0.1056p pd=1.64u ps=0.92u
    I_MXI1_I40_MP0 (VDD B_30 XI1_I40_An VDD) gpdk090_pmos1v w=0.24u l=0.1u ad=0.0816p as=0.0816p pd=1.16u ps=1.16u
    I_MXI4_I66_MP1 (VDD CO XI4_I66_Bn VDD) gpdk090_pmos1v w=0.24u l=0.1u ad=0.0816p as=0.0816p pd=1.16u ps=1.16u
    I_MXI4_I66_MP5 (I4_ovf XI4_I66_Bn XI4_I66_p1 VDD) gpdk090_pmos1v w=0.48u l=0.1u ad=0.1056p as=0.1632p pd=0.92u ps=1.64u
    I_MXI4_I66_MP4 (XI4_I66_p1 XI4_I66_An I4_ovf VDD) gpdk090_pmos1v w=0.48u l=0.1u ad=0.1056p as=0.1056p pd=0.92u ps=0.92u
    I_MXI4_I66_MP2 (VDD CM XI4_I66_p1 VDD) gpdk090_pmos1v w=0.48u l=0.1u ad=0.1056p as=0.1056p pd=0.92u ps=0.92u
    I_MXI4_I66_MP3 (XI4_I66_p1 CO VDD VDD) gpdk090_pmos1v w=0.48u l=0.1u ad=0.1632p as=0.1056p pd=1.64u ps=0.92u
    I_MXI4_I66_MP0 (VDD CM XI4_I66_An VDD) gpdk090_pmos1v w=0.24u l=0.1u ad=0.0816p as=0.0816p pd=1.16u ps=1.16u
    I_MXI2_I70_MP1 (VDD B_11 XI2_I70_Bn VDD) gpdk090_pmos1v w=0.24u l=0.1u ad=0.0816p as=0.0816p pd=1.16u ps=1.16u
    I_MXI2_I70_MP5 (XOR_11 XI2_I70_Bn XI2_I70_p1 VDD) gpdk090_pmos1v w=0.48u l=0.1u ad=0.1056p as=0.1632p pd=0.92u ps=1.64u
    I_MXI2_I70_MP4 (XI2_I70_p1 XI2_I70_An XOR_11 VDD) gpdk090_pmos1v w=0.48u l=0.1u ad=0.1056p as=0.1056p pd=0.92u ps=0.92u
    I_MXI2_I70_MP2 (VDD A_11 XI2_I70_p1 VDD) gpdk090_pmos1v w=0.48u l=0.1u ad=0.1056p as=0.1056p pd=0.92u ps=0.92u
    I_MXI2_I70_MP3 (XI2_I70_p1 B_11 VDD VDD) gpdk090_pmos1v w=0.48u l=0.1u ad=0.1632p as=0.1056p pd=1.64u ps=0.92u
    I_MXI2_I70_MP0 (VDD A_11 XI2_I70_An VDD) gpdk090_pmos1v w=0.24u l=0.1u ad=0.0816p as=0.0816p pd=1.16u ps=1.16u
    I_MXI2_I190_MP1 (VDD B_31 XI2_I190_Bn VDD) gpdk090_pmos1v w=0.24u l=0.1u ad=0.0816p as=0.0816p pd=1.16u ps=1.16u
    I_MXI2_I190_MP5 (XOR_31 XI2_I190_Bn XI2_I190_p1 VDD) gpdk090_pmos1v w=0.48u l=0.1u ad=0.1056p as=0.1632p pd=0.92u ps=1.64u
    I_MXI2_I190_MP4 (XI2_I190_p1 XI2_I190_An XOR_31 VDD) gpdk090_pmos1v w=0.48u l=0.1u ad=0.1056p as=0.1056p pd=0.92u ps=0.92u
    I_MXI2_I190_MP2 (VDD A_31 XI2_I190_p1 VDD) gpdk090_pmos1v w=0.48u l=0.1u ad=0.1056p as=0.1056p pd=0.92u ps=0.92u
    I_MXI2_I190_MP3 (XI2_I190_p1 B_31 VDD VDD) gpdk090_pmos1v w=0.48u l=0.1u ad=0.1632p as=0.1056p pd=1.64u ps=0.92u
    I_MXI2_I190_MP0 (VDD A_31 XI2_I190_An VDD) gpdk090_pmos1v w=0.24u l=0.1u ad=0.0816p as=0.0816p pd=1.16u ps=1.16u
    I_MXI1_I42_I214_MP1 (VDD I1_I42_G10_0n XI1_I42_I214_Bn VDD) gpdk090_pmos1v w=0.24u l=0.1u ad=0.0816p as=0.0816p pd=1.16u ps=1.16u
    I_MXI1_I42_I214_MP5 (S_11 XI1_I42_I214_Bn XI1_I42_I214_p1 VDD) gpdk090_pmos1v w=0.48u l=0.1u ad=0.1056p as=0.1632p pd=0.92u ps=1.64u
    I_MXI1_I42_I214_MP4 (XI1_I42_I214_p1 XI1_I42_I214_An S_11 VDD) gpdk090_pmos1v w=0.48u l=0.1u ad=0.1056p as=0.1056p pd=0.92u ps=0.92u
    I_MXI1_I42_I214_MP2 (VDD I1_I42_pn11 XI1_I42_I214_p1 VDD) gpdk090_pmos1v w=0.48u l=0.1u ad=0.1056p as=0.1056p pd=0.92u ps=0.92u
    I_MXI1_I42_I214_MP3 (XI1_I42_I214_p1 I1_I42_G10_0n VDD VDD) gpdk090_pmos1v w=0.48u l=0.1u ad=0.1632p as=0.1056p pd=1.64u ps=0.92u
    I_MXI1_I42_I214_MP0 (VDD I1_I42_pn11 XI1_I42_I214_An VDD) gpdk090_pmos1v w=0.24u l=0.1u ad=0.0816p as=0.0816p pd=1.16u ps=1.16u
    I_MXI1_I21_MP1 (VDD I1_SUB_b3_2 XI1_I21_Bn VDD) gpdk090_pmos1v w=0.24u l=0.1u ad=0.0816p as=0.0816p pd=1.16u ps=1.16u
    I_MXI1_I21_MP5 (I1_bx11 XI1_I21_Bn XI1_I21_p1 VDD) gpdk090_pmos1v w=0.48u l=0.1u ad=0.1056p as=0.1632p pd=0.92u ps=1.64u
    I_MXI1_I21_MP4 (XI1_I21_p1 XI1_I21_An I1_bx11 VDD) gpdk090_pmos1v w=0.48u l=0.1u ad=0.1056p as=0.1056p pd=0.92u ps=0.92u
    I_MXI1_I21_MP2 (VDD B_11 XI1_I21_p1 VDD) gpdk090_pmos1v w=0.48u l=0.1u ad=0.1056p as=0.1056p pd=0.92u ps=0.92u
    I_MXI1_I21_MP3 (XI1_I21_p1 I1_SUB_b3_2 VDD VDD) gpdk090_pmos1v w=0.48u l=0.1u ad=0.1632p as=0.1056p pd=1.64u ps=0.92u
    I_MXI1_I21_MP0 (VDD B_11 XI1_I21_An VDD) gpdk090_pmos1v w=0.24u l=0.1u ad=0.0816p as=0.0816p pd=1.16u ps=1.16u
    I_MXI1_I22_MP1 (VDD I1_SUB_b3_2 XI1_I22_Bn VDD) gpdk090_pmos1v w=0.24u l=0.1u ad=0.0816p as=0.0816p pd=1.16u ps=1.16u
    I_MXI1_I22_MP5 (I1_bx12 XI1_I22_Bn XI1_I22_p1 VDD) gpdk090_pmos1v w=0.48u l=0.1u ad=0.1056p as=0.1632p pd=0.92u ps=1.64u
    I_MXI1_I22_MP4 (XI1_I22_p1 XI1_I22_An I1_bx12 VDD) gpdk090_pmos1v w=0.48u l=0.1u ad=0.1056p as=0.1056p pd=0.92u ps=0.92u
    I_MXI1_I22_MP2 (VDD B_12 XI1_I22_p1 VDD) gpdk090_pmos1v w=0.48u l=0.1u ad=0.1056p as=0.1056p pd=0.92u ps=0.92u
    I_MXI1_I22_MP3 (XI1_I22_p1 I1_SUB_b3_2 VDD VDD) gpdk090_pmos1v w=0.48u l=0.1u ad=0.1632p as=0.1056p pd=1.64u ps=0.92u
    I_MXI1_I22_MP0 (VDD B_12 XI1_I22_An VDD) gpdk090_pmos1v w=0.24u l=0.1u ad=0.0816p as=0.0816p pd=1.16u ps=1.16u
    I_MXI2_I76_MP1 (VDD B_12 XI2_I76_Bn VDD) gpdk090_pmos1v w=0.24u l=0.1u ad=0.0816p as=0.0816p pd=1.16u ps=1.16u
    I_MXI2_I76_MP5 (XOR_12 XI2_I76_Bn XI2_I76_p1 VDD) gpdk090_pmos1v w=0.48u l=0.1u ad=0.1056p as=0.1632p pd=0.92u ps=1.64u
    I_MXI2_I76_MP4 (XI2_I76_p1 XI2_I76_An XOR_12 VDD) gpdk090_pmos1v w=0.48u l=0.1u ad=0.1056p as=0.1056p pd=0.92u ps=0.92u
    I_MXI2_I76_MP2 (VDD A_12 XI2_I76_p1 VDD) gpdk090_pmos1v w=0.48u l=0.1u ad=0.1056p as=0.1056p pd=0.92u ps=0.92u
    I_MXI2_I76_MP3 (XI2_I76_p1 B_12 VDD VDD) gpdk090_pmos1v w=0.48u l=0.1u ad=0.1632p as=0.1056p pd=1.64u ps=0.92u
    I_MXI2_I76_MP0 (VDD A_12 XI2_I76_An VDD) gpdk090_pmos1v w=0.24u l=0.1u ad=0.0816p as=0.0816p pd=1.16u ps=1.16u
    I_MXI1_I41_MP1 (VDD I1_SUB_b3_5 XI1_I41_Bn VDD) gpdk090_pmos1v w=0.24u l=0.1u ad=0.0816p as=0.0816p pd=1.16u ps=1.16u
    I_MXI1_I41_MP5 (I1_bx31 XI1_I41_Bn XI1_I41_p1 VDD) gpdk090_pmos1v w=0.48u l=0.1u ad=0.1056p as=0.1632p pd=0.92u ps=1.64u
    I_MXI1_I41_MP4 (XI1_I41_p1 XI1_I41_An I1_bx31 VDD) gpdk090_pmos1v w=0.48u l=0.1u ad=0.1056p as=0.1056p pd=0.92u ps=0.92u
    I_MXI1_I41_MP2 (VDD B_31 XI1_I41_p1 VDD) gpdk090_pmos1v w=0.48u l=0.1u ad=0.1056p as=0.1056p pd=0.92u ps=0.92u
    I_MXI1_I41_MP3 (XI1_I41_p1 I1_SUB_b3_5 VDD VDD) gpdk090_pmos1v w=0.48u l=0.1u ad=0.1632p as=0.1056p pd=1.64u ps=0.92u
    I_MXI1_I41_MP0 (VDD B_31 XI1_I41_An VDD) gpdk090_pmos1v w=0.24u l=0.1u ad=0.0816p as=0.0816p pd=1.16u ps=1.16u
    I_MXI1_I42_I215_MP1 (VDD I1_I42_G11_0n XI1_I42_I215_Bn VDD) gpdk090_pmos1v w=0.24u l=0.1u ad=0.0816p as=0.0816p pd=1.16u ps=1.16u
    I_MXI1_I42_I215_MP5 (S_12 XI1_I42_I215_Bn XI1_I42_I215_p1 VDD) gpdk090_pmos1v w=0.48u l=0.1u ad=0.1056p as=0.1632p pd=0.92u ps=1.64u
    I_MXI1_I42_I215_MP4 (XI1_I42_I215_p1 XI1_I42_I215_An S_12 VDD) gpdk090_pmos1v w=0.48u l=0.1u ad=0.1056p as=0.1056p pd=0.92u ps=0.92u
    I_MXI1_I42_I215_MP2 (VDD I1_I42_pn12 XI1_I42_I215_p1 VDD) gpdk090_pmos1v w=0.48u l=0.1u ad=0.1056p as=0.1056p pd=0.92u ps=0.92u
    I_MXI1_I42_I215_MP3 (XI1_I42_I215_p1 I1_I42_G11_0n VDD VDD) gpdk090_pmos1v w=0.48u l=0.1u ad=0.1632p as=0.1056p pd=1.64u ps=0.92u
    I_MXI1_I42_I215_MP0 (VDD I1_I42_pn12 XI1_I42_I215_An VDD) gpdk090_pmos1v w=0.24u l=0.1u ad=0.0816p as=0.0816p pd=1.16u ps=1.16u
    I_MXI1_I23_MP1 (VDD I1_SUB_b3_2 XI1_I23_Bn VDD) gpdk090_pmos1v w=0.24u l=0.1u ad=0.0816p as=0.0816p pd=1.16u ps=1.16u
    I_MXI1_I23_MP5 (I1_bx13 XI1_I23_Bn XI1_I23_p1 VDD) gpdk090_pmos1v w=0.48u l=0.1u ad=0.1056p as=0.1632p pd=0.92u ps=1.64u
    I_MXI1_I23_MP4 (XI1_I23_p1 XI1_I23_An I1_bx13 VDD) gpdk090_pmos1v w=0.48u l=0.1u ad=0.1056p as=0.1056p pd=0.92u ps=0.92u
    I_MXI1_I23_MP2 (VDD B_13 XI1_I23_p1 VDD) gpdk090_pmos1v w=0.48u l=0.1u ad=0.1056p as=0.1056p pd=0.92u ps=0.92u
    I_MXI1_I23_MP3 (XI1_I23_p1 I1_SUB_b3_2 VDD VDD) gpdk090_pmos1v w=0.48u l=0.1u ad=0.1632p as=0.1056p pd=1.64u ps=0.92u
    I_MXI1_I23_MP0 (VDD B_13 XI1_I23_An VDD) gpdk090_pmos1v w=0.24u l=0.1u ad=0.0816p as=0.0816p pd=1.16u ps=1.16u
    I_MXI2_I178_MP1 (VDD B_29 XI2_I178_Bn VDD) gpdk090_pmos1v w=0.24u l=0.1u ad=0.0816p as=0.0816p pd=1.16u ps=1.16u
    I_MXI2_I178_MP5 (XOR_29 XI2_I178_Bn XI2_I178_p1 VDD) gpdk090_pmos1v w=0.48u l=0.1u ad=0.1056p as=0.1632p pd=0.92u ps=1.64u
    I_MXI2_I178_MP4 (XI2_I178_p1 XI2_I178_An XOR_29 VDD) gpdk090_pmos1v w=0.48u l=0.1u ad=0.1056p as=0.1056p pd=0.92u ps=0.92u
    I_MXI2_I178_MP2 (VDD A_29 XI2_I178_p1 VDD) gpdk090_pmos1v w=0.48u l=0.1u ad=0.1056p as=0.1056p pd=0.92u ps=0.92u
    I_MXI2_I178_MP3 (XI2_I178_p1 B_29 VDD VDD) gpdk090_pmos1v w=0.48u l=0.1u ad=0.1632p as=0.1056p pd=1.64u ps=0.92u
    I_MXI2_I178_MP0 (VDD A_29 XI2_I178_An VDD) gpdk090_pmos1v w=0.24u l=0.1u ad=0.0816p as=0.0816p pd=1.16u ps=1.16u
    I_MXI1_I39_MP1 (VDD I1_SUB_b3_5 XI1_I39_Bn VDD) gpdk090_pmos1v w=0.24u l=0.1u ad=0.0816p as=0.0816p pd=1.16u ps=1.16u
    I_MXI1_I39_MP5 (I1_bx29 XI1_I39_Bn XI1_I39_p1 VDD) gpdk090_pmos1v w=0.48u l=0.1u ad=0.1056p as=0.1632p pd=0.92u ps=1.64u
    I_MXI1_I39_MP4 (XI1_I39_p1 XI1_I39_An I1_bx29 VDD) gpdk090_pmos1v w=0.48u l=0.1u ad=0.1056p as=0.1056p pd=0.92u ps=0.92u
    I_MXI1_I39_MP2 (VDD B_29 XI1_I39_p1 VDD) gpdk090_pmos1v w=0.48u l=0.1u ad=0.1056p as=0.1056p pd=0.92u ps=0.92u
    I_MXI1_I39_MP3 (XI1_I39_p1 I1_SUB_b3_5 VDD VDD) gpdk090_pmos1v w=0.48u l=0.1u ad=0.1632p as=0.1056p pd=1.64u ps=0.92u
    I_MXI1_I39_MP0 (VDD B_29 XI1_I39_An VDD) gpdk090_pmos1v w=0.24u l=0.1u ad=0.0816p as=0.0816p pd=1.16u ps=1.16u
    I_MXI1_I42_I216_MP1 (VDD I1_I42_G12_0n XI1_I42_I216_Bn VDD) gpdk090_pmos1v w=0.24u l=0.1u ad=0.0816p as=0.0816p pd=1.16u ps=1.16u
    I_MXI1_I42_I216_MP5 (S_13 XI1_I42_I216_Bn XI1_I42_I216_p1 VDD) gpdk090_pmos1v w=0.48u l=0.1u ad=0.1056p as=0.1632p pd=0.92u ps=1.64u
    I_MXI1_I42_I216_MP4 (XI1_I42_I216_p1 XI1_I42_I216_An S_13 VDD) gpdk090_pmos1v w=0.48u l=0.1u ad=0.1056p as=0.1056p pd=0.92u ps=0.92u
    I_MXI1_I42_I216_MP2 (VDD I1_I42_pn13 XI1_I42_I216_p1 VDD) gpdk090_pmos1v w=0.48u l=0.1u ad=0.1056p as=0.1056p pd=0.92u ps=0.92u
    I_MXI1_I42_I216_MP3 (XI1_I42_I216_p1 I1_I42_G12_0n VDD VDD) gpdk090_pmos1v w=0.48u l=0.1u ad=0.1632p as=0.1056p pd=1.64u ps=0.92u
    I_MXI1_I42_I216_MP0 (VDD I1_I42_pn13 XI1_I42_I216_An VDD) gpdk090_pmos1v w=0.24u l=0.1u ad=0.0816p as=0.0816p pd=1.16u ps=1.16u
    I_MXI1_I42_I217_MP1 (VDD I1_I42_G13_0n XI1_I42_I217_Bn VDD) gpdk090_pmos1v w=0.24u l=0.1u ad=0.0816p as=0.0816p pd=1.16u ps=1.16u
    I_MXI1_I42_I217_MP5 (S_14 XI1_I42_I217_Bn XI1_I42_I217_p1 VDD) gpdk090_pmos1v w=0.48u l=0.1u ad=0.1056p as=0.1632p pd=0.92u ps=1.64u
    I_MXI1_I42_I217_MP4 (XI1_I42_I217_p1 XI1_I42_I217_An S_14 VDD) gpdk090_pmos1v w=0.48u l=0.1u ad=0.1056p as=0.1056p pd=0.92u ps=0.92u
    I_MXI1_I42_I217_MP2 (VDD I1_I42_pn14 XI1_I42_I217_p1 VDD) gpdk090_pmos1v w=0.48u l=0.1u ad=0.1056p as=0.1056p pd=0.92u ps=0.92u
    I_MXI1_I42_I217_MP3 (XI1_I42_I217_p1 I1_I42_G13_0n VDD VDD) gpdk090_pmos1v w=0.48u l=0.1u ad=0.1632p as=0.1056p pd=1.64u ps=0.92u
    I_MXI1_I42_I217_MP0 (VDD I1_I42_pn14 XI1_I42_I217_An VDD) gpdk090_pmos1v w=0.24u l=0.1u ad=0.0816p as=0.0816p pd=1.16u ps=1.16u
    I_MXI2_I82_MP1 (VDD B_13 XI2_I82_Bn VDD) gpdk090_pmos1v w=0.24u l=0.1u ad=0.0816p as=0.0816p pd=1.16u ps=1.16u
    I_MXI2_I82_MP5 (XOR_13 XI2_I82_Bn XI2_I82_p1 VDD) gpdk090_pmos1v w=0.48u l=0.1u ad=0.1056p as=0.1632p pd=0.92u ps=1.64u
    I_MXI2_I82_MP4 (XI2_I82_p1 XI2_I82_An XOR_13 VDD) gpdk090_pmos1v w=0.48u l=0.1u ad=0.1056p as=0.1056p pd=0.92u ps=0.92u
    I_MXI2_I82_MP2 (VDD A_13 XI2_I82_p1 VDD) gpdk090_pmos1v w=0.48u l=0.1u ad=0.1056p as=0.1056p pd=0.92u ps=0.92u
    I_MXI2_I82_MP3 (XI2_I82_p1 B_13 VDD VDD) gpdk090_pmos1v w=0.48u l=0.1u ad=0.1632p as=0.1056p pd=1.64u ps=0.92u
    I_MXI2_I82_MP0 (VDD A_13 XI2_I82_An VDD) gpdk090_pmos1v w=0.24u l=0.1u ad=0.0816p as=0.0816p pd=1.16u ps=1.16u
    I_MXI1_I38_MP1 (VDD I1_SUB_b3_5 XI1_I38_Bn VDD) gpdk090_pmos1v w=0.24u l=0.1u ad=0.0816p as=0.0816p pd=1.16u ps=1.16u
    I_MXI1_I38_MP5 (I1_bx28 XI1_I38_Bn XI1_I38_p1 VDD) gpdk090_pmos1v w=0.48u l=0.1u ad=0.1056p as=0.1632p pd=0.92u ps=1.64u
    I_MXI1_I38_MP4 (XI1_I38_p1 XI1_I38_An I1_bx28 VDD) gpdk090_pmos1v w=0.48u l=0.1u ad=0.1056p as=0.1056p pd=0.92u ps=0.92u
    I_MXI1_I38_MP2 (VDD B_28 XI1_I38_p1 VDD) gpdk090_pmos1v w=0.48u l=0.1u ad=0.1056p as=0.1056p pd=0.92u ps=0.92u
    I_MXI1_I38_MP3 (XI1_I38_p1 I1_SUB_b3_5 VDD VDD) gpdk090_pmos1v w=0.48u l=0.1u ad=0.1632p as=0.1056p pd=1.64u ps=0.92u
    I_MXI1_I38_MP0 (VDD B_28 XI1_I38_An VDD) gpdk090_pmos1v w=0.24u l=0.1u ad=0.0816p as=0.0816p pd=1.16u ps=1.16u
    I_MXI2_I88_MP1 (VDD B_14 XI2_I88_Bn VDD) gpdk090_pmos1v w=0.24u l=0.1u ad=0.0816p as=0.0816p pd=1.16u ps=1.16u
    I_MXI2_I88_MP5 (XOR_14 XI2_I88_Bn XI2_I88_p1 VDD) gpdk090_pmos1v w=0.48u l=0.1u ad=0.1056p as=0.1632p pd=0.92u ps=1.64u
    I_MXI2_I88_MP4 (XI2_I88_p1 XI2_I88_An XOR_14 VDD) gpdk090_pmos1v w=0.48u l=0.1u ad=0.1056p as=0.1056p pd=0.92u ps=0.92u
    I_MXI2_I88_MP2 (VDD A_14 XI2_I88_p1 VDD) gpdk090_pmos1v w=0.48u l=0.1u ad=0.1056p as=0.1056p pd=0.92u ps=0.92u
    I_MXI2_I88_MP3 (XI2_I88_p1 B_14 VDD VDD) gpdk090_pmos1v w=0.48u l=0.1u ad=0.1632p as=0.1056p pd=1.64u ps=0.92u
    I_MXI2_I88_MP0 (VDD A_14 XI2_I88_An VDD) gpdk090_pmos1v w=0.24u l=0.1u ad=0.0816p as=0.0816p pd=1.16u ps=1.16u
    I_MXI2_I172_MP1 (VDD B_28 XI2_I172_Bn VDD) gpdk090_pmos1v w=0.24u l=0.1u ad=0.0816p as=0.0816p pd=1.16u ps=1.16u
    I_MXI2_I172_MP5 (XOR_28 XI2_I172_Bn XI2_I172_p1 VDD) gpdk090_pmos1v w=0.48u l=0.1u ad=0.1056p as=0.1632p pd=0.92u ps=1.64u
    I_MXI2_I172_MP4 (XI2_I172_p1 XI2_I172_An XOR_28 VDD) gpdk090_pmos1v w=0.48u l=0.1u ad=0.1056p as=0.1056p pd=0.92u ps=0.92u
    I_MXI2_I172_MP2 (VDD A_28 XI2_I172_p1 VDD) gpdk090_pmos1v w=0.48u l=0.1u ad=0.1056p as=0.1056p pd=0.92u ps=0.92u
    I_MXI2_I172_MP3 (XI2_I172_p1 B_28 VDD VDD) gpdk090_pmos1v w=0.48u l=0.1u ad=0.1632p as=0.1056p pd=1.64u ps=0.92u
    I_MXI2_I172_MP0 (VDD A_28 XI2_I172_An VDD) gpdk090_pmos1v w=0.24u l=0.1u ad=0.0816p as=0.0816p pd=1.16u ps=1.16u
    I_MXI1_I42_I218_MP1 (VDD I1_I42_G14_0n XI1_I42_I218_Bn VDD) gpdk090_pmos1v w=0.24u l=0.1u ad=0.0816p as=0.0816p pd=1.16u ps=1.16u
    I_MXI1_I42_I218_MP5 (S_15 XI1_I42_I218_Bn XI1_I42_I218_p1 VDD) gpdk090_pmos1v w=0.48u l=0.1u ad=0.1056p as=0.1632p pd=0.92u ps=1.64u
    I_MXI1_I42_I218_MP4 (XI1_I42_I218_p1 XI1_I42_I218_An S_15 VDD) gpdk090_pmos1v w=0.48u l=0.1u ad=0.1056p as=0.1056p pd=0.92u ps=0.92u
    I_MXI1_I42_I218_MP2 (VDD I1_I42_pn15 XI1_I42_I218_p1 VDD) gpdk090_pmos1v w=0.48u l=0.1u ad=0.1056p as=0.1056p pd=0.92u ps=0.92u
    I_MXI1_I42_I218_MP3 (XI1_I42_I218_p1 I1_I42_G14_0n VDD VDD) gpdk090_pmos1v w=0.48u l=0.1u ad=0.1632p as=0.1056p pd=1.64u ps=0.92u
    I_MXI1_I42_I218_MP0 (VDD I1_I42_pn15 XI1_I42_I218_An VDD) gpdk090_pmos1v w=0.24u l=0.1u ad=0.0816p as=0.0816p pd=1.16u ps=1.16u
    I_MXI1_I24_MP1 (VDD I1_SUB_b3_2 XI1_I24_Bn VDD) gpdk090_pmos1v w=0.24u l=0.1u ad=0.0816p as=0.0816p pd=1.16u ps=1.16u
    I_MXI1_I24_MP5 (I1_bx14 XI1_I24_Bn XI1_I24_p1 VDD) gpdk090_pmos1v w=0.48u l=0.1u ad=0.1056p as=0.1632p pd=0.92u ps=1.64u
    I_MXI1_I24_MP4 (XI1_I24_p1 XI1_I24_An I1_bx14 VDD) gpdk090_pmos1v w=0.48u l=0.1u ad=0.1056p as=0.1056p pd=0.92u ps=0.92u
    I_MXI1_I24_MP2 (VDD B_14 XI1_I24_p1 VDD) gpdk090_pmos1v w=0.48u l=0.1u ad=0.1056p as=0.1056p pd=0.92u ps=0.92u
    I_MXI1_I24_MP3 (XI1_I24_p1 I1_SUB_b3_2 VDD VDD) gpdk090_pmos1v w=0.48u l=0.1u ad=0.1632p as=0.1056p pd=1.64u ps=0.92u
    I_MXI1_I24_MP0 (VDD B_14 XI1_I24_An VDD) gpdk090_pmos1v w=0.24u l=0.1u ad=0.0816p as=0.0816p pd=1.16u ps=1.16u
    I_MXI2_I166_MP1 (VDD B_27 XI2_I166_Bn VDD) gpdk090_pmos1v w=0.24u l=0.1u ad=0.0816p as=0.0816p pd=1.16u ps=1.16u
    I_MXI2_I166_MP5 (XOR_27 XI2_I166_Bn XI2_I166_p1 VDD) gpdk090_pmos1v w=0.48u l=0.1u ad=0.1056p as=0.1632p pd=0.92u ps=1.64u
    I_MXI2_I166_MP4 (XI2_I166_p1 XI2_I166_An XOR_27 VDD) gpdk090_pmos1v w=0.48u l=0.1u ad=0.1056p as=0.1056p pd=0.92u ps=0.92u
    I_MXI2_I166_MP2 (VDD A_27 XI2_I166_p1 VDD) gpdk090_pmos1v w=0.48u l=0.1u ad=0.1056p as=0.1056p pd=0.92u ps=0.92u
    I_MXI2_I166_MP3 (XI2_I166_p1 B_27 VDD VDD) gpdk090_pmos1v w=0.48u l=0.1u ad=0.1632p as=0.1056p pd=1.64u ps=0.92u
    I_MXI2_I166_MP0 (VDD A_27 XI2_I166_An VDD) gpdk090_pmos1v w=0.24u l=0.1u ad=0.0816p as=0.0816p pd=1.16u ps=1.16u
    I_MXI1_I25_MP1 (VDD I1_SUB_b3_2 XI1_I25_Bn VDD) gpdk090_pmos1v w=0.24u l=0.1u ad=0.0816p as=0.0816p pd=1.16u ps=1.16u
    I_MXI1_I25_MP5 (I1_bx15 XI1_I25_Bn XI1_I25_p1 VDD) gpdk090_pmos1v w=0.48u l=0.1u ad=0.1056p as=0.1632p pd=0.92u ps=1.64u
    I_MXI1_I25_MP4 (XI1_I25_p1 XI1_I25_An I1_bx15 VDD) gpdk090_pmos1v w=0.48u l=0.1u ad=0.1056p as=0.1056p pd=0.92u ps=0.92u
    I_MXI1_I25_MP2 (VDD B_15 XI1_I25_p1 VDD) gpdk090_pmos1v w=0.48u l=0.1u ad=0.1056p as=0.1056p pd=0.92u ps=0.92u
    I_MXI1_I25_MP3 (XI1_I25_p1 I1_SUB_b3_2 VDD VDD) gpdk090_pmos1v w=0.48u l=0.1u ad=0.1632p as=0.1056p pd=1.64u ps=0.92u
    I_MXI1_I25_MP0 (VDD B_15 XI1_I25_An VDD) gpdk090_pmos1v w=0.24u l=0.1u ad=0.0816p as=0.0816p pd=1.16u ps=1.16u
    I_MXI2_I94_MP1 (VDD B_15 XI2_I94_Bn VDD) gpdk090_pmos1v w=0.24u l=0.1u ad=0.0816p as=0.0816p pd=1.16u ps=1.16u
    I_MXI2_I94_MP5 (XOR_15 XI2_I94_Bn XI2_I94_p1 VDD) gpdk090_pmos1v w=0.48u l=0.1u ad=0.1056p as=0.1632p pd=0.92u ps=1.64u
    I_MXI2_I94_MP4 (XI2_I94_p1 XI2_I94_An XOR_15 VDD) gpdk090_pmos1v w=0.48u l=0.1u ad=0.1056p as=0.1056p pd=0.92u ps=0.92u
    I_MXI2_I94_MP2 (VDD A_15 XI2_I94_p1 VDD) gpdk090_pmos1v w=0.48u l=0.1u ad=0.1056p as=0.1056p pd=0.92u ps=0.92u
    I_MXI2_I94_MP3 (XI2_I94_p1 B_15 VDD VDD) gpdk090_pmos1v w=0.48u l=0.1u ad=0.1632p as=0.1056p pd=1.64u ps=0.92u
    I_MXI2_I94_MP0 (VDD A_15 XI2_I94_An VDD) gpdk090_pmos1v w=0.24u l=0.1u ad=0.0816p as=0.0816p pd=1.16u ps=1.16u
    I_MXI1_I37_MP1 (VDD I1_SUB_b3_4 XI1_I37_Bn VDD) gpdk090_pmos1v w=0.24u l=0.1u ad=0.0816p as=0.0816p pd=1.16u ps=1.16u
    I_MXI1_I37_MP5 (I1_bx27 XI1_I37_Bn XI1_I37_p1 VDD) gpdk090_pmos1v w=0.48u l=0.1u ad=0.1056p as=0.1632p pd=0.92u ps=1.64u
    I_MXI1_I37_MP4 (XI1_I37_p1 XI1_I37_An I1_bx27 VDD) gpdk090_pmos1v w=0.48u l=0.1u ad=0.1056p as=0.1056p pd=0.92u ps=0.92u
    I_MXI1_I37_MP2 (VDD B_27 XI1_I37_p1 VDD) gpdk090_pmos1v w=0.48u l=0.1u ad=0.1056p as=0.1056p pd=0.92u ps=0.92u
    I_MXI1_I37_MP3 (XI1_I37_p1 I1_SUB_b3_4 VDD VDD) gpdk090_pmos1v w=0.48u l=0.1u ad=0.1632p as=0.1056p pd=1.64u ps=0.92u
    I_MXI1_I37_MP0 (VDD B_27 XI1_I37_An VDD) gpdk090_pmos1v w=0.24u l=0.1u ad=0.0816p as=0.0816p pd=1.16u ps=1.16u
    I_MXI1_I42_I219_MP1 (VDD I1_I42_G15_0n XI1_I42_I219_Bn VDD) gpdk090_pmos1v w=0.24u l=0.1u ad=0.0816p as=0.0816p pd=1.16u ps=1.16u
    I_MXI1_I42_I219_MP5 (S_16 XI1_I42_I219_Bn XI1_I42_I219_p1 VDD) gpdk090_pmos1v w=0.48u l=0.1u ad=0.1056p as=0.1632p pd=0.92u ps=1.64u
    I_MXI1_I42_I219_MP4 (XI1_I42_I219_p1 XI1_I42_I219_An S_16 VDD) gpdk090_pmos1v w=0.48u l=0.1u ad=0.1056p as=0.1056p pd=0.92u ps=0.92u
    I_MXI1_I42_I219_MP2 (VDD I1_I42_pn16 XI1_I42_I219_p1 VDD) gpdk090_pmos1v w=0.48u l=0.1u ad=0.1056p as=0.1056p pd=0.92u ps=0.92u
    I_MXI1_I42_I219_MP3 (XI1_I42_I219_p1 I1_I42_G15_0n VDD VDD) gpdk090_pmos1v w=0.48u l=0.1u ad=0.1632p as=0.1056p pd=1.64u ps=0.92u
    I_MXI1_I42_I219_MP0 (VDD I1_I42_pn16 XI1_I42_I219_An VDD) gpdk090_pmos1v w=0.24u l=0.1u ad=0.0816p as=0.0816p pd=1.16u ps=1.16u
    I_MXI1_I26_MP1 (VDD I1_SUB_b3_2 XI1_I26_Bn VDD) gpdk090_pmos1v w=0.24u l=0.1u ad=0.0816p as=0.0816p pd=1.16u ps=1.16u
    I_MXI1_I26_MP5 (I1_bx16 XI1_I26_Bn XI1_I26_p1 VDD) gpdk090_pmos1v w=0.48u l=0.1u ad=0.1056p as=0.1632p pd=0.92u ps=1.64u
    I_MXI1_I26_MP4 (XI1_I26_p1 XI1_I26_An I1_bx16 VDD) gpdk090_pmos1v w=0.48u l=0.1u ad=0.1056p as=0.1056p pd=0.92u ps=0.92u
    I_MXI1_I26_MP2 (VDD B_16 XI1_I26_p1 VDD) gpdk090_pmos1v w=0.48u l=0.1u ad=0.1056p as=0.1056p pd=0.92u ps=0.92u
    I_MXI1_I26_MP3 (XI1_I26_p1 I1_SUB_b3_2 VDD VDD) gpdk090_pmos1v w=0.48u l=0.1u ad=0.1632p as=0.1056p pd=1.64u ps=0.92u
    I_MXI1_I26_MP0 (VDD B_16 XI1_I26_An VDD) gpdk090_pmos1v w=0.24u l=0.1u ad=0.0816p as=0.0816p pd=1.16u ps=1.16u
    I_MXI2_I160_MP1 (VDD B_26 XI2_I160_Bn VDD) gpdk090_pmos1v w=0.24u l=0.1u ad=0.0816p as=0.0816p pd=1.16u ps=1.16u
    I_MXI2_I160_MP5 (XOR_26 XI2_I160_Bn XI2_I160_p1 VDD) gpdk090_pmos1v w=0.48u l=0.1u ad=0.1056p as=0.1632p pd=0.92u ps=1.64u
    I_MXI2_I160_MP4 (XI2_I160_p1 XI2_I160_An XOR_26 VDD) gpdk090_pmos1v w=0.48u l=0.1u ad=0.1056p as=0.1056p pd=0.92u ps=0.92u
    I_MXI2_I160_MP2 (VDD A_26 XI2_I160_p1 VDD) gpdk090_pmos1v w=0.48u l=0.1u ad=0.1056p as=0.1056p pd=0.92u ps=0.92u
    I_MXI2_I160_MP3 (XI2_I160_p1 B_26 VDD VDD) gpdk090_pmos1v w=0.48u l=0.1u ad=0.1632p as=0.1056p pd=1.64u ps=0.92u
    I_MXI2_I160_MP0 (VDD A_26 XI2_I160_An VDD) gpdk090_pmos1v w=0.24u l=0.1u ad=0.0816p as=0.0816p pd=1.16u ps=1.16u
    I_MXI1_I35_MP1 (VDD I1_SUB_b3_4 XI1_I35_Bn VDD) gpdk090_pmos1v w=0.24u l=0.1u ad=0.0816p as=0.0816p pd=1.16u ps=1.16u
    I_MXI1_I35_MP5 (I1_bx25 XI1_I35_Bn XI1_I35_p1 VDD) gpdk090_pmos1v w=0.48u l=0.1u ad=0.1056p as=0.1632p pd=0.92u ps=1.64u
    I_MXI1_I35_MP4 (XI1_I35_p1 XI1_I35_An I1_bx25 VDD) gpdk090_pmos1v w=0.48u l=0.1u ad=0.1056p as=0.1056p pd=0.92u ps=0.92u
    I_MXI1_I35_MP2 (VDD B_25 XI1_I35_p1 VDD) gpdk090_pmos1v w=0.48u l=0.1u ad=0.1056p as=0.1056p pd=0.92u ps=0.92u
    I_MXI1_I35_MP3 (XI1_I35_p1 I1_SUB_b3_4 VDD VDD) gpdk090_pmos1v w=0.48u l=0.1u ad=0.1632p as=0.1056p pd=1.64u ps=0.92u
    I_MXI1_I35_MP0 (VDD B_25 XI1_I35_An VDD) gpdk090_pmos1v w=0.24u l=0.1u ad=0.0816p as=0.0816p pd=1.16u ps=1.16u
    I_MXI1_I36_MP1 (VDD I1_SUB_b3_4 XI1_I36_Bn VDD) gpdk090_pmos1v w=0.24u l=0.1u ad=0.0816p as=0.0816p pd=1.16u ps=1.16u
    I_MXI1_I36_MP5 (I1_bx26 XI1_I36_Bn XI1_I36_p1 VDD) gpdk090_pmos1v w=0.48u l=0.1u ad=0.1056p as=0.1632p pd=0.92u ps=1.64u
    I_MXI1_I36_MP4 (XI1_I36_p1 XI1_I36_An I1_bx26 VDD) gpdk090_pmos1v w=0.48u l=0.1u ad=0.1056p as=0.1056p pd=0.92u ps=0.92u
    I_MXI1_I36_MP2 (VDD B_26 XI1_I36_p1 VDD) gpdk090_pmos1v w=0.48u l=0.1u ad=0.1056p as=0.1056p pd=0.92u ps=0.92u
    I_MXI1_I36_MP3 (XI1_I36_p1 I1_SUB_b3_4 VDD VDD) gpdk090_pmos1v w=0.48u l=0.1u ad=0.1632p as=0.1056p pd=1.64u ps=0.92u
    I_MXI1_I36_MP0 (VDD B_26 XI1_I36_An VDD) gpdk090_pmos1v w=0.24u l=0.1u ad=0.0816p as=0.0816p pd=1.16u ps=1.16u
    I_MXI1_I34_MP1 (VDD I1_SUB_b3_4 XI1_I34_Bn VDD) gpdk090_pmos1v w=0.24u l=0.1u ad=0.0816p as=0.0816p pd=1.16u ps=1.16u
    I_MXI1_I34_MP5 (I1_bx24 XI1_I34_Bn XI1_I34_p1 VDD) gpdk090_pmos1v w=0.48u l=0.1u ad=0.1056p as=0.1632p pd=0.92u ps=1.64u
    I_MXI1_I34_MP4 (XI1_I34_p1 XI1_I34_An I1_bx24 VDD) gpdk090_pmos1v w=0.48u l=0.1u ad=0.1056p as=0.1056p pd=0.92u ps=0.92u
    I_MXI1_I34_MP2 (VDD B_24 XI1_I34_p1 VDD) gpdk090_pmos1v w=0.48u l=0.1u ad=0.1056p as=0.1056p pd=0.92u ps=0.92u
    I_MXI1_I34_MP3 (XI1_I34_p1 I1_SUB_b3_4 VDD VDD) gpdk090_pmos1v w=0.48u l=0.1u ad=0.1632p as=0.1056p pd=1.64u ps=0.92u
    I_MXI1_I34_MP0 (VDD B_24 XI1_I34_An VDD) gpdk090_pmos1v w=0.24u l=0.1u ad=0.0816p as=0.0816p pd=1.16u ps=1.16u
    I_MXI1_I33_MP1 (VDD I1_SUB_b3_4 XI1_I33_Bn VDD) gpdk090_pmos1v w=0.24u l=0.1u ad=0.0816p as=0.0816p pd=1.16u ps=1.16u
    I_MXI1_I33_MP5 (I1_bx23 XI1_I33_Bn XI1_I33_p1 VDD) gpdk090_pmos1v w=0.48u l=0.1u ad=0.1056p as=0.1632p pd=0.92u ps=1.64u
    I_MXI1_I33_MP4 (XI1_I33_p1 XI1_I33_An I1_bx23 VDD) gpdk090_pmos1v w=0.48u l=0.1u ad=0.1056p as=0.1056p pd=0.92u ps=0.92u
    I_MXI1_I33_MP2 (VDD B_23 XI1_I33_p1 VDD) gpdk090_pmos1v w=0.48u l=0.1u ad=0.1056p as=0.1056p pd=0.92u ps=0.92u
    I_MXI1_I33_MP3 (XI1_I33_p1 I1_SUB_b3_4 VDD VDD) gpdk090_pmos1v w=0.48u l=0.1u ad=0.1632p as=0.1056p pd=1.64u ps=0.92u
    I_MXI1_I33_MP0 (VDD B_23 XI1_I33_An VDD) gpdk090_pmos1v w=0.24u l=0.1u ad=0.0816p as=0.0816p pd=1.16u ps=1.16u
    I_MXI1_I32_MP1 (VDD I1_SUB_b3_4 XI1_I32_Bn VDD) gpdk090_pmos1v w=0.24u l=0.1u ad=0.0816p as=0.0816p pd=1.16u ps=1.16u
    I_MXI1_I32_MP5 (I1_bx22 XI1_I32_Bn XI1_I32_p1 VDD) gpdk090_pmos1v w=0.48u l=0.1u ad=0.1056p as=0.1632p pd=0.92u ps=1.64u
    I_MXI1_I32_MP4 (XI1_I32_p1 XI1_I32_An I1_bx22 VDD) gpdk090_pmos1v w=0.48u l=0.1u ad=0.1056p as=0.1056p pd=0.92u ps=0.92u
    I_MXI1_I32_MP2 (VDD B_22 XI1_I32_p1 VDD) gpdk090_pmos1v w=0.48u l=0.1u ad=0.1056p as=0.1056p pd=0.92u ps=0.92u
    I_MXI1_I32_MP3 (XI1_I32_p1 I1_SUB_b3_4 VDD VDD) gpdk090_pmos1v w=0.48u l=0.1u ad=0.1632p as=0.1056p pd=1.64u ps=0.92u
    I_MXI1_I32_MP0 (VDD B_22 XI1_I32_An VDD) gpdk090_pmos1v w=0.24u l=0.1u ad=0.0816p as=0.0816p pd=1.16u ps=1.16u
    I_MXI1_I31_MP1 (VDD I1_SUB_b3_3 XI1_I31_Bn VDD) gpdk090_pmos1v w=0.24u l=0.1u ad=0.0816p as=0.0816p pd=1.16u ps=1.16u
    I_MXI1_I31_MP5 (I1_bx21 XI1_I31_Bn XI1_I31_p1 VDD) gpdk090_pmos1v w=0.48u l=0.1u ad=0.1056p as=0.1632p pd=0.92u ps=1.64u
    I_MXI1_I31_MP4 (XI1_I31_p1 XI1_I31_An I1_bx21 VDD) gpdk090_pmos1v w=0.48u l=0.1u ad=0.1056p as=0.1056p pd=0.92u ps=0.92u
    I_MXI1_I31_MP2 (VDD B_21 XI1_I31_p1 VDD) gpdk090_pmos1v w=0.48u l=0.1u ad=0.1056p as=0.1056p pd=0.92u ps=0.92u
    I_MXI1_I31_MP3 (XI1_I31_p1 I1_SUB_b3_3 VDD VDD) gpdk090_pmos1v w=0.48u l=0.1u ad=0.1632p as=0.1056p pd=1.64u ps=0.92u
    I_MXI1_I31_MP0 (VDD B_21 XI1_I31_An VDD) gpdk090_pmos1v w=0.24u l=0.1u ad=0.0816p as=0.0816p pd=1.16u ps=1.16u
    I_MXI1_I30_MP1 (VDD I1_SUB_b3_3 XI1_I30_Bn VDD) gpdk090_pmos1v w=0.24u l=0.1u ad=0.0816p as=0.0816p pd=1.16u ps=1.16u
    I_MXI1_I30_MP5 (I1_bx20 XI1_I30_Bn XI1_I30_p1 VDD) gpdk090_pmos1v w=0.48u l=0.1u ad=0.1056p as=0.1632p pd=0.92u ps=1.64u
    I_MXI1_I30_MP4 (XI1_I30_p1 XI1_I30_An I1_bx20 VDD) gpdk090_pmos1v w=0.48u l=0.1u ad=0.1056p as=0.1056p pd=0.92u ps=0.92u
    I_MXI1_I30_MP2 (VDD B_20 XI1_I30_p1 VDD) gpdk090_pmos1v w=0.48u l=0.1u ad=0.1056p as=0.1056p pd=0.92u ps=0.92u
    I_MXI1_I30_MP3 (XI1_I30_p1 I1_SUB_b3_3 VDD VDD) gpdk090_pmos1v w=0.48u l=0.1u ad=0.1632p as=0.1056p pd=1.64u ps=0.92u
    I_MXI1_I30_MP0 (VDD B_20 XI1_I30_An VDD) gpdk090_pmos1v w=0.24u l=0.1u ad=0.0816p as=0.0816p pd=1.16u ps=1.16u
    I_MXI2_I124_MP1 (VDD B_20 XI2_I124_Bn VDD) gpdk090_pmos1v w=0.24u l=0.1u ad=0.0816p as=0.0816p pd=1.16u ps=1.16u
    I_MXI2_I124_MP5 (XOR_20 XI2_I124_Bn XI2_I124_p1 VDD) gpdk090_pmos1v w=0.48u l=0.1u ad=0.1056p as=0.1632p pd=0.92u ps=1.64u
    I_MXI2_I124_MP4 (XI2_I124_p1 XI2_I124_An XOR_20 VDD) gpdk090_pmos1v w=0.48u l=0.1u ad=0.1056p as=0.1056p pd=0.92u ps=0.92u
    I_MXI2_I124_MP2 (VDD A_20 XI2_I124_p1 VDD) gpdk090_pmos1v w=0.48u l=0.1u ad=0.1056p as=0.1056p pd=0.92u ps=0.92u
    I_MXI2_I124_MP3 (XI2_I124_p1 B_20 VDD VDD) gpdk090_pmos1v w=0.48u l=0.1u ad=0.1632p as=0.1056p pd=1.64u ps=0.92u
    I_MXI2_I124_MP0 (VDD A_20 XI2_I124_An VDD) gpdk090_pmos1v w=0.24u l=0.1u ad=0.0816p as=0.0816p pd=1.16u ps=1.16u
    I_MXI1_I29_MP1 (VDD I1_SUB_b3_3 XI1_I29_Bn VDD) gpdk090_pmos1v w=0.24u l=0.1u ad=0.0816p as=0.0816p pd=1.16u ps=1.16u
    I_MXI1_I29_MP5 (I1_bx19 XI1_I29_Bn XI1_I29_p1 VDD) gpdk090_pmos1v w=0.48u l=0.1u ad=0.1056p as=0.1632p pd=0.92u ps=1.64u
    I_MXI1_I29_MP4 (XI1_I29_p1 XI1_I29_An I1_bx19 VDD) gpdk090_pmos1v w=0.48u l=0.1u ad=0.1056p as=0.1056p pd=0.92u ps=0.92u
    I_MXI1_I29_MP2 (VDD B_19 XI1_I29_p1 VDD) gpdk090_pmos1v w=0.48u l=0.1u ad=0.1056p as=0.1056p pd=0.92u ps=0.92u
    I_MXI1_I29_MP3 (XI1_I29_p1 I1_SUB_b3_3 VDD VDD) gpdk090_pmos1v w=0.48u l=0.1u ad=0.1632p as=0.1056p pd=1.64u ps=0.92u
    I_MXI1_I29_MP0 (VDD B_19 XI1_I29_An VDD) gpdk090_pmos1v w=0.24u l=0.1u ad=0.0816p as=0.0816p pd=1.16u ps=1.16u
    I_MXI1_I28_MP1 (VDD I1_SUB_b3_3 XI1_I28_Bn VDD) gpdk090_pmos1v w=0.24u l=0.1u ad=0.0816p as=0.0816p pd=1.16u ps=1.16u
    I_MXI1_I28_MP5 (I1_bx18 XI1_I28_Bn XI1_I28_p1 VDD) gpdk090_pmos1v w=0.48u l=0.1u ad=0.1056p as=0.1632p pd=0.92u ps=1.64u
    I_MXI1_I28_MP4 (XI1_I28_p1 XI1_I28_An I1_bx18 VDD) gpdk090_pmos1v w=0.48u l=0.1u ad=0.1056p as=0.1056p pd=0.92u ps=0.92u
    I_MXI1_I28_MP2 (VDD B_18 XI1_I28_p1 VDD) gpdk090_pmos1v w=0.48u l=0.1u ad=0.1056p as=0.1056p pd=0.92u ps=0.92u
    I_MXI1_I28_MP3 (XI1_I28_p1 I1_SUB_b3_3 VDD VDD) gpdk090_pmos1v w=0.48u l=0.1u ad=0.1632p as=0.1056p pd=1.64u ps=0.92u
    I_MXI1_I28_MP0 (VDD B_18 XI1_I28_An VDD) gpdk090_pmos1v w=0.24u l=0.1u ad=0.0816p as=0.0816p pd=1.16u ps=1.16u
    I_MXI1_I27_MP1 (VDD I1_SUB_b3_3 XI1_I27_Bn VDD) gpdk090_pmos1v w=0.24u l=0.1u ad=0.0816p as=0.0816p pd=1.16u ps=1.16u
    I_MXI1_I27_MP5 (I1_bx17 XI1_I27_Bn XI1_I27_p1 VDD) gpdk090_pmos1v w=0.48u l=0.1u ad=0.1056p as=0.1632p pd=0.92u ps=1.64u
    I_MXI1_I27_MP4 (XI1_I27_p1 XI1_I27_An I1_bx17 VDD) gpdk090_pmos1v w=0.48u l=0.1u ad=0.1056p as=0.1056p pd=0.92u ps=0.92u
    I_MXI1_I27_MP2 (VDD B_17 XI1_I27_p1 VDD) gpdk090_pmos1v w=0.48u l=0.1u ad=0.1056p as=0.1056p pd=0.92u ps=0.92u
    I_MXI1_I27_MP3 (XI1_I27_p1 I1_SUB_b3_3 VDD VDD) gpdk090_pmos1v w=0.48u l=0.1u ad=0.1632p as=0.1056p pd=1.64u ps=0.92u
    I_MXI1_I27_MP0 (VDD B_17 XI1_I27_An VDD) gpdk090_pmos1v w=0.24u l=0.1u ad=0.0816p as=0.0816p pd=1.16u ps=1.16u
    I_MXI2_I100_MP1 (VDD B_16 XI2_I100_Bn VDD) gpdk090_pmos1v w=0.24u l=0.1u ad=0.0816p as=0.0816p pd=1.16u ps=1.16u
    I_MXI2_I100_MP5 (XOR_16 XI2_I100_Bn XI2_I100_p1 VDD) gpdk090_pmos1v w=0.48u l=0.1u ad=0.1056p as=0.1632p pd=0.92u ps=1.64u
    I_MXI2_I100_MP4 (XI2_I100_p1 XI2_I100_An XOR_16 VDD) gpdk090_pmos1v w=0.48u l=0.1u ad=0.1056p as=0.1056p pd=0.92u ps=0.92u
    I_MXI2_I100_MP2 (VDD A_16 XI2_I100_p1 VDD) gpdk090_pmos1v w=0.48u l=0.1u ad=0.1056p as=0.1056p pd=0.92u ps=0.92u
    I_MXI2_I100_MP3 (XI2_I100_p1 B_16 VDD VDD) gpdk090_pmos1v w=0.48u l=0.1u ad=0.1632p as=0.1056p pd=1.64u ps=0.92u
    I_MXI2_I100_MP0 (VDD A_16 XI2_I100_An VDD) gpdk090_pmos1v w=0.24u l=0.1u ad=0.0816p as=0.0816p pd=1.16u ps=1.16u
    I_MXI2_I148_MP1 (VDD B_24 XI2_I148_Bn VDD) gpdk090_pmos1v w=0.24u l=0.1u ad=0.0816p as=0.0816p pd=1.16u ps=1.16u
    I_MXI2_I148_MP5 (XOR_24 XI2_I148_Bn XI2_I148_p1 VDD) gpdk090_pmos1v w=0.48u l=0.1u ad=0.1056p as=0.1632p pd=0.92u ps=1.64u
    I_MXI2_I148_MP4 (XI2_I148_p1 XI2_I148_An XOR_24 VDD) gpdk090_pmos1v w=0.48u l=0.1u ad=0.1056p as=0.1056p pd=0.92u ps=0.92u
    I_MXI2_I148_MP2 (VDD A_24 XI2_I148_p1 VDD) gpdk090_pmos1v w=0.48u l=0.1u ad=0.1056p as=0.1056p pd=0.92u ps=0.92u
    I_MXI2_I148_MP3 (XI2_I148_p1 B_24 VDD VDD) gpdk090_pmos1v w=0.48u l=0.1u ad=0.1632p as=0.1056p pd=1.64u ps=0.92u
    I_MXI2_I148_MP0 (VDD A_24 XI2_I148_An VDD) gpdk090_pmos1v w=0.24u l=0.1u ad=0.0816p as=0.0816p pd=1.16u ps=1.16u
    I_MXI2_I142_MP1 (VDD B_23 XI2_I142_Bn VDD) gpdk090_pmos1v w=0.24u l=0.1u ad=0.0816p as=0.0816p pd=1.16u ps=1.16u
    I_MXI2_I142_MP5 (XOR_23 XI2_I142_Bn XI2_I142_p1 VDD) gpdk090_pmos1v w=0.48u l=0.1u ad=0.1056p as=0.1632p pd=0.92u ps=1.64u
    I_MXI2_I142_MP4 (XI2_I142_p1 XI2_I142_An XOR_23 VDD) gpdk090_pmos1v w=0.48u l=0.1u ad=0.1056p as=0.1056p pd=0.92u ps=0.92u
    I_MXI2_I142_MP2 (VDD A_23 XI2_I142_p1 VDD) gpdk090_pmos1v w=0.48u l=0.1u ad=0.1056p as=0.1056p pd=0.92u ps=0.92u
    I_MXI2_I142_MP3 (XI2_I142_p1 B_23 VDD VDD) gpdk090_pmos1v w=0.48u l=0.1u ad=0.1632p as=0.1056p pd=1.64u ps=0.92u
    I_MXI2_I142_MP0 (VDD A_23 XI2_I142_An VDD) gpdk090_pmos1v w=0.24u l=0.1u ad=0.0816p as=0.0816p pd=1.16u ps=1.16u
    I_MXI2_I136_MP1 (VDD B_22 XI2_I136_Bn VDD) gpdk090_pmos1v w=0.24u l=0.1u ad=0.0816p as=0.0816p pd=1.16u ps=1.16u
    I_MXI2_I136_MP5 (XOR_22 XI2_I136_Bn XI2_I136_p1 VDD) gpdk090_pmos1v w=0.48u l=0.1u ad=0.1056p as=0.1632p pd=0.92u ps=1.64u
    I_MXI2_I136_MP4 (XI2_I136_p1 XI2_I136_An XOR_22 VDD) gpdk090_pmos1v w=0.48u l=0.1u ad=0.1056p as=0.1056p pd=0.92u ps=0.92u
    I_MXI2_I136_MP2 (VDD A_22 XI2_I136_p1 VDD) gpdk090_pmos1v w=0.48u l=0.1u ad=0.1056p as=0.1056p pd=0.92u ps=0.92u
    I_MXI2_I136_MP3 (XI2_I136_p1 B_22 VDD VDD) gpdk090_pmos1v w=0.48u l=0.1u ad=0.1632p as=0.1056p pd=1.64u ps=0.92u
    I_MXI2_I136_MP0 (VDD A_22 XI2_I136_An VDD) gpdk090_pmos1v w=0.24u l=0.1u ad=0.0816p as=0.0816p pd=1.16u ps=1.16u
    I_MXI2_I112_MP1 (VDD B_18 XI2_I112_Bn VDD) gpdk090_pmos1v w=0.24u l=0.1u ad=0.0816p as=0.0816p pd=1.16u ps=1.16u
    I_MXI2_I112_MP5 (XOR_18 XI2_I112_Bn XI2_I112_p1 VDD) gpdk090_pmos1v w=0.48u l=0.1u ad=0.1056p as=0.1632p pd=0.92u ps=1.64u
    I_MXI2_I112_MP4 (XI2_I112_p1 XI2_I112_An XOR_18 VDD) gpdk090_pmos1v w=0.48u l=0.1u ad=0.1056p as=0.1056p pd=0.92u ps=0.92u
    I_MXI2_I112_MP2 (VDD A_18 XI2_I112_p1 VDD) gpdk090_pmos1v w=0.48u l=0.1u ad=0.1056p as=0.1056p pd=0.92u ps=0.92u
    I_MXI2_I112_MP3 (XI2_I112_p1 B_18 VDD VDD) gpdk090_pmos1v w=0.48u l=0.1u ad=0.1632p as=0.1056p pd=1.64u ps=0.92u
    I_MXI2_I112_MP0 (VDD A_18 XI2_I112_An VDD) gpdk090_pmos1v w=0.24u l=0.1u ad=0.0816p as=0.0816p pd=1.16u ps=1.16u
    I_MXI2_I154_MP1 (VDD B_25 XI2_I154_Bn VDD) gpdk090_pmos1v w=0.24u l=0.1u ad=0.0816p as=0.0816p pd=1.16u ps=1.16u
    I_MXI2_I154_MP5 (XOR_25 XI2_I154_Bn XI2_I154_p1 VDD) gpdk090_pmos1v w=0.48u l=0.1u ad=0.1056p as=0.1632p pd=0.92u ps=1.64u
    I_MXI2_I154_MP4 (XI2_I154_p1 XI2_I154_An XOR_25 VDD) gpdk090_pmos1v w=0.48u l=0.1u ad=0.1056p as=0.1056p pd=0.92u ps=0.92u
    I_MXI2_I154_MP2 (VDD A_25 XI2_I154_p1 VDD) gpdk090_pmos1v w=0.48u l=0.1u ad=0.1056p as=0.1056p pd=0.92u ps=0.92u
    I_MXI2_I154_MP3 (XI2_I154_p1 B_25 VDD VDD) gpdk090_pmos1v w=0.48u l=0.1u ad=0.1632p as=0.1056p pd=1.64u ps=0.92u
    I_MXI2_I154_MP0 (VDD A_25 XI2_I154_An VDD) gpdk090_pmos1v w=0.24u l=0.1u ad=0.0816p as=0.0816p pd=1.16u ps=1.16u
    I_MXI2_I130_MP1 (VDD B_21 XI2_I130_Bn VDD) gpdk090_pmos1v w=0.24u l=0.1u ad=0.0816p as=0.0816p pd=1.16u ps=1.16u
    I_MXI2_I130_MP5 (XOR_21 XI2_I130_Bn XI2_I130_p1 VDD) gpdk090_pmos1v w=0.48u l=0.1u ad=0.1056p as=0.1632p pd=0.92u ps=1.64u
    I_MXI2_I130_MP4 (XI2_I130_p1 XI2_I130_An XOR_21 VDD) gpdk090_pmos1v w=0.48u l=0.1u ad=0.1056p as=0.1056p pd=0.92u ps=0.92u
    I_MXI2_I130_MP2 (VDD A_21 XI2_I130_p1 VDD) gpdk090_pmos1v w=0.48u l=0.1u ad=0.1056p as=0.1056p pd=0.92u ps=0.92u
    I_MXI2_I130_MP3 (XI2_I130_p1 B_21 VDD VDD) gpdk090_pmos1v w=0.48u l=0.1u ad=0.1632p as=0.1056p pd=1.64u ps=0.92u
    I_MXI2_I130_MP0 (VDD A_21 XI2_I130_An VDD) gpdk090_pmos1v w=0.24u l=0.1u ad=0.0816p as=0.0816p pd=1.16u ps=1.16u
    I_MXI2_I118_MP1 (VDD B_19 XI2_I118_Bn VDD) gpdk090_pmos1v w=0.24u l=0.1u ad=0.0816p as=0.0816p pd=1.16u ps=1.16u
    I_MXI2_I118_MP5 (XOR_19 XI2_I118_Bn XI2_I118_p1 VDD) gpdk090_pmos1v w=0.48u l=0.1u ad=0.1056p as=0.1632p pd=0.92u ps=1.64u
    I_MXI2_I118_MP4 (XI2_I118_p1 XI2_I118_An XOR_19 VDD) gpdk090_pmos1v w=0.48u l=0.1u ad=0.1056p as=0.1056p pd=0.92u ps=0.92u
    I_MXI2_I118_MP2 (VDD A_19 XI2_I118_p1 VDD) gpdk090_pmos1v w=0.48u l=0.1u ad=0.1056p as=0.1056p pd=0.92u ps=0.92u
    I_MXI2_I118_MP3 (XI2_I118_p1 B_19 VDD VDD) gpdk090_pmos1v w=0.48u l=0.1u ad=0.1632p as=0.1056p pd=1.64u ps=0.92u
    I_MXI2_I118_MP0 (VDD A_19 XI2_I118_An VDD) gpdk090_pmos1v w=0.24u l=0.1u ad=0.0816p as=0.0816p pd=1.16u ps=1.16u
    I_MXI2_I106_MP1 (VDD B_17 XI2_I106_Bn VDD) gpdk090_pmos1v w=0.24u l=0.1u ad=0.0816p as=0.0816p pd=1.16u ps=1.16u
    I_MXI2_I106_MP5 (XOR_17 XI2_I106_Bn XI2_I106_p1 VDD) gpdk090_pmos1v w=0.48u l=0.1u ad=0.1056p as=0.1632p pd=0.92u ps=1.64u
    I_MXI2_I106_MP4 (XI2_I106_p1 XI2_I106_An XOR_17 VDD) gpdk090_pmos1v w=0.48u l=0.1u ad=0.1056p as=0.1056p pd=0.92u ps=0.92u
    I_MXI2_I106_MP2 (VDD A_17 XI2_I106_p1 VDD) gpdk090_pmos1v w=0.48u l=0.1u ad=0.1056p as=0.1056p pd=0.92u ps=0.92u
    I_MXI2_I106_MP3 (XI2_I106_p1 B_17 VDD VDD) gpdk090_pmos1v w=0.48u l=0.1u ad=0.1632p as=0.1056p pd=1.64u ps=0.92u
    I_MXI2_I106_MP0 (VDD A_17 XI2_I106_An VDD) gpdk090_pmos1v w=0.24u l=0.1u ad=0.0816p as=0.0816p pd=1.16u ps=1.16u
    I_C1 (VDD VSS) capacitor c=4.537E-13
    I_C2 (A_0 VSS) capacitor c=5.945E-15
    I_C3 (A_1 VSS) capacitor c=6.395E-15
    I_C4 (A_10 VSS) capacitor c=8.127E-15
    I_C5 (A_11 VSS) capacitor c=7.858E-15
    I_C6 (A_12 VSS) capacitor c=5.874E-15
    I_C7 (A_13 VSS) capacitor c=6.545E-15
    I_C8 (A_14 VSS) capacitor c=6.303E-15
    I_C9 (A_15 VSS) capacitor c=5.839E-15
    I_C10 (A_16 VSS) capacitor c=5.372E-15
    I_C11 (A_17 VSS) capacitor c=6.583E-15
    I_C12 (A_18 VSS) capacitor c=7.143E-15
    I_C13 (A_19 VSS) capacitor c=8.416E-15
    I_C14 (A_2 VSS) capacitor c=8.729E-15
    I_C15 (A_20 VSS) capacitor c=6.300E-15
    I_C16 (A_21 VSS) capacitor c=6.173E-15
    I_C17 (A_22 VSS) capacitor c=6.016E-15
    I_C18 (A_23 VSS) capacitor c=6.793E-15
    I_C19 (A_24 VSS) capacitor c=5.925E-15
    I_C20 (A_25 VSS) capacitor c=6.506E-15
    I_C21 (A_26 VSS) capacitor c=5.288E-15
    I_C22 (A_27 VSS) capacitor c=6.024E-15
    I_C23 (A_28 VSS) capacitor c=6.209E-15
    I_C24 (A_29 VSS) capacitor c=6.708E-15
    I_C25 (A_3 VSS) capacitor c=5.729E-15
    I_C26 (A_30 VSS) capacitor c=7.283E-15
    I_C27 (A_31 VSS) capacitor c=7.663E-15
    I_C28 (A_4 VSS) capacitor c=6.435E-15
    I_C29 (A_5 VSS) capacitor c=6.788E-15
    I_C30 (A_6 VSS) capacitor c=7.020E-15
    I_C31 (A_7 VSS) capacitor c=7.879E-15
    I_C32 (A_8 VSS) capacitor c=8.315E-15
    I_C33 (A_9 VSS) capacitor c=8.380E-15
    I_C34 (B_0 VSS) capacitor c=4.190E-15
    I_C35 (B_1 VSS) capacitor c=4.204E-15
    I_C36 (B_10 VSS) capacitor c=6.173E-15
    I_C37 (B_11 VSS) capacitor c=5.226E-15
    I_C38 (B_12 VSS) capacitor c=4.588E-15
    I_C39 (B_13 VSS) capacitor c=5.373E-15
    I_C40 (B_14 VSS) capacitor c=5.282E-15
    I_C41 (B_15 VSS) capacitor c=4.187E-15
    I_C42 (B_16 VSS) capacitor c=4.574E-15
    I_C43 (B_17 VSS) capacitor c=4.797E-15
    I_C44 (B_18 VSS) capacitor c=4.958E-15
    I_C45 (B_19 VSS) capacitor c=5.361E-15
    I_C46 (B_2 VSS) capacitor c=5.238E-15
    I_C47 (B_20 VSS) capacitor c=4.671E-15
    I_C48 (B_21 VSS) capacitor c=4.523E-15
    I_C49 (B_22 VSS) capacitor c=4.455E-15
    I_C50 (B_23 VSS) capacitor c=4.990E-15
    I_C51 (B_24 VSS) capacitor c=4.180E-15
    I_C52 (B_25 VSS) capacitor c=4.779E-15
    I_C53 (B_26 VSS) capacitor c=4.115E-15
    I_C54 (B_27 VSS) capacitor c=5.018E-15
    I_C55 (B_28 VSS) capacitor c=5.495E-15
    I_C56 (B_29 VSS) capacitor c=5.885E-15
    I_C57 (B_3 VSS) capacitor c=3.771E-15
    I_C58 (B_30 VSS) capacitor c=5.390E-15
    I_C59 (B_31 VSS) capacitor c=6.370E-15
    I_C60 (B_4 VSS) capacitor c=4.782E-15
    I_C61 (B_5 VSS) capacitor c=5.715E-15
    I_C62 (B_6 VSS) capacitor c=5.352E-15
    I_C63 (B_7 VSS) capacitor c=4.931E-15
    I_C64 (B_8 VSS) capacitor c=5.603E-15
    I_C65 (B_9 VSS) capacitor c=5.543E-15
    I_C66 (C VSS) capacitor c=3.465E-15
    I_C67 (DIVDZ VSS) capacitor c=6.332E-16
    I_C68 (DIVQ_0 VSS) capacitor c=2.331E-15
    I_C69 (DIVQ_1 VSS) capacitor c=1.797E-15
    I_C70 (DIVQ_10 VSS) capacitor c=6.941E-16
    I_C71 (DIVQ_11 VSS) capacitor c=1.916E-15
    I_C72 (DIVQ_12 VSS) capacitor c=8.386E-16
    I_C73 (DIVQ_13 VSS) capacitor c=1.129E-15
    I_C74 (DIVQ_14 VSS) capacitor c=8.317E-16
    I_C75 (DIVQ_15 VSS) capacitor c=6.473E-16
    I_C76 (DIVQ_16 VSS) capacitor c=1.421E-15
    I_C77 (DIVQ_17 VSS) capacitor c=1.078E-15
    I_C78 (DIVQ_18 VSS) capacitor c=1.690E-15
    I_C79 (DIVQ_19 VSS) capacitor c=9.944E-16
    I_C80 (DIVQ_2 VSS) capacitor c=1.918E-15
    I_C81 (DIVQ_20 VSS) capacitor c=1.538E-15
    I_C82 (DIVQ_21 VSS) capacitor c=1.443E-15
    I_C83 (DIVQ_22 VSS) capacitor c=1.324E-15
    I_C84 (DIVQ_23 VSS) capacitor c=1.201E-15
    I_C85 (DIVQ_24 VSS) capacitor c=8.397E-16
    I_C86 (DIVQ_25 VSS) capacitor c=6.483E-16
    I_C87 (DIVQ_26 VSS) capacitor c=9.688E-16
    I_C88 (DIVQ_27 VSS) capacitor c=5.274E-16
    I_C89 (DIVQ_28 VSS) capacitor c=6.284E-16
    I_C90 (DIVQ_29 VSS) capacitor c=5.990E-16
    I_C91 (DIVQ_3 VSS) capacitor c=1.457E-15
    I_C92 (DIVQ_30 VSS) capacitor c=9.555E-16
    I_C93 (DIVQ_31 VSS) capacitor c=2.038E-15
    I_C94 (DIVQ_4 VSS) capacitor c=1.510E-15
    I_C95 (DIVQ_5 VSS) capacitor c=2.083E-15
    I_C96 (DIVQ_6 VSS) capacitor c=1.740E-15
    I_C97 (DIVQ_7 VSS) capacitor c=9.527E-16
    I_C98 (DIVQ_8 VSS) capacitor c=9.998E-16
    I_C99 (DIVQ_9 VSS) capacitor c=6.028E-16
    I_C100 (DIVR_0 VSS) capacitor c=1.643E-15
    I_C101 (DIVR_1 VSS) capacitor c=1.827E-15
    I_C102 (DIVR_10 VSS) capacitor c=2.162E-15
    I_C103 (DIVR_11 VSS) capacitor c=3.108E-15
    I_C104 (DIVR_12 VSS) capacitor c=2.807E-15
    I_C105 (DIVR_13 VSS) capacitor c=2.159E-15
    I_C106 (DIVR_14 VSS) capacitor c=1.830E-15
    I_C107 (DIVR_15 VSS) capacitor c=1.474E-15
    I_C108 (DIVR_16 VSS) capacitor c=6.881E-16
    I_C109 (DIVR_17 VSS) capacitor c=1.663E-15
    I_C110 (DIVR_18 VSS) capacitor c=2.049E-15
    I_C111 (DIVR_19 VSS) capacitor c=2.707E-15
    I_C112 (DIVR_2 VSS) capacitor c=7.478E-16
    I_C113 (DIVR_20 VSS) capacitor c=7.010E-16
    I_C114 (DIVR_21 VSS) capacitor c=6.669E-16
    I_C115 (DIVR_22 VSS) capacitor c=5.351E-16
    I_C116 (DIVR_23 VSS) capacitor c=1.173E-15
    I_C117 (DIVR_24 VSS) capacitor c=1.305E-15
    I_C118 (DIVR_25 VSS) capacitor c=8.421E-16
    I_C119 (DIVR_26 VSS) capacitor c=8.151E-16
    I_C120 (DIVR_27 VSS) capacitor c=6.887E-16
    I_C121 (DIVR_28 VSS) capacitor c=8.357E-16
    I_C122 (DIVR_29 VSS) capacitor c=1.271E-15
    I_C123 (DIVR_3 VSS) capacitor c=1.354E-15
    I_C124 (DIVR_30 VSS) capacitor c=7.797E-16
    I_C125 (DIVR_31 VSS) capacitor c=1.280E-15
    I_C126 (DIVR_4 VSS) capacitor c=7.070E-16
    I_C127 (DIVR_5 VSS) capacitor c=1.385E-15
    I_C128 (DIVR_6 VSS) capacitor c=1.721E-15
    I_C129 (DIVR_7 VSS) capacitor c=9.756E-16
    I_C130 (DIVR_8 VSS) capacitor c=1.103E-15
    I_C131 (DIVR_9 VSS) capacitor c=2.428E-15
    I_C132 (DIVV VSS) capacitor c=2.396E-15
    I_C133 (DZ VSS) capacitor c=5.690E-16
    I_C134 (MULP_0 VSS) capacitor c=1.951E-15
    I_C135 (MULP_1 VSS) capacitor c=1.568E-15
    I_C136 (MULP_10 VSS) capacitor c=6.149E-16
    I_C137 (MULP_11 VSS) capacitor c=2.781E-15
    I_C138 (MULP_12 VSS) capacitor c=6.005E-16
    I_C139 (MULP_13 VSS) capacitor c=8.090E-16
    I_C140 (MULP_14 VSS) capacitor c=6.179E-16
    I_C141 (MULP_15 VSS) capacitor c=8.089E-16
    I_C142 (MULP_16 VSS) capacitor c=1.063E-15
    I_C143 (MULP_17 VSS) capacitor c=7.232E-16
    I_C144 (MULP_18 VSS) capacitor c=1.523E-15
    I_C145 (MULP_19 VSS) capacitor c=1.407E-15
    I_C146 (MULP_2 VSS) capacitor c=2.224E-15
    I_C147 (MULP_20 VSS) capacitor c=1.625E-15
    I_C148 (MULP_21 VSS) capacitor c=1.309E-15
    I_C149 (MULP_22 VSS) capacitor c=1.857E-15
    I_C150 (MULP_23 VSS) capacitor c=1.463E-15
    I_C151 (MULP_24 VSS) capacitor c=1.084E-15
    I_C152 (MULP_25 VSS) capacitor c=6.464E-16
    I_C153 (MULP_26 VSS) capacitor c=8.405E-16
    I_C154 (MULP_27 VSS) capacitor c=8.281E-16
    I_C155 (MULP_28 VSS) capacitor c=8.540E-16
    I_C156 (MULP_29 VSS) capacitor c=6.494E-16
    I_C157 (MULP_3 VSS) capacitor c=1.465E-15
    I_C158 (MULP_30 VSS) capacitor c=9.847E-16
    I_C159 (MULP_31 VSS) capacitor c=1.171E-15
    I_C160 (MULP_32 VSS) capacitor c=2.026E-15
    I_C161 (MULP_33 VSS) capacitor c=1.456E-15
    I_C162 (MULP_34 VSS) capacitor c=7.891E-16
    I_C163 (MULP_35 VSS) capacitor c=2.616E-15
    I_C164 (MULP_36 VSS) capacitor c=9.130E-16
    I_C165 (MULP_37 VSS) capacitor c=1.036E-15
    I_C166 (MULP_38 VSS) capacitor c=1.795E-15
    I_C167 (MULP_39 VSS) capacitor c=7.655E-16
    I_C168 (MULP_4 VSS) capacitor c=1.738E-15
    I_C169 (MULP_40 VSS) capacitor c=1.191E-15
    I_C170 (MULP_41 VSS) capacitor c=2.193E-15
    I_C171 (MULP_42 VSS) capacitor c=2.171E-15
    I_C172 (MULP_43 VSS) capacitor c=2.886E-15
    I_C173 (MULP_44 VSS) capacitor c=2.177E-15
    I_C174 (MULP_45 VSS) capacitor c=1.787E-15
    I_C175 (MULP_46 VSS) capacitor c=2.067E-15
    I_C176 (MULP_47 VSS) capacitor c=1.012E-15
    I_C177 (MULP_48 VSS) capacitor c=9.041E-16
    I_C178 (MULP_49 VSS) capacitor c=9.552E-16
    I_C179 (MULP_5 VSS) capacitor c=2.259E-15
    I_C180 (MULP_50 VSS) capacitor c=1.250E-15
    I_C181 (MULP_51 VSS) capacitor c=1.363E-15
    I_C182 (MULP_52 VSS) capacitor c=1.121E-15
    I_C183 (MULP_53 VSS) capacitor c=7.658E-16
    I_C184 (MULP_54 VSS) capacitor c=6.928E-16
    I_C185 (MULP_55 VSS) capacitor c=8.524E-16
    I_C186 (MULP_56 VSS) capacitor c=1.693E-15
    I_C187 (MULP_57 VSS) capacitor c=6.147E-16
    I_C188 (MULP_58 VSS) capacitor c=6.026E-16
    I_C189 (MULP_59 VSS) capacitor c=1.066E-15
    I_C190 (MULP_6 VSS) capacitor c=5.845E-16
    I_C191 (MULP_60 VSS) capacitor c=6.689E-16
    I_C192 (MULP_61 VSS) capacitor c=1.338E-15
    I_C193 (MULP_62 VSS) capacitor c=1.140E-15
    I_C194 (MULP_63 VSS) capacitor c=1.307E-15
    I_C195 (MULP_7 VSS) capacitor c=1.184E-15
    I_C196 (MULP_8 VSS) capacitor c=1.441E-15
    I_C197 (MULP_9 VSS) capacitor c=8.946E-16
    I_C198 (OP_0 VSS) capacitor c=6.132E-15
    I_C199 (OP_1 VSS) capacitor c=6.516E-15
    I_C200 (OP_2 VSS) capacitor c=3.904E-15
    I_C201 (OP_3 VSS) capacitor c=3.492E-15
    I_C202 (V VSS) capacitor c=3.828E-15
    I_C203 (Y_0 VSS) capacitor c=2.079E-15
    I_C204 (Y_1 VSS) capacitor c=1.592E-15
    I_C205 (Y_10 VSS) capacitor c=3.746E-15
    I_C206 (Y_11 VSS) capacitor c=6.511E-15
    I_C207 (Y_12 VSS) capacitor c=1.032E-15
    I_C208 (Y_13 VSS) capacitor c=2.001E-15
    I_C209 (Y_14 VSS) capacitor c=1.553E-15
    I_C210 (Y_15 VSS) capacitor c=2.296E-15
    I_C211 (Y_16 VSS) capacitor c=1.823E-15
    I_C212 (Y_17 VSS) capacitor c=1.883E-15
    I_C213 (Y_18 VSS) capacitor c=2.175E-15
    I_C214 (Y_19 VSS) capacitor c=2.161E-15
    I_C215 (Y_2 VSS) capacitor c=1.984E-15
    I_C216 (Y_20 VSS) capacitor c=1.512E-15
    I_C217 (Y_21 VSS) capacitor c=1.409E-15
    I_C218 (Y_22 VSS) capacitor c=1.212E-15
    I_C219 (Y_23 VSS) capacitor c=1.560E-15
    I_C220 (Y_24 VSS) capacitor c=2.470E-15
    I_C221 (Y_25 VSS) capacitor c=1.730E-15
    I_C222 (Y_26 VSS) capacitor c=1.239E-15
    I_C223 (Y_27 VSS) capacitor c=2.346E-15
    I_C224 (Y_28 VSS) capacitor c=1.692E-15
    I_C225 (Y_29 VSS) capacitor c=2.310E-15
    I_C226 (Y_3 VSS) capacitor c=1.791E-15
    I_C227 (Y_30 VSS) capacitor c=1.656E-15
    I_C228 (Y_31 VSS) capacitor c=2.815E-15
    I_C229 (Y_32 VSS) capacitor c=3.415E-15
    I_C230 (Y_33 VSS) capacitor c=3.102E-15
    I_C231 (Y_34 VSS) capacitor c=3.576E-15
    I_C232 (Y_35 VSS) capacitor c=3.828E-15
    I_C233 (Y_36 VSS) capacitor c=2.865E-15
    I_C234 (Y_37 VSS) capacitor c=3.079E-15
    I_C235 (Y_38 VSS) capacitor c=3.952E-15
    I_C236 (Y_39 VSS) capacitor c=3.524E-15
    I_C237 (Y_4 VSS) capacitor c=1.377E-15
    I_C238 (Y_40 VSS) capacitor c=2.398E-15
    I_C239 (Y_41 VSS) capacitor c=3.647E-15
    I_C240 (Y_42 VSS) capacitor c=3.565E-15
    I_C241 (Y_43 VSS) capacitor c=2.925E-15
    I_C242 (Y_44 VSS) capacitor c=2.961E-15
    I_C243 (Y_45 VSS) capacitor c=2.487E-15
    I_C244 (Y_46 VSS) capacitor c=2.865E-15
    I_C245 (Y_47 VSS) capacitor c=2.848E-15
    I_C246 (Y_48 VSS) capacitor c=1.942E-15
    I_C247 (Y_49 VSS) capacitor c=2.776E-15
    I_C248 (Y_5 VSS) capacitor c=2.520E-15
    I_C249 (Y_50 VSS) capacitor c=2.415E-15
    I_C250 (Y_51 VSS) capacitor c=3.634E-15
    I_C251 (Y_52 VSS) capacitor c=1.556E-15
    I_C252 (Y_53 VSS) capacitor c=1.917E-15
    I_C253 (Y_54 VSS) capacitor c=1.820E-15
    I_C254 (Y_55 VSS) capacitor c=1.484E-15
    I_C255 (Y_56 VSS) capacitor c=1.526E-15
    I_C256 (Y_57 VSS) capacitor c=1.654E-15
    I_C257 (Y_58 VSS) capacitor c=1.249E-15
    I_C258 (Y_59 VSS) capacitor c=1.099E-15
    I_C259 (Y_6 VSS) capacitor c=1.102E-15
    I_C260 (Y_60 VSS) capacitor c=1.321E-15
    I_C261 (Y_61 VSS) capacitor c=2.127E-15
    I_C262 (Y_62 VSS) capacitor c=1.574E-15
    I_C263 (Y_63 VSS) capacitor c=2.194E-15
    I_C264 (Y_7 VSS) capacitor c=2.420E-15
    I_C265 (Y_8 VSS) capacitor c=2.872E-15
    I_C266 (Y_9 VSS) capacitor c=2.580E-15
    I_C267 (Z VSS) capacitor c=1.151E-15
    I_C268 (XOR_17 VSS) capacitor c=8.313E-16
    I_C269 (XOR_19 VSS) capacitor c=1.506E-15
    I_C270 (XOR_21 VSS) capacitor c=9.024E-16
    I_C271 (XOR_25 VSS) capacitor c=1.460E-15
    I_C272 (XOR_18 VSS) capacitor c=1.158E-15
    I_C273 (XOR_22 VSS) capacitor c=1.349E-15
    I_C274 (XOR_23 VSS) capacitor c=9.195E-16
    I_C275 (XOR_24 VSS) capacitor c=1.010E-15
    I_C276 (XOR_16 VSS) capacitor c=8.960E-16
    I_C277 (I1_SUB_b3_3 VSS) capacitor c=9.286E-15
    I_C278 (I1_bx17 VSS) capacitor c=2.227E-15
    I_C279 (I1_bx18 VSS) capacitor c=2.548E-15
    I_C280 (I1_bx19 VSS) capacitor c=2.219E-15
    I_C281 (XOR_20 VSS) capacitor c=9.694E-16
    I_C282 (I1_bx20 VSS) capacitor c=2.129E-15
    I_C283 (I1_bx21 VSS) capacitor c=2.515E-15
    I_C284 (I1_SUB_b3_4 VSS) capacitor c=1.088E-14
    I_C285 (I1_bx22 VSS) capacitor c=1.950E-15
    I_C286 (I1_bx23 VSS) capacitor c=2.134E-15
    I_C287 (I1_bx24 VSS) capacitor c=2.287E-15
    I_C288 (I1_bx26 VSS) capacitor c=2.094E-15
    I_C289 (I1_bx25 VSS) capacitor c=2.618E-15
    I_C290 (XOR_26 VSS) capacitor c=8.844E-16
    I_C291 (I1_SUB_b3_2 VSS) capacitor c=1.186E-14
    I_C292 (I1_bx16 VSS) capacitor c=2.652E-15
    I_C293 (I1_I42_pn16 VSS) capacitor c=5.785E-15
    I_C294 (I1_I42_G15_0n VSS) capacitor c=9.035E-15
    I_C295 (S_16 VSS) capacitor c=2.409E-15
    I_C296 (I1_bx27 VSS) capacitor c=2.364E-15
    I_C297 (XOR_15 VSS) capacitor c=8.700E-16
    I_C298 (I1_bx15 VSS) capacitor c=2.053E-15
    I_C299 (XOR_27 VSS) capacitor c=8.531E-16
    I_C300 (I1_bx14 VSS) capacitor c=2.245E-15
    I_C301 (I1_I42_pn15 VSS) capacitor c=4.572E-15
    I_C302 (I1_I42_G14_0n VSS) capacitor c=6.930E-15
    I_C303 (S_15 VSS) capacitor c=2.174E-15
    I_C304 (XOR_28 VSS) capacitor c=1.559E-15
    I_C305 (XOR_14 VSS) capacitor c=1.051E-15
    I_C306 (I1_SUB_b3_5 VSS) capacitor c=1.505E-14
    I_C307 (I1_bx28 VSS) capacitor c=2.642E-15
    I_C308 (XOR_13 VSS) capacitor c=1.338E-15
    I_C309 (I1_I42_pn14 VSS) capacitor c=3.666E-15
    I_C310 (I1_I42_G13_0n VSS) capacitor c=7.167E-15
    I_C311 (S_14 VSS) capacitor c=2.239E-15
    I_C312 (I1_I42_pn13 VSS) capacitor c=4.286E-15
    I_C313 (I1_I42_G12_0n VSS) capacitor c=3.123E-15
    I_C314 (S_13 VSS) capacitor c=2.156E-15
    I_C315 (I1_bx29 VSS) capacitor c=2.374E-15
    I_C316 (XOR_29 VSS) capacitor c=8.972E-16
    I_C317 (I1_bx13 VSS) capacitor c=2.363E-15
    I_C318 (I1_I42_pn12 VSS) capacitor c=4.529E-15
    I_C319 (I1_I42_G11_0n VSS) capacitor c=6.602E-15
    I_C320 (S_12 VSS) capacitor c=2.090E-15
    I_C321 (I1_bx31 VSS) capacitor c=2.541E-15
    I_C322 (XOR_12 VSS) capacitor c=9.998E-16
    I_C323 (I1_bx12 VSS) capacitor c=2.142E-15
    I_C324 (I1_bx11 VSS) capacitor c=2.206E-15
    I_C325 (I1_I42_pn11 VSS) capacitor c=5.946E-15
    I_C326 (I1_I42_G10_0n VSS) capacitor c=3.759E-15
    I_C327 (S_11 VSS) capacitor c=1.572E-15
    I_C328 (XOR_31 VSS) capacitor c=9.292E-16
    I_C329 (XOR_11 VSS) capacitor c=1.274E-15
    I_C330 (CM VSS) capacitor c=6.853E-15
    I_C331 (CO VSS) capacitor c=5.080E-15
    I_C332 (I4_ovf VSS) capacitor c=1.015E-15
    I_C333 (I1_bx30 VSS) capacitor c=3.171E-15
    I_C334 (XOR_30 VSS) capacitor c=8.568E-16
    I_C335 (I1_SUB_b3_0 VSS) capacitor c=1.307E-14
    I_C336 (I1_bx3 VSS) capacitor c=2.354E-15
    I_C337 (I1_I42_pn3 VSS) capacitor c=4.812E-15
    I_C338 (I1_I42_G2_0n VSS) capacitor c=8.097E-15
    I_C339 (S_3 VSS) capacitor c=2.296E-15
    I_C340 (I1_I42_pn10 VSS) capacitor c=6.216E-15
    I_C341 (I1_I42_G9_0n VSS) capacitor c=3.055E-15
    I_C342 (S_10 VSS) capacitor c=3.482E-15
    I_C343 (XOR_3 VSS) capacitor c=1.693E-15
    I_C344 (I1_bx2 VSS) capacitor c=2.422E-15
    I_C345 (I1_I42_pn4 VSS) capacitor c=7.252E-15
    I_C346 (I1_I42_G3_0n VSS) capacitor c=8.034E-15
    I_C347 (S_4 VSS) capacitor c=1.374E-15
    I_C348 (I1_I42_pn9 VSS) capacitor c=4.606E-15
    I_C349 (I1_I42_G8_0n VSS) capacitor c=7.051E-15
    I_C350 (S_9 VSS) capacitor c=3.408E-15
    I_C351 (I1_SUB_b3_1 VSS) capacitor c=9.501E-15
    I_C352 (I1_bx10 VSS) capacitor c=1.750E-15
    I_C353 (I1_bx5 VSS) capacitor c=2.176E-15
    I_C354 (I1_bx6 VSS) capacitor c=2.421E-15
    I_C355 (I1_bx7 VSS) capacitor c=2.083E-15
    I_C356 (I1_bx9 VSS) capacitor c=1.943E-15
    I_C357 (I1_bx8 VSS) capacitor c=1.867E-15
    I_C358 (XOR_2 VSS) capacitor c=8.803E-16
    I_C359 (XOR_5 VSS) capacitor c=1.166E-15
    I_C360 (XOR_7 VSS) capacitor c=1.103E-15
    I_C361 (XOR_10 VSS) capacitor c=9.445E-16
    I_C362 (I1_bx4 VSS) capacitor c=2.457E-15
    I_C363 (I1_bx1 VSS) capacitor c=1.835E-15
    I_C364 (XOR_6 VSS) capacitor c=1.710E-15
    I_C365 (XOR_9 VSS) capacitor c=1.160E-15
    I_C366 (XOR_8 VSS) capacitor c=8.085E-16
    I_C367 (XOR_4 VSS) capacitor c=1.592E-15
    I_C368 (XOR_1 VSS) capacitor c=1.163E-15
    I_C369 (XOR_0 VSS) capacitor c=1.152E-15
    I_C370 (I1_bx0 VSS) capacitor c=2.272E-15
    I_C371 (I2_nor17 VSS) capacitor c=6.857E-16
    I_C372 (OR_17 VSS) capacitor c=9.272E-16
    I_C373 (I2_nand17 VSS) capacitor c=9.380E-16
    I_C374 (AND_17 VSS) capacitor c=8.893E-16
    I_C375 (I2_nor18 VSS) capacitor c=1.033E-15
    I_C376 (OR_18 VSS) capacitor c=5.486E-16
    I_C377 (I2_nand18 VSS) capacitor c=1.308E-15
    I_C378 (AND_18 VSS) capacitor c=9.118E-16
    I_C379 (I2_nor19 VSS) capacitor c=6.938E-16
    I_C380 (OR_19 VSS) capacitor c=7.321E-16
    I_C381 (I2_nand19 VSS) capacitor c=7.009E-16
    I_C382 (AND_19 VSS) capacitor c=7.318E-16
    I_C383 (I2_nor20 VSS) capacitor c=8.778E-16
    I_C384 (OR_20 VSS) capacitor c=7.732E-16
    I_C385 (I2_nand20 VSS) capacitor c=7.339E-16
    I_C386 (AND_20 VSS) capacitor c=8.183E-16
    I_C387 (I2_nand21 VSS) capacitor c=7.939E-16
    I_C388 (AND_21 VSS) capacitor c=6.559E-16
    I_C389 (I2_nor22 VSS) capacitor c=1.170E-15
    I_C390 (OR_22 VSS) capacitor c=9.780E-16
    I_C391 (I2_nand22 VSS) capacitor c=8.211E-16
    I_C392 (AND_22 VSS) capacitor c=5.315E-16
    I_C393 (I2_nand23 VSS) capacitor c=1.037E-15
    I_C394 (AND_23 VSS) capacitor c=6.342E-16
    I_C395 (I2_nor23 VSS) capacitor c=8.967E-16
    I_C396 (OR_23 VSS) capacitor c=5.456E-16
    I_C397 (I2_nor24 VSS) capacitor c=8.669E-16
    I_C398 (OR_24 VSS) capacitor c=5.430E-16
    I_C399 (I2_nand24 VSS) capacitor c=8.520E-16
    I_C400 (AND_24 VSS) capacitor c=6.807E-16
    I_C401 (I2_nor25 VSS) capacitor c=6.700E-16
    I_C402 (OR_25 VSS) capacitor c=9.890E-16
    I_C403 (I2_nand25 VSS) capacitor c=8.697E-16
    I_C404 (AND_25 VSS) capacitor c=6.723E-16
    I_C405 (I2_nor16 VSS) capacitor c=1.256E-15
    I_C406 (OR_16 VSS) capacitor c=5.413E-16
    I_C407 (NOT_17 VSS) capacitor c=9.744E-16
    I_C408 (NOT_18 VSS) capacitor c=5.944E-16
    I_C409 (NOT_20 VSS) capacitor c=7.170E-16
    I_C410 (NOT_21 VSS) capacitor c=5.210E-16
    I_C411 (I2_nor21 VSS) capacitor c=9.317E-16
    I_C412 (OR_21 VSS) capacitor c=6.395E-16
    I_C413 (NOT_22 VSS) capacitor c=9.800E-16
    I_C414 (NOT_23 VSS) capacitor c=5.424E-16
    I_C415 (NOT_25 VSS) capacitor c=5.537E-16
    I_C416 (I2_nor26 VSS) capacitor c=1.302E-15
    I_C417 (OR_26 VSS) capacitor c=5.313E-16
    I_C418 (I2_nand16 VSS) capacitor c=8.277E-16
    I_C419 (AND_16 VSS) capacitor c=6.929E-16
    I_C420 (NOT_16 VSS) capacitor c=7.440E-16
    I_C421 (NOT_19 VSS) capacitor c=7.843E-16
    I_C422 (NOT_24 VSS) capacitor c=5.455E-16
    I_C423 (NOT_26 VSS) capacitor c=7.857E-16
    I_C424 (I2_nand26 VSS) capacitor c=9.010E-16
    I_C425 (AND_26 VSS) capacitor c=5.467E-16
    I_C426 (I2_nand15 VSS) capacitor c=7.338E-16
    I_C427 (AND_15 VSS) capacitor c=7.104E-16
    I_C428 (I2_nor15 VSS) capacitor c=7.096E-16
    I_C429 (OR_15 VSS) capacitor c=6.762E-16
    I_C430 (NOT_15 VSS) capacitor c=7.826E-16
    I_C431 (NOT_27 VSS) capacitor c=6.585E-16
    I_C432 (I2_nand27 VSS) capacitor c=7.901E-16
    I_C433 (AND_27 VSS) capacitor c=9.647E-16
    I_C434 (I2_nor27 VSS) capacitor c=7.058E-16
    I_C435 (OR_27 VSS) capacitor c=1.248E-15
    I_C436 (I2_nor14 VSS) capacitor c=8.167E-16
    I_C437 (OR_14 VSS) capacitor c=5.288E-16
    I_C438 (I1_I42_G6_0 VSS) capacitor c=9.086E-15
    I_C439 (I1_I42_G6_0n VSS) capacitor c=6.999E-16
    I_C440 (I2_nand14 VSS) capacitor c=1.520E-15
    I_C441 (AND_14 VSS) capacitor c=8.205E-16
    I_C442 (NOT_14 VSS) capacitor c=4.949E-16
    I_C443 (NOT_28 VSS) capacitor c=5.657E-16
    I_C444 (I2_nor28 VSS) capacitor c=1.010E-15
    I_C445 (OR_28 VSS) capacitor c=5.386E-16
    I_C446 (I2_nand28 VSS) capacitor c=9.585E-16
    I_C447 (AND_28 VSS) capacitor c=6.058E-16
    I_C448 (I2_nand13 VSS) capacitor c=2.159E-15
    I_C449 (AND_13 VSS) capacitor c=7.559E-16
    I_C450 (I1_I42_G4_0 VSS) capacitor c=4.439E-15
    I_C451 (I1_I42_G4_0n VSS) capacitor c=1.313E-15
    I_C452 (I1_I42_G7_0 VSS) capacitor c=7.170E-15
    I_C453 (I1_I42_G7_0n VSS) capacitor c=8.494E-16
    I_C454 (NOT_29 VSS) capacitor c=8.888E-16
    I_C455 (I2_nor13 VSS) capacitor c=6.699E-16
    I_C456 (OR_13 VSS) capacitor c=5.371E-16
    I_C457 (NOT_12 VSS) capacitor c=5.439E-16
    I_C458 (NOT_13 VSS) capacitor c=6.359E-16
    I_C459 (I1_I42_G2_0np VSS) capacitor c=1.223E-15
    I_C460 (I1_I42_G3_0np VSS) capacitor c=6.051E-16
    I_C461 (I2_nor31 VSS) capacitor c=1.072E-15
    I_C462 (OR_31 VSS) capacitor c=7.717E-16
    I_C463 (I2_nand31 VSS) capacitor c=1.569E-15
    I_C464 (AND_31 VSS) capacitor c=6.432E-16
    I_C465 (I2_nor29 VSS) capacitor c=8.322E-16
    I_C466 (OR_29 VSS) capacitor c=5.508E-16
    I_C467 (I2_nand29 VSS) capacitor c=1.162E-15
    I_C468 (AND_29 VSS) capacitor c=8.600E-16
    I_C469 (I2_nand30 VSS) capacitor c=1.087E-15
    I_C470 (AND_30 VSS) capacitor c=7.526E-16
    I_C471 (I2_nand12 VSS) capacitor c=7.170E-16
    I_C472 (AND_12 VSS) capacitor c=5.823E-16
    I_C473 (I1_I42_G5_0 VSS) capacitor c=4.782E-15
    I_C474 (I1_I42_G5_0n VSS) capacitor c=9.269E-16
    I_C475 (I4_cn VSS) capacitor c=1.279E-15
    I_C476 (NOT_31 VSS) capacitor c=8.103E-16
    I_C477 (NOT_30 VSS) capacitor c=5.977E-16
    I_C478 (I2_nor30 VSS) capacitor c=8.585E-16
    I_C479 (OR_30 VSS) capacitor c=6.061E-16
    I_C480 (I2_nor12 VSS) capacitor c=9.694E-16
    I_C481 (OR_12 VSS) capacitor c=5.915E-16
    I_C482 (NOT_11 VSS) capacitor c=5.739E-16
    I_C483 (I2_nor11 VSS) capacitor c=6.913E-16
    I_C484 (OR_11 VSS) capacitor c=7.869E-16
    I_C485 (I2_nand11 VSS) capacitor c=7.366E-16
    I_C486 (AND_11 VSS) capacitor c=7.386E-16
    I_C487 (I1_I42_G0_0 VSS) capacitor c=7.299E-15
    I_C488 (I1_I42_G0_0n VSS) capacitor c=2.834E-15
    I_C489 (SEL_AND VSS) capacitor c=1.009E-15
    I_C490 (I3_SEL_AND_b0 VSS) capacitor c=8.525E-16
    I_C491 (SEL_AS VSS) capacitor c=2.178E-15
    I_C492 (I3_SEL_AS_b0 VSS) capacitor c=1.258E-15
    I_C493 (I2_nor3 VSS) capacitor c=6.250E-16
    I_C494 (OR_3 VSS) capacitor c=1.646E-15
    I_C495 (I2_nand3 VSS) capacitor c=7.460E-16
    I_C496 (AND_3 VSS) capacitor c=1.100E-15
    I_C497 (I1_I42_G1_0 VSS) capacitor c=6.768E-15
    I_C498 (I1_I42_G1_0n VSS) capacitor c=1.655E-15
    I_C499 (I1_SUB_b0 VSS) capacitor c=1.127E-15
    I_C500 (SEL_XOR VSS) capacitor c=6.656E-16
    I_C501 (I3_SEL_XOR_b0 VSS) capacitor c=9.764E-16
    I_C502 (SEL_OR VSS) capacitor c=1.153E-15
    I_C503 (I3_SEL_OR_b0 VSS) capacitor c=1.286E-15
    I_C504 (I0_opn1 VSS) capacitor c=1.338E-15
    I_C505 (I0_opn0 VSS) capacitor c=1.507E-15
    I_C506 (NOT_3 VSS) capacitor c=1.381E-15
    I_C507 (SEL_NOT VSS) capacitor c=7.781E-16
    I_C508 (I3_SEL_NOT_b0 VSS) capacitor c=1.031E-15
    I_C509 (SEL_MUL VSS) capacitor c=6.182E-16
    I_C510 (I3_SEL_MUL_b0 VSS) capacitor c=8.278E-16
    I_C511 (I0_opn3 VSS) capacitor c=1.838E-15
    I_C512 (I0_opn2 VSS) capacitor c=1.287E-15
    I_C513 (I2_nand5 VSS) capacitor c=1.238E-15
    I_C514 (AND_5 VSS) capacitor c=6.535E-16
    I_C515 (I2_nor5 VSS) capacitor c=8.107E-16
    I_C516 (OR_5 VSS) capacitor c=5.015E-16
    I_C517 (I2_nor10 VSS) capacitor c=6.821E-16
    I_C518 (OR_10 VSS) capacitor c=5.689E-16
    I_C519 (I2_nand10 VSS) capacitor c=1.002E-15
    I_C520 (AND_10 VSS) capacitor c=7.286E-16
    I_C521 (SEL_DIV VSS) capacitor c=5.208E-15
    I_C522 (I3_SEL_DIV_b0 VSS) capacitor c=8.879E-16
    I_C523 (NOT_2 VSS) capacitor c=5.713E-16
    I_C524 (I1_I42_cinn VSS) capacitor c=7.187E-16
    I_C525 (NOT_7 VSS) capacitor c=5.678E-16
    I_C526 (NOT_9 VSS) capacitor c=5.558E-16
    I_C527 (NOT_10 VSS) capacitor c=1.132E-15
    I_C528 (I2_nand2 VSS) capacitor c=1.038E-15
    I_C529 (AND_2 VSS) capacitor c=5.239E-16
    I_C530 (I2_nor2 VSS) capacitor c=7.450E-16
    I_C531 (OR_2 VSS) capacitor c=6.681E-16
    I_C532 (NOT_4 VSS) capacitor c=5.470E-16
    I_C533 (NOT_1 VSS) capacitor c=8.020E-16
    I_C534 (NOT_5 VSS) capacitor c=5.399E-16
    I_C535 (I2_nor7 VSS) capacitor c=7.599E-16
    I_C536 (OR_7 VSS) capacitor c=9.653E-16
    I_C537 (NOT_6 VSS) capacitor c=6.971E-16
    I_C538 (I2_nand7 VSS) capacitor c=6.964E-16
    I_C539 (AND_7 VSS) capacitor c=5.144E-16
    I_C540 (NOT_8 VSS) capacitor c=5.479E-16
    I_C541 (I4_z5_0 VSS) capacitor c=9.176E-16
    I_C542 (I2_nand4 VSS) capacitor c=8.503E-16
    I_C543 (AND_4 VSS) capacitor c=5.924E-16
    I_C544 (I2_nor4 VSS) capacitor c=8.058E-16
    I_C545 (OR_4 VSS) capacitor c=7.324E-16
    I_C546 (I2_nor1 VSS) capacitor c=8.822E-16
    I_C547 (OR_1 VSS) capacitor c=5.475E-16
    I_C548 (I2_nand1 VSS) capacitor c=1.054E-15
    I_C549 (AND_1 VSS) capacitor c=5.694E-16
    I_C550 (NOT_0 VSS) capacitor c=5.678E-16
    I_C551 (I2_nor6 VSS) capacitor c=1.375E-15
    I_C552 (OR_6 VSS) capacitor c=4.952E-16
    I_C553 (I2_nor9 VSS) capacitor c=9.249E-16
    I_C554 (OR_9 VSS) capacitor c=8.004E-16
    I_C555 (I2_nand8 VSS) capacitor c=7.319E-16
    I_C556 (AND_8 VSS) capacitor c=1.046E-15
    I_C557 (I2_nor8 VSS) capacitor c=6.742E-16
    I_C558 (OR_8 VSS) capacitor c=6.748E-16
    I_C559 (I2_nor0 VSS) capacitor c=1.009E-15
    I_C560 (OR_0 VSS) capacitor c=5.752E-16
    I_C561 (I2_nand0 VSS) capacitor c=7.309E-16
    I_C562 (AND_0 VSS) capacitor c=1.246E-15
    I_C563 (I2_nand6 VSS) capacitor c=1.503E-15
    I_C564 (AND_6 VSS) capacitor c=7.211E-16
    I_C565 (I2_nand9 VSS) capacitor c=9.798E-16
    I_C566 (AND_9 VSS) capacitor c=5.423E-16
    I_C567 (I4_dzn VSS) capacitor c=6.861E-16
    I_C568 (I4_z0_8 VSS) capacitor c=1.624E-15
    I_C569 (I4_z0_9 VSS) capacitor c=9.429E-16
    I_C570 (I3_o20_0 VSS) capacitor c=6.228E-16
    I_C571 (I3_o20_1 VSS) capacitor c=1.791E-15
    I_C572 (I3_q20_1 VSS) capacitor c=1.280E-15
    I_C573 (I4_z0_10 VSS) capacitor c=2.242E-15
    I_C574 (I3_o21_0 VSS) capacitor c=7.585E-16
    I_C575 (I3_o21_1 VSS) capacitor c=8.614E-16
    I_C576 (I3_q21_1 VSS) capacitor c=1.244E-15
    I_C577 (I4_z0_11 VSS) capacitor c=6.593E-16
    I_C578 (I4_z1_4 VSS) capacitor c=4.076E-15
    I_C579 (I4_z1_5 VSS) capacitor c=1.052E-15
    I_C580 (I4_z2_2 VSS) capacitor c=4.754E-15
    I_C581 (I3_o22_0 VSS) capacitor c=9.941E-16
    I_C582 (I3_o22_1 VSS) capacitor c=1.404E-15
    I_C583 (I3_q22_1 VSS) capacitor c=1.409E-15
    I_C584 (I3_o17_0 VSS) capacitor c=6.074E-16
    I_C585 (I3_o17_1 VSS) capacitor c=8.997E-16
    I_C586 (I3_q17_1 VSS) capacitor c=1.689E-15
    I_C587 (I3_o16_0 VSS) capacitor c=9.463E-16
    I_C588 (I3_o16_1 VSS) capacitor c=8.787E-16
    I_C589 (I3_q16_1 VSS) capacitor c=1.207E-15
    I_C590 (I3_o18_0 VSS) capacitor c=1.349E-15
    I_C591 (I3_o18_1 VSS) capacitor c=1.207E-15
    I_C592 (I3_q18_1 VSS) capacitor c=1.372E-15
    I_C593 (I3_o19_0 VSS) capacitor c=7.732E-16
    I_C594 (I3_o19_1 VSS) capacitor c=7.412E-16
    I_C595 (I3_q19_1 VSS) capacitor c=7.992E-16
    I_C596 (I3_o23_0 VSS) capacitor c=1.266E-15
    I_C597 (I3_o23_1 VSS) capacitor c=1.136E-15
    I_C598 (I3_q23_1 VSS) capacitor c=1.853E-15
    I_C599 (I3_o24_0 VSS) capacitor c=7.252E-16
    I_C600 (I3_o24_1 VSS) capacitor c=1.197E-15
    I_C601 (I3_q24_1 VSS) capacitor c=8.808E-16
    I_C602 (I3_o25_0 VSS) capacitor c=8.102E-16
    I_C603 (I3_o25_1 VSS) capacitor c=7.273E-16
    I_C604 (I3_q25_1 VSS) capacitor c=1.212E-15
    I_C605 (I3_o26_0 VSS) capacitor c=6.533E-16
    I_C606 (I3_o26_1 VSS) capacitor c=7.707E-16
    I_C607 (I3_q26_1 VSS) capacitor c=1.667E-15
    I_C608 (I4_z0_12 VSS) capacitor c=8.647E-16
    I_C609 (I4_z0_13 VSS) capacitor c=6.588E-16
    I_C610 (I1_I42_pn18 VSS) capacitor c=4.732E-15
    I_C611 (I1_I42_pn17 VSS) capacitor c=6.676E-15
    I_C612 (I1_I42_P18_17 VSS) capacitor c=2.362E-15
    I_C613 (I1_I42_pn19 VSS) capacitor c=3.880E-15
    I_C614 (I1_I42_P19_18 VSS) capacitor c=4.283E-15
    I_C615 (I1_I42_pn20 VSS) capacitor c=4.445E-15
    I_C616 (I1_I42_P20_19 VSS) capacitor c=3.200E-15
    I_C617 (I1_I42_pn21 VSS) capacitor c=3.520E-15
    I_C618 (I1_I42_P21_20 VSS) capacitor c=2.638E-15
    I_C619 (I1_I42_pn22 VSS) capacitor c=3.983E-15
    I_C620 (I1_I42_P22_21 VSS) capacitor c=2.899E-15
    I_C621 (I1_I42_pn23 VSS) capacitor c=3.822E-15
    I_C622 (I1_I42_P23_22 VSS) capacitor c=3.293E-15
    I_C623 (I1_I42_pn24 VSS) capacitor c=4.220E-15
    I_C624 (I1_I42_P24_23 VSS) capacitor c=3.273E-15
    I_C625 (I1_I42_pn25 VSS) capacitor c=4.633E-15
    I_C626 (I1_I42_P25_24 VSS) capacitor c=3.095E-15
    I_C627 (I1_I42_pn26 VSS) capacitor c=4.782E-15
    I_C628 (I1_I42_P26_25 VSS) capacitor c=3.180E-15
    I_C629 (I1_I42_pn27 VSS) capacitor c=4.345E-15
    I_C630 (I1_I42_P27_26 VSS) capacitor c=3.204E-15
    I_C631 (I3_o15_0 VSS) capacitor c=7.509E-16
    I_C632 (I3_o15_1 VSS) capacitor c=1.048E-15
    I_C633 (I3_q15_1 VSS) capacitor c=8.181E-16
    I_C634 (I1_I42_P16_15 VSS) capacitor c=2.806E-15
    I_C635 (I1_I42_P17_16 VSS) capacitor c=6.006E-15
    I_C636 (I1_I42_P24_21n VSS) capacitor c=4.948E-15
    I_C637 (I1_I42_P20_17n VSS) capacitor c=2.972E-15
    I_C638 (I1_I42_P24_17 VSS) capacitor c=2.810E-15
    I_C639 (I1_I42_P18_15n VSS) capacitor c=3.938E-15
    I_C640 (I1_I42_P14_11n VSS) capacitor c=3.275E-15
    I_C641 (I1_I42_P18_11 VSS) capacitor c=3.072E-15
    I_C642 (I1_I42_P22_19n VSS) capacitor c=2.617E-15
    I_C643 (I1_I42_P22_15 VSS) capacitor c=4.155E-15
    I_C644 (I1_I42_P26_23n VSS) capacitor c=4.242E-15
    I_C645 (I1_I42_P26_19 VSS) capacitor c=2.980E-15
    I_C646 (I1_I42_P28_25n VSS) capacitor c=3.331E-15
    I_C647 (I1_I42_P28_21 VSS) capacitor c=3.767E-15
    I_C648 (I1_I42_P30_27n VSS) capacitor c=2.076E-15
    I_C649 (I1_I42_P30_23 VSS) capacitor c=1.791E-15
    I_C650 (I1_I42_pn28 VSS) capacitor c=4.449E-15
    I_C651 (I1_I42_P28_27 VSS) capacitor c=2.768E-15
    I_C652 (I3_o27_0 VSS) capacitor c=9.232E-16
    I_C653 (I3_o27_1 VSS) capacitor c=1.417E-15
    I_C654 (I3_q27_1 VSS) capacitor c=1.315E-15
    I_C655 (I4_z1_6 VSS) capacitor c=2.593E-15
    I_C656 (I4_z1_7 VSS) capacitor c=1.772E-15
    I_C657 (I4_z2_3 VSS) capacitor c=2.895E-15
    I_C658 (I4_z0_7 VSS) capacitor c=1.998E-15
    I_C659 (I3_o14_0 VSS) capacitor c=1.381E-15
    I_C660 (I3_o14_1 VSS) capacitor c=1.012E-15
    I_C661 (I3_q14_1 VSS) capacitor c=9.091E-16
    I_C662 (I1_I42_P14_13 VSS) capacitor c=2.309E-15
    I_C663 (I1_I42_P16_13n VSS) capacitor c=3.414E-15
    I_C664 (I1_I42_P20_13 VSS) capacitor c=2.721E-15
    I_C665 (I1_I42_P10_7n VSS) capacitor c=5.109E-15
    I_C666 (I1_I42_P14_7 VSS) capacitor c=2.249E-15
    I_C667 (I1_I42_P23_20n VSS) capacitor c=2.001E-15
    I_C668 (I1_I42_P19_16n VSS) capacitor c=3.214E-15
    I_C669 (I1_I42_P23_16 VSS) capacitor c=2.627E-15
    I_C670 (I1_I42_P27_24n VSS) capacitor c=2.493E-15
    I_C671 (I1_I42_P27_20 VSS) capacitor c=2.111E-15
    I_C672 (I1_I42_pn29 VSS) capacitor c=4.968E-15
    I_C673 (I1_I42_P29_28 VSS) capacitor c=2.499E-15
    I_C674 (I1_I42_pn30 VSS) capacitor c=5.253E-15
    I_C675 (I1_I42_P30_29 VSS) capacitor c=2.841E-15
    I_C676 (I3_o28_0 VSS) capacitor c=9.408E-16
    I_C677 (I3_o28_1 VSS) capacitor c=1.008E-15
    I_C678 (I3_q28_1 VSS) capacitor c=1.182E-15
    I_C679 (I3_o13_0 VSS) capacitor c=8.599E-16
    I_C680 (I3_o13_1 VSS) capacitor c=1.275E-15
    I_C681 (I3_q13_1 VSS) capacitor c=1.528E-15
    I_C682 (I1_I42_P15_14 VSS) capacitor c=4.745E-15
    I_C683 (I1_I42_P15_12n VSS) capacitor c=2.246E-15
    I_C684 (I1_I42_P19_12 VSS) capacitor c=2.769E-15
    I_C685 (I1_I42_P31_28n VSS) capacitor c=1.783E-15
    I_C686 (I1_I42_P31_24 VSS) capacitor c=1.460E-15
    I_C687 (I3_o29_0 VSS) capacitor c=6.284E-16
    I_C688 (I3_o29_1 VSS) capacitor c=1.358E-15
    I_C689 (I3_q29_1 VSS) capacitor c=1.235E-15
    I_C690 (I4_z0_14 VSS) capacitor c=9.734E-16
    I_C691 (I4_z0_6 VSS) capacitor c=7.421E-16
    I_C692 (I3_o12_0 VSS) capacitor c=1.470E-15
    I_C693 (I3_o12_1 VSS) capacitor c=1.136E-15
    I_C694 (I3_q12_1 VSS) capacitor c=8.705E-16
    I_C695 (I1_I42_P13_12 VSS) capacitor c=3.946E-15
    I_C696 (I1_I42_P12_9n VSS) capacitor c=2.478E-15
    I_C697 (I1_I42_P16_9 VSS) capacitor c=3.385E-15
    I_C698 (I1_I42_P8_5n VSS) capacitor c=4.120E-15
    I_C699 (I1_I42_P12_5 VSS) capacitor c=2.162E-15
    I_C700 (I1_I42_P11_8n VSS) capacitor c=3.586E-15
    I_C701 (I1_I42_P15_8 VSS) capacitor c=1.707E-15
    I_C702 (I1_I42_P21_18n VSS) capacitor c=3.520E-15
    I_C703 (I1_I42_P17_14n VSS) capacitor c=3.128E-15
    I_C704 (I1_I42_P21_14 VSS) capacitor c=3.063E-15
    I_C705 (I1_I42_P25_22n VSS) capacitor c=3.732E-15
    I_C706 (I1_I42_P25_18 VSS) capacitor c=2.023E-15
    I_C707 (I1_I42_P29_26n VSS) capacitor c=2.493E-15
    I_C708 (I1_I42_P29_22 VSS) capacitor c=1.835E-15
    I_C709 (I1_I42_pn31 VSS) capacitor c=3.092E-15
    I_C710 (I1_I42_P31_30 VSS) capacitor c=2.313E-15
    I_C711 (I4_z0_15 VSS) capacitor c=1.231E-15
    I_C712 (I1_I42_P12_11 VSS) capacitor c=3.936E-15
    I_C713 (I1_I42_P6_3n VSS) capacitor c=1.920E-15
    I_C714 (I1_I42_P10_3 VSS) capacitor c=1.578E-15
    I_C715 (I1_I42_P13_10n VSS) capacitor c=2.274E-15
    I_C716 (I1_I42_P9_6n VSS) capacitor c=3.096E-15
    I_C717 (I1_I42_P13_6 VSS) capacitor c=1.706E-15
    I_C718 (I1_I42_P17_10 VSS) capacitor c=3.195E-15
    I_C719 (I3_o31_0 VSS) capacitor c=7.589E-16
    I_C720 (I3_o31_1 VSS) capacitor c=1.179E-15
    I_C721 (I3_q31_1 VSS) capacitor c=8.242E-16
    I_C722 (I3_o30_0 VSS) capacitor c=1.545E-15
    I_C723 (I3_o30_1 VSS) capacitor c=1.583E-15
    I_C724 (I3_q30_1 VSS) capacitor c=8.601E-16
    I_C725 (I3_o11_0 VSS) capacitor c=7.633E-16
    I_C726 (I3_o11_1 VSS) capacitor c=1.332E-15
    I_C727 (I3_q11_1 VSS) capacitor c=4.916E-15
    I_C728 (I1_I42_P4_1n VSS) capacitor c=2.012E-15
    I_C729 (I1_I42_P8_1 VSS) capacitor c=1.424E-15
    I_C730 (I1_I42_P7_4n VSS) capacitor c=1.812E-15
    I_C731 (I1_I42_P11_4 VSS) capacitor c=2.714E-15
    I_C732 (I1_I42_P11_10 VSS) capacitor c=2.562E-15
    I_C733 (I0_h00 VSS) capacitor c=2.383E-15
    I_C734 (I0_l10 VSS) capacitor c=1.029E-15
    I_C735 (I1_I42_pn2 VSS) capacitor c=5.914E-15
    I_C736 (I1_I42_pn1 VSS) capacitor c=5.203E-15
    I_C737 (I1_I42_P2_1 VSS) capacitor c=1.326E-15
    I_C738 (I1_I42_P3_2 VSS) capacitor c=1.506E-15
    I_C739 (I1_I42_P4_3 VSS) capacitor c=3.585E-15
    I_C740 (I1_I42_pn6 VSS) capacitor c=5.040E-15
    I_C741 (I1_I42_pn5 VSS) capacitor c=3.987E-15
    I_C742 (I1_I42_P6_5 VSS) capacitor c=1.982E-15
    I_C743 (I1_I42_pn8 VSS) capacitor c=6.189E-15
    I_C744 (I1_I42_pn7 VSS) capacitor c=4.806E-15
    I_C745 (I1_I42_P8_7 VSS) capacitor c=3.485E-15
    I_C746 (I1_I42_P7_6 VSS) capacitor c=2.226E-15
    I_C747 (I1_I42_P10_9 VSS) capacitor c=4.663E-15
    I_C748 (I1_I42_P9_8 VSS) capacitor c=2.979E-15
    I_C749 (I1_I42_P5_2n VSS) capacitor c=5.663E-15
    I_C750 (I1_I42_P9_2 VSS) capacitor c=1.461E-15
    I_C751 (I0_h01 VSS) capacitor c=1.639E-15
    I_C752 (I0_l00 VSS) capacitor c=9.402E-16
    I_C753 (I0_l11 VSS) capacitor c=1.375E-15
    I_C754 (I0_h10 VSS) capacitor c=2.281E-15
    I_C755 (I4_z0_16 VSS) capacitor c=9.720E-16
    I_C756 (I4_z0_17 VSS) capacitor c=6.606E-16
    I_C757 (I4_z0_18 VSS) capacitor c=2.027E-15
    I_C758 (I1_I42_P5_4 VSS) capacitor c=3.123E-15
    I_C759 (I0_l01 VSS) capacitor c=2.077E-15
    I_C760 (I4_z1_8 VSS) capacitor c=7.733E-16
    I_C761 (I4_z1_9 VSS) capacitor c=9.527E-16
    I_C762 (I4_z2_4 VSS) capacitor c=2.092E-15
    I_C763 (I4_z0_19 VSS) capacitor c=1.467E-15
    I_C764 (I3_o3_0 VSS) capacitor c=9.056E-16
    I_C765 (I3_o3_1 VSS) capacitor c=1.020E-15
    I_C766 (I3_q3_1 VSS) capacitor c=7.803E-16
    I_C767 (I4_z0_1 VSS) capacitor c=3.749E-15
    I_C768 (I4_z0_20 VSS) capacitor c=1.710E-15
    I_C769 (I3_o2_0 VSS) capacitor c=1.145E-15
    I_C770 (I3_o2_1 VSS) capacitor c=8.018E-16
    I_C771 (I3_q2_1 VSS) capacitor c=1.040E-15
    I_C772 (I3_o5_0 VSS) capacitor c=9.307E-16
    I_C773 (I3_o5_1 VSS) capacitor c=8.729E-16
    I_C774 (I3_q5_1 VSS) capacitor c=7.463E-16
    I_C775 (I4_z1_2 VSS) capacitor c=2.352E-15
    I_C776 (I4_z1_3 VSS) capacitor c=5.190E-15
    I_C777 (I4_z2_1 VSS) capacitor c=6.519E-16
    I_C778 (I3_o7_0 VSS) capacitor c=6.211E-16
    I_C779 (I3_o7_1 VSS) capacitor c=1.037E-15
    I_C780 (I3_q7_1 VSS) capacitor c=1.082E-15
    I_C781 (I4_z0_5 VSS) capacitor c=6.129E-16
    I_C782 (I3_o10_0 VSS) capacitor c=8.470E-16
    I_C783 (I3_o10_1 VSS) capacitor c=1.103E-15
    I_C784 (I3_q10_1 VSS) capacitor c=1.243E-15
    I_C785 (I4_z3_0 VSS) capacitor c=3.457E-15
    I_C786 (I4_z3_1 VSS) capacitor c=4.900E-15
    I_C787 (I4_z4_0 VSS) capacitor c=1.068E-15
    I_C788 (I4_z0_21 VSS) capacitor c=7.036E-16
    I_C789 (I4_z1_10 VSS) capacitor c=6.547E-16
    I_C790 (I4_z1_11 VSS) capacitor c=1.294E-15
    I_C791 (I4_z2_5 VSS) capacitor c=1.087E-15
    I_C792 (I4_z0_23 VSS) capacitor c=1.334E-15
    I_C793 (I4_z0_25 VSS) capacitor c=6.125E-16
    I_C794 (I4_z0_24 VSS) capacitor c=1.787E-15
    I_C795 (I3_o9_0 VSS) capacitor c=8.945E-16
    I_C796 (I3_o9_1 VSS) capacitor c=1.032E-15
    I_C797 (I3_q9_1 VSS) capacitor c=1.373E-15
    I_C798 (I4_z0_4 VSS) capacitor c=1.923E-15
    I_C799 (I3_o8_0 VSS) capacitor c=6.601E-16
    I_C800 (I3_o8_1 VSS) capacitor c=1.028E-15
    I_C801 (I3_q8_1 VSS) capacitor c=1.290E-15
    I_C802 (I4_z0_22 VSS) capacitor c=1.085E-15
    I_C803 (I4_z3_2 VSS) capacitor c=7.081E-16
    I_C804 (I4_z3_3 VSS) capacitor c=9.798E-16
    I_C805 (I4_z4_1 VSS) capacitor c=2.266E-15
    I_C806 (I4_z1_12 VSS) capacitor c=8.741E-16
    I_C807 (I4_z1_13 VSS) capacitor c=1.267E-15
    I_C808 (I4_z2_6 VSS) capacitor c=9.189E-16
    I_C809 (I4_z0_27 VSS) capacitor c=9.269E-16
    I_C810 (I4_z0_26 VSS) capacitor c=1.111E-15
    I_C811 (I3_o1_0 VSS) capacitor c=8.217E-16
    I_C812 (I3_o1_1 VSS) capacitor c=8.421E-16
    I_C813 (I3_q1_1 VSS) capacitor c=9.404E-16
    I_C814 (I4_z0_0 VSS) capacitor c=1.328E-15
    I_C815 (I3_o0_0 VSS) capacitor c=9.226E-16
    I_C816 (I3_o0_1 VSS) capacitor c=9.907E-16
    I_C817 (I3_q0_1 VSS) capacitor c=1.412E-15
    I_C818 (I4_z1_0 VSS) capacitor c=2.047E-15
    I_C819 (I4_z1_1 VSS) capacitor c=9.001E-16
    I_C820 (I4_z2_0 VSS) capacitor c=1.949E-15
    I_C821 (I3_o6_0 VSS) capacitor c=7.167E-16
    I_C822 (I3_o6_1 VSS) capacitor c=8.980E-16
    I_C823 (I3_q6_1 VSS) capacitor c=7.118E-16
    I_C824 (I4_z0_31 VSS) capacitor c=6.623E-16
    I_C825 (I4_z1_14 VSS) capacitor c=9.877E-16
    I_C826 (I4_z1_15 VSS) capacitor c=9.226E-16
    I_C827 (I4_z2_7 VSS) capacitor c=1.444E-15
    I_C828 (I4_z0_28 VSS) capacitor c=1.218E-15
    I_C829 (I3_o4_0 VSS) capacitor c=9.356E-16
    I_C830 (I3_o4_1 VSS) capacitor c=1.021E-15
    I_C831 (I3_q4_1 VSS) capacitor c=1.719E-15
    I_C832 (I4_z0_2 VSS) capacitor c=1.516E-15
    I_C833 (I4_z0_3 VSS) capacitor c=1.263E-15
    I_C834 (I4_z0_30 VSS) capacitor c=2.017E-15
    I_C835 (I4_z0_29 VSS) capacitor c=7.986E-16
    I_C836 (I3_SEL_AND_b3_3 VSS) capacitor c=8.841E-15
    I_C837 (I3_n17_0 VSS) capacitor c=9.434E-16
    I_C838 (I3_SEL_XOR_b3_3 VSS) capacitor c=9.258E-15
    I_C839 (I3_n17_2 VSS) capacitor c=9.336E-16
    I_C840 (I3_SEL_OR_b3_3 VSS) capacitor c=9.904E-15
    I_C841 (I3_n18_1 VSS) capacitor c=6.611E-16
    I_C842 (I3_n18_0 VSS) capacitor c=1.240E-15
    I_C843 (I3_n19_0 VSS) capacitor c=1.277E-15
    I_C844 (I3_n19_1 VSS) capacitor c=6.238E-16
    I_C845 (I3_SEL_DIV_b3_3 VSS) capacitor c=7.768E-15
    I_C846 (I3_n19_5 VSS) capacitor c=9.908E-16
    I_C847 (I3_n20_1 VSS) capacitor c=6.558E-16
    I_C848 (I3_n20_0 VSS) capacitor c=1.159E-15
    I_C849 (I3_q20_2 VSS) capacitor c=1.545E-15
    I_C850 (I3_q21_2 VSS) capacitor c=1.458E-15
    I_C851 (I3_n23_5 VSS) capacitor c=1.029E-15
    I_C852 (I3_n21_2 VSS) capacitor c=1.111E-15
    I_C853 (I3_n21_0 VSS) capacitor c=9.511E-16
    I_C854 (I3_n21_1 VSS) capacitor c=7.233E-16
    I_C855 (I3_q22_2 VSS) capacitor c=1.689E-15
    I_C856 (I3_SEL_AND_b3_4 VSS) capacitor c=6.316E-15
    I_C857 (I3_n22_0 VSS) capacitor c=1.101E-15
    I_C858 (I3_n22_1 VSS) capacitor c=9.981E-16
    I_C859 (I3_SEL_OR_b3_4 VSS) capacitor c=5.828E-15
    I_C860 (I3_n23_0 VSS) capacitor c=1.016E-15
    I_C861 (I3_n23_1 VSS) capacitor c=1.099E-15
    I_C862 (I3_n24_1 VSS) capacitor c=9.870E-16
    I_C863 (I3_n24_0 VSS) capacitor c=1.041E-15
    I_C864 (I3_n25_0 VSS) capacitor c=1.121E-15
    I_C865 (I3_n25_1 VSS) capacitor c=1.089E-15
    I_C866 (I3_n16_1 VSS) capacitor c=6.048E-16
    I_C867 (I3_n17_1 VSS) capacitor c=9.550E-16
    I_C868 (I3_n16_0 VSS) capacitor c=7.459E-16
    I_C869 (I3_n17_3 VSS) capacitor c=7.998E-16
    I_C870 (I3_q16_2 VSS) capacitor c=1.428E-15
    I_C871 (I3_SEL_NOT_b3_3 VSS) capacitor c=8.561E-15
    I_C872 (I3_q17_2 VSS) capacitor c=1.561E-15
    I_C873 (I3_n18_2 VSS) capacitor c=7.658E-16
    I_C874 (I3_n18_3 VSS) capacitor c=1.014E-15
    I_C875 (I3_q18_2 VSS) capacitor c=1.504E-15
    I_C876 (I3_n19_2 VSS) capacitor c=9.375E-16
    I_C877 (I3_n19_3 VSS) capacitor c=7.834E-16
    I_C878 (I3_SEL_MUL_b3_3 VSS) capacitor c=6.389E-15
    I_C879 (I3_n18_4 VSS) capacitor c=9.728E-16
    I_C880 (I3_q19_2 VSS) capacitor c=1.509E-15
    I_C881 (I3_n18_5 VSS) capacitor c=7.970E-16
    I_C882 (I3_n19_4 VSS) capacitor c=1.000E-15
    I_C883 (I3_o19_2 VSS) capacitor c=1.132E-15
    I_C884 (I3_n20_3 VSS) capacitor c=8.880E-16
    I_C885 (I3_n20_2 VSS) capacitor c=9.253E-16
    I_C886 (I3_n20_4 VSS) capacitor c=1.055E-15
    I_C887 (I3_n20_5 VSS) capacitor c=8.138E-16
    I_C888 (I3_o20_2 VSS) capacitor c=9.322E-16
    I_C889 (I3_n21_5 VSS) capacitor c=8.120E-16
    I_C890 (I3_n21_4 VSS) capacitor c=9.156E-16
    I_C891 (I3_o21_2 VSS) capacitor c=9.645E-16
    I_C892 (I3_n22_4 VSS) capacitor c=1.032E-15
    I_C893 (I3_n23_4 VSS) capacitor c=1.003E-15
    I_C894 (I3_o23_2 VSS) capacitor c=1.547E-15
    I_C895 (I3_n22_5 VSS) capacitor c=9.567E-16
    I_C896 (I3_n21_3 VSS) capacitor c=8.412E-16
    I_C897 (I3_q23_2 VSS) capacitor c=8.612E-16
    I_C898 (I3_SEL_XOR_b3_4 VSS) capacitor c=5.588E-15
    I_C899 (I3_n22_2 VSS) capacitor c=1.086E-15
    I_C900 (I3_n22_3 VSS) capacitor c=1.132E-15
    I_C901 (I3_SEL_NOT_b3_4 VSS) capacitor c=5.239E-15
    I_C902 (I3_n23_3 VSS) capacitor c=8.762E-16
    I_C903 (I3_n23_2 VSS) capacitor c=1.105E-15
    I_C904 (I3_n24_2 VSS) capacitor c=8.174E-16
    I_C905 (I3_n24_3 VSS) capacitor c=8.151E-16
    I_C906 (I3_q24_2 VSS) capacitor c=1.872E-15
    I_C907 (I3_n25_2 VSS) capacitor c=1.036E-15
    I_C908 (I3_n26_3 VSS) capacitor c=9.899E-16
    I_C909 (I3_n25_3 VSS) capacitor c=6.376E-16
    I_C910 (I3_n26_1 VSS) capacitor c=9.734E-16
    I_C911 (I3_n17_4 VSS) capacitor c=1.446E-15
    I_C912 (I3_n17_5 VSS) capacitor c=1.079E-15
    I_C913 (I3_o17_2 VSS) capacitor c=1.585E-15
    I_C914 (I3_n16_2 VSS) capacitor c=7.464E-16
    I_C915 (I3_n16_3 VSS) capacitor c=6.389E-16
    I_C916 (I1_I42_gn18 VSS) capacitor c=2.282E-15
    I_C917 (I3_o18_2 VSS) capacitor c=1.011E-15
    I_C918 (I3_o22_2 VSS) capacitor c=1.717E-15
    I_C919 (I1_I42_gn21 VSS) capacitor c=1.734E-15
    I_C920 (I1_I42_gn22 VSS) capacitor c=2.100E-15
    I_C921 (I1_I42_gn24 VSS) capacitor c=1.952E-15
    I_C922 (I3_n26_2 VSS) capacitor c=1.051E-15
    I_C923 (I3_q25_2 VSS) capacitor c=1.045E-15
    I_C924 (I3_n26_0 VSS) capacitor c=9.324E-16
    I_C925 (I3_SEL_MUL_b3_2 VSS) capacitor c=8.065E-15
    I_C926 (I3_SEL_DIV_b3_2 VSS) capacitor c=7.837E-15
    I_C927 (I3_n16_4 VSS) capacitor c=1.038E-15
    I_C928 (I3_n16_5 VSS) capacitor c=6.462E-16
    I_C929 (I3_o16_2 VSS) capacitor c=9.277E-16
    I_C930 (I1_I42_gn16 VSS) capacitor c=2.241E-15
    I_C931 (I1_I42_gn17 VSS) capacitor c=2.535E-15
    I_C932 (I1_I42_gn19 VSS) capacitor c=1.669E-15
    I_C933 (I1_I42_gn20 VSS) capacitor c=2.269E-15
    I_C934 (I1_I42_gn23 VSS) capacitor c=1.325E-15
    I_C935 (I1_I42_gn25 VSS) capacitor c=2.106E-15
    I_C936 (I1_I42_gn26 VSS) capacitor c=2.927E-15
    I_C937 (I3_q26_2 VSS) capacitor c=1.295E-15
    I_C938 (I3_n24_4 VSS) capacitor c=1.019E-15
    I_C939 (I3_n24_5 VSS) capacitor c=1.396E-15
    I_C940 (I3_o24_2 VSS) capacitor c=1.253E-15
    I_C941 (I3_SEL_MUL_b3_4 VSS) capacitor c=6.500E-15
    I_C942 (I3_n25_4 VSS) capacitor c=9.931E-16
    I_C943 (I3_n25_5 VSS) capacitor c=1.654E-15
    I_C944 (I3_o25_2 VSS) capacitor c=1.350E-15
    I_C945 (I3_n15_5 VSS) capacitor c=1.101E-15
    I_C946 (I3_SEL_AND_b3_2 VSS) capacitor c=6.577E-15
    I_C947 (I3_n15_0 VSS) capacitor c=7.401E-16
    I_C948 (I3_n15_4 VSS) capacitor c=9.588E-16
    I_C949 (I3_n15_1 VSS) capacitor c=6.259E-16
    I_C950 (I3_SEL_OR_b3_2 VSS) capacitor c=6.218E-15
    I_C951 (I3_SEL_XOR_b3_2 VSS) capacitor c=6.634E-15
    I_C952 (I3_n15_2 VSS) capacitor c=8.443E-16
    I_C953 (I1_I42_gn15 VSS) capacitor c=1.951E-15
    I_C954 (I1_I42_gn27 VSS) capacitor c=3.081E-15
    I_C955 (I3_SEL_XOR_b3_5 VSS) capacitor c=7.237E-15
    I_C956 (I3_n27_2 VSS) capacitor c=9.931E-16
    I_C957 (I3_n26_4 VSS) capacitor c=9.516E-16
    I_C958 (I3_n26_5 VSS) capacitor c=6.745E-16
    I_C959 (I3_o26_2 VSS) capacitor c=1.597E-15
    I_C960 (I3_SEL_DIV_b3_4 VSS) capacitor c=6.066E-15
    I_C961 (I3_n14_4 VSS) capacitor c=1.089E-15
    I_C962 (I3_o15_2 VSS) capacitor c=2.116E-15
    I_C963 (I3_n14_5 VSS) capacitor c=7.069E-16
    I_C964 (I3_o14_2 VSS) capacitor c=1.961E-15
    I_C965 (I3_q15_2 VSS) capacitor c=1.055E-15
    I_C966 (I3_n14_1 VSS) capacitor c=1.495E-15
    I_C967 (I3_n15_3 VSS) capacitor c=6.963E-16
    I_C968 (I3_SEL_NOT_b3_2 VSS) capacitor c=6.260E-15
    I_C969 (I1_I42_gn14 VSS) capacitor c=1.634E-15
    I_C970 (I1_I42_P26_11n VSS) capacitor c=1.094E-15
    I_C971 (I1_I42_P22_7n VSS) capacitor c=1.238E-15
    I_C972 (I1_I42_P30_15n VSS) capacitor c=9.792E-16
    I_C973 (I3_SEL_NOT_b3_5 VSS) capacitor c=8.362E-15
    I_C974 (I3_n27_3 VSS) capacitor c=6.505E-16
    I_C975 (I3_SEL_AND_b3_5 VSS) capacitor c=8.981E-15
    I_C976 (I3_n27_0 VSS) capacitor c=7.904E-16
    I_C977 (I3_n27_1 VSS) capacitor c=8.696E-16
    I_C978 (I3_q27_2 VSS) capacitor c=8.598E-16
    I_C979 (I3_n27_4 VSS) capacitor c=8.295E-16
    I_C980 (I3_n27_5 VSS) capacitor c=6.533E-16
    I_C981 (I3_o27_2 VSS) capacitor c=9.351E-16
    I_C982 (I3_n13_4 VSS) capacitor c=1.176E-15
    I_C983 (I3_n14_0 VSS) capacitor c=1.272E-15
    I_C984 (I3_n13_5 VSS) capacitor c=1.068E-15
    I_C985 (I3_q14_2 VSS) capacitor c=9.694E-16
    I_C986 (I3_n14_2 VSS) capacitor c=9.696E-16
    I_C987 (I3_n14_3 VSS) capacitor c=6.558E-16
    I_C988 (I1_I42_P20_5n VSS) capacitor c=1.044E-15
    I_C989 (I1_I42_P28_13n VSS) capacitor c=8.816E-16
    I_C990 (I1_I42_gn28 VSS) capacitor c=2.294E-15
    I_C991 (I3_n28_2 VSS) capacitor c=9.480E-16
    I_C992 (I3_n28_3 VSS) capacitor c=1.171E-15
    I_C993 (I3_SEL_OR_b3_5 VSS) capacitor c=6.790E-15
    I_C994 (I3_n28_0 VSS) capacitor c=1.160E-15
    I_C995 (I3_n28_1 VSS) capacitor c=6.827E-16
    I_C996 (I3_q28_2 VSS) capacitor c=6.800E-16
    I_C997 (I3_n28_4 VSS) capacitor c=8.764E-16
    I_C998 (I3_n28_5 VSS) capacitor c=9.133E-16
    I_C999 (I3_o28_2 VSS) capacitor c=1.005E-15
    I_C1000 (I3_n12_4 VSS) capacitor c=9.908E-16
    I_C1001 (I3_n12_5 VSS) capacitor c=6.944E-16
    I_C1002 (I3_n13_0 VSS) capacitor c=1.218E-15
    I_C1003 (I3_o12_2 VSS) capacitor c=1.706E-15
    I_C1004 (I3_o13_2 VSS) capacitor c=1.025E-15
    I_C1005 (I3_n13_1 VSS) capacitor c=1.075E-15
    I_C1006 (I3_q13_2 VSS) capacitor c=1.646E-15
    I_C1007 (I3_n13_2 VSS) capacitor c=9.451E-16
    I_C1008 (I3_n13_3 VSS) capacitor c=1.287E-15
    I_C1009 (I1_I42_P18_3n VSS) capacitor c=9.139E-16
    I_C1010 (I1_I42_P27_12n VSS) capacitor c=1.168E-15
    I_C1011 (I1_I42_P23_8n VSS) capacitor c=1.140E-15
    I_C1012 (I1_I42_P31_16n VSS) capacitor c=8.988E-16
    I_C1013 (I1_I42_gn29 VSS) capacitor c=1.280E-15
    I_C1014 (I3_n29_2 VSS) capacitor c=1.122E-15
    I_C1015 (I3_n29_3 VSS) capacitor c=6.578E-16
    I_C1016 (I3_q29_2 VSS) capacitor c=7.552E-16
    I_C1017 (I3_n29_0 VSS) capacitor c=8.465E-16
    I_C1018 (I3_n29_1 VSS) capacitor c=1.267E-15
    I_C1019 (I3_n29_4 VSS) capacitor c=1.361E-15
    I_C1020 (I3_n29_5 VSS) capacitor c=8.338E-16
    I_C1021 (I3_o29_2 VSS) capacitor c=1.793E-15
    I_C1022 (I3_q12_2 VSS) capacitor c=1.022E-15
    I_C1023 (I3_n12_2 VSS) capacitor c=9.976E-16
    I_C1024 (I3_n12_3 VSS) capacitor c=6.466E-16
    I_C1025 (I1_I42_gn12 VSS) capacitor c=2.273E-15
    I_C1026 (I1_I42_gn13 VSS) capacitor c=1.719E-15
    I_C1027 (I1_I42_P24_9n VSS) capacitor c=1.011E-15
    I_C1028 (I1_I42_P19_4n VSS) capacitor c=8.644E-16
    I_C1029 (I1_I42_P29_14n VSS) capacitor c=1.164E-15
    I_C1030 (I1_I42_gn31 VSS) capacitor c=6.851E-16
    I_C1031 (I3_n31_0 VSS) capacitor c=9.558E-16
    I_C1032 (I3_n31_1 VSS) capacitor c=9.673E-16
    I_C1033 (I3_n30_0 VSS) capacitor c=1.014E-15
    I_C1034 (I3_n30_1 VSS) capacitor c=8.448E-16
    I_C1035 (I3_n12_0 VSS) capacitor c=9.698E-16
    I_C1036 (I3_n12_1 VSS) capacitor c=1.040E-15
    I_C1037 (I1_I42_gn11 VSS) capacitor c=4.208E-15
    I_C1038 (I1_I42_P16_1n VSS) capacitor c=1.211E-15
    I_C1039 (I1_I42_P21_6n VSS) capacitor c=1.416E-15
    I_C1040 (I1_I42_P25_10n VSS) capacitor c=1.256E-15
    I_C1041 (I1_I42_gn30 VSS) capacitor c=2.391E-15
    I_C1042 (I3_n31_2 VSS) capacitor c=1.041E-15
    I_C1043 (I3_n31_3 VSS) capacitor c=6.413E-16
    I_C1044 (I3_n30_3 VSS) capacitor c=6.734E-16
    I_C1045 (I3_n30_2 VSS) capacitor c=1.131E-15
    I_C1046 (I3_q31_2 VSS) capacitor c=1.256E-15
    I_C1047 (I3_q30_2 VSS) capacitor c=7.207E-16
    I_C1048 (I3_n11_2 VSS) capacitor c=1.309E-15
    I_C1049 (I3_n11_3 VSS) capacitor c=1.138E-15
    I_C1050 (I3_n11_1 VSS) capacitor c=1.091E-15
    I_C1051 (I3_n11_0 VSS) capacitor c=1.098E-15
    I_C1052 (I3_q11_2 VSS) capacitor c=6.504E-16
    I_C1053 (I1_I42_P17_2n VSS) capacitor c=1.144E-15
    I_C1054 (I4_v1 VSS) capacitor c=2.396E-15
    I_C1055 (I4_v2 VSS) capacitor c=8.769E-16
    I_C1056 (I3_SEL_DIV_b3_5 VSS) capacitor c=3.665E-15
    I_C1057 (I3_hd32 VSS) capacitor c=8.630E-16
    I_C1058 (I3_n31_4 VSS) capacitor c=9.542E-16
    I_C1059 (I3_n31_5 VSS) capacitor c=7.736E-16
    I_C1060 (I3_o31_2 VSS) capacitor c=8.323E-16
    I_C1061 (I3_hd33 VSS) capacitor c=8.830E-16
    I_C1062 (I3_SEL_MUL_b3_5 VSS) capacitor c=4.414E-15
    I_C1063 (I3_n30_4 VSS) capacitor c=8.429E-16
    I_C1064 (I3_n30_5 VSS) capacitor c=6.310E-16
    I_C1065 (I3_o30_2 VSS) capacitor c=1.189E-15
    I_C1066 (I3_hm34 VSS) capacitor c=1.126E-15
    I_C1067 (I3_hd34 VSS) capacitor c=1.543E-15
    I_C1068 (I1_I42_gn3 VSS) capacitor c=2.994E-15
    I_C1069 (I3_hm32 VSS) capacitor c=8.393E-16
    I_C1070 (I3_hm35 VSS) capacitor c=8.886E-16
    I_C1071 (I3_hd35 VSS) capacitor c=8.251E-16
    I_C1072 (I3_hm33 VSS) capacitor c=7.804E-16
    I_C1073 (I3_SEL_DIV_b3_6 VSS) capacitor c=4.868E-15
    I_C1074 (I3_hm37 VSS) capacitor c=9.342E-16
    I_C1075 (I3_hd37 VSS) capacitor c=9.469E-16
    I_C1076 (I3_SEL_MUL_b3_6 VSS) capacitor c=5.491E-15
    I_C1077 (I3_hm36 VSS) capacitor c=8.192E-16
    I_C1078 (I3_hd36 VSS) capacitor c=6.424E-16
    I_C1079 (I3_SEL_AND_b3_0 VSS) capacitor c=9.625E-15
    I_C1080 (I3_n3_0 VSS) capacitor c=7.677E-16
    I_C1081 (I3_n3_1 VSS) capacitor c=6.582E-16
    I_C1082 (I3_SEL_OR_b3_0 VSS) capacitor c=1.143E-14
    I_C1083 (I3_SEL_DIV_b3_0 VSS) capacitor c=6.311E-15
    I_C1084 (I3_n4_5 VSS) capacitor c=9.154E-16
    I_C1085 (I3_SEL_MUL_b3_0 VSS) capacitor c=6.211E-15
    I_C1086 (I3_n4_4 VSS) capacitor c=1.005E-15
    I_C1087 (I3_o4_2 VSS) capacitor c=2.062E-15
    I_C1088 (I3_n5_5 VSS) capacitor c=8.131E-16
    I_C1089 (I1_I42_gn2 VSS) capacitor c=2.108E-15
    I_C1090 (I3_n5_4 VSS) capacitor c=1.413E-15
    I_C1091 (I3_o5_2 VSS) capacitor c=2.107E-15
    I_C1092 (I1_I42_gn5 VSS) capacitor c=1.424E-15
    I_C1093 (I1_I42_gn10 VSS) capacitor c=4.078E-15
    I_C1094 (I3_hm38 VSS) capacitor c=1.283E-15
    I_C1095 (I3_hd38 VSS) capacitor c=1.056E-15
    I_C1096 (I3_hm40 VSS) capacitor c=9.446E-16
    I_C1097 (I3_hd40 VSS) capacitor c=9.231E-16
    I_C1098 (I3_hm39 VSS) capacitor c=9.506E-16
    I_C1099 (I3_hd39 VSS) capacitor c=8.661E-16
    I_C1100 (I3_SEL_XOR_b3_0 VSS) capacitor c=9.414E-15
    I_C1101 (I3_n3_2 VSS) capacitor c=8.684E-16
    I_C1102 (I3_n3_3 VSS) capacitor c=6.938E-16
    I_C1103 (I3_q3_2 VSS) capacitor c=1.726E-15
    I_C1104 (I3_SEL_NOT_b3_0 VSS) capacitor c=7.948E-15
    I_C1105 (I3_n3_5 VSS) capacitor c=8.713E-16
    I_C1106 (I3_n2_5 VSS) capacitor c=1.267E-15
    I_C1107 (I3_n3_4 VSS) capacitor c=1.152E-15
    I_C1108 (I3_n2_4 VSS) capacitor c=8.935E-16
    I_C1109 (I3_o3_2 VSS) capacitor c=9.441E-16
    I_C1110 (I3_o2_2 VSS) capacitor c=1.133E-15
    I_C1111 (I3_n5_0 VSS) capacitor c=9.445E-16
    I_C1112 (I3_n5_1 VSS) capacitor c=8.869E-16
    I_C1113 (I1_I42_gn6 VSS) capacitor c=1.694E-15
    I_C1114 (I1_I42_gn7 VSS) capacitor c=1.466E-15
    I_C1115 (I1_I42_gn9 VSS) capacitor c=1.887E-15
    I_C1116 (I1_I42_gn8 VSS) capacitor c=3.441E-15
    I_C1117 (I3_n10_0 VSS) capacitor c=9.907E-16
    I_C1118 (I3_n10_1 VSS) capacitor c=6.250E-16
    I_C1119 (I3_SEL_OR_b3_1 VSS) capacitor c=7.423E-15
    I_C1120 (I3_SEL_AND_b3_1 VSS) capacitor c=9.122E-15
    I_C1121 (I3_hm41 VSS) capacitor c=1.129E-15
    I_C1122 (I3_hd41 VSS) capacitor c=1.239E-15
    I_C1123 (I3_SEL_DIV_b3_7 VSS) capacitor c=5.060E-15
    I_C1124 (I3_SEL_MUL_b3_7 VSS) capacitor c=6.372E-15
    I_C1125 (I3_SEL_DIV_b3_8 VSS) capacitor c=6.267E-15
    I_C1126 (I3_hd51 VSS) capacitor c=9.134E-16
    I_C1127 (I3_hm51 VSS) capacitor c=1.052E-15
    I_C1128 (I3_hd50 VSS) capacitor c=9.451E-16
    I_C1129 (I3_hd49 VSS) capacitor c=6.617E-16
    I_C1130 (I3_SEL_MUL_b3_8 VSS) capacitor c=6.119E-15
    I_C1131 (I3_hm49 VSS) capacitor c=9.670E-16
    I_C1132 (I3_hm48 VSS) capacitor c=9.546E-16
    I_C1133 (I3_hd48 VSS) capacitor c=8.092E-16
    I_C1134 (I3_n2_2 VSS) capacitor c=1.311E-15
    I_C1135 (I3_q2_2 VSS) capacitor c=1.942E-15
    I_C1136 (I3_n1_4 VSS) capacitor c=1.130E-15
    I_C1137 (I3_n2_3 VSS) capacitor c=6.936E-16
    I_C1138 (I3_n1_5 VSS) capacitor c=6.065E-16
    I_C1139 (I3_o1_2 VSS) capacitor c=1.657E-15
    I_C1140 (I1_I42_gn4 VSS) capacitor c=5.010E-15
    I_C1141 (I3_n0_4 VSS) capacitor c=9.414E-16
    I_C1142 (I3_n0_5 VSS) capacitor c=7.521E-16
    I_C1143 (I3_o0_2 VSS) capacitor c=8.565E-16
    I_C1144 (I3_n5_2 VSS) capacitor c=7.268E-16
    I_C1145 (I3_n5_3 VSS) capacitor c=7.153E-16
    I_C1146 (I3_q5_2 VSS) capacitor c=1.929E-15
    I_C1147 (I3_n7_1 VSS) capacitor c=6.635E-16
    I_C1148 (I3_n7_0 VSS) capacitor c=8.398E-16
    I_C1149 (I3_SEL_XOR_b3_1 VSS) capacitor c=7.323E-15
    I_C1150 (I3_n7_2 VSS) capacitor c=9.578E-16
    I_C1151 (I3_n7_3 VSS) capacitor c=6.502E-16
    I_C1152 (I3_SEL_NOT_b3_1 VSS) capacitor c=7.428E-15
    I_C1153 (I3_n9_3 VSS) capacitor c=9.805E-16
    I_C1154 (I3_n11_4 VSS) capacitor c=8.365E-16
    I_C1155 (I3_n11_5 VSS) capacitor c=1.839E-15
    I_C1156 (I3_o11_2 VSS) capacitor c=5.341E-15
    I_C1157 (I3_SEL_MUL_b3_1 VSS) capacitor c=7.610E-15
    I_C1158 (I3_q10_2 VSS) capacitor c=1.070E-15
    I_C1159 (I3_n10_3 VSS) capacitor c=1.108E-15
    I_C1160 (I3_n10_2 VSS) capacitor c=8.841E-16
    I_C1161 (I3_hd43 VSS) capacitor c=6.441E-16
    I_C1162 (I3_hm43 VSS) capacitor c=8.774E-16
    I_C1163 (I3_hm46 VSS) capacitor c=1.241E-15
    I_C1164 (I3_hd46 VSS) capacitor c=8.116E-16
    I_C1165 (I3_hm50 VSS) capacitor c=9.523E-16
    I_C1166 (I3_hm47 VSS) capacitor c=8.440E-16
    I_C1167 (I3_hd47 VSS) capacitor c=8.542E-16
    I_C1168 (I3_hm52 VSS) capacitor c=1.632E-15
    I_C1169 (I3_hd52 VSS) capacitor c=1.028E-15
    I_C1170 (I3_n2_0 VSS) capacitor c=8.184E-16
    I_C1171 (I3_n2_1 VSS) capacitor c=9.849E-16
    I_C1172 (I3_n4_3 VSS) capacitor c=1.278E-15
    I_C1173 (I3_n1_2 VSS) capacitor c=9.326E-16
    I_C1174 (I3_n1_3 VSS) capacitor c=1.487E-15
    I_C1175 (I1_I42_gn1 VSS) capacitor c=4.347E-15
    I_C1176 (I3_q0_2 VSS) capacitor c=1.524E-15
    I_C1177 (I1_I42_gn0 VSS) capacitor c=9.960E-16
    I_C1178 (I3_n6_3 VSS) capacitor c=1.250E-15
    I_C1179 (I3_n6_2 VSS) capacitor c=1.292E-15
    I_C1180 (I3_q7_2 VSS) capacitor c=1.232E-15
    I_C1181 (I3_n9_2 VSS) capacitor c=7.881E-16
    I_C1182 (I3_SEL_DIV_b3_1 VSS) capacitor c=6.590E-15
    I_C1183 (I3_q9_2 VSS) capacitor c=6.925E-16
    I_C1184 (I3_q8_2 VSS) capacitor c=9.734E-16
    I_C1185 (I3_n8_0 VSS) capacitor c=1.136E-15
    I_C1186 (I3_n8_3 VSS) capacitor c=9.428E-16
    I_C1187 (I3_n8_2 VSS) capacitor c=1.063E-15
    I_C1188 (I3_n8_1 VSS) capacitor c=8.185E-16
    I_C1189 (I3_hm44 VSS) capacitor c=1.174E-15
    I_C1190 (I3_hd42 VSS) capacitor c=1.066E-15
    I_C1191 (I3_hd44 VSS) capacitor c=9.947E-16
    I_C1192 (I3_hm42 VSS) capacitor c=1.827E-15
    I_C1193 (I3_hd45 VSS) capacitor c=8.842E-16
    I_C1194 (I3_hm45 VSS) capacitor c=9.967E-16
    I_C1195 (I3_hm53 VSS) capacitor c=8.669E-16
    I_C1196 (I3_hd53 VSS) capacitor c=7.996E-16
    I_C1197 (I3_SEL_MUL_b3_9 VSS) capacitor c=5.165E-15
    I_C1198 (I3_SEL_DIV_b3_9 VSS) capacitor c=4.961E-15
    I_C1199 (I3_n4_0 VSS) capacitor c=1.101E-15
    I_C1200 (I3_n4_2 VSS) capacitor c=7.923E-16
    I_C1201 (I3_n1_1 VSS) capacitor c=6.403E-16
    I_C1202 (I3_n1_0 VSS) capacitor c=7.442E-16
    I_C1203 (I3_q1_2 VSS) capacitor c=1.898E-15
    I_C1204 (I3_n0_0 VSS) capacitor c=8.251E-16
    I_C1205 (I3_n0_1 VSS) capacitor c=9.538E-16
    I_C1206 (I3_n0_2 VSS) capacitor c=1.248E-15
    I_C1207 (I3_n0_3 VSS) capacitor c=6.083E-16
    I_C1208 (I3_n6_1 VSS) capacitor c=6.454E-16
    I_C1209 (I3_n6_0 VSS) capacitor c=9.614E-16
    I_C1210 (I3_q6_2 VSS) capacitor c=1.513E-15
    I_C1211 (I3_n9_1 VSS) capacitor c=1.120E-15
    I_C1212 (I3_n9_0 VSS) capacitor c=1.621E-15
    I_C1213 (I3_n7_4 VSS) capacitor c=9.992E-16
    I_C1214 (I3_n7_5 VSS) capacitor c=1.227E-15
    I_C1215 (I3_o7_2 VSS) capacitor c=1.669E-15
    I_C1216 (I3_n6_4 VSS) capacitor c=1.124E-15
    I_C1217 (I3_n6_5 VSS) capacitor c=6.310E-16
    I_C1218 (I3_o6_2 VSS) capacitor c=1.135E-15
    I_C1219 (I3_n9_4 VSS) capacitor c=9.090E-16
    I_C1220 (I3_n9_5 VSS) capacitor c=8.284E-16
    I_C1221 (I3_o9_2 VSS) capacitor c=1.818E-15
    I_C1222 (I3_n8_4 VSS) capacitor c=7.528E-16
    I_C1223 (I3_n8_5 VSS) capacitor c=8.734E-16
    I_C1224 (I3_o8_2 VSS) capacitor c=1.240E-15
    I_C1225 (I3_SEL_MUL_b3_10 VSS) capacitor c=4.377E-15
    I_C1226 (I3_hm61 VSS) capacitor c=9.549E-16
    I_C1227 (I3_SEL_DIV_b3_10 VSS) capacitor c=4.938E-15
    I_C1228 (I3_hd61 VSS) capacitor c=9.046E-16
    I_C1229 (I3_hd63 VSS) capacitor c=8.466E-16
    I_C1230 (I3_hm63 VSS) capacitor c=8.675E-16
    I_C1231 (I3_hm62 VSS) capacitor c=8.986E-16
    I_C1232 (I3_hd62 VSS) capacitor c=8.485E-16
    I_C1233 (I3_hm59 VSS) capacitor c=1.081E-15
    I_C1234 (I3_hm56 VSS) capacitor c=9.069E-16
    I_C1235 (I3_hd56 VSS) capacitor c=1.115E-15
    I_C1236 (I3_hd55 VSS) capacitor c=7.129E-16
    I_C1237 (I3_hm57 VSS) capacitor c=1.145E-15
    I_C1238 (I3_hd57 VSS) capacitor c=6.686E-16
    I_C1239 (I3_hm55 VSS) capacitor c=8.118E-16
    I_C1240 (I3_hm54 VSS) capacitor c=9.866E-16
    I_C1241 (I3_hd54 VSS) capacitor c=8.713E-16
    I_C1242 (I3_n4_1 VSS) capacitor c=6.324E-16
    I_C1243 (I3_q4_2 VSS) capacitor c=2.900E-15
    I_C1244 (I3_n10_5 VSS) capacitor c=6.328E-16
    I_C1245 (I3_n10_4 VSS) capacitor c=7.084E-16
    I_C1246 (I3_o10_2 VSS) capacitor c=2.671E-15
    I_C1247 (I3_hm60 VSS) capacitor c=1.187E-15
    I_C1248 (I3_hd60 VSS) capacitor c=6.313E-16
    I_C1249 (I3_hd59 VSS) capacitor c=7.141E-16
    I_C1250 (I3_hm58 VSS) capacitor c=7.821E-16
    I_C1251 (I3_hd58 VSS) capacitor c=6.479E-16
    I_C1252 (I1_I42_G18_17 VSS) capacitor c=1.860E-15
    I_C1253 (I1_I42_G19_18 VSS) capacitor c=4.927E-15
    I_C1254 (I1_I42_G20_19 VSS) capacitor c=2.936E-15
    I_C1255 (I1_I42_G21_20 VSS) capacitor c=3.049E-15
    I_C1256 (I1_I42_G22_21 VSS) capacitor c=2.696E-15
    I_C1257 (I1_I42_G23_22 VSS) capacitor c=2.850E-15
    I_C1258 (I1_I42_G24_23 VSS) capacitor c=3.373E-15
    I_C1259 (I1_I42_G25_24 VSS) capacitor c=3.073E-15
    I_C1260 (I1_I42_G26_25 VSS) capacitor c=2.746E-15
    I_C1261 (I1_I42_G16_15 VSS) capacitor c=1.976E-15
    I_C1262 (I1_I42_G17_16 VSS) capacitor c=5.884E-15
    I_C1263 (I1_I42_G18_15n VSS) capacitor c=5.786E-15
    I_C1264 (I1_I42_G22_19n VSS) capacitor c=1.833E-15
    I_C1265 (I1_I42_G22_15 VSS) capacitor c=3.574E-15
    I_C1266 (I1_I42_G26_23n VSS) capacitor c=4.777E-15
    I_C1267 (I1_I42_G26_19 VSS) capacitor c=2.133E-15
    I_C1268 (I1_I42_G27_26 VSS) capacitor c=3.659E-15
    I_C1269 (I1_I42_G15_14 VSS) capacitor c=4.166E-15
    I_C1270 (I1_I42_G16_13n VSS) capacitor c=2.477E-15
    I_C1271 (I1_I42_G20_17n VSS) capacitor c=2.030E-15
    I_C1272 (I1_I42_G20_13 VSS) capacitor c=2.798E-15
    I_C1273 (I1_I42_G24_21n VSS) capacitor c=5.346E-15
    I_C1274 (I1_I42_G24_17 VSS) capacitor c=2.392E-15
    I_C1275 (I1_I42_G14_11n VSS) capacitor c=2.101E-15
    I_C1276 (I1_I42_G18_11 VSS) capacitor c=3.359E-15
    I_C1277 (I1_I42_G26_11n VSS) capacitor c=1.258E-15
    I_C1278 (I1_I42_G26_0 VSS) capacitor c=5.640E-15
    I_C1279 (I1_I42_G22_7n VSS) capacitor c=9.159E-16
    I_C1280 (I1_I42_G22_0 VSS) capacitor c=3.666E-15
    I_C1281 (I1_I42_G28_25n VSS) capacitor c=2.855E-15
    I_C1282 (I1_I42_G28_21 VSS) capacitor c=2.665E-15
    I_C1283 (I1_I42_G30_15n VSS) capacitor c=1.059E-15
    I_C1284 (I1_I42_G30_27n VSS) capacitor c=2.033E-15
    I_C1285 (I1_I42_G30_23 VSS) capacitor c=1.827E-15
    I_C1286 (I1_I42_G28_27 VSS) capacitor c=2.073E-15
    I_C1287 (I1_I42_G14_13 VSS) capacitor c=2.532E-15
    I_C1288 (I1_I42_G20_5n VSS) capacitor c=9.049E-16
    I_C1289 (I1_I42_G20_0 VSS) capacitor c=4.070E-15
    I_C1290 (I1_I42_G10_7n VSS) capacitor c=4.756E-15
    I_C1291 (I1_I42_G14_7 VSS) capacitor c=3.089E-15
    I_C1292 (I1_I42_G15_12n VSS) capacitor c=2.410E-15
    I_C1293 (I1_I42_G19_16n VSS) capacitor c=2.248E-15
    I_C1294 (I1_I42_G19_12 VSS) capacitor c=3.377E-15
    I_C1295 (I1_I42_G23_20n VSS) capacitor c=1.647E-15
    I_C1296 (I1_I42_G23_16 VSS) capacitor c=1.700E-15
    I_C1297 (I1_I42_G27_24n VSS) capacitor c=2.423E-15
    I_C1298 (I1_I42_G27_20 VSS) capacitor c=1.783E-15
    I_C1299 (I1_I42_G12_9n VSS) capacitor c=2.266E-15
    I_C1300 (I1_I42_G16_9 VSS) capacitor c=3.211E-15
    I_C1301 (I1_I42_G18_3n VSS) capacitor c=8.709E-16
    I_C1302 (I1_I42_G18_0 VSS) capacitor c=3.369E-15
    I_C1303 (I1_I42_G28_13n VSS) capacitor c=1.157E-15
    I_C1304 (I1_I42_G28_0 VSS) capacitor c=5.287E-15
    I_C1305 (I1_I42_G19_4n VSS) capacitor c=9.658E-16
    I_C1306 (I1_I42_G19_0 VSS) capacitor c=4.046E-15
    I_C1307 (I1_I42_G11_8n VSS) capacitor c=2.589E-15
    I_C1308 (I1_I42_G15_8 VSS) capacitor c=2.654E-15
    I_C1309 (I1_I42_G27_12n VSS) capacitor c=9.828E-16
    I_C1310 (I1_I42_G27_0 VSS) capacitor c=3.550E-15
    I_C1311 (I1_I42_G23_8n VSS) capacitor c=8.985E-16
    I_C1312 (I1_I42_G23_0 VSS) capacitor c=3.801E-15
    I_C1313 (I1_I42_G31_16n VSS) capacitor c=8.749E-16
    I_C1314 (I1_I42_G31_28n VSS) capacitor c=1.111E-15
    I_C1315 (I1_I42_G31_24 VSS) capacitor c=1.360E-15
    I_C1316 (I1_I42_G25_22n VSS) capacitor c=4.357E-15
    I_C1317 (I1_I42_G29_26n VSS) capacitor c=1.296E-15
    I_C1318 (I1_I42_G29_22 VSS) capacitor c=1.464E-15
    I_C1319 (I1_I42_G30_29 VSS) capacitor c=2.429E-15
    I_C1320 (I1_I42_G29_28 VSS) capacitor c=2.208E-15
    I_C1321 (I1_I42_G13_12 VSS) capacitor c=5.438E-15
    I_C1322 (I1_I42_G12_11 VSS) capacitor c=3.138E-15
    I_C1323 (I1_I42_G8_5n VSS) capacitor c=3.983E-15
    I_C1324 (I1_I42_G12_5 VSS) capacitor c=3.015E-15
    I_C1325 (I1_I42_G24_9n VSS) capacitor c=9.049E-16
    I_C1326 (I1_I42_G24_0 VSS) capacitor c=5.666E-15
    I_C1327 (I1_I42_G6_3n VSS) capacitor c=2.353E-15
    I_C1328 (I1_I42_G10_3 VSS) capacitor c=2.559E-15
    I_C1329 (I1_I42_G13_10n VSS) capacitor c=2.173E-15
    I_C1330 (I1_I42_G17_14n VSS) capacitor c=3.170E-15
    I_C1331 (I1_I42_G17_10 VSS) capacitor c=4.263E-15
    I_C1332 (I1_I42_G21_18n VSS) capacitor c=3.320E-15
    I_C1333 (I1_I42_G21_14 VSS) capacitor c=2.863E-15
    I_C1334 (I1_I42_G25_18 VSS) capacitor c=1.676E-15
    I_C1335 (I1_I42_G31_30 VSS) capacitor c=1.618E-15
    I_C1336 (I1_I42_G16_1n VSS) capacitor c=1.604E-15
    I_C1337 (I1_I42_G16_0 VSS) capacitor c=4.670E-15
    I_C1338 (I1_I42_G11_10 VSS) capacitor c=1.835E-15
    I_C1339 (I1_I42_G7_4n VSS) capacitor c=2.036E-15
    I_C1340 (I1_I42_G11_4 VSS) capacitor c=2.379E-15
    I_C1341 (I1_I42_G9_6n VSS) capacitor c=2.369E-15
    I_C1342 (I1_I42_G13_6 VSS) capacitor c=2.278E-15
    I_C1343 (I1_I42_G21_6n VSS) capacitor c=1.135E-15
    I_C1344 (I1_I42_G21_0 VSS) capacitor c=3.563E-15
    I_C1345 (I1_I42_G25_10n VSS) capacitor c=8.428E-16
    I_C1346 (I1_I42_G25_0 VSS) capacitor c=5.445E-15
    I_C1347 (I1_I42_G29_14n VSS) capacitor c=9.372E-16
    I_C1348 (I1_I42_G29_0 VSS) capacitor c=1.864E-15
    I_C1349 (I1_I42_G4_1n VSS) capacitor c=1.641E-15
    I_C1350 (I1_I42_G8_1 VSS) capacitor c=1.752E-15
    I_C1351 (I1_I42_G17_2n VSS) capacitor c=1.112E-15
    I_C1352 (I1_I42_G17_0 VSS) capacitor c=7.188E-15
    I_C1353 (I1_I42_G2_1 VSS) capacitor c=2.262E-15
    I_C1354 (I1_I42_G3_2 VSS) capacitor c=3.144E-15
    I_C1355 (I1_I42_G10_9 VSS) capacitor c=5.051E-15
    I_C1356 (I1_I42_G5_2n VSS) capacitor c=3.273E-15
    I_C1357 (I1_I42_G9_2 VSS) capacitor c=2.071E-15
    I_C1358 (I1_I42_G4_3 VSS) capacitor c=2.512E-15
    I_C1359 (I1_I42_G5_4 VSS) capacitor c=2.869E-15
    I_C1360 (I1_I42_G6_5 VSS) capacitor c=1.770E-15
    I_C1361 (I1_I42_G7_6 VSS) capacitor c=3.045E-15
    I_C1362 (I1_I42_G8_7 VSS) capacitor c=3.074E-15
    I_C1363 (I1_I42_G9_8 VSS) capacitor c=2.451E-15
    I_C1364 (I1_I42_pn0 VSS) capacitor c=3.267E-15
    I_C1365 (I3_SEL_AS_b3_4 VSS) capacitor c=6.953E-15
    I_C1366 (S_23 VSS) capacitor c=5.268E-15
    I_C1367 (I3_SEL_AS_b3_3 VSS) capacitor c=7.700E-15
    I_C1368 (S_17 VSS) capacitor c=1.692E-15
    I_C1369 (S_18 VSS) capacitor c=1.603E-15
    I_C1370 (S_19 VSS) capacitor c=1.839E-15
    I_C1371 (S_20 VSS) capacitor c=1.492E-15
    I_C1372 (S_21 VSS) capacitor c=1.326E-15
    I_C1373 (S_22 VSS) capacitor c=1.604E-15
    I_C1374 (S_24 VSS) capacitor c=4.010E-15
    I_C1375 (S_26 VSS) capacitor c=2.537E-15
    I_C1376 (S_25 VSS) capacitor c=2.328E-15
    I_C1377 (I3_SEL_AS_b3_2 VSS) capacitor c=7.761E-15
    I_C1378 (I3_SEL_AS_b3_5 VSS) capacitor c=7.579E-15
    I_C1379 (S_27 VSS) capacitor c=2.206E-15
    I_C1380 (S_28 VSS) capacitor c=2.143E-15
    I_C1381 (S_29 VSS) capacitor c=2.132E-15
    I_C1382 (S_31 VSS) capacitor c=3.427E-15
    I_C1383 (S_30 VSS) capacitor c=3.228E-15
    I_C1384 (I3_SEL_AS_b3_0 VSS) capacitor c=7.039E-15
    I_C1385 (S_5 VSS) capacitor c=9.061E-16
    I_C1386 (S_2 VSS) capacitor c=2.401E-15
    I_C1387 (S_1 VSS) capacitor c=1.441E-15
    I_C1388 (S_0 VSS) capacitor c=1.932E-15
    I_C1389 (I3_SEL_AS_b3_1 VSS) capacitor c=5.985E-15
    I_C1390 (S_6 VSS) capacitor c=3.175E-15
    I_C1391 (S_7 VSS) capacitor c=2.223E-15
    I_C1392 (S_8 VSS) capacitor c=3.247E-15
    I_C1393 (I3_SEL_OR_b2_1 VSS) capacitor c=8.612E-15
    I_C1394 (I3_SEL_AND_b2_1 VSS) capacitor c=8.057E-15
    I_C1395 (I3_SEL_MUL_b2_0 VSS) capacitor c=2.360E-14
    I_C1396 (I3_SEL_XOR_b2_1 VSS) capacitor c=8.252E-15
    I_C1397 (I1_SUB_b2_1 VSS) capacitor c=6.869E-15
    I_C1398 (I3_SEL_NOT_b2_1 VSS) capacitor c=9.010E-15
    I_C1399 (I3_SEL_AS_b2_1 VSS) capacitor c=6.762E-15
    I_C1400 (I3_SEL_DIV_b2_0 VSS) capacitor c=1.950E-14
    I_C1401 (I3_SEL_OR_b1_0 VSS) capacitor c=3.938E-15
    I_C1402 (I3_SEL_MUL_b2_1 VSS) capacitor c=4.703E-15
    I_C1403 (I3_SEL_AS_b1_0 VSS) capacitor c=2.273E-15
    I_C1404 (I3_SEL_AND_b1_0 VSS) capacitor c=2.464E-15
    I_C1405 (I3_SEL_DIV_b2_1 VSS) capacitor c=6.369E-15
    I_C1406 (I3_SEL_AND_b2_0 VSS) capacitor c=9.794E-15
    I_C1407 (I3_SEL_OR_b2_0 VSS) capacitor c=1.000E-14
    I_C1408 (I1_SUB_b2_0 VSS) capacitor c=8.811E-15
    I_C1409 (I3_SEL_AS_b2_0 VSS) capacitor c=7.972E-15
    I_C1410 (I1_SUB_b1_0 VSS) capacitor c=2.527E-15
    I_C1411 (I3_SEL_XOR_b1_0 VSS) capacitor c=2.474E-15
    I_C1412 (I3_SEL_NOT_b1_0 VSS) capacitor c=2.601E-15
    I_C1413 (I3_SEL_NOT_b2_0 VSS) capacitor c=9.886E-15
    I_C1414 (I3_SEL_XOR_b2_0 VSS) capacitor c=1.002E-14
    I_C1415 (I3_SEL_MUL_b1_0 VSS) capacitor c=3.045E-15
    I_C1416 (I3_SEL_DIV_b1_0 VSS) capacitor c=2.744E-15
    I_C1417 (I3_SEL_DIV_b2_2 VSS) capacitor c=3.673E-15
    I_C1418 (I3_SEL_MUL_b2_2 VSS) capacitor c=4.246E-15
    I_C1419 (XI1_I42_I203_p1 VSS) capacitor c=5.140E-16
    I_C1420 (XI1_I42_I203_n2 VSS) capacitor c=7.396E-18
    I_C1421 (XI1_I42_I203_Bn VSS) capacitor c=1.062E-15
    I_C1422 (XI1_I42_I203_An VSS) capacitor c=9.443E-16
    I_C1423 (XI1_I42_I32_p1 VSS) capacitor c=5.507E-16
    I_C1424 (XI1_I42_I32_n1 VSS) capacitor c=4.983E-19
    I_C1425 (XI1_I42_I32_n2 VSS) capacitor c=8.632E-18
    I_C1426 (XI1_I42_I32_Bn VSS) capacitor c=1.078E-15
    I_C1427 (XI1_I42_I32_An VSS) capacitor c=8.886E-16
    I_C1428 (XI1_I42_I33_p1 VSS) capacitor c=5.302E-16
    I_C1429 (XI1_I42_I33_n1 VSS) capacitor c=4.345E-18
    I_C1430 (XI1_I42_I33_n2 VSS) capacitor c=7.758E-18
    I_C1431 (XI1_I42_I33_Bn VSS) capacitor c=1.103E-15
    I_C1432 (XI1_I42_I33_An VSS) capacitor c=9.359E-16
    I_C1433 (XI1_I42_I36_p1 VSS) capacitor c=5.652E-16
    I_C1434 (XI1_I42_I36_n1 VSS) capacitor c=1.032E-18
    I_C1435 (XI1_I42_I36_n2 VSS) capacitor c=6.949E-18
    I_C1436 (XI1_I42_I36_Bn VSS) capacitor c=1.070E-15
    I_C1437 (XI1_I42_I36_An VSS) capacitor c=9.465E-16
    I_C1438 (XI1_I42_I40_p1 VSS) capacitor c=5.200E-16
    I_C1439 (XI1_I42_I40_n2 VSS) capacitor c=8.118E-18
    I_C1440 (XI1_I42_I40_Bn VSS) capacitor c=1.067E-15
    I_C1441 (XI1_I42_I40_An VSS) capacitor c=9.591E-16
    I_C1442 (XI1_I42_I41_p1 VSS) capacitor c=5.665E-16
    I_C1443 (XI1_I42_I41_n1 VSS) capacitor c=5.717E-19
    I_C1444 (XI1_I42_I41_n2 VSS) capacitor c=5.947E-18
    I_C1445 (XI1_I42_I41_Bn VSS) capacitor c=1.057E-15
    I_C1446 (XI1_I42_I41_An VSS) capacitor c=9.314E-16
    I_C1447 (XI1_I42_I39_p1 VSS) capacitor c=5.317E-16
    I_C1448 (XI1_I42_I39_n2 VSS) capacitor c=7.560E-18
    I_C1449 (XI1_I42_I39_Bn VSS) capacitor c=1.038E-15
    I_C1450 (XI1_I42_I39_An VSS) capacitor c=9.421E-16
    I_C1451 (XI1_I42_I37_p1 VSS) capacitor c=5.499E-16
    I_C1452 (XI1_I42_I37_n1 VSS) capacitor c=1.435E-18
    I_C1453 (XI1_I42_I37_n2 VSS) capacitor c=5.755E-18
    I_C1454 (XI1_I42_I37_Bn VSS) capacitor c=1.050E-15
    I_C1455 (XI1_I42_I37_An VSS) capacitor c=9.082E-16
    I_C1456 (XI1_I42_I204_p1 VSS) capacitor c=5.826E-16
    I_C1457 (XI1_I42_I204_n1 VSS) capacitor c=2.592E-19
    I_C1458 (XI1_I42_I204_n2 VSS) capacitor c=5.001E-18
    I_C1459 (XI1_I42_I204_Bn VSS) capacitor c=1.071E-15
    I_C1460 (XI1_I42_I204_An VSS) capacitor c=9.679E-16
    I_C1461 (XI1_I42_I42_p1 VSS) capacitor c=5.529E-16
    I_C1462 (XI1_I42_I42_n1 VSS) capacitor c=3.307E-18
    I_C1463 (XI1_I42_I42_n2 VSS) capacitor c=8.507E-18
    I_C1464 (XI1_I42_I42_Bn VSS) capacitor c=1.087E-15
    I_C1465 (XI1_I42_I42_An VSS) capacitor c=9.219E-16
    I_C1466 (XI1_I42_I211_p1 VSS) capacitor c=5.657E-16
    I_C1467 (XI1_I42_I211_n1 VSS) capacitor c=5.007E-20
    I_C1468 (XI1_I42_I211_n2 VSS) capacitor c=9.243E-18
    I_C1469 (XI1_I42_I211_Bn VSS) capacitor c=1.085E-15
    I_C1470 (XI1_I42_I211_An VSS) capacitor c=9.344E-16
    I_C1471 (XI1_I42_I209_p1 VSS) capacitor c=5.708E-16
    I_C1472 (XI1_I42_I209_n1 VSS) capacitor c=1.016E-19
    I_C1473 (XI1_I42_I209_n2 VSS) capacitor c=8.340E-18
    I_C1474 (XI1_I42_I209_Bn VSS) capacitor c=1.066E-15
    I_C1475 (XI1_I42_I209_An VSS) capacitor c=9.093E-16
    I_C1476 (XI1_I42_I210_p1 VSS) capacitor c=5.249E-16
    I_C1477 (XI1_I42_I210_n2 VSS) capacitor c=9.524E-18
    I_C1478 (XI1_I42_I210_Bn VSS) capacitor c=1.040E-15
    I_C1479 (XI1_I42_I210_An VSS) capacitor c=8.934E-16
    I_C1480 (XI1_I42_I38_p1 VSS) capacitor c=5.676E-16
    I_C1481 (XI1_I42_I38_n2 VSS) capacitor c=7.483E-18
    I_C1482 (XI1_I42_I38_Bn VSS) capacitor c=1.044E-15
    I_C1483 (XI1_I42_I38_An VSS) capacitor c=9.277E-16
    I_C1484 (XI1_I42_I208_p1 VSS) capacitor c=5.718E-16
    I_C1485 (XI1_I42_I208_n1 VSS) capacitor c=4.140E-18
    I_C1486 (XI1_I42_I208_n2 VSS) capacitor c=6.380E-18
    I_C1487 (XI1_I42_I208_Bn VSS) capacitor c=1.062E-15
    I_C1488 (XI1_I42_I208_An VSS) capacitor c=9.567E-16
    I_C1489 (XI1_I42_I205_p1 VSS) capacitor c=5.450E-16
    I_C1490 (XI1_I42_I205_n2 VSS) capacitor c=8.845E-18
    I_C1491 (XI1_I42_I205_Bn VSS) capacitor c=1.033E-15
    I_C1492 (XI1_I42_I205_An VSS) capacitor c=9.272E-16
    I_C1493 (XI1_I42_I34_p1 VSS) capacitor c=5.566E-16
    I_C1494 (XI1_I42_I34_n2 VSS) capacitor c=6.463E-18
    I_C1495 (XI1_I42_I34_Bn VSS) capacitor c=1.075E-15
    I_C1496 (XI1_I42_I34_An VSS) capacitor c=9.499E-16
    I_C1497 (XI1_I42_I35_p1 VSS) capacitor c=5.301E-16
    I_C1498 (XI1_I42_I35_n1 VSS) capacitor c=5.840E-18
    I_C1499 (XI1_I42_I35_n2 VSS) capacitor c=6.074E-18
    I_C1500 (XI1_I42_I35_Bn VSS) capacitor c=1.095E-15
    I_C1501 (XI1_I42_I35_An VSS) capacitor c=9.475E-16
    I_C1502 (XI1_I42_I62_p1 VSS) capacitor c=5.362E-16
    I_C1503 (XI1_I42_I62_n1 VSS) capacitor c=3.566E-18
    I_C1504 (XI1_I42_I62_n2 VSS) capacitor c=7.310E-18
    I_C1505 (XI1_I42_I62_Bn VSS) capacitor c=1.048E-15
    I_C1506 (XI1_I42_I62_An VSS) capacitor c=9.436E-16
    I_C1507 (XI1_I42_I233_p1 VSS) capacitor c=5.469E-16
    I_C1508 (XI1_I42_I233_n1 VSS) capacitor c=5.786E-19
    I_C1509 (XI1_I42_I233_n2 VSS) capacitor c=1.076E-17
    I_C1510 (XI1_I42_I233_Bn VSS) capacitor c=1.063E-15
    I_C1511 (XI1_I42_I233_An VSS) capacitor c=9.658E-16
    I_C1512 (XI1_I42_I43_p1 VSS) capacitor c=5.320E-16
    I_C1513 (XI1_I42_I43_n1 VSS) capacitor c=4.645E-19
    I_C1514 (XI1_I42_I43_n2 VSS) capacitor c=8.059E-18
    I_C1515 (XI1_I42_I43_Bn VSS) capacitor c=1.054E-15
    I_C1516 (XI1_I42_I43_An VSS) capacitor c=9.458E-16
    I_C1517 (XI1_I42_I44_p1 VSS) capacitor c=5.821E-16
    I_C1518 (XI1_I42_I44_n2 VSS) capacitor c=8.016E-18
    I_C1519 (XI1_I42_I44_Bn VSS) capacitor c=1.080E-15
    I_C1520 (XI1_I42_I44_An VSS) capacitor c=9.399E-16
    I_C1521 (XI1_I42_I63_p1 VSS) capacitor c=5.946E-16
    I_C1522 (XI1_I42_I63_n1 VSS) capacitor c=4.715E-19
    I_C1523 (XI1_I42_I63_n2 VSS) capacitor c=9.553E-18
    I_C1524 (XI1_I42_I63_Bn VSS) capacitor c=1.088E-15
    I_C1525 (XI1_I42_I63_An VSS) capacitor c=9.053E-16
    I_C1526 (XI1_I42_I234_p1 VSS) capacitor c=5.672E-16
    I_C1527 (XI1_I42_I234_n1 VSS) capacitor c=5.374E-18
    I_C1528 (XI1_I42_I234_n2 VSS) capacitor c=1.019E-17
    I_C1529 (XI1_I42_I234_Bn VSS) capacitor c=1.083E-15
    I_C1530 (XI1_I42_I234_An VSS) capacitor c=9.385E-16
    I_C1531 (XI1_I42_I232_p1 VSS) capacitor c=5.544E-16
    I_C1532 (XI1_I42_I232_n2 VSS) capacitor c=7.901E-18
    I_C1533 (XI1_I42_I232_Bn VSS) capacitor c=1.059E-15
    I_C1534 (XI1_I42_I232_An VSS) capacitor c=9.519E-16
    I_C1535 (XI1_I42_I45_p1 VSS) capacitor c=5.603E-16
    I_C1536 (XI1_I42_I45_n1 VSS) capacitor c=1.814E-18
    I_C1537 (XI1_I42_I45_n2 VSS) capacitor c=1.138E-17
    I_C1538 (XI1_I42_I45_Bn VSS) capacitor c=1.115E-15
    I_C1539 (XI1_I42_I45_An VSS) capacitor c=9.096E-16
    I_C1540 (XI1_I42_I61_p1 VSS) capacitor c=5.397E-16
    I_C1541 (XI1_I42_I61_n1 VSS) capacitor c=9.564E-18
    I_C1542 (XI1_I42_I61_n2 VSS) capacitor c=7.642E-18
    I_C1543 (XI1_I42_I61_Bn VSS) capacitor c=1.046E-15
    I_C1544 (XI1_I42_I61_An VSS) capacitor c=9.472E-16
    I_C1545 (XI1_I42_I231_p1 VSS) capacitor c=5.795E-16
    I_C1546 (XI1_I42_I231_n1 VSS) capacitor c=1.225E-18
    I_C1547 (XI1_I42_I231_n2 VSS) capacitor c=8.618E-18
    I_C1548 (XI1_I42_I231_Bn VSS) capacitor c=1.091E-15
    I_C1549 (XI1_I42_I231_An VSS) capacitor c=9.461E-16
    I_C1550 (XI1_I42_I46_p1 VSS) capacitor c=5.364E-16
    I_C1551 (XI1_I42_I46_n1 VSS) capacitor c=1.195E-18
    I_C1552 (XI1_I42_I46_n2 VSS) capacitor c=7.084E-18
    I_C1553 (XI1_I42_I46_Bn VSS) capacitor c=1.059E-15
    I_C1554 (XI1_I42_I46_An VSS) capacitor c=9.238E-16
    I_C1555 (XI1_I42_I60_p1 VSS) capacitor c=5.433E-16
    I_C1556 (XI1_I42_I60_n2 VSS) capacitor c=7.659E-18
    I_C1557 (XI1_I42_I60_Bn VSS) capacitor c=1.153E-15
    I_C1558 (XI1_I42_I60_An VSS) capacitor c=9.335E-16
    I_C1559 (XI1_I42_I230_p1 VSS) capacitor c=5.601E-16
    I_C1560 (XI1_I42_I230_n1 VSS) capacitor c=5.786E-19
    I_C1561 (XI1_I42_I230_n2 VSS) capacitor c=8.631E-18
    I_C1562 (XI1_I42_I230_Bn VSS) capacitor c=1.057E-15
    I_C1563 (XI1_I42_I230_An VSS) capacitor c=9.307E-16
    I_C1564 (XI1_I42_I59_p1 VSS) capacitor c=5.292E-16
    I_C1565 (XI1_I42_I59_n1 VSS) capacitor c=3.820E-19
    I_C1566 (XI1_I42_I59_n2 VSS) capacitor c=6.183E-18
    I_C1567 (XI1_I42_I59_Bn VSS) capacitor c=1.073E-15
    I_C1568 (XI1_I42_I59_An VSS) capacitor c=9.805E-16
    I_C1569 (XI1_I42_I229_p1 VSS) capacitor c=5.425E-16
    I_C1570 (XI1_I42_I229_n2 VSS) capacitor c=8.705E-18
    I_C1571 (XI1_I42_I229_Bn VSS) capacitor c=1.068E-15
    I_C1572 (XI1_I42_I229_An VSS) capacitor c=9.720E-16
    I_C1573 (XI1_I42_I227_p1 VSS) capacitor c=6.009E-16
    I_C1574 (XI1_I42_I227_n2 VSS) capacitor c=6.988E-18
    I_C1575 (XI1_I42_I227_Bn VSS) capacitor c=1.069E-15
    I_C1576 (XI1_I42_I227_An VSS) capacitor c=9.733E-16
    I_C1577 (XI1_I42_I226_p1 VSS) capacitor c=5.021E-16
    I_C1578 (XI1_I42_I226_n1 VSS) capacitor c=5.786E-19
    I_C1579 (XI1_I42_I226_n2 VSS) capacitor c=8.658E-18
    I_C1580 (XI1_I42_I226_Bn VSS) capacitor c=1.045E-15
    I_C1581 (XI1_I42_I226_An VSS) capacitor c=9.230E-16
    I_C1582 (XI1_I42_I222_p1 VSS) capacitor c=5.702E-16
    I_C1583 (XI1_I42_I222_n1 VSS) capacitor c=3.820E-19
    I_C1584 (XI1_I42_I222_n2 VSS) capacitor c=9.381E-18
    I_C1585 (XI1_I42_I222_Bn VSS) capacitor c=1.064E-15
    I_C1586 (XI1_I42_I222_An VSS) capacitor c=9.336E-16
    I_C1587 (XI1_I42_I47_p1 VSS) capacitor c=5.345E-16
    I_C1588 (XI1_I42_I47_n1 VSS) capacitor c=6.145E-18
    I_C1589 (XI1_I42_I47_n2 VSS) capacitor c=9.309E-18
    I_C1590 (XI1_I42_I47_Bn VSS) capacitor c=1.080E-15
    I_C1591 (XI1_I42_I47_An VSS) capacitor c=9.249E-16
    I_C1592 (XI1_I42_I58_p1 VSS) capacitor c=5.669E-16
    I_C1593 (XI1_I42_I58_n2 VSS) capacitor c=9.060E-18
    I_C1594 (XI1_I42_I58_Bn VSS) capacitor c=1.073E-15
    I_C1595 (XI1_I42_I58_An VSS) capacitor c=9.363E-16
    I_C1596 (XI1_I42_I228_p1 VSS) capacitor c=5.662E-16
    I_C1597 (XI1_I42_I228_n1 VSS) capacitor c=3.883E-19
    I_C1598 (XI1_I42_I228_n2 VSS) capacitor c=9.323E-18
    I_C1599 (XI1_I42_I228_Bn VSS) capacitor c=1.066E-15
    I_C1600 (XI1_I42_I228_An VSS) capacitor c=9.719E-16
    I_C1601 (XI1_I42_I56_p1 VSS) capacitor c=5.714E-16
    I_C1602 (XI1_I42_I56_n1 VSS) capacitor c=5.786E-19
    I_C1603 (XI1_I42_I56_n2 VSS) capacitor c=7.676E-18
    I_C1604 (XI1_I42_I56_Bn VSS) capacitor c=1.064E-15
    I_C1605 (XI1_I42_I56_An VSS) capacitor c=9.282E-16
    I_C1606 (XI1_I42_I55_p1 VSS) capacitor c=5.620E-16
    I_C1607 (XI1_I42_I55_n1 VSS) capacitor c=5.794E-19
    I_C1608 (XI1_I42_I55_n2 VSS) capacitor c=1.036E-17
    I_C1609 (XI1_I42_I55_Bn VSS) capacitor c=1.118E-15
    I_C1610 (XI1_I42_I55_An VSS) capacitor c=9.522E-16
    I_C1611 (XI1_I42_I225_p1 VSS) capacitor c=5.609E-16
    I_C1612 (XI1_I42_I225_n2 VSS) capacitor c=9.029E-18
    I_C1613 (XI1_I42_I225_Bn VSS) capacitor c=1.061E-15
    I_C1614 (XI1_I42_I225_An VSS) capacitor c=9.148E-16
    I_C1615 (XI1_I42_I53_p1 VSS) capacitor c=5.545E-16
    I_C1616 (XI1_I42_I53_n2 VSS) capacitor c=1.137E-17
    I_C1617 (XI1_I42_I53_Bn VSS) capacitor c=1.107E-15
    I_C1618 (XI1_I42_I53_An VSS) capacitor c=8.970E-16
    I_C1619 (XI1_I42_I224_p1 VSS) capacitor c=5.404E-16
    I_C1620 (XI1_I42_I224_n2 VSS) capacitor c=8.571E-18
    I_C1621 (XI1_I42_I224_Bn VSS) capacitor c=1.066E-15
    I_C1622 (XI1_I42_I224_An VSS) capacitor c=9.319E-16
    I_C1623 (XI1_I42_I52_p1 VSS) capacitor c=5.313E-16
    I_C1624 (XI1_I42_I52_n1 VSS) capacitor c=6.113E-18
    I_C1625 (XI1_I42_I52_n2 VSS) capacitor c=9.230E-18
    I_C1626 (XI1_I42_I52_Bn VSS) capacitor c=1.091E-15
    I_C1627 (XI1_I42_I52_An VSS) capacitor c=9.074E-16
    I_C1628 (XI1_I42_I223_p1 VSS) capacitor c=5.896E-16
    I_C1629 (XI1_I42_I223_n1 VSS) capacitor c=4.789E-19
    I_C1630 (XI1_I42_I223_n2 VSS) capacitor c=7.682E-18
    I_C1631 (XI1_I42_I223_Bn VSS) capacitor c=1.067E-15
    I_C1632 (XI1_I42_I223_An VSS) capacitor c=9.317E-16
    I_C1633 (XI1_I42_I51_p1 VSS) capacitor c=5.516E-16
    I_C1634 (XI1_I42_I51_n1 VSS) capacitor c=3.820E-19
    I_C1635 (XI1_I42_I51_n2 VSS) capacitor c=8.517E-18
    I_C1636 (XI1_I42_I51_Bn VSS) capacitor c=1.047E-15
    I_C1637 (XI1_I42_I51_An VSS) capacitor c=9.045E-16
    I_C1638 (XI1_I42_I221_p1 VSS) capacitor c=5.524E-16
    I_C1639 (XI1_I42_I221_n1 VSS) capacitor c=3.820E-19
    I_C1640 (XI1_I42_I221_n2 VSS) capacitor c=9.864E-18
    I_C1641 (XI1_I42_I221_Bn VSS) capacitor c=1.043E-15
    I_C1642 (XI1_I42_I221_An VSS) capacitor c=9.705E-16
    I_C1643 (XI1_I42_I50_p1 VSS) capacitor c=5.603E-16
    I_C1644 (XI1_I42_I50_n1 VSS) capacitor c=6.113E-18
    I_C1645 (XI1_I42_I50_n2 VSS) capacitor c=9.438E-18
    I_C1646 (XI1_I42_I50_Bn VSS) capacitor c=1.086E-15
    I_C1647 (XI1_I42_I50_An VSS) capacitor c=9.406E-16
    I_C1648 (XI1_I42_I220_p1 VSS) capacitor c=5.294E-16
    I_C1649 (XI1_I42_I220_n1 VSS) capacitor c=5.786E-19
    I_C1650 (XI1_I42_I220_n2 VSS) capacitor c=8.898E-18
    I_C1651 (XI1_I42_I220_Bn VSS) capacitor c=1.080E-15
    I_C1652 (XI1_I42_I220_An VSS) capacitor c=9.609E-16
    I_C1653 (XI1_I42_I48_p1 VSS) capacitor c=5.323E-16
    I_C1654 (XI1_I42_I48_n1 VSS) capacitor c=4.183E-19
    I_C1655 (XI1_I42_I48_n2 VSS) capacitor c=8.227E-18
    I_C1656 (XI1_I42_I48_Bn VSS) capacitor c=1.134E-15
    I_C1657 (XI1_I42_I48_An VSS) capacitor c=9.268E-16
    I_C1658 (XI1_I42_I57_p1 VSS) capacitor c=5.668E-16
    I_C1659 (XI1_I42_I57_n2 VSS) capacitor c=5.551E-18
    I_C1660 (XI1_I42_I57_Bn VSS) capacitor c=1.056E-15
    I_C1661 (XI1_I42_I57_An VSS) capacitor c=9.409E-16
    I_C1662 (XI1_I42_I54_p1 VSS) capacitor c=5.472E-16
    I_C1663 (XI1_I42_I54_n1 VSS) capacitor c=4.399E-20
    I_C1664 (XI1_I42_I54_n2 VSS) capacitor c=8.134E-18
    I_C1665 (XI1_I42_I54_Bn VSS) capacitor c=1.074E-15
    I_C1666 (XI1_I42_I54_An VSS) capacitor c=9.447E-16
    I_C1667 (XI1_I42_I49_p1 VSS) capacitor c=5.661E-16
    I_C1668 (XI1_I42_I49_n2 VSS) capacitor c=6.872E-18
    I_C1669 (XI1_I42_I49_Bn VSS) capacitor c=1.048E-15
    I_C1670 (XI1_I42_I49_An VSS) capacitor c=9.430E-16
    I_C1671 (XI3_I188_p1 VSS) capacitor c=2.630E-16
    I_C1672 (XI3_I188_n1 VSS) capacitor c=4.723E-19
    I_C1673 (XI3_I200_p1 VSS) capacitor c=2.702E-16
    I_C1674 (XI3_I200_n1 VSS) capacitor c=1.517E-18
    I_C1675 (XI3_I176_p1 VSS) capacitor c=2.639E-16
    I_C1676 (XI3_I176_n1 VSS) capacitor c=3.540E-18
    I_C1677 (XI3_I164_p1 VSS) capacitor c=2.598E-16
    I_C1678 (XI3_I164_n1 VSS) capacitor c=4.553E-18
    I_C1679 (XI3_I212_p1 VSS) capacitor c=2.516E-16
    I_C1680 (XI3_I212_n1 VSS) capacitor c=5.652E-19
    I_C1681 (XI3_I92_p1 VSS) capacitor c=2.466E-16
    I_C1682 (XI3_I92_n1 VSS) capacitor c=6.321E-19
    I_C1683 (XI3_I104_p1 VSS) capacitor c=2.538E-16
    I_C1684 (XI3_I104_n1 VSS) capacitor c=4.015E-18
    I_C1685 (XI3_I140_p1 VSS) capacitor c=2.454E-16
    I_C1686 (XI3_I140_n1 VSS) capacitor c=2.972E-18
    I_C1687 (XI3_I116_p1 VSS) capacitor c=2.664E-16
    I_C1688 (XI3_I116_n1 VSS) capacitor c=4.162E-19
    I_C1689 (XI3_I128_p1 VSS) capacitor c=2.412E-16
    I_C1690 (XI3_I128_n1 VSS) capacitor c=9.248E-19
    I_C1691 (XI3_I152_p1 VSS) capacitor c=2.689E-16
    I_C1692 (XI1_I42_I158_XG_p1 VSS) capacitor c=2.712E-16
    I_C1693 (XI1_I42_I158_XG_n1 VSS) capacitor c=5.951E-19
    I_C1694 (XI1_I42_I105_XG_p1 VSS) capacitor c=2.554E-16
    I_C1695 (XI1_I42_I105_XG_n1 VSS) capacitor c=1.431E-18
    I_C1696 (XI1_I42_I103_XG_p1 VSS) capacitor c=2.331E-16
    I_C1697 (XI1_I42_I103_XG_n1 VSS) capacitor c=8.860E-19
    I_C1698 (XI1_I42_I101_XG_p1 VSS) capacitor c=2.608E-16
    I_C1699 (XI1_I42_I101_XG_n1 VSS) capacitor c=3.426E-18
    I_C1700 (XI1_I42_I104_XG_p1 VSS) capacitor c=2.583E-16
    I_C1701 (XI1_I42_I104_XG_n1 VSS) capacitor c=3.244E-18
    I_C1702 (XI1_I42_I102_XG_p1 VSS) capacitor c=2.575E-16
    I_C1703 (XI1_I42_I102_XG_n1 VSS) capacitor c=4.500E-18
    I_C1704 (XI1_I42_I100_XG_p1 VSS) capacitor c=2.559E-16
    I_C1705 (XI1_I42_I100_XG_n1 VSS) capacitor c=4.906E-18
    I_C1706 (XI1_I42_I99_XG_p1 VSS) capacitor c=2.685E-16
    I_C1707 (XI1_I42_I99_XG_n1 VSS) capacitor c=1.383E-18
    I_C1708 (XI1_I42_I98_XG_p1 VSS) capacitor c=2.715E-16
    I_C1709 (XI1_I42_I168_XG_p1 VSS) capacitor c=2.492E-16
    I_C1710 (XI1_I42_I168_XG_n1 VSS) capacitor c=1.987E-18
    I_C1711 (XI3_I224_p1 VSS) capacitor c=2.558E-16
    I_C1712 (XI3_I224_n1 VSS) capacitor c=2.415E-18
    I_C1713 (XI1_I42_I106_XG_p1 VSS) capacitor c=2.505E-16
    I_C1714 (XI1_I42_I106_XG_n1 VSS) capacitor c=4.165E-18
    I_C1715 (XI1_I42_I157_XG_p1 VSS) capacitor c=2.590E-16
    I_C1716 (XI1_I42_I157_XG_n1 VSS) capacitor c=1.201E-18
    I_C1717 (XI3_I452_p1 VSS) capacitor c=2.571E-16
    I_C1718 (XI3_I464_p1 VSS) capacitor c=2.613E-16
    I_C1719 (XI3_I464_n1 VSS) capacitor c=2.655E-18
    I_C1720 (XI1_I42_I176_XG_p1 VSS) capacitor c=2.510E-16
    I_C1721 (XI1_I42_I176_XG_n1 VSS) capacitor c=1.624E-18
    I_C1722 (XI1_I42_I164_XG_p1 VSS) capacitor c=2.535E-16
    I_C1723 (XI1_I42_I164_XG_n1 VSS) capacitor c=3.009E-18
    I_C1724 (XI1_I42_I107_XG_p1 VSS) capacitor c=2.701E-16
    I_C1725 (XI1_I42_I109_XG_p1 VSS) capacitor c=2.624E-16
    I_C1726 (XI1_I42_I109_XG_n1 VSS) capacitor c=1.364E-20
    I_C1727 (XI1_I42_I167_XG_p1 VSS) capacitor c=2.677E-16
    I_C1728 (XI1_I42_I180_XG_p1 VSS) capacitor c=2.580E-16
    I_C1729 (XI1_I42_I180_XG_n1 VSS) capacitor c=4.095E-19
    I_C1730 (XI1_I42_I172_XG_p1 VSS) capacitor c=2.466E-16
    I_C1731 (XI1_I42_I172_XG_n1 VSS) capacitor c=4.261E-18
    I_C1732 (XI1_I42_I162_XG_p1 VSS) capacitor c=2.758E-16
    I_C1733 (XI1_I42_I162_XG_n1 VSS) capacitor c=2.446E-18
    I_C1734 (XI1_I42_I160_XG_p1 VSS) capacitor c=2.697E-16
    I_C1735 (XI1_I42_I160_XG_n1 VSS) capacitor c=1.783E-20
    I_C1736 (XI1_I42_I108_XG_p1 VSS) capacitor c=2.549E-16
    I_C1737 (XI3_I236_p1 VSS) capacitor c=2.797E-16
    I_C1738 (XI3_I236_n1 VSS) capacitor c=5.348E-19
    I_C1739 (XI3_I440_p1 VSS) capacitor c=2.435E-16
    I_C1740 (XI3_I440_n1 VSS) capacitor c=2.122E-18
    I_C1741 (XI1_I42_I125_XG_p1 VSS) capacitor c=2.575E-16
    I_C1742 (XI1_I42_I125_XG_n1 VSS) capacitor c=1.228E-19
    I_C1743 (XI1_I42_I127_XG_p1 VSS) capacitor c=2.570E-16
    I_C1744 (XI1_I42_I127_XG_n1 VSS) capacitor c=2.786E-18
    I_C1745 (XI1_I42_I182_XG_p1 VSS) capacitor c=2.448E-16
    I_C1746 (XI1_I42_I182_XG_n1 VSS) capacitor c=5.137E-18
    I_C1747 (XI1_I42_I174_XG_p1 VSS) capacitor c=2.279E-16
    I_C1748 (XI1_I42_I174_XG_n1 VSS) capacitor c=2.635E-19
    I_C1749 (XI1_I42_I166_XG_p1 VSS) capacitor c=2.483E-16
    I_C1750 (XI1_I42_I166_XG_n1 VSS) capacitor c=4.230E-19
    I_C1751 (XI1_I42_I170_XG_p1 VSS) capacitor c=2.795E-16
    I_C1752 (XI1_I42_I170_XG_n1 VSS) capacitor c=2.827E-18
    I_C1753 (XI1_I42_I111_XG_p1 VSS) capacitor c=2.798E-16
    I_C1754 (XI1_I42_I111_XG_n1 VSS) capacitor c=6.016E-19
    I_C1755 (XI1_I42_I169_XG_p1 VSS) capacitor c=2.414E-16
    I_C1756 (XI1_I42_I169_XG_n1 VSS) capacitor c=4.303E-18
    I_C1757 (XI1_I42_I175_XG_p1 VSS) capacitor c=2.818E-16
    I_C1758 (XI1_I42_I175_XG_n1 VSS) capacitor c=5.989E-18
    I_C1759 (XI1_I42_I163_XG_p1 VSS) capacitor c=2.631E-16
    I_C1760 (XI3_I248_p1 VSS) capacitor c=2.585E-16
    I_C1761 (XI3_I248_n1 VSS) capacitor c=1.530E-18
    I_C1762 (XI3_I428_p1 VSS) capacitor c=2.733E-16
    I_C1763 (XI3_I428_n1 VSS) capacitor c=2.948E-18
    I_C1764 (XI1_I42_I123_XG_p1 VSS) capacitor c=2.580E-16
    I_C1765 (XI1_I42_I123_XG_n1 VSS) capacitor c=8.237E-18
    I_C1766 (XI1_I42_I178_XG_p1 VSS) capacitor c=2.504E-16
    I_C1767 (XI1_I42_I178_XG_n1 VSS) capacitor c=6.036E-18
    I_C1768 (XI1_I42_I113_XG_p1 VSS) capacitor c=2.706E-16
    I_C1769 (XI1_I42_I179_XG_p1 VSS) capacitor c=2.489E-16
    I_C1770 (XI1_I42_I179_XG_n1 VSS) capacitor c=5.511E-18
    I_C1771 (XI1_I42_I171_XG_p1 VSS) capacitor c=2.308E-16
    I_C1772 (XI1_I42_I171_XG_n1 VSS) capacitor c=2.824E-18
    I_C1773 (XI1_I42_I110_XG_p1 VSS) capacitor c=2.762E-16
    I_C1774 (XI1_I42_I110_XG_n1 VSS) capacitor c=2.564E-18
    I_C1775 (XI3_I260_p1 VSS) capacitor c=2.806E-16
    I_C1776 (XI3_I416_p1 VSS) capacitor c=2.473E-16
    I_C1777 (XI3_I416_n1 VSS) capacitor c=2.326E-18
    I_C1778 (XI1_I42_I126_XG_p1 VSS) capacitor c=2.446E-16
    I_C1779 (XI1_I42_I126_XG_n1 VSS) capacitor c=1.808E-18
    I_C1780 (XI1_I42_I124_XG_p1 VSS) capacitor c=2.541E-16
    I_C1781 (XI1_I42_I124_XG_n1 VSS) capacitor c=4.699E-18
    I_C1782 (XI1_I42_I121_XG_p1 VSS) capacitor c=2.387E-16
    I_C1783 (XI1_I42_I121_XG_n1 VSS) capacitor c=2.962E-18
    I_C1784 (XI1_I42_I119_XG_p1 VSS) capacitor c=2.358E-16
    I_C1785 (XI1_I42_I119_XG_n1 VSS) capacitor c=4.842E-18
    I_C1786 (XI1_I42_I181_XG_p1 VSS) capacitor c=2.448E-16
    I_C1787 (XI1_I42_I181_XG_n1 VSS) capacitor c=4.802E-18
    I_C1788 (XI1_I42_I117_XG_p1 VSS) capacitor c=2.573E-16
    I_C1789 (XI1_I42_I117_XG_n1 VSS) capacitor c=6.024E-18
    I_C1790 (XI1_I42_I115_XG_p1 VSS) capacitor c=2.572E-16
    I_C1791 (XI1_I42_I115_XG_n1 VSS) capacitor c=4.260E-18
    I_C1792 (XI1_I42_I173_XG_p1 VSS) capacitor c=2.692E-16
    I_C1793 (XI1_I42_I173_XG_n1 VSS) capacitor c=4.257E-19
    I_C1794 (XI1_I42_I165_XG_p1 VSS) capacitor c=2.650E-16
    I_C1795 (XI1_I42_I165_XG_n1 VSS) capacitor c=2.324E-18
    I_C1796 (XI1_I42_I112_XG_p1 VSS) capacitor c=2.590E-16
    I_C1797 (XI1_I42_I112_XG_n1 VSS) capacitor c=3.365E-18
    I_C1798 (XI3_I272_p1 VSS) capacitor c=2.653E-16
    I_C1799 (XI3_I272_n1 VSS) capacitor c=1.217E-18
    I_C1800 (XI1_I42_I122_XG_p1 VSS) capacitor c=2.450E-16
    I_C1801 (XI1_I42_I122_XG_n1 VSS) capacitor c=3.176E-18
    I_C1802 (XI1_I42_I120_XG_p1 VSS) capacitor c=2.576E-16
    I_C1803 (XI1_I42_I120_XG_n1 VSS) capacitor c=7.514E-19
    I_C1804 (XI1_I42_I118_XG_p1 VSS) capacitor c=2.375E-16
    I_C1805 (XI1_I42_I177_XG_p1 VSS) capacitor c=2.706E-16
    I_C1806 (XI1_I42_I177_XG_n1 VSS) capacitor c=4.425E-19
    I_C1807 (XI1_I42_I116_XG_p1 VSS) capacitor c=2.695E-16
    I_C1808 (XI1_I42_I116_XG_n1 VSS) capacitor c=5.989E-18
    I_C1809 (XI1_I42_I114_XG_p1 VSS) capacitor c=2.767E-16
    I_C1810 (XI1_I42_I114_XG_n1 VSS) capacitor c=5.046E-19
    I_C1811 (XI3_I392_p1 VSS) capacitor c=2.567E-16
    I_C1812 (XI3_I392_n1 VSS) capacitor c=8.077E-19
    I_C1813 (XI3_I404_p1 VSS) capacitor c=2.557E-16
    I_C1814 (XI3_I404_n1 VSS) capacitor c=9.996E-20
    I_C1815 (XI3_I380_p1 VSS) capacitor c=2.973E-16
    I_C1816 (XI3_I380_n1 VSS) capacitor c=3.268E-18
    I_C1817 (XI3_I284_p1 VSS) capacitor c=2.858E-16
    I_C1818 (XI3_I284_n1 VSS) capacitor c=1.166E-18
    I_C1819 (XI3_I356_p1 VSS) capacitor c=2.451E-16
    I_C1820 (XI3_I356_n1 VSS) capacitor c=4.336E-18
    I_C1821 (XI3_I344_p1 VSS) capacitor c=2.628E-16
    I_C1822 (XI3_I344_n1 VSS) capacitor c=2.782E-18
    I_C1823 (XI3_I332_p1 VSS) capacitor c=2.579E-16
    I_C1824 (XI3_I332_n1 VSS) capacitor c=4.630E-18
    I_C1825 (XI3_I320_p1 VSS) capacitor c=2.472E-16
    I_C1826 (XI3_I320_n1 VSS) capacitor c=2.726E-18
    I_C1827 (XI3_I308_p1 VSS) capacitor c=2.444E-16
    I_C1828 (XI3_I308_n1 VSS) capacitor c=2.628E-18
    I_C1829 (XI3_I296_p1 VSS) capacitor c=2.822E-16
    I_C1830 (XI3_I368_p1 VSS) capacitor c=2.340E-16
    I_C1831 (XI3_I368_n1 VSS) capacitor c=1.402E-18
    I_C1832 (XI1_I42_I65_XG_p1 VSS) capacitor c=6.516E-18
    I_C1833 (XI1_I42_I65_XG_n1 VSS) capacitor c=2.915E-16
    I_C1834 (XI1_I42_I75_XG_p1 VSS) capacitor c=3.550E-18
    I_C1835 (XI1_I42_I75_XG_n1 VSS) capacitor c=2.912E-16
    I_C1836 (XI1_I42_I74_XG_p1 VSS) capacitor c=6.373E-18
    I_C1837 (XI1_I42_I74_XG_n1 VSS) capacitor c=2.835E-16
    I_C1838 (XI1_I42_I73_XG_p1 VSS) capacitor c=3.111E-18
    I_C1839 (XI1_I42_I73_XG_n1 VSS) capacitor c=3.174E-16
    I_C1840 (XI1_I42_I72_XG_p1 VSS) capacitor c=4.049E-18
    I_C1841 (XI1_I42_I72_XG_n1 VSS) capacitor c=3.164E-16
    I_C1842 (XI1_I42_I71_XG_p1 VSS) capacitor c=1.035E-17
    I_C1843 (XI1_I42_I71_XG_n1 VSS) capacitor c=3.067E-16
    I_C1844 (XI1_I42_I70_XG_p1 VSS) capacitor c=4.819E-19
    I_C1845 (XI1_I42_I70_XG_n1 VSS) capacitor c=2.972E-16
    I_C1846 (XI1_I42_I130_XG_p1 VSS) capacitor c=5.134E-18
    I_C1847 (XI1_I42_I130_XG_n1 VSS) capacitor c=3.060E-16
    I_C1848 (XI1_I42_I134_XG_p1 VSS) capacitor c=1.212E-17
    I_C1849 (XI1_I42_I134_XG_n1 VSS) capacitor c=3.024E-16
    I_C1850 (XI1_I42_I76_XG_p1 VSS) capacitor c=3.122E-18
    I_C1851 (XI1_I42_I76_XG_n1 VSS) capacitor c=3.271E-16
    I_C1852 (XI1_I42_I69_XG_p1 VSS) capacitor c=1.553E-18
    I_C1853 (XI1_I42_I69_XG_n1 VSS) capacitor c=3.185E-16
    I_C1854 (XI1_I42_I68_XG_p1 VSS) capacitor c=7.321E-18
    I_C1855 (XI1_I42_I68_XG_n1 VSS) capacitor c=3.310E-16
    I_C1856 (XI1_I42_I67_XG_p1 VSS) capacitor c=9.459E-18
    I_C1857 (XI1_I42_I67_XG_n1 VSS) capacitor c=3.090E-16
    I_C1858 (XI1_I42_I184_XG_p1 VSS) capacitor c=9.054E-18
    I_C1859 (XI1_I42_I184_XG_n1 VSS) capacitor c=3.235E-16
    I_C1860 (XI1_I42_I132_XG_p1 VSS) capacitor c=3.410E-18
    I_C1861 (XI1_I42_I132_XG_n1 VSS) capacitor c=3.049E-16
    I_C1862 (XI1_I42_I133_XG_p1 VSS) capacitor c=6.033E-18
    I_C1863 (XI1_I42_I133_XG_n1 VSS) capacitor c=3.329E-16
    I_C1864 (XI1_I42_I128_XG_p1 VSS) capacitor c=1.288E-17
    I_C1865 (XI1_I42_I128_XG_n1 VSS) capacitor c=3.148E-16
    I_C1866 (XI1_I42_I200_XG_p1 VSS) capacitor c=3.088E-18
    I_C1867 (XI1_I42_I200_XG_n1 VSS) capacitor c=2.937E-16
    I_C1868 (XI1_I42_I196_XG_p1 VSS) capacitor c=8.582E-18
    I_C1869 (XI1_I42_I196_XG_n1 VSS) capacitor c=2.925E-16
    I_C1870 (XI1_I42_I190_XG_p1 VSS) capacitor c=4.810E-18
    I_C1871 (XI1_I42_I190_XG_n1 VSS) capacitor c=3.384E-16
    I_C1872 (XI1_I42_I138_XG_p1 VSS) capacitor c=2.353E-18
    I_C1873 (XI1_I42_I138_XG_n1 VSS) capacitor c=3.096E-16
    I_C1874 (XI1_I42_I136_XG_p1 VSS) capacitor c=3.551E-18
    I_C1875 (XI1_I42_I136_XG_n1 VSS) capacitor c=2.805E-16
    I_C1876 (XI1_I42_I77_XG_p1 VSS) capacitor c=1.029E-17
    I_C1877 (XI1_I42_I77_XG_n1 VSS) capacitor c=2.879E-16
    I_C1878 (XI1_I42_I131_XG_p1 VSS) capacitor c=9.127E-18
    I_C1879 (XI1_I42_I131_XG_n1 VSS) capacitor c=3.293E-16
    I_C1880 (XI1_I42_I183_XG_p1 VSS) capacitor c=3.372E-18
    I_C1881 (XI1_I42_I183_XG_n1 VSS) capacitor c=2.841E-16
    I_C1882 (XI1_I42_I97_XG_n1 VSS) capacitor c=2.952E-16
    I_C1883 (XI1_I42_I150_XG_p1 VSS) capacitor c=4.301E-19
    I_C1884 (XI1_I42_I150_XG_n1 VSS) capacitor c=3.087E-16
    I_C1885 (XI1_I42_I146_XG_p1 VSS) capacitor c=1.173E-17
    I_C1886 (XI1_I42_I146_XG_n1 VSS) capacitor c=2.995E-16
    I_C1887 (XI1_I42_I142_XG_p1 VSS) capacitor c=6.493E-18
    I_C1888 (XI1_I42_I142_XG_n1 VSS) capacitor c=2.989E-16
    I_C1889 (XI1_I42_I135_XG_p1 VSS) capacitor c=5.384E-18
    I_C1890 (XI1_I42_I135_XG_n1 VSS) capacitor c=3.201E-16
    I_C1891 (XI1_I42_I195_XG_p1 VSS) capacitor c=8.775E-18
    I_C1892 (XI1_I42_I195_XG_n1 VSS) capacitor c=3.017E-16
    I_C1893 (XI1_I42_I137_XG_p1 VSS) capacitor c=2.903E-19
    I_C1894 (XI1_I42_I137_XG_n1 VSS) capacitor c=3.352E-16
    I_C1895 (XI1_I42_I78_XG_p1 VSS) capacitor c=4.780E-18
    I_C1896 (XI1_I42_I78_XG_n1 VSS) capacitor c=3.050E-16
    I_C1897 (XI1_I42_I79_XG_p1 VSS) capacitor c=1.267E-17
    I_C1898 (XI1_I42_I79_XG_n1 VSS) capacitor c=3.088E-16
    I_C1899 (XI1_I42_I95_XG_p1 VSS) capacitor c=6.374E-18
    I_C1900 (XI1_I42_I95_XG_n1 VSS) capacitor c=3.229E-16
    I_C1901 (XI1_I42_I96_XG_p1 VSS) capacitor c=1.382E-17
    I_C1902 (XI1_I42_I96_XG_n1 VSS) capacitor c=3.070E-16
    I_C1903 (XI1_I42_I154_XG_p1 VSS) capacitor c=9.696E-18
    I_C1904 (XI1_I42_I154_XG_n1 VSS) capacitor c=2.831E-16
    I_C1905 (XI1_I42_I156_XG_p1 VSS) capacitor c=4.059E-18
    I_C1906 (XI1_I42_I156_XG_n1 VSS) capacitor c=2.948E-16
    I_C1907 (XI1_I42_I202_XG_p1 VSS) capacitor c=4.198E-18
    I_C1908 (XI1_I42_I202_XG_n1 VSS) capacitor c=3.069E-16
    I_C1909 (XI1_I42_I194_XG_p1 VSS) capacitor c=4.147E-18
    I_C1910 (XI1_I42_I194_XG_n1 VSS) capacitor c=3.128E-16
    I_C1911 (XI1_I42_I198_XG_p1 VSS) capacitor c=9.531E-18
    I_C1912 (XI1_I42_I198_XG_n1 VSS) capacitor c=3.029E-16
    I_C1913 (XI1_I42_I140_XG_p1 VSS) capacitor c=1.354E-18
    I_C1914 (XI1_I42_I140_XG_n1 VSS) capacitor c=3.346E-16
    I_C1915 (XI1_I42_I186_XG_p1 VSS) capacitor c=9.254E-18
    I_C1916 (XI1_I42_I186_XG_n1 VSS) capacitor c=2.830E-16
    I_C1917 (XI1_I42_I199_XG_p1 VSS) capacitor c=3.015E-18
    I_C1918 (XI1_I42_I199_XG_n1 VSS) capacitor c=2.990E-16
    I_C1919 (XI1_I42_I185_XG_p1 VSS) capacitor c=1.672E-17
    I_C1920 (XI1_I42_I185_XG_n1 VSS) capacitor c=3.297E-16
    I_C1921 (XI1_I42_I141_XG_p1 VSS) capacitor c=9.685E-18
    I_C1922 (XI1_I42_I141_XG_n1 VSS) capacitor c=2.990E-16
    I_C1923 (XI1_I42_I152_XG_n1 VSS) capacitor c=2.954E-16
    I_C1924 (XI1_I42_I148_XG_p1 VSS) capacitor c=2.558E-19
    I_C1925 (XI1_I42_I148_XG_n1 VSS) capacitor c=3.178E-16
    I_C1926 (XI1_I42_I144_XG_p1 VSS) capacitor c=1.338E-17
    I_C1927 (XI1_I42_I144_XG_n1 VSS) capacitor c=2.751E-16
    I_C1928 (XI1_I42_I139_XG_p1 VSS) capacitor c=5.645E-18
    I_C1929 (XI1_I42_I139_XG_n1 VSS) capacitor c=3.266E-16
    I_C1930 (XI1_I42_I188_XG_p1 VSS) capacitor c=6.152E-18
    I_C1931 (XI1_I42_I188_XG_n1 VSS) capacitor c=2.958E-16
    I_C1932 (XI1_I42_I80_XG_p1 VSS) capacitor c=1.112E-18
    I_C1933 (XI1_I42_I80_XG_n1 VSS) capacitor c=2.826E-16
    I_C1934 (XI1_I42_I94_XG_p1 VSS) capacitor c=8.733E-19
    I_C1935 (XI1_I42_I94_XG_n1 VSS) capacitor c=3.071E-16
    I_C1936 (XI1_I42_I155_XG_p1 VSS) capacitor c=6.727E-18
    I_C1937 (XI1_I42_I155_XG_n1 VSS) capacitor c=3.091E-16
    I_C1938 (XI1_I42_I201_XG_p1 VSS) capacitor c=2.061E-18
    I_C1939 (XI1_I42_I201_XG_n1 VSS) capacitor c=3.199E-16
    I_C1940 (XI1_I42_I153_XG_p1 VSS) capacitor c=1.612E-17
    I_C1941 (XI1_I42_I153_XG_n1 VSS) capacitor c=3.013E-16
    I_C1942 (XI1_I42_I192_XG_p1 VSS) capacitor c=8.605E-19
    I_C1943 (XI1_I42_I192_XG_n1 VSS) capacitor c=3.184E-16
    I_C1944 (XI1_I42_I197_XG_p1 VSS) capacitor c=4.366E-18
    I_C1945 (XI1_I42_I197_XG_n1 VSS) capacitor c=3.433E-16
    I_C1946 (XI1_I42_I143_XG_p1 VSS) capacitor c=8.289E-18
    I_C1947 (XI1_I42_I143_XG_n1 VSS) capacitor c=3.114E-16
    I_C1948 (XI1_I42_I149_XG_p1 VSS) capacitor c=7.607E-19
    I_C1949 (XI1_I42_I149_XG_n1 VSS) capacitor c=3.260E-16
    I_C1950 (XI1_I42_I145_XG_p1 VSS) capacitor c=2.952E-18
    I_C1951 (XI1_I42_I145_XG_n1 VSS) capacitor c=3.508E-16
    I_C1952 (XI1_I42_I81_XG_p1 VSS) capacitor c=2.473E-18
    I_C1953 (XI1_I42_I81_XG_n1 VSS) capacitor c=3.068E-16
    I_C1954 (XI1_I42_I93_XG_p1 VSS) capacitor c=5.590E-18
    I_C1955 (XI1_I42_I93_XG_n1 VSS) capacitor c=3.126E-16
    I_C1956 (XI1_I42_I151_XG_p1 VSS) capacitor c=8.742E-18
    I_C1957 (XI1_I42_I151_XG_n1 VSS) capacitor c=2.984E-16
    I_C1958 (XI1_I42_I147_XG_p1 VSS) capacitor c=7.839E-18
    I_C1959 (XI1_I42_I147_XG_n1 VSS) capacitor c=2.644E-16
    I_C1960 (XI1_I42_I83_XG_p1 VSS) capacitor c=6.452E-18
    I_C1961 (XI1_I42_I83_XG_n1 VSS) capacitor c=2.760E-16
    I_C1962 (XI1_I42_I82_XG_p1 VSS) capacitor c=7.933E-18
    I_C1963 (XI1_I42_I82_XG_n1 VSS) capacitor c=2.791E-16
    I_C1964 (XI1_I42_I92_XG_p1 VSS) capacitor c=5.825E-18
    I_C1965 (XI1_I42_I92_XG_n1 VSS) capacitor c=3.288E-16
    I_C1966 (XI1_I42_I91_XG_p1 VSS) capacitor c=5.006E-21
    I_C1967 (XI1_I42_I91_XG_n1 VSS) capacitor c=2.981E-16
    I_C1968 (XI1_I42_I90_XG_p1 VSS) capacitor c=2.981E-18
    I_C1969 (XI1_I42_I90_XG_n1 VSS) capacitor c=2.990E-16
    I_C1970 (XI1_I42_I89_XG_p1 VSS) capacitor c=2.190E-18
    I_C1971 (XI1_I42_I89_XG_n1 VSS) capacitor c=3.057E-16
    I_C1972 (XI1_I42_I88_XG_p1 VSS) capacitor c=1.270E-17
    I_C1973 (XI1_I42_I88_XG_n1 VSS) capacitor c=2.675E-16
    I_C1974 (XI1_I42_I87_XG_p1 VSS) capacitor c=3.905E-18
    I_C1975 (XI1_I42_I87_XG_n1 VSS) capacitor c=2.966E-16
    I_C1976 (XI1_I42_I86_XG_n1 VSS) capacitor c=3.323E-16
    I_C1977 (XI1_I42_I85_XG_p1 VSS) capacitor c=4.595E-18
    I_C1978 (XI1_I42_I85_XG_n1 VSS) capacitor c=2.860E-16
    I_C1979 (XI1_I42_I84_XG_p1 VSS) capacitor c=5.654E-18
    I_C1980 (XI1_I42_I84_XG_n1 VSS) capacitor c=2.920E-16
    I_C1981 (XI3_I541_n1 VSS) capacitor c=1.118E-18
    I_C1982 (XI3_I545_n1 VSS) capacitor c=2.986E-18
    I_C1983 (XI3_I544_n1 VSS) capacitor c=9.831E-19
    I_C1984 (XI3_I549_n1 VSS) capacitor c=2.763E-18
    I_C1985 (XI3_I548_n1 VSS) capacitor c=2.936E-19
    I_C1986 (XI3_I557_n1 VSS) capacitor c=4.533E-18
    I_C1987 (XI3_I552_n1 VSS) capacitor c=7.987E-18
    I_C1988 (XI3_I551_n1 VSS) capacitor c=5.082E-18
    I_C1989 (XI3_I550_n1 VSS) capacitor c=2.624E-18
    I_C1990 (XI3_I210_n1 VSS) capacitor c=5.866E-18
    I_C1991 (XI3_I207_n1 VSS) capacitor c=8.811E-19
    I_C1992 (XI3_I195_n1 VSS) capacitor c=1.974E-18
    I_C1993 (XI3_I171_n1 VSS) capacitor c=4.600E-18
    I_C1994 (XI3_I158_n1 VSS) capacitor c=6.141E-18
    I_C1995 (XI3_I154_n1 VSS) capacitor c=5.200E-18
    I_C1996 (XI4_I33_n1 VSS) capacitor c=4.555E-18
    I_C1997 (XI2_I0_n1 VSS) capacitor c=4.741E-18
    I_C1998 (XI3_I83_n1 VSS) capacitor c=5.973E-18
    I_C1999 (XI3_I141_n1 VSS) capacitor c=1.091E-18
    I_C2000 (XI2_I6_n1 VSS) capacitor c=1.407E-18
    I_C2001 (XI3_I534_n1 VSS) capacitor c=5.248E-19
    I_C2002 (XI3_I535_n1 VSS) capacitor c=4.394E-19
    I_C2003 (XI3_I542_n1 VSS) capacitor c=5.833E-19
    I_C2004 (XI3_I537_n1 VSS) capacitor c=1.362E-18
    I_C2005 (XI3_I543_n1 VSS) capacitor c=1.308E-19
    I_C2006 (XI3_I539_n1 VSS) capacitor c=7.853E-19
    I_C2007 (XI3_I538_n1 VSS) capacitor c=1.202E-18
    I_C2008 (XI4_I46_n1 VSS) capacitor c=3.655E-18
    I_C2009 (XI4_I47_n1 VSS) capacitor c=4.894E-18
    I_C2010 (XI3_I558_n1 VSS) capacitor c=1.590E-18
    I_C2011 (XI3_I505_n1 VSS) capacitor c=1.504E-18
    I_C2012 (XI3_I556_n1 VSS) capacitor c=2.926E-18
    I_C2013 (XI3_I561_n1 VSS) capacitor c=2.637E-19
    I_C2014 (XI3_I559_n1 VSS) capacitor c=1.325E-18
    I_C2015 (XI3_I496_n1 VSS) capacitor c=3.835E-18
    I_C2016 (XI3_I560_n1 VSS) capacitor c=2.244E-18
    I_C2017 (XI3_I555_n1 VSS) capacitor c=2.382E-18
    I_C2018 (XI3_I554_n1 VSS) capacitor c=1.989E-18
    I_C2019 (XI3_I553_n1 VSS) capacitor c=5.004E-19
    I_C2020 (XI3_I179_n1 VSS) capacitor c=3.629E-18
    I_C2021 (XI3_I182_n1 VSS) capacitor c=2.985E-18
    I_C2022 (XI3_I186_n1 VSS) capacitor c=1.309E-18
    I_C2023 (XI3_I198_n1 VSS) capacitor c=2.303E-18
    I_C2024 (XI3_I159_n1 VSS) capacitor c=3.820E-19
    I_C2025 (XI3_I194_n1 VSS) capacitor c=1.992E-18
    I_C2026 (XI3_I162_n1 VSS) capacitor c=1.820E-18
    I_C2027 (XI3_I174_n1 VSS) capacitor c=4.089E-19
    I_C2028 (XI2_I54_n1 VSS) capacitor c=8.410E-19
    I_C2029 (XI3_I196_n1 VSS) capacitor c=4.599E-18
    I_C2030 (XI3_I191_n1 VSS) capacitor c=5.833E-19
    I_C2031 (XI3_I165_n1 VSS) capacitor c=3.817E-18
    I_C2032 (XI3_I161_n1 VSS) capacitor c=6.834E-18
    I_C2033 (XI3_I160_n1 VSS) capacitor c=5.727E-18
    I_C2034 (XI3_I155_n1 VSS) capacitor c=2.062E-18
    I_C2035 (XI2_I36_n1 VSS) capacitor c=6.434E-18
    I_C2036 (XI3_I84_n1 VSS) capacitor c=6.732E-19
    I_C2037 (XI3_I85_n1 VSS) capacitor c=1.019E-18
    I_C2038 (XI3_I82_n1 VSS) capacitor c=2.309E-18
    I_C2039 (XI3_I89_n1 VSS) capacitor c=2.568E-18
    I_C2040 (XI3_I88_n1 VSS) capacitor c=3.137E-19
    I_C2041 (XI4_I32_n1 VSS) capacitor c=3.319E-18
    I_C2042 (XI3_I94_n1 VSS) capacitor c=3.140E-18
    I_C2043 (XI3_I105_n1 VSS) capacitor c=3.934E-18
    I_C2044 (XI3_I100_n1 VSS) capacitor c=3.746E-18
    I_C2045 (XI3_I95_n1 VSS) capacitor c=3.167E-18
    I_C2046 (XI3_I132_n1 VSS) capacitor c=2.051E-18
    I_C2047 (XI3_I137_n1 VSS) capacitor c=2.253E-18
    I_C2048 (XI3_I130_n1 VSS) capacitor c=3.315E-18
    I_C2049 (XI2_I24_n1 VSS) capacitor c=8.733E-18
    I_C2050 (XI3_I530_n1 VSS) capacitor c=4.058E-19
    I_C2051 (XI3_I529_n1 VSS) capacitor c=2.286E-18
    I_C2052 (XI3_I528_n1 VSS) capacitor c=1.347E-18
    I_C2053 (XI3_I512_n1 VSS) capacitor c=4.797E-18
    I_C2054 (XI4_I45_n1 VSS) capacitor c=5.539E-18
    I_C2055 (XI4_I59_n1 VSS) capacitor c=3.820E-19
    I_C2056 (XI3_I509_n1 VSS) capacitor c=3.290E-18
    I_C2057 (XI3_I506_n1 VSS) capacitor c=3.535E-18
    I_C2058 (XI3_I504_n1 VSS) capacitor c=6.189E-19
    I_C2059 (XI3_I498_n1 VSS) capacitor c=6.990E-19
    I_C2060 (XI3_I503_n1 VSS) capacitor c=2.569E-18
    I_C2061 (XI3_I497_n1 VSS) capacitor c=2.305E-18
    I_C2062 (XI4_I62_n1 VSS) capacitor c=4.573E-18
    I_C2063 (XI3_I502_n1 VSS) capacitor c=4.360E-18
    I_C2064 (XI3_I184_n1 VSS) capacitor c=2.321E-18
    I_C2065 (XI3_I185_n1 VSS) capacitor c=2.554E-18
    I_C2066 (XI3_I181_n1 VSS) capacitor c=1.148E-18
    I_C2067 (XI3_I178_n1 VSS) capacitor c=3.015E-18
    I_C2068 (XI3_I189_n1 VSS) capacitor c=2.047E-18
    I_C2069 (XI3_I201_n1 VSS) capacitor c=1.651E-19
    I_C2070 (XI3_I219_n1 VSS) capacitor c=5.191E-18
    I_C2071 (XI3_I192_n1 VSS) capacitor c=1.541E-18
    I_C2072 (XI3_I156_n1 VSS) capacitor c=6.603E-18
    I_C2073 (XI3_I166_n1 VSS) capacitor c=3.491E-18
    I_C2074 (XI3_I157_n1 VSS) capacitor c=6.242E-18
    I_C2075 (XI2_I42_n1 VSS) capacitor c=1.351E-18
    I_C2076 (XI1_I42_I0_n1 VSS) capacitor c=3.216E-18
    I_C2077 (XI3_I145_n1 VSS) capacitor c=1.076E-18
    I_C2078 (XI3_I93_n1 VSS) capacitor c=1.228E-19
    I_C2079 (XI1_I42_I1_n1 VSS) capacitor c=1.958E-18
    I_C2080 (XI3_I101_n1 VSS) capacitor c=1.403E-18
    I_C2081 (XI3_I97_n1 VSS) capacitor c=3.201E-18
    I_C2082 (XI3_I133_n1 VSS) capacitor c=4.274E-18
    I_C2083 (XI3_I107_n1 VSS) capacitor c=3.739E-19
    I_C2084 (XI3_I112_n1 VSS) capacitor c=3.040E-18
    I_C2085 (XI2_I12_n1 VSS) capacitor c=4.685E-19
    I_C2086 (XI3_I106_n1 VSS) capacitor c=8.221E-20
    I_C2087 (XI3_I527_n1 VSS) capacitor c=3.564E-18
    I_C2088 (XI3_I516_n1 VSS) capacitor c=2.047E-19
    I_C2089 (XI3_I511_n1 VSS) capacitor c=3.859E-18
    I_C2090 (XI3_I526_n1 VSS) capacitor c=1.130E-19
    I_C2091 (XI3_I520_n1 VSS) capacitor c=1.553E-19
    I_C2092 (XI3_I513_n1 VSS) capacitor c=1.127E-18
    I_C2093 (XI4_I44_n1 VSS) capacitor c=3.542E-18
    I_C2094 (XI3_I522_n1 VSS) capacitor c=1.218E-18
    I_C2095 (XI4_I58_n1 VSS) capacitor c=9.318E-19
    I_C2096 (XI3_I510_n1 VSS) capacitor c=2.109E-18
    I_C2097 (XI4_I43_n1 VSS) capacitor c=3.992E-19
    I_C2098 (XI3_I501_n1 VSS) capacitor c=4.398E-18
    I_C2099 (XI3_I499_n1 VSS) capacitor c=3.820E-19
    I_C2100 (XI3_I500_n1 VSS) capacitor c=1.203E-18
    I_C2101 (XI3_I204_n1 VSS) capacitor c=4.093E-18
    I_C2102 (XI3_I209_n1 VSS) capacitor c=2.057E-18
    I_C2103 (XI3_I213_n1 VSS) capacitor c=1.165E-18
    I_C2104 (XI3_I218_n1 VSS) capacitor c=2.269E-18
    I_C2105 (XI3_I222_n1 VSS) capacitor c=1.721E-18
    I_C2106 (XI3_I193_n1 VSS) capacitor c=2.183E-18
    I_C2107 (XI4_I34_n1 VSS) capacitor c=7.647E-18
    I_C2108 (XI3_I169_n1 VSS) capacitor c=2.228E-18
    I_C2109 (XI3_I168_n1 VSS) capacitor c=3.039E-18
    I_C2110 (XI3_I172_n1 VSS) capacitor c=1.653E-18
    I_C2111 (XI3_I167_n1 VSS) capacitor c=3.519E-18
    I_C2112 (XI4_I56_n1 VSS) capacitor c=3.064E-18
    I_C2113 (XI3_I144_n1 VSS) capacitor c=8.308E-19
    I_C2114 (XI3_I153_n1 VSS) capacitor c=4.138E-18
    I_C2115 (XI3_I149_n1 VSS) capacitor c=4.276E-18
    I_C2116 (XI3_I90_n1 VSS) capacitor c=1.582E-18
    I_C2117 (XI3_I87_n1 VSS) capacitor c=3.025E-19
    I_C2118 (XI3_I86_n1 VSS) capacitor c=1.166E-18
    I_C2119 (XI1_I42_I4_n1 VSS) capacitor c=2.224E-18
    I_C2120 (XI3_I109_n1 VSS) capacitor c=2.662E-18
    I_C2121 (XI3_I99_n1 VSS) capacitor c=7.329E-19
    I_C2122 (XI3_I113_n1 VSS) capacitor c=7.058E-20
    I_C2123 (XI3_I98_n1 VSS) capacitor c=2.426E-18
    I_C2124 (XI3_I117_n1 VSS) capacitor c=3.112E-18
    I_C2125 (XI3_I108_n1 VSS) capacitor c=2.799E-18
    I_C2126 (XI3_I515_n1 VSS) capacitor c=5.355E-18
    I_C2127 (XI3_I488_n1 VSS) capacitor c=1.478E-18
    I_C2128 (XI3_I517_n1 VSS) capacitor c=2.391E-18
    I_C2129 (XI3_I514_n1 VSS) capacitor c=2.173E-18
    I_C2130 (XI3_I492_n1 VSS) capacitor c=1.559E-18
    I_C2131 (XI3_I519_n1 VSS) capacitor c=2.173E-18
    I_C2132 (XI3_I523_n1 VSS) capacitor c=5.007E-18
    I_C2133 (XI3_I518_n1 VSS) capacitor c=3.565E-18
    I_C2134 (XI3_I521_n1 VSS) capacitor c=3.590E-18
    I_C2135 (XI3_I524_n1 VSS) capacitor c=4.832E-18
    I_C2136 (XI3_I493_n1 VSS) capacitor c=4.400E-18
    I_C2137 (XI3_I494_n1 VSS) capacitor c=4.721E-18
    I_C2138 (XI3_I495_n1 VSS) capacitor c=2.819E-18
    I_C2139 (XI3_I203_n1 VSS) capacitor c=4.806E-19
    I_C2140 (XI3_I208_n1 VSS) capacitor c=1.600E-18
    I_C2141 (XI1_I42_I8_n1 VSS) capacitor c=3.339E-18
    I_C2142 (XI1_I42_I9_n1 VSS) capacitor c=5.305E-18
    I_C2143 (XI1_I42_I7_n1 VSS) capacitor c=2.547E-18
    I_C2144 (XI1_I42_I6_n1 VSS) capacitor c=3.311E-19
    I_C2145 (XI2_I30_n1 VSS) capacitor c=4.407E-19
    I_C2146 (XI3_I143_n1 VSS) capacitor c=4.131E-18
    I_C2147 (XI3_I142_n1 VSS) capacitor c=4.928E-18
    I_C2148 (XI3_I148_n1 VSS) capacitor c=2.080E-18
    I_C2149 (XI3_I146_n1 VSS) capacitor c=4.324E-18
    I_C2150 (XI3_I114_n1 VSS) capacitor c=2.518E-18
    I_C2151 (XI3_I126_n1 VSS) capacitor c=1.411E-19
    I_C2152 (XI3_I122_n1 VSS) capacitor c=1.664E-18
    I_C2153 (XI3_I111_n1 VSS) capacitor c=2.813E-18
    I_C2154 (XI3_I123_n1 VSS) capacitor c=1.833E-18
    I_C2155 (XI3_I121_n1 VSS) capacitor c=2.777E-18
    I_C2156 (XI3_I129_n1 VSS) capacitor c=5.656E-19
    I_C2157 (XI3_I125_n1 VSS) capacitor c=1.049E-18
    I_C2158 (XI3_I487_n1 VSS) capacitor c=4.260E-18
    I_C2159 (XI3_I489_n1 VSS) capacitor c=4.460E-18
    I_C2160 (XI3_I478_n1 VSS) capacitor c=2.808E-18
    I_C2161 (XI3_I491_n1 VSS) capacitor c=4.477E-18
    I_C2162 (XI3_I482_n1 VSS) capacitor c=2.061E-18
    I_C2163 (XI3_I484_n1 VSS) capacitor c=1.940E-18
    I_C2164 (XI3_I490_n1 VSS) capacitor c=4.035E-18
    I_C2165 (XI3_I485_n1 VSS) capacitor c=2.764E-18
    I_C2166 (XI3_I486_n1 VSS) capacitor c=2.385E-18
    I_C2167 (XI3_I475_n1 VSS) capacitor c=5.980E-18
    I_C2168 (XI4_I41_n1 VSS) capacitor c=1.152E-18
    I_C2169 (XI0_I6_n1 VSS) capacitor c=4.583E-18
    I_C2170 (XI0_I4_n1 VSS) capacitor c=2.887E-18
    I_C2171 (XI0_I5_n1 VSS) capacitor c=4.907E-18
    I_C2172 (XI0_I8_n1 VSS) capacitor c=5.688E-19
    I_C2173 (XI2_I60_n1 VSS) capacitor c=7.295E-18
    I_C2174 (XI1_I42_I10_n1 VSS) capacitor c=5.220E-19
    I_C2175 (XI1_I42_I5_n1 VSS) capacitor c=4.093E-20
    I_C2176 (XI3_I150_n1 VSS) capacitor c=5.853E-19
    I_C2177 (XI3_I147_n1 VSS) capacitor c=7.197E-19
    I_C2178 (XI3_I138_n1 VSS) capacitor c=4.155E-18
    I_C2179 (XI3_I134_n1 VSS) capacitor c=2.671E-18
    I_C2180 (XI3_I135_n1 VSS) capacitor c=1.986E-18
    I_C2181 (XI3_I119_n1 VSS) capacitor c=4.528E-18
    I_C2182 (XI3_I124_n1 VSS) capacitor c=8.170E-19
    I_C2183 (XI3_I118_n1 VSS) capacitor c=6.927E-18
    I_C2184 (XI3_I479_n1 VSS) capacitor c=3.704E-18
    I_C2185 (XI3_I474_n1 VSS) capacitor c=3.910E-18
    I_C2186 (XI3_I480_n1 VSS) capacitor c=2.609E-18
    I_C2187 (XI3_I481_n1 VSS) capacitor c=2.870E-18
    I_C2188 (XI3_I469_n1 VSS) capacitor c=1.537E-18
    I_C2189 (XI3_I483_n1 VSS) capacitor c=5.691E-18
    I_C2190 (XI3_I476_n1 VSS) capacitor c=5.298E-18
    I_C2191 (XI3_I471_n1 VSS) capacitor c=1.600E-18
    I_C2192 (XI3_I466_n1 VSS) capacitor c=3.634E-18
    I_C2193 (XI3_I477_n1 VSS) capacitor c=3.662E-18
    I_C2194 (XI3_I468_n1 VSS) capacitor c=1.681E-18
    I_C2195 (XI4_I40_n1 VSS) capacitor c=2.002E-18
    I_C2196 (XI4_I68_n1 VSS) capacitor c=3.632E-18
    I_C2197 (XI0_I10_n1 VSS) capacitor c=1.398E-18
    I_C2198 (XI0_I7_n1 VSS) capacitor c=3.968E-18
    I_C2199 (XI0_I9_n1 VSS) capacitor c=2.523E-18
    I_C2200 (XI1_I42_I105_XP_n1 VSS) capacitor c=4.701E-18
    I_C2201 (XI1_I42_I103_XP_n1 VSS) capacitor c=2.804E-18
    I_C2202 (XI1_I42_I101_XP_n1 VSS) capacitor c=2.108E-18
    I_C2203 (XI1_I42_I3_n1 VSS) capacitor c=2.922E-18
    I_C2204 (XI3_I216_n1 VSS) capacitor c=7.199E-18
    I_C2205 (XI2_I18_n1 VSS) capacitor c=1.066E-18
    I_C2206 (XI3_I473_n1 VSS) capacitor c=5.522E-18
    I_C2207 (XI3_I472_n1 VSS) capacitor c=1.657E-18
    I_C2208 (XI3_I447_n1 VSS) capacitor c=3.793E-18
    I_C2209 (XI3_I446_n1 VSS) capacitor c=2.864E-18
    I_C2210 (XI3_I450_n1 VSS) capacitor c=2.545E-18
    I_C2211 (XI3_I458_n1 VSS) capacitor c=3.708E-18
    I_C2212 (XI3_I470_n1 VSS) capacitor c=7.562E-19
    I_C2213 (XI3_I467_n1 VSS) capacitor c=3.311E-19
    I_C2214 (XI3_I444_n1 VSS) capacitor c=9.230E-19
    I_C2215 (XI4_I69_n1 VSS) capacitor c=1.012E-17
    I_C2216 (XI4_I64_n1 VSS) capacitor c=1.016E-17
    I_C2217 (XI4_I67_n1 VSS) capacitor c=3.683E-18
    I_C2218 (XI1_I42_I168_XP_n1 VSS) capacitor c=5.446E-18
    I_C2219 (XI1_I42_I107_XP_n1 VSS) capacitor c=1.802E-18
    I_C2220 (XI3_I225_n1 VSS) capacitor c=2.311E-18
    I_C2221 (XI1_I42_I106_XP_n1 VSS) capacitor c=3.444E-18
    I_C2222 (XI1_I42_I104_XP_n1 VSS) capacitor c=4.033E-18
    I_C2223 (XI1_I42_I102_XP_n1 VSS) capacitor c=3.703E-18
    I_C2224 (XI1_I42_I100_XP_n1 VSS) capacitor c=1.387E-18
    I_C2225 (XI3_I214_n1 VSS) capacitor c=1.010E-18
    I_C2226 (XI3_I220_n1 VSS) capacitor c=4.451E-18
    I_C2227 (XI2_I66_n1 VSS) capacitor c=2.005E-18
    I_C2228 (XI3_I217_n1 VSS) capacitor c=2.077E-18
    I_C2229 (XI3_I221_n1 VSS) capacitor c=6.029E-18
    I_C2230 (XI2_I180_n1 VSS) capacitor c=1.262E-18
    I_C2231 (XI3_I443_n1 VSS) capacitor c=4.273E-18
    I_C2232 (XI3_I453_n1 VSS) capacitor c=2.029E-18
    I_C2233 (XI3_I465_n1 VSS) capacitor c=3.216E-19
    I_C2234 (XI3_I449_n1 VSS) capacitor c=2.535E-18
    I_C2235 (XI3_I445_n1 VSS) capacitor c=2.319E-19
    I_C2236 (XI3_I461_n1 VSS) capacitor c=2.558E-18
    I_C2237 (XI3_I457_n1 VSS) capacitor c=3.188E-18
    I_C2238 (XI3_I456_n1 VSS) capacitor c=4.531E-18
    I_C2239 (XI1_I42_I30_n1 VSS) capacitor c=2.010E-18
    I_C2240 (XI1_I42_I176_XP_n1 VSS) capacitor c=4.747E-18
    I_C2241 (XI1_I42_I172_XP_n1 VSS) capacitor c=6.470E-18
    I_C2242 (XI1_I42_I108_XP_n1 VSS) capacitor c=3.690E-18
    I_C2243 (XI1_I42_I167_XP_n1 VSS) capacitor c=8.028E-18
    I_C2244 (XI1_I42_I11_n1 VSS) capacitor c=4.032E-18
    I_C2245 (XI3_I226_n1 VSS) capacitor c=3.675E-18
    I_C2246 (XI3_I232_n1 VSS) capacitor c=4.938E-18
    I_C2247 (XI3_I442_n1 VSS) capacitor c=4.652E-18
    I_C2248 (XI3_I430_n1 VSS) capacitor c=4.769E-18
    I_C2249 (XI3_I448_n1 VSS) capacitor c=1.700E-18
    I_C2250 (XI3_I431_n1 VSS) capacitor c=8.798E-18
    I_C2251 (XI3_I454_n1 VSS) capacitor c=1.357E-18
    I_C2252 (XI3_I455_n1 VSS) capacitor c=2.506E-18
    I_C2253 (XI3_I460_n1 VSS) capacitor c=3.546E-18
    I_C2254 (XI1_I42_I31_n1 VSS) capacitor c=2.242E-18
    I_C2255 (XI1_I42_I180_XP_n1 VSS) capacitor c=2.772E-18
    I_C2256 (XI1_I42_I111_XP_n1 VSS) capacitor c=4.333E-19
    I_C2257 (XI1_I42_I170_XP_n1 VSS) capacitor c=6.397E-18
    I_C2258 (XI1_I42_I175_XP_n1 VSS) capacitor c=2.657E-19
    I_C2259 (XI1_I42_I13_n1 VSS) capacitor c=1.763E-19
    I_C2260 (XI3_I241_n1 VSS) capacitor c=2.438E-19
    I_C2261 (XI3_I239_n1 VSS) capacitor c=3.843E-18
    I_C2262 (XI3_I237_n1 VSS) capacitor c=3.240E-18
    I_C2263 (XI4_I35_n1 VSS) capacitor c=4.105E-18
    I_C2264 (XI3_I435_n1 VSS) capacitor c=5.020E-18
    I_C2265 (XI3_I434_n1 VSS) capacitor c=1.211E-17
    I_C2266 (XI3_I438_n1 VSS) capacitor c=4.485E-18
    I_C2267 (XI3_I436_n1 VSS) capacitor c=7.685E-19
    I_C2268 (XI4_I39_n1 VSS) capacitor c=2.774E-18
    I_C2269 (XI2_I174_n1 VSS) capacitor c=3.876E-18
    I_C2270 (XI3_I441_n1 VSS) capacitor c=1.203E-18
    I_C2271 (XI3_I437_n1 VSS) capacitor c=4.039E-18
    I_C2272 (XI3_I433_n1 VSS) capacitor c=4.080E-18
    I_C2273 (XI3_I432_n1 VSS) capacitor c=2.756E-18
    I_C2274 (XI1_I42_I29_n1 VSS) capacitor c=4.502E-18
    I_C2275 (XI1_I42_I127_XP_n1 VSS) capacitor c=2.859E-18
    I_C2276 (XI1_I42_I182_XP_n1 VSS) capacitor c=2.994E-18
    I_C2277 (XI1_I42_I174_XP_n1 VSS) capacitor c=2.793E-18
    I_C2278 (XI1_I42_I113_XP_n1 VSS) capacitor c=5.325E-19
    I_C2279 (XI1_I42_I169_XP_n1 VSS) capacitor c=5.989E-18
    I_C2280 (XI3_I240_n1 VSS) capacitor c=3.159E-19
    I_C2281 (XI3_I245_n1 VSS) capacitor c=8.682E-19
    I_C2282 (XI2_I78_n1 VSS) capacitor c=3.104E-18
    I_C2283 (XI3_I249_n1 VSS) capacitor c=5.150E-18
    I_C2284 (XI3_I244_n1 VSS) capacitor c=4.599E-18
    I_C2285 (XI3_I246_n1 VSS) capacitor c=2.963E-18
    I_C2286 (XI3_I234_n1 VSS) capacitor c=4.883E-18
    I_C2287 (XI3_I238_n1 VSS) capacitor c=2.542E-18
    I_C2288 (XI3_I231_n1 VSS) capacitor c=2.280E-18
    I_C2289 (XI3_I230_n1 VSS) capacitor c=5.882E-18
    I_C2290 (XI3_I423_n1 VSS) capacitor c=4.691E-18
    I_C2291 (XI3_I422_n1 VSS) capacitor c=2.778E-18
    I_C2292 (XI3_I418_n1 VSS) capacitor c=3.040E-19
    I_C2293 (XI3_I426_n1 VSS) capacitor c=6.543E-19
    I_C2294 (XI3_I429_n1 VSS) capacitor c=2.607E-19
    I_C2295 (XI3_I407_n1 VSS) capacitor c=2.193E-18
    I_C2296 (XI3_I421_n1 VSS) capacitor c=5.130E-18
    I_C2297 (XI3_I425_n1 VSS) capacitor c=3.239E-18
    I_C2298 (XI3_I420_n1 VSS) capacitor c=3.655E-18
    I_C2299 (XI1_I42_I28_n1 VSS) capacitor c=4.823E-18
    I_C2300 (XI1_I42_I125_XP_n1 VSS) capacitor c=4.766E-18
    I_C2301 (XI1_I42_I123_XP_n1 VSS) capacitor c=6.922E-18
    I_C2302 (XI1_I42_I119_XP_n1 VSS) capacitor c=3.058E-18
    I_C2303 (XI1_I42_I179_XP_n1 VSS) capacitor c=6.856E-19
    I_C2304 (XI1_I42_I171_XP_n1 VSS) capacitor c=4.823E-18
    I_C2305 (XI1_I42_I110_XP_n1 VSS) capacitor c=4.443E-18
    I_C2306 (XI1_I42_I112_XP_n1 VSS) capacitor c=3.978E-18
    I_C2307 (XI3_I252_n1 VSS) capacitor c=1.364E-20
    I_C2308 (XI3_I253_n1 VSS) capacitor c=1.590E-18
    I_C2309 (XI3_I257_n1 VSS) capacitor c=2.377E-18
    I_C2310 (XI2_I84_n1 VSS) capacitor c=1.413E-18
    I_C2311 (XI3_I261_n1 VSS) capacitor c=5.915E-19
    I_C2312 (XI3_I256_n1 VSS) capacitor c=2.014E-19
    I_C2313 (XI3_I250_n1 VSS) capacitor c=3.535E-18
    I_C2314 (XI3_I242_n1 VSS) capacitor c=4.129E-18
    I_C2315 (XI2_I168_n1 VSS) capacitor c=2.626E-19
    I_C2316 (XI3_I411_n1 VSS) capacitor c=1.789E-18
    I_C2317 (XI3_I414_n1 VSS) capacitor c=4.095E-18
    I_C2318 (XI3_I417_n1 VSS) capacitor c=2.091E-18
    I_C2319 (XI3_I412_n1 VSS) capacitor c=1.185E-18
    I_C2320 (XI3_I413_n1 VSS) capacitor c=5.728E-18
    I_C2321 (XI3_I409_n1 VSS) capacitor c=4.740E-18
    I_C2322 (XI4_I57_n1 VSS) capacitor c=2.087E-18
    I_C2323 (XI1_I42_I126_XP_n1 VSS) capacitor c=5.379E-18
    I_C2324 (XI1_I42_I124_XP_n1 VSS) capacitor c=2.660E-18
    I_C2325 (XI1_I42_I181_XP_n1 VSS) capacitor c=2.847E-18
    I_C2326 (XI1_I42_I173_XP_n1 VSS) capacitor c=6.724E-18
    I_C2327 (XI1_I42_I177_XP_n1 VSS) capacitor c=4.313E-18
    I_C2328 (XI1_I42_I114_XP_n1 VSS) capacitor c=2.019E-18
    I_C2329 (XI1_I42_I14_n1 VSS) capacitor c=1.132E-20
    I_C2330 (XI3_I265_n1 VSS) capacitor c=4.433E-18
    I_C2331 (XI3_I269_n1 VSS) capacitor c=3.977E-19
    I_C2332 (XI3_I251_n1 VSS) capacitor c=6.319E-18
    I_C2333 (XI3_I273_n1 VSS) capacitor c=1.450E-18
    I_C2334 (XI3_I258_n1 VSS) capacitor c=2.400E-18
    I_C2335 (XI3_I255_n1 VSS) capacitor c=7.412E-18
    I_C2336 (XI3_I270_n1 VSS) capacitor c=3.820E-19
    I_C2337 (XI3_I254_n1 VSS) capacitor c=5.499E-18
    I_C2338 (XI3_I387_n1 VSS) capacitor c=4.393E-18
    I_C2339 (XI3_I398_n1 VSS) capacitor c=7.448E-19
    I_C2340 (XI3_I375_n1 VSS) capacitor c=2.883E-18
    I_C2341 (XI3_I399_n1 VSS) capacitor c=2.003E-18
    I_C2342 (XI3_I402_n1 VSS) capacitor c=9.366E-19
    I_C2343 (XI2_I162_n1 VSS) capacitor c=3.820E-19
    I_C2344 (XI3_I408_n1 VSS) capacitor c=6.058E-18
    I_C2345 (XI1_I42_I122_XP_n1 VSS) capacitor c=5.555E-18
    I_C2346 (XI1_I42_I120_XP_n1 VSS) capacitor c=4.378E-18
    I_C2347 (XI1_I42_I118_XP_n1 VSS) capacitor c=8.745E-20
    I_C2348 (XI1_I42_I116_XP_n1 VSS) capacitor c=3.944E-18
    I_C2349 (XI3_I264_n1 VSS) capacitor c=3.397E-18
    I_C2350 (XI3_I268_n1 VSS) capacitor c=6.731E-19
    I_C2351 (XI2_I90_n1 VSS) capacitor c=2.623E-18
    I_C2352 (XI3_I266_n1 VSS) capacitor c=3.603E-20
    I_C2353 (XI3_I267_n1 VSS) capacitor c=3.880E-18
    I_C2354 (XI4_I38_n1 VSS) capacitor c=2.152E-19
    I_C2355 (XI3_I374_n1 VSS) capacitor c=7.068E-19
    I_C2356 (XI3_I378_n1 VSS) capacitor c=1.707E-18
    I_C2357 (XI3_I405_n1 VSS) capacitor c=7.126E-18
    I_C2358 (XI1_I42_I23_n1 VSS) capacitor c=3.820E-19
    I_C2359 (XI1_I42_I20_n1 VSS) capacitor c=5.997E-19
    I_C2360 (XI1_I42_I19_n1 VSS) capacitor c=4.136E-18
    I_C2361 (XI1_I42_I16_n1 VSS) capacitor c=2.281E-18
    I_C2362 (XI3_I282_n1 VSS) capacitor c=6.809E-18
    I_C2363 (XI3_I279_n1 VSS) capacitor c=4.231E-18
    I_C2364 (XI3_I278_n1 VSS) capacitor c=3.440E-20
    I_C2365 (XI3_I291_n1 VSS) capacitor c=3.515E-18
    I_C2366 (XI3_I290_n1 VSS) capacitor c=3.128E-18
    I_C2367 (XI2_I156_n1 VSS) capacitor c=5.698E-18
    I_C2368 (XI3_I400_n1 VSS) capacitor c=2.237E-18
    I_C2369 (XI3_I393_n1 VSS) capacitor c=5.802E-19
    I_C2370 (XI3_I396_n1 VSS) capacitor c=2.659E-18
    I_C2371 (XI3_I373_n1 VSS) capacitor c=4.007E-18
    I_C2372 (XI1_I42_I22_n1 VSS) capacitor c=1.362E-19
    I_C2373 (XI1_I42_I21_n1 VSS) capacitor c=1.911E-18
    I_C2374 (XI3_I354_n1 VSS) capacitor c=2.557E-18
    I_C2375 (XI3_I324_n1 VSS) capacitor c=2.918E-18
    I_C2376 (XI3_I306_n1 VSS) capacitor c=4.293E-18
    I_C2377 (XI1_I42_I18_n1 VSS) capacitor c=4.745E-18
    I_C2378 (XI3_I281_n1 VSS) capacitor c=4.518E-18
    I_C2379 (XI3_I276_n1 VSS) capacitor c=9.187E-18
    I_C2380 (XI3_I388_n1 VSS) capacitor c=7.004E-19
    I_C2381 (XI3_I395_n1 VSS) capacitor c=4.625E-18
    I_C2382 (XI3_I389_n1 VSS) capacitor c=5.849E-18
    I_C2383 (XI3_I385_n1 VSS) capacitor c=3.122E-18
    I_C2384 (XI3_I384_n1 VSS) capacitor c=7.164E-19
    I_C2385 (XI3_I381_n1 VSS) capacitor c=3.742E-18
    I_C2386 (XI3_I376_n1 VSS) capacitor c=1.009E-17
    I_C2387 (XI3_I377_n1 VSS) capacitor c=2.866E-18
    I_C2388 (XI3_I372_n1 VSS) capacitor c=3.678E-18
    I_C2389 (XI3_I364_n1 VSS) capacitor c=3.516E-18
    I_C2390 (XI3_I365_n1 VSS) capacitor c=9.760E-20
    I_C2391 (XI3_I361_n1 VSS) capacitor c=9.968E-20
    I_C2392 (XI3_I349_n1 VSS) capacitor c=7.410E-20
    I_C2393 (XI3_I353_n1 VSS) capacitor c=1.586E-18
    I_C2394 (XI3_I348_n1 VSS) capacitor c=1.306E-18
    I_C2395 (XI3_I369_n1 VSS) capacitor c=7.198E-19
    I_C2396 (XI3_I335_n1 VSS) capacitor c=1.877E-18
    I_C2397 (XI3_I337_n1 VSS) capacitor c=1.473E-19
    I_C2398 (XI3_I341_n1 VSS) capacitor c=3.270E-18
    I_C2399 (XI3_I351_n1 VSS) capacitor c=3.311E-19
    I_C2400 (XI3_I366_n1 VSS) capacitor c=3.214E-19
    I_C2401 (XI3_I362_n1 VSS) capacitor c=1.813E-18
    I_C2402 (XI3_I350_n1 VSS) capacitor c=1.922E-19
    I_C2403 (XI3_I338_n1 VSS) capacitor c=2.702E-18
    I_C2404 (XI3_I339_n1 VSS) capacitor c=1.788E-18
    I_C2405 (XI3_I330_n1 VSS) capacitor c=3.739E-19
    I_C2406 (XI3_I327_n1 VSS) capacitor c=3.630E-18
    I_C2407 (XI3_I326_n1 VSS) capacitor c=3.427E-18
    I_C2408 (XI3_I325_n1 VSS) capacitor c=2.000E-18
    I_C2409 (XI3_I318_n1 VSS) capacitor c=3.992E-18
    I_C2410 (XI3_I314_n1 VSS) capacitor c=3.041E-18
    I_C2411 (XI3_I303_n1 VSS) capacitor c=4.114E-18
    I_C2412 (XI3_I321_n1 VSS) capacitor c=2.489E-18
    I_C2413 (XI3_I302_n1 VSS) capacitor c=2.933E-18
    I_C2414 (XI3_I317_n1 VSS) capacitor c=2.575E-18
    I_C2415 (XI3_I313_n1 VSS) capacitor c=4.720E-18
    I_C2416 (XI3_I312_n1 VSS) capacitor c=6.913E-18
    I_C2417 (XI3_I309_n1 VSS) capacitor c=3.360E-18
    I_C2418 (XI3_I301_n1 VSS) capacitor c=2.980E-18
    I_C2419 (XI2_I108_n1 VSS) capacitor c=5.039E-19
    I_C2420 (XI3_I305_n1 VSS) capacitor c=8.998E-19
    I_C2421 (XI3_I297_n1 VSS) capacitor c=1.051E-18
    I_C2422 (XI3_I289_n1 VSS) capacitor c=5.951E-19
    I_C2423 (XI3_I285_n1 VSS) capacitor c=6.305E-19
    I_C2424 (XI3_I293_n1 VSS) capacitor c=5.853E-19
    I_C2425 (XI3_I287_n1 VSS) capacitor c=5.803E-18
    I_C2426 (XI3_I382_n1 VSS) capacitor c=1.499E-18
    I_C2427 (XI2_I150_n1 VSS) capacitor c=1.412E-17
    I_C2428 (XI3_I370_n1 VSS) capacitor c=1.757E-19
    I_C2429 (XI2_I144_n1 VSS) capacitor c=2.573E-18
    I_C2430 (XI3_I358_n1 VSS) capacitor c=3.176E-18
    I_C2431 (XI3_I347_n1 VSS) capacitor c=3.880E-19
    I_C2432 (XI2_I138_n1 VSS) capacitor c=4.824E-19
    I_C2433 (XI3_I352_n1 VSS) capacitor c=3.890E-18
    I_C2434 (XI2_I132_n1 VSS) capacitor c=2.507E-18
    I_C2435 (XI3_I357_n1 VSS) capacitor c=2.245E-18
    I_C2436 (XI4_I37_n1 VSS) capacitor c=2.677E-18
    I_C2437 (XI3_I334_n1 VSS) capacitor c=9.341E-18
    I_C2438 (XI3_I340_n1 VSS) capacitor c=9.884E-19
    I_C2439 (XI2_I126_n1 VSS) capacitor c=2.212E-19
    I_C2440 (XI3_I336_n1 VSS) capacitor c=2.799E-18
    I_C2441 (XI3_I363_n1 VSS) capacitor c=7.450E-19
    I_C2442 (XI3_I345_n1 VSS) capacitor c=1.082E-17
    I_C2443 (XI3_I333_n1 VSS) capacitor c=9.487E-19
    I_C2444 (XI3_I322_n1 VSS) capacitor c=5.446E-19
    I_C2445 (XI2_I120_n1 VSS) capacitor c=2.003E-18
    I_C2446 (XI3_I328_n1 VSS) capacitor c=8.526E-19
    I_C2447 (XI3_I323_n1 VSS) capacitor c=6.763E-18
    I_C2448 (XI2_I114_n1 VSS) capacitor c=4.557E-18
    I_C2449 (XI3_I310_n1 VSS) capacitor c=2.223E-18
    I_C2450 (XI3_I311_n1 VSS) capacitor c=3.652E-18
    I_C2451 (XI3_I316_n1 VSS) capacitor c=3.361E-18
    I_C2452 (XI4_I36_n1 VSS) capacitor c=5.864E-18
    I_C2453 (XI3_I304_n1 VSS) capacitor c=3.965E-18
    I_C2454 (XI3_I298_n1 VSS) capacitor c=3.982E-18
    I_C2455 (XI3_I299_n1 VSS) capacitor c=1.768E-18
    I_C2456 (XI3_I288_n1 VSS) capacitor c=5.430E-18
    I_C2457 (XI2_I102_n1 VSS) capacitor c=3.925E-18
    I_C2458 (XI3_I286_n1 VSS) capacitor c=2.016E-18
    I_C2459 (XI4_I29_p1 VSS) capacitor c=7.641E-19
    I_C2460 (XI4_I30_p1 VSS) capacitor c=2.470E-18
    I_C2461 (XI2_I2_p1 VSS) capacitor c=5.533E-18
    I_C2462 (XI4_I2_p1 VSS) capacitor c=1.894E-19
    I_C2463 (XI2_I8_p1 VSS) capacitor c=4.237E-18
    I_C2464 (XI3_I139_p1 VSS) capacitor c=7.351E-18
    I_C2465 (XI4_I28_p1 VSS) capacitor c=5.231E-18
    I_C2466 (XI4_I55_p1 VSS) capacitor c=4.975E-18
    I_C2467 (XI4_I31_p1 VSS) capacitor c=2.663E-18
    I_C2468 (XI2_I50_p1 VSS) capacitor c=1.563E-18
    I_C2469 (XI2_I56_p1 VSS) capacitor c=4.688E-18
    I_C2470 (XI3_I163_p1 VSS) capacitor c=8.286E-18
    I_C2471 (XI2_I38_p1 VSS) capacitor c=1.499E-17
    I_C2472 (XI4_I48_p1 VSS) capacitor c=1.261E-18
    I_C2473 (XI4_I0_p1 VSS) capacitor c=2.635E-18
    I_C2474 (XI3_I103_p1 VSS) capacitor c=1.042E-17
    I_C2475 (XI2_I26_p1 VSS) capacitor c=9.997E-18
    I_C2476 (XI4_I26_p1 VSS) capacitor c=1.124E-17
    I_C2477 (XI4_I27_p1 VSS) capacitor c=2.123E-17
    I_C2478 (XI4_I54_p1 VSS) capacitor c=3.353E-18
    I_C2479 (XI4_I61_p1 VSS) capacitor c=1.655E-18
    I_C2480 (XI3_I187_p1 VSS) capacitor c=9.182E-19
    I_C2481 (XI4_I4_p1 VSS) capacitor c=6.999E-18
    I_C2482 (XI3_I199_p1 VSS) capacitor c=7.589E-18
    I_C2483 (XI2_I44_p1 VSS) capacitor c=5.705E-18
    I_C2484 (XI2_I14_p1 VSS) capacitor c=2.300E-18
    I_C2485 (XI4_I24_p1 VSS) capacitor c=4.416E-18
    I_C2486 (XI4_I25_p1 VSS) capacitor c=7.803E-19
    I_C2487 (XI4_I23_p1 VSS) capacitor c=4.751E-18
    I_C2488 (XI4_I53_p1 VSS) capacitor c=9.741E-18
    I_C2489 (XI4_I21_p1 VSS) capacitor c=4.843E-18
    I_C2490 (XI3_I211_p1 VSS) capacitor c=6.282E-18
    I_C2491 (XI4_I5_p1 VSS) capacitor c=9.225E-18
    I_C2492 (XI3_I175_p1 VSS) capacitor c=1.436E-18
    I_C2493 (XI4_I49_p1 VSS) capacitor c=8.256E-18
    I_C2494 (XI3_I151_p1 VSS) capacitor c=6.719E-18
    I_C2495 (XI3_I115_p1 VSS) capacitor c=1.633E-18
    I_C2496 (XI4_I20_p1 VSS) capacitor c=8.972E-18
    I_C2497 (XI2_I62_p1 VSS) capacitor c=2.648E-18
    I_C2498 (XI2_I32_p1 VSS) capacitor c=1.166E-18
    I_C2499 (XI4_I1_p1 VSS) capacitor c=3.492E-18
    I_C2500 (XI3_I127_p1 VSS) capacitor c=1.210E-17
    I_C2501 (XI4_I19_p1 VSS) capacitor c=2.089E-19
    I_C2502 (XI4_I52_p1 VSS) capacitor c=2.415E-18
    I_C2503 (XI0_I16_p1 VSS) capacitor c=5.518E-18
    I_C2504 (XI0_I15_p1 VSS) capacitor c=7.393E-18
    I_C2505 (XI1_I42_I71_XP_p1 VSS) capacitor c=6.864E-18
    I_C2506 (XI4_I18_p1 VSS) capacitor c=3.629E-18
    I_C2507 (XI4_I17_p1 VSS) capacitor c=1.344E-17
    I_C2508 (XI4_I16_p1 VSS) capacitor c=1.317E-17
    I_C2509 (XI0_I17_p1 VSS) capacitor c=7.629E-18
    I_C2510 (XI0_I13_p1 VSS) capacitor c=1.393E-17
    I_C2511 (XI0_I14_p1 VSS) capacitor c=1.895E-18
    I_C2512 (XI1_I42_I134_XP_p1 VSS) capacitor c=4.213E-18
    I_C2513 (XI1_I42_I75_XP_p1 VSS) capacitor c=5.885E-18
    I_C2514 (XI1_I42_I76_XP_p1 VSS) capacitor c=7.081E-18
    I_C2515 (XI1_I42_I73_XP_p1 VSS) capacitor c=1.260E-18
    I_C2516 (XI1_I42_I74_XP_p1 VSS) capacitor c=5.563E-18
    I_C2517 (XI1_I42_I72_XP_p1 VSS) capacitor c=5.652E-18
    I_C2518 (XI1_I42_I70_XP_p1 VSS) capacitor c=6.556E-18
    I_C2519 (XI1_I42_I69_XP_p1 VSS) capacitor c=9.573E-18
    I_C2520 (XI1_I42_I68_XP_p1 VSS) capacitor c=3.046E-19
    I_C2521 (XI2_I20_p1 VSS) capacitor c=3.551E-18
    I_C2522 (XI0_I11_p1 VSS) capacitor c=7.945E-18
    I_C2523 (XI0_I12_p1 VSS) capacitor c=1.070E-17
    I_C2524 (XI1_I42_I77_XP_p1 VSS) capacitor c=6.982E-18
    I_C2525 (XI1_I42_I136_XP_p1 VSS) capacitor c=3.027E-18
    I_C2526 (XI1_I42_I133_XP_p1 VSS) capacitor c=9.865E-18
    I_C2527 (XI3_I223_p1 VSS) capacitor c=1.225E-17
    I_C2528 (XI2_I68_p1 VSS) capacitor c=1.400E-18
    I_C2529 (XI2_I182_p1 VSS) capacitor c=6.182E-18
    I_C2530 (XI3_I451_p1 VSS) capacitor c=8.925E-19
    I_C2531 (XI3_I463_p1 VSS) capacitor c=1.353E-18
    I_C2532 (XI1_I42_I142_XP_p1 VSS) capacitor c=1.967E-19
    I_C2533 (XI1_I42_I138_XP_p1 VSS) capacitor c=4.612E-18
    I_C2534 (XI1_I42_I78_XP_p1 VSS) capacitor c=3.484E-18
    I_C2535 (XI2_I74_p1 VSS) capacitor c=2.966E-18
    I_C2536 (XI4_I15_p1 VSS) capacitor c=6.993E-18
    I_C2537 (XI2_I188_p1 VSS) capacitor c=1.213E-17
    I_C2538 (XI1_I42_I97_XP_p1 VSS) capacitor c=8.053E-18
    I_C2539 (XI1_I42_I154_XP_p1 VSS) capacitor c=4.943E-18
    I_C2540 (XI1_I42_I150_XP_p1 VSS) capacitor c=2.133E-17
    I_C2541 (XI1_I42_I146_XP_p1 VSS) capacitor c=1.157E-17
    I_C2542 (XI1_I42_I140_XP_p1 VSS) capacitor c=1.786E-18
    I_C2543 (XI1_I42_I137_XP_p1 VSS) capacitor c=2.944E-18
    I_C2544 (XI1_I42_I141_XP_p1 VSS) capacitor c=1.910E-19
    I_C2545 (XI1_I42_I79_XP_p1 VSS) capacitor c=1.546E-17
    I_C2546 (XI2_I80_p1 VSS) capacitor c=1.210E-18
    I_C2547 (XI3_I235_p1 VSS) capacitor c=9.813E-18
    I_C2548 (XI4_I6_p1 VSS) capacitor c=7.152E-18
    I_C2549 (XI4_I14_p1 VSS) capacitor c=3.021E-18
    I_C2550 (XI3_I439_p1 VSS) capacitor c=6.819E-18
    I_C2551 (XI2_I176_p1 VSS) capacitor c=2.753E-19
    I_C2552 (XI1_I42_I156_XP_p1 VSS) capacitor c=1.218E-18
    I_C2553 (XI1_I42_I144_XP_p1 VSS) capacitor c=9.161E-18
    I_C2554 (XI1_I42_I81_XP_p1 VSS) capacitor c=3.395E-18
    I_C2555 (XI3_I247_p1 VSS) capacitor c=6.180E-18
    I_C2556 (XI3_I427_p1 VSS) capacitor c=1.069E-17
    I_C2557 (XI1_I42_I96_XP_p1 VSS) capacitor c=4.720E-18
    I_C2558 (XI1_I42_I95_XP_p1 VSS) capacitor c=7.452E-18
    I_C2559 (XI1_I42_I152_XP_p1 VSS) capacitor c=4.274E-18
    I_C2560 (XI1_I42_I148_XP_p1 VSS) capacitor c=1.465E-17
    I_C2561 (XI1_I42_I139_XP_p1 VSS) capacitor c=7.738E-18
    I_C2562 (XI1_I42_I145_XP_p1 VSS) capacitor c=5.066E-18
    I_C2563 (XI1_I42_I80_XP_p1 VSS) capacitor c=5.796E-18
    I_C2564 (XI3_I259_p1 VSS) capacitor c=1.069E-17
    I_C2565 (XI4_I7_p1 VSS) capacitor c=1.092E-17
    I_C2566 (XI2_I170_p1 VSS) capacitor c=9.093E-18
    I_C2567 (XI4_I51_p1 VSS) capacitor c=5.008E-18
    I_C2568 (XI3_I415_p1 VSS) capacitor c=5.601E-18
    I_C2569 (XI1_I42_I94_XP_p1 VSS) capacitor c=4.682E-18
    I_C2570 (XI1_I42_I155_XP_p1 VSS) capacitor c=7.657E-18
    I_C2571 (XI1_I42_I153_XP_p1 VSS) capacitor c=7.546E-18
    I_C2572 (XI1_I42_I151_XP_p1 VSS) capacitor c=1.148E-17
    I_C2573 (XI1_I42_I147_XP_p1 VSS) capacitor c=7.806E-18
    I_C2574 (XI1_I42_I143_XP_p1 VSS) capacitor c=6.831E-18
    I_C2575 (XI1_I42_I149_XP_p1 VSS) capacitor c=8.428E-18
    I_C2576 (XI1_I42_I83_XP_p1 VSS) capacitor c=4.615E-18
    I_C2577 (XI1_I42_I82_XP_p1 VSS) capacitor c=1.166E-17
    I_C2578 (XI2_I86_p1 VSS) capacitor c=1.070E-18
    I_C2579 (XI3_I271_p1 VSS) capacitor c=8.453E-18
    I_C2580 (XI2_I164_p1 VSS) capacitor c=1.282E-17
    I_C2581 (XI1_I42_I93_XP_p1 VSS) capacitor c=1.015E-17
    I_C2582 (XI1_I42_I92_XP_p1 VSS) capacitor c=2.459E-18
    I_C2583 (XI1_I42_I91_XP_p1 VSS) capacitor c=1.213E-18
    I_C2584 (XI1_I42_I90_XP_p1 VSS) capacitor c=5.885E-18
    I_C2585 (XI1_I42_I89_XP_p1 VSS) capacitor c=7.581E-18
    I_C2586 (XI1_I42_I88_XP_p1 VSS) capacitor c=1.020E-17
    I_C2587 (XI1_I42_I87_XP_p1 VSS) capacitor c=1.020E-17
    I_C2588 (XI1_I42_I86_XP_p1 VSS) capacitor c=4.972E-18
    I_C2589 (XI1_I42_I85_XP_p1 VSS) capacitor c=6.801E-18
    I_C2590 (XI1_I42_I84_XP_p1 VSS) capacitor c=1.133E-17
    I_C2591 (XI2_I92_p1 VSS) capacitor c=3.948E-18
    I_C2592 (XI4_I13_p1 VSS) capacitor c=1.248E-18
    I_C2593 (XI2_I158_p1 VSS) capacitor c=3.687E-18
    I_C2594 (XI4_I12_p1 VSS) capacitor c=5.768E-18
    I_C2595 (XI3_I403_p1 VSS) capacitor c=4.386E-19
    I_C2596 (XI2_I128_p1 VSS) capacitor c=7.573E-18
    I_C2597 (XI2_I98_p1 VSS) capacitor c=1.261E-18
    I_C2598 (XI3_I391_p1 VSS) capacitor c=1.223E-18
    I_C2599 (XI3_I379_p1 VSS) capacitor c=6.031E-18
    I_C2600 (XI3_I319_p1 VSS) capacitor c=5.443E-19
    I_C2601 (XI3_I307_p1 VSS) capacitor c=1.287E-17
    I_C2602 (XI2_I110_p1 VSS) capacitor c=8.094E-19
    I_C2603 (XI3_I283_p1 VSS) capacitor c=7.459E-18
    I_C2604 (XI3_I295_p1 VSS) capacitor c=2.639E-18
    I_C2605 (XI2_I152_p1 VSS) capacitor c=6.596E-18
    I_C2606 (XI2_I146_p1 VSS) capacitor c=5.661E-18
    I_C2607 (XI2_I140_p1 VSS) capacitor c=1.114E-18
    I_C2608 (XI3_I355_p1 VSS) capacitor c=8.061E-18
    I_C2609 (XI2_I134_p1 VSS) capacitor c=1.345E-17
    I_C2610 (XI4_I50_p1 VSS) capacitor c=2.838E-19
    I_C2611 (XI4_I11_p1 VSS) capacitor c=4.598E-18
    I_C2612 (XI3_I343_p1 VSS) capacitor c=3.044E-18
    I_C2613 (XI4_I10_p1 VSS) capacitor c=5.771E-18
    I_C2614 (XI2_I122_p1 VSS) capacitor c=3.855E-18
    I_C2615 (XI3_I331_p1 VSS) capacitor c=8.667E-18
    I_C2616 (XI2_I116_p1 VSS) capacitor c=9.137E-19
    I_C2617 (XI4_I9_p1 VSS) capacitor c=6.923E-19
    I_C2618 (XI4_I8_p1 VSS) capacitor c=6.623E-19
    I_C2619 (XI2_I104_p1 VSS) capacitor c=1.685E-19
    I_C2620 (XI1_I10_p1 VSS) capacitor c=5.355E-16
    I_C2621 (XI1_I10_n1 VSS) capacitor c=1.853E-19
    I_C2622 (XI1_I10_n2 VSS) capacitor c=7.752E-18
    I_C2623 (XI1_I10_An VSS) capacitor c=9.697E-16
    I_C2624 (XI1_I10_Bn VSS) capacitor c=7.884E-16
    I_C2625 (XI2_I4_p1 VSS) capacitor c=5.640E-16
    I_C2626 (XI2_I4_n2 VSS) capacitor c=5.215E-18
    I_C2627 (XI2_I4_An VSS) capacitor c=9.478E-16
    I_C2628 (XI2_I4_Bn VSS) capacitor c=7.864E-16
    I_C2629 (XI2_I10_p1 VSS) capacitor c=5.538E-16
    I_C2630 (XI2_I10_n2 VSS) capacitor c=1.098E-17
    I_C2631 (XI2_I10_An VSS) capacitor c=9.613E-16
    I_C2632 (XI2_I10_Bn VSS) capacitor c=7.954E-16
    I_C2633 (XI2_I28_p1 VSS) capacitor c=5.629E-16
    I_C2634 (XI2_I28_n1 VSS) capacitor c=4.134E-19
    I_C2635 (XI2_I28_n2 VSS) capacitor c=8.810E-18
    I_C2636 (XI2_I28_An VSS) capacitor c=1.005E-15
    I_C2637 (XI2_I28_Bn VSS) capacitor c=7.730E-16
    I_C2638 (XI2_I52_p1 VSS) capacitor c=5.247E-16
    I_C2639 (XI2_I52_n1 VSS) capacitor c=3.820E-19
    I_C2640 (XI2_I52_n2 VSS) capacitor c=7.679E-18
    I_C2641 (XI2_I52_An VSS) capacitor c=9.696E-16
    I_C2642 (XI2_I52_Bn VSS) capacitor c=7.973E-16
    I_C2643 (XI2_I58_p1 VSS) capacitor c=5.601E-16
    I_C2644 (XI2_I58_n1 VSS) capacitor c=3.915E-18
    I_C2645 (XI2_I58_n2 VSS) capacitor c=6.970E-18
    I_C2646 (XI2_I58_An VSS) capacitor c=1.027E-15
    I_C2647 (XI2_I58_Bn VSS) capacitor c=8.383E-16
    I_C2648 (XI2_I40_p1 VSS) capacitor c=5.597E-16
    I_C2649 (XI2_I40_n1 VSS) capacitor c=3.525E-18
    I_C2650 (XI2_I40_n2 VSS) capacitor c=9.127E-18
    I_C2651 (XI2_I40_An VSS) capacitor c=1.003E-15
    I_C2652 (XI2_I40_Bn VSS) capacitor c=7.823E-16
    I_C2653 (XI1_I11_p1 VSS) capacitor c=5.750E-16
    I_C2654 (XI1_I11_n1 VSS) capacitor c=1.501E-19
    I_C2655 (XI1_I11_n2 VSS) capacitor c=6.998E-18
    I_C2656 (XI1_I11_An VSS) capacitor c=1.006E-15
    I_C2657 (XI1_I11_Bn VSS) capacitor c=8.290E-16
    I_C2658 (XI1_I14_p1 VSS) capacitor c=5.559E-16
    I_C2659 (XI1_I14_n1 VSS) capacitor c=2.011E-18
    I_C2660 (XI1_I14_n2 VSS) capacitor c=7.270E-18
    I_C2661 (XI1_I14_An VSS) capacitor c=9.784E-16
    I_C2662 (XI1_I14_Bn VSS) capacitor c=8.106E-16
    I_C2663 (XI2_I64_p1 VSS) capacitor c=5.597E-16
    I_C2664 (XI2_I64_n1 VSS) capacitor c=4.867E-18
    I_C2665 (XI2_I64_n2 VSS) capacitor c=6.997E-18
    I_C2666 (XI2_I64_An VSS) capacitor c=9.805E-16
    I_C2667 (XI2_I64_Bn VSS) capacitor c=8.071E-16
    I_C2668 (XI2_I46_p1 VSS) capacitor c=5.991E-16
    I_C2669 (XI2_I46_n1 VSS) capacitor c=9.994E-19
    I_C2670 (XI2_I46_n2 VSS) capacitor c=7.242E-18
    I_C2671 (XI2_I46_An VSS) capacitor c=9.978E-16
    I_C2672 (XI2_I46_Bn VSS) capacitor c=7.855E-16
    I_C2673 (XI2_I34_p1 VSS) capacitor c=5.747E-16
    I_C2674 (XI2_I34_n2 VSS) capacitor c=5.206E-18
    I_C2675 (XI2_I34_An VSS) capacitor c=9.459E-16
    I_C2676 (XI2_I34_Bn VSS) capacitor c=8.334E-16
    I_C2677 (XI2_I16_p1 VSS) capacitor c=5.753E-16
    I_C2678 (XI2_I16_n1 VSS) capacitor c=1.364E-20
    I_C2679 (XI2_I16_n2 VSS) capacitor c=6.787E-18
    I_C2680 (XI2_I16_An VSS) capacitor c=1.014E-15
    I_C2681 (XI2_I16_Bn VSS) capacitor c=8.181E-16
    I_C2682 (XI1_I18_p1 VSS) capacitor c=5.596E-16
    I_C2683 (XI1_I18_n2 VSS) capacitor c=8.200E-18
    I_C2684 (XI1_I18_An VSS) capacitor c=9.766E-16
    I_C2685 (XI1_I18_Bn VSS) capacitor c=7.723E-16
    I_C2686 (XI1_I19_p1 VSS) capacitor c=5.402E-16
    I_C2687 (XI1_I19_n2 VSS) capacitor c=8.987E-18
    I_C2688 (XI1_I19_An VSS) capacitor c=9.371E-16
    I_C2689 (XI1_I19_Bn VSS) capacitor c=7.787E-16
    I_C2690 (XI1_I17_p1 VSS) capacitor c=5.524E-16
    I_C2691 (XI1_I17_n2 VSS) capacitor c=8.377E-18
    I_C2692 (XI1_I17_An VSS) capacitor c=1.022E-15
    I_C2693 (XI1_I17_Bn VSS) capacitor c=7.583E-16
    I_C2694 (XI1_I16_p1 VSS) capacitor c=5.218E-16
    I_C2695 (XI1_I16_n2 VSS) capacitor c=7.111E-18
    I_C2696 (XI1_I16_An VSS) capacitor c=9.477E-16
    I_C2697 (XI1_I16_Bn VSS) capacitor c=8.007E-16
    I_C2698 (XI1_I15_p1 VSS) capacitor c=5.617E-16
    I_C2699 (XI1_I15_n1 VSS) capacitor c=8.759E-20
    I_C2700 (XI1_I15_n2 VSS) capacitor c=7.804E-18
    I_C2701 (XI1_I15_An VSS) capacitor c=9.499E-16
    I_C2702 (XI1_I15_Bn VSS) capacitor c=7.723E-16
    I_C2703 (XI1_I20_p1 VSS) capacitor c=5.427E-16
    I_C2704 (XI1_I20_n2 VSS) capacitor c=7.693E-18
    I_C2705 (XI1_I20_An VSS) capacitor c=9.619E-16
    I_C2706 (XI1_I20_Bn VSS) capacitor c=8.200E-16
    I_C2707 (XI1_I42_I212_p1 VSS) capacitor c=5.597E-16
    I_C2708 (XI1_I42_I212_n1 VSS) capacitor c=1.469E-18
    I_C2709 (XI1_I42_I212_n2 VSS) capacitor c=8.642E-18
    I_C2710 (XI1_I42_I212_An VSS) capacitor c=9.866E-16
    I_C2711 (XI1_I42_I212_Bn VSS) capacitor c=8.098E-16
    I_C2712 (XI1_I42_I207_p1 VSS) capacitor c=5.698E-16
    I_C2713 (XI1_I42_I207_n1 VSS) capacitor c=3.820E-19
    I_C2714 (XI1_I42_I207_n2 VSS) capacitor c=6.085E-18
    I_C2715 (XI1_I42_I207_An VSS) capacitor c=9.521E-16
    I_C2716 (XI1_I42_I207_Bn VSS) capacitor c=7.728E-16
    I_C2717 (XI1_I12_p1 VSS) capacitor c=5.136E-16
    I_C2718 (XI1_I12_n1 VSS) capacitor c=1.574E-19
    I_C2719 (XI1_I12_n2 VSS) capacitor c=7.649E-18
    I_C2720 (XI1_I12_An VSS) capacitor c=9.671E-16
    I_C2721 (XI1_I12_Bn VSS) capacitor c=8.138E-16
    I_C2722 (XI2_I22_p1 VSS) capacitor c=5.651E-16
    I_C2723 (XI2_I22_n1 VSS) capacitor c=6.607E-19
    I_C2724 (XI2_I22_n2 VSS) capacitor c=7.940E-18
    I_C2725 (XI2_I22_An VSS) capacitor c=9.901E-16
    I_C2726 (XI2_I22_Bn VSS) capacitor c=7.780E-16
    I_C2727 (XI1_I42_I213_p1 VSS) capacitor c=5.807E-16
    I_C2728 (XI1_I42_I213_n1 VSS) capacitor c=1.026E-18
    I_C2729 (XI1_I42_I213_n2 VSS) capacitor c=9.404E-18
    I_C2730 (XI1_I42_I213_An VSS) capacitor c=1.034E-15
    I_C2731 (XI1_I42_I213_Bn VSS) capacitor c=8.100E-16
    I_C2732 (XI1_I42_I206_p1 VSS) capacitor c=5.801E-16
    I_C2733 (XI1_I42_I206_n1 VSS) capacitor c=1.173E-18
    I_C2734 (XI1_I42_I206_n2 VSS) capacitor c=6.154E-18
    I_C2735 (XI1_I42_I206_An VSS) capacitor c=9.896E-16
    I_C2736 (XI1_I42_I206_Bn VSS) capacitor c=8.210E-16
    I_C2737 (XI1_I13_p1 VSS) capacitor c=5.246E-16
    I_C2738 (XI1_I13_n1 VSS) capacitor c=2.549E-19
    I_C2739 (XI1_I13_n2 VSS) capacitor c=5.702E-18
    I_C2740 (XI1_I13_An VSS) capacitor c=9.629E-16
    I_C2741 (XI1_I13_Bn VSS) capacitor c=7.798E-16
    I_C2742 (XI2_I184_p1 VSS) capacitor c=5.813E-16
    I_C2743 (XI2_I184_n2 VSS) capacitor c=1.004E-17
    I_C2744 (XI2_I184_An VSS) capacitor c=9.666E-16
    I_C2745 (XI2_I184_Bn VSS) capacitor c=7.902E-16
    I_C2746 (XI1_I40_p1 VSS) capacitor c=5.202E-16
    I_C2747 (XI1_I40_n2 VSS) capacitor c=1.166E-17
    I_C2748 (XI1_I40_An VSS) capacitor c=9.545E-16
    I_C2749 (XI1_I40_Bn VSS) capacitor c=7.754E-16
    I_C2750 (XI4_I66_p1 VSS) capacitor c=5.307E-16
    I_C2751 (XI4_I66_n1 VSS) capacitor c=9.594E-19
    I_C2752 (XI4_I66_n2 VSS) capacitor c=8.917E-18
    I_C2753 (XI4_I66_An VSS) capacitor c=9.966E-16
    I_C2754 (XI4_I66_Bn VSS) capacitor c=7.958E-16
    I_C2755 (XI2_I70_p1 VSS) capacitor c=5.219E-16
    I_C2756 (XI2_I70_n1 VSS) capacitor c=5.049E-18
    I_C2757 (XI2_I70_n2 VSS) capacitor c=6.664E-18
    I_C2758 (XI2_I70_An VSS) capacitor c=9.820E-16
    I_C2759 (XI2_I70_Bn VSS) capacitor c=8.035E-16
    I_C2760 (XI2_I190_p1 VSS) capacitor c=5.617E-16
    I_C2761 (XI2_I190_n2 VSS) capacitor c=6.144E-18
    I_C2762 (XI2_I190_An VSS) capacitor c=9.886E-16
    I_C2763 (XI2_I190_Bn VSS) capacitor c=8.799E-16
    I_C2764 (XI1_I42_I214_p1 VSS) capacitor c=5.801E-16
    I_C2765 (XI1_I42_I214_n1 VSS) capacitor c=3.132E-19
    I_C2766 (XI1_I42_I214_n2 VSS) capacitor c=1.006E-17
    I_C2767 (XI1_I42_I214_An VSS) capacitor c=9.982E-16
    I_C2768 (XI1_I42_I214_Bn VSS) capacitor c=7.437E-16
    I_C2769 (XI1_I21_p1 VSS) capacitor c=5.223E-16
    I_C2770 (XI1_I21_n2 VSS) capacitor c=7.183E-18
    I_C2771 (XI1_I21_An VSS) capacitor c=9.568E-16
    I_C2772 (XI1_I21_Bn VSS) capacitor c=8.153E-16
    I_C2773 (XI1_I22_p1 VSS) capacitor c=5.096E-16
    I_C2774 (XI1_I22_n2 VSS) capacitor c=7.945E-18
    I_C2775 (XI1_I22_An VSS) capacitor c=9.661E-16
    I_C2776 (XI1_I22_Bn VSS) capacitor c=8.159E-16
    I_C2777 (XI2_I76_p1 VSS) capacitor c=5.615E-16
    I_C2778 (XI2_I76_n1 VSS) capacitor c=1.887E-18
    I_C2779 (XI2_I76_n2 VSS) capacitor c=7.230E-18
    I_C2780 (XI2_I76_An VSS) capacitor c=9.426E-16
    I_C2781 (XI2_I76_Bn VSS) capacitor c=7.670E-16
    I_C2782 (XI1_I41_p1 VSS) capacitor c=5.224E-16
    I_C2783 (XI1_I41_n2 VSS) capacitor c=1.219E-17
    I_C2784 (XI1_I41_An VSS) capacitor c=9.870E-16
    I_C2785 (XI1_I41_Bn VSS) capacitor c=8.070E-16
    I_C2786 (XI1_I42_I215_p1 VSS) capacitor c=5.646E-16
    I_C2787 (XI1_I42_I215_n2 VSS) capacitor c=7.356E-18
    I_C2788 (XI1_I42_I215_An VSS) capacitor c=1.002E-15
    I_C2789 (XI1_I42_I215_Bn VSS) capacitor c=7.998E-16
    I_C2790 (XI1_I23_p1 VSS) capacitor c=5.539E-16
    I_C2791 (XI1_I23_n1 VSS) capacitor c=1.899E-18
    I_C2792 (XI1_I23_n2 VSS) capacitor c=6.545E-18
    I_C2793 (XI1_I23_An VSS) capacitor c=1.023E-15
    I_C2794 (XI1_I23_Bn VSS) capacitor c=8.107E-16
    I_C2795 (XI2_I178_p1 VSS) capacitor c=5.906E-16
    I_C2796 (XI2_I178_n1 VSS) capacitor c=6.822E-20
    I_C2797 (XI2_I178_n2 VSS) capacitor c=8.351E-18
    I_C2798 (XI2_I178_An VSS) capacitor c=1.008E-15
    I_C2799 (XI2_I178_Bn VSS) capacitor c=8.441E-16
    I_C2800 (XI1_I39_p1 VSS) capacitor c=5.403E-16
    I_C2801 (XI1_I39_n1 VSS) capacitor c=5.209E-18
    I_C2802 (XI1_I39_n2 VSS) capacitor c=4.303E-18
    I_C2803 (XI1_I39_An VSS) capacitor c=1.014E-15
    I_C2804 (XI1_I39_Bn VSS) capacitor c=9.010E-16
    I_C2805 (XI1_I42_I216_p1 VSS) capacitor c=5.172E-16
    I_C2806 (XI1_I42_I216_n1 VSS) capacitor c=4.170E-18
    I_C2807 (XI1_I42_I216_n2 VSS) capacitor c=7.184E-18
    I_C2808 (XI1_I42_I216_An VSS) capacitor c=1.007E-15
    I_C2809 (XI1_I42_I216_Bn VSS) capacitor c=8.048E-16
    I_C2810 (XI1_I42_I217_p1 VSS) capacitor c=5.503E-16
    I_C2811 (XI1_I42_I217_n1 VSS) capacitor c=6.756E-18
    I_C2812 (XI1_I42_I217_n2 VSS) capacitor c=4.484E-18
    I_C2813 (XI1_I42_I217_An VSS) capacitor c=9.843E-16
    I_C2814 (XI1_I42_I217_Bn VSS) capacitor c=7.970E-16
    I_C2815 (XI2_I82_p1 VSS) capacitor c=5.499E-16
    I_C2816 (XI2_I82_n1 VSS) capacitor c=1.059E-18
    I_C2817 (XI2_I82_n2 VSS) capacitor c=9.110E-18
    I_C2818 (XI2_I82_An VSS) capacitor c=9.621E-16
    I_C2819 (XI2_I82_Bn VSS) capacitor c=7.702E-16
    I_C2820 (XI1_I38_p1 VSS) capacitor c=5.481E-16
    I_C2821 (XI1_I38_n1 VSS) capacitor c=3.962E-18
    I_C2822 (XI1_I38_n2 VSS) capacitor c=9.353E-18
    I_C2823 (XI1_I38_An VSS) capacitor c=1.008E-15
    I_C2824 (XI1_I38_Bn VSS) capacitor c=8.520E-16
    I_C2825 (XI2_I88_p1 VSS) capacitor c=5.561E-16
    I_C2826 (XI2_I88_n1 VSS) capacitor c=1.447E-19
    I_C2827 (XI2_I88_n2 VSS) capacitor c=5.717E-18
    I_C2828 (XI2_I88_An VSS) capacitor c=9.621E-16
    I_C2829 (XI2_I88_Bn VSS) capacitor c=8.062E-16
    I_C2830 (XI2_I172_p1 VSS) capacitor c=5.505E-16
    I_C2831 (XI2_I172_n2 VSS) capacitor c=6.456E-18
    I_C2832 (XI2_I172_An VSS) capacitor c=9.859E-16
    I_C2833 (XI2_I172_Bn VSS) capacitor c=7.859E-16
    I_C2834 (XI1_I42_I218_p1 VSS) capacitor c=5.667E-16
    I_C2835 (XI1_I42_I218_n2 VSS) capacitor c=1.006E-17
    I_C2836 (XI1_I42_I218_An VSS) capacitor c=9.877E-16
    I_C2837 (XI1_I42_I218_Bn VSS) capacitor c=7.906E-16
    I_C2838 (XI1_I24_p1 VSS) capacitor c=5.601E-16
    I_C2839 (XI1_I24_n2 VSS) capacitor c=7.258E-18
    I_C2840 (XI1_I24_An VSS) capacitor c=9.922E-16
    I_C2841 (XI1_I24_Bn VSS) capacitor c=7.787E-16
    I_C2842 (XI2_I166_p1 VSS) capacitor c=6.005E-16
    I_C2843 (XI2_I166_n2 VSS) capacitor c=8.265E-18
    I_C2844 (XI2_I166_An VSS) capacitor c=9.996E-16
    I_C2845 (XI2_I166_Bn VSS) capacitor c=8.393E-16
    I_C2846 (XI1_I25_p1 VSS) capacitor c=5.644E-16
    I_C2847 (XI1_I25_n2 VSS) capacitor c=6.523E-18
    I_C2848 (XI1_I25_An VSS) capacitor c=9.623E-16
    I_C2849 (XI1_I25_Bn VSS) capacitor c=8.013E-16
    I_C2850 (XI2_I94_p1 VSS) capacitor c=5.672E-16
    I_C2851 (XI2_I94_n1 VSS) capacitor c=3.298E-18
    I_C2852 (XI2_I94_n2 VSS) capacitor c=9.557E-18
    I_C2853 (XI2_I94_An VSS) capacitor c=9.563E-16
    I_C2854 (XI2_I94_Bn VSS) capacitor c=8.055E-16
    I_C2855 (XI1_I37_p1 VSS) capacitor c=5.530E-16
    I_C2856 (XI1_I37_n2 VSS) capacitor c=7.782E-18
    I_C2857 (XI1_I37_An VSS) capacitor c=1.020E-15
    I_C2858 (XI1_I37_Bn VSS) capacitor c=8.418E-16
    I_C2859 (XI1_I42_I219_p1 VSS) capacitor c=5.587E-16
    I_C2860 (XI1_I42_I219_n2 VSS) capacitor c=7.364E-18
    I_C2861 (XI1_I42_I219_An VSS) capacitor c=1.019E-15
    I_C2862 (XI1_I42_I219_Bn VSS) capacitor c=7.957E-16
    I_C2863 (XI1_I26_p1 VSS) capacitor c=5.320E-16
    I_C2864 (XI1_I26_n2 VSS) capacitor c=7.162E-18
    I_C2865 (XI1_I26_An VSS) capacitor c=9.604E-16
    I_C2866 (XI1_I26_Bn VSS) capacitor c=7.832E-16
    I_C2867 (XI2_I160_p1 VSS) capacitor c=5.230E-16
    I_C2868 (XI2_I160_n2 VSS) capacitor c=9.855E-18
    I_C2869 (XI2_I160_An VSS) capacitor c=9.874E-16
    I_C2870 (XI2_I160_Bn VSS) capacitor c=7.844E-16
    I_C2871 (XI1_I35_p1 VSS) capacitor c=5.841E-16
    I_C2872 (XI1_I35_n2 VSS) capacitor c=8.277E-18
    I_C2873 (XI1_I35_An VSS) capacitor c=9.658E-16
    I_C2874 (XI1_I35_Bn VSS) capacitor c=7.997E-16
    I_C2875 (XI1_I36_p1 VSS) capacitor c=5.449E-16
    I_C2876 (XI1_I36_n1 VSS) capacitor c=1.518E-18
    I_C2877 (XI1_I36_n2 VSS) capacitor c=6.529E-18
    I_C2878 (XI1_I36_An VSS) capacitor c=9.818E-16
    I_C2879 (XI1_I36_Bn VSS) capacitor c=8.047E-16
    I_C2880 (XI1_I34_p1 VSS) capacitor c=5.677E-16
    I_C2881 (XI1_I34_n1 VSS) capacitor c=1.243E-19
    I_C2882 (XI1_I34_n2 VSS) capacitor c=8.966E-18
    I_C2883 (XI1_I34_An VSS) capacitor c=9.751E-16
    I_C2884 (XI1_I34_Bn VSS) capacitor c=7.725E-16
    I_C2885 (XI1_I33_p1 VSS) capacitor c=5.367E-16
    I_C2886 (XI1_I33_n2 VSS) capacitor c=7.770E-18
    I_C2887 (XI1_I33_An VSS) capacitor c=9.556E-16
    I_C2888 (XI1_I33_Bn VSS) capacitor c=7.452E-16
    I_C2889 (XI1_I32_p1 VSS) capacitor c=5.840E-16
    I_C2890 (XI1_I32_n1 VSS) capacitor c=2.978E-18
    I_C2891 (XI1_I32_n2 VSS) capacitor c=8.896E-18
    I_C2892 (XI1_I32_An VSS) capacitor c=1.009E-15
    I_C2893 (XI1_I32_Bn VSS) capacitor c=7.866E-16
    I_C2894 (XI1_I31_p1 VSS) capacitor c=5.769E-16
    I_C2895 (XI1_I31_n2 VSS) capacitor c=5.217E-18
    I_C2896 (XI1_I31_An VSS) capacitor c=9.796E-16
    I_C2897 (XI1_I31_Bn VSS) capacitor c=8.068E-16
    I_C2898 (XI1_I30_p1 VSS) capacitor c=5.647E-16
    I_C2899 (XI1_I30_n2 VSS) capacitor c=6.962E-18
    I_C2900 (XI1_I30_An VSS) capacitor c=9.892E-16
    I_C2901 (XI1_I30_Bn VSS) capacitor c=7.727E-16
    I_C2902 (XI2_I124_p1 VSS) capacitor c=6.052E-16
    I_C2903 (XI2_I124_n2 VSS) capacitor c=7.727E-18
    I_C2904 (XI2_I124_An VSS) capacitor c=1.010E-15
    I_C2905 (XI2_I124_Bn VSS) capacitor c=8.145E-16
    I_C2906 (XI1_I29_p1 VSS) capacitor c=5.303E-16
    I_C2907 (XI1_I29_n2 VSS) capacitor c=7.792E-18
    I_C2908 (XI1_I29_An VSS) capacitor c=1.005E-15
    I_C2909 (XI1_I29_Bn VSS) capacitor c=8.116E-16
    I_C2910 (XI1_I28_p1 VSS) capacitor c=6.101E-16
    I_C2911 (XI1_I28_n1 VSS) capacitor c=2.352E-18
    I_C2912 (XI1_I28_n2 VSS) capacitor c=9.279E-18
    I_C2913 (XI1_I28_An VSS) capacitor c=1.009E-15
    I_C2914 (XI1_I28_Bn VSS) capacitor c=7.951E-16
    I_C2915 (XI1_I27_p1 VSS) capacitor c=5.071E-16
    I_C2916 (XI1_I27_n1 VSS) capacitor c=7.567E-18
    I_C2917 (XI1_I27_n2 VSS) capacitor c=1.187E-17
    I_C2918 (XI1_I27_An VSS) capacitor c=9.864E-16
    I_C2919 (XI1_I27_Bn VSS) capacitor c=8.029E-16
    I_C2920 (XI2_I100_p1 VSS) capacitor c=5.720E-16
    I_C2921 (XI2_I100_n1 VSS) capacitor c=2.258E-18
    I_C2922 (XI2_I100_n2 VSS) capacitor c=9.246E-18
    I_C2923 (XI2_I100_An VSS) capacitor c=9.945E-16
    I_C2924 (XI2_I100_Bn VSS) capacitor c=8.212E-16
    I_C2925 (XI2_I148_p1 VSS) capacitor c=5.745E-16
    I_C2926 (XI2_I148_n1 VSS) capacitor c=3.820E-19
    I_C2927 (XI2_I148_n2 VSS) capacitor c=8.638E-18
    I_C2928 (XI2_I148_An VSS) capacitor c=9.816E-16
    I_C2929 (XI2_I148_Bn VSS) capacitor c=7.906E-16
    I_C2930 (XI2_I142_p1 VSS) capacitor c=5.697E-16
    I_C2931 (XI2_I142_n2 VSS) capacitor c=1.140E-17
    I_C2932 (XI2_I142_An VSS) capacitor c=9.481E-16
    I_C2933 (XI2_I142_Bn VSS) capacitor c=7.893E-16
    I_C2934 (XI2_I136_p1 VSS) capacitor c=5.707E-16
    I_C2935 (XI2_I136_n1 VSS) capacitor c=3.939E-18
    I_C2936 (XI2_I136_n2 VSS) capacitor c=7.651E-18
    I_C2937 (XI2_I136_An VSS) capacitor c=1.021E-15
    I_C2938 (XI2_I136_Bn VSS) capacitor c=7.967E-16
    I_C2939 (XI2_I112_p1 VSS) capacitor c=5.331E-16
    I_C2940 (XI2_I112_n1 VSS) capacitor c=5.335E-20
    I_C2941 (XI2_I112_n2 VSS) capacitor c=8.870E-18
    I_C2942 (XI2_I112_An VSS) capacitor c=1.029E-15
    I_C2943 (XI2_I112_Bn VSS) capacitor c=8.210E-16
    I_C2944 (XI2_I154_p1 VSS) capacitor c=6.269E-16
    I_C2945 (XI2_I154_n2 VSS) capacitor c=1.043E-17
    I_C2946 (XI2_I154_An VSS) capacitor c=1.006E-15
    I_C2947 (XI2_I154_Bn VSS) capacitor c=8.026E-16
    I_C2948 (XI2_I130_p1 VSS) capacitor c=6.040E-16
    I_C2949 (XI2_I130_n1 VSS) capacitor c=4.680E-20
    I_C2950 (XI2_I130_n2 VSS) capacitor c=8.018E-18
    I_C2951 (XI2_I130_An VSS) capacitor c=1.022E-15
    I_C2952 (XI2_I130_Bn VSS) capacitor c=7.802E-16
    I_C2953 (XI2_I118_p1 VSS) capacitor c=5.778E-16
    I_C2954 (XI2_I118_n2 VSS) capacitor c=4.893E-18
    I_C2955 (XI2_I118_An VSS) capacitor c=1.001E-15
    I_C2956 (XI2_I118_Bn VSS) capacitor c=8.062E-16
    I_C2957 (XI2_I106_p1 VSS) capacitor c=5.722E-16
    I_C2958 (XI2_I106_n2 VSS) capacitor c=7.815E-18
    I_C2959 (XI2_I106_An VSS) capacitor c=9.644E-16
    I_C2960 (XI2_I106_Bn VSS) capacitor c=7.762E-16
ends CORE32
