// ALU_TOPK sau layout: Assura RCX -> layout/rcx2scs.py - khong sua tay
simulator lang=spectre
subckt ALU_TOPK A_0 A_1 A_2 A_3 A_4 A_5 A_6 A_7 B_0 B_1 B_2 B_3 B_4 B_5 B_6 B_7 OP_0 OP_1 OP_2 OP_3 Y_0 Y_1 Y_2 Y_3 Y_4 Y_5 Y_6 Y_7 Y_8 Y_9 Y_10 Y_11 Y_12 Y_13 Y_14 Y_15 Z C V DZ VDD VSS
    I_MXI0_I55_MN12 (XI0_I55_sn I0_cm11_2 XI0_I55_n5 VSS) gpdk090_nmos1v w=0.18u l=0.1u ad=0.0756p as=0.0468p pd=1.16u ps=0.68u
    I_MXI0_I55_MN25 (I0_fa12_0 XI0_I55_sn VSS VSS) gpdk090_nmos1v w=0.12u l=0.1u ad=0.0696p as=0.0696p pd=1.16u ps=1.16u
    I_MXI0_I55_MN5 (XI0_I55_con I0_cm11_2 XI0_I55_n2 VSS) gpdk090_nmos1v w=0.24u l=0.1u ad=0.0528p as=0.0816p pd=0.68u ps=1.16u
    I_MXI0_I55_MN2 (XI0_I55_n1 I0_pp3_7 XI0_I55_con VSS) gpdk090_nmos1v w=0.24u l=0.1u ad=0.0528p as=0.0528p pd=0.68u ps=0.68u
    I_MXI0_I55_MN1 (VSS I0_sn2 XI0_I55_n1 VSS) gpdk090_nmos1v w=0.24u l=0.1u ad=0.0528p as=0.0528p pd=0.68u ps=0.68u
    I_MXI0_I55_MN3 (XI0_I55_n2 I0_sn2 VSS VSS) gpdk090_nmos1v w=0.24u l=0.1u ad=0.0528p as=0.0528p pd=0.68u ps=0.68u
    I_MXI0_I55_MN4 (VSS I0_pp3_7 XI0_I55_n2 VSS) gpdk090_nmos1v w=0.24u l=0.1u ad=0.0468p as=0.0528p pd=0.68u ps=0.68u
    I_MXI0_I55_MN27 (I0_fa12_1 XI0_I55_con VSS VSS) gpdk090_nmos1v w=0.12u l=0.1u ad=0.0696p as=0.0468p pd=1.16u ps=0.68u
    I_MXI0_I55_MN10 (XI0_I55_n4 I0_sn2 VSS VSS) gpdk090_nmos1v w=0.18u l=0.1u ad=0.0468p as=0.0756p pd=0.68u ps=1.16u
    I_MXI0_I55_MN11 (XI0_I55_n5 I0_pp3_7 XI0_I55_n4 VSS) gpdk090_nmos1v w=0.18u l=0.1u ad=0.0468p as=0.0468p pd=0.68u ps=0.68u
    I_MXI0_I55_MN11_1 (XI0_I55_n4 I0_pp3_7 XI0_I55_n5 VSS) gpdk090_nmos1v w=0.18u l=0.1u ad=0.0468p as=0.0468p pd=0.68u ps=0.68u
    I_MXI0_I55_MN10_1 (VSS I0_sn2 XI0_I55_n4 VSS) gpdk090_nmos1v w=0.18u l=0.1u ad=0.0498p as=0.0468p pd=0.68u ps=0.68u
    I_MXI0_I55_MN6 (XI0_I55_n3 I0_sn2 VSS VSS) gpdk090_nmos1v w=0.24u l=0.1u ad=0.0528p as=0.0498p pd=0.68u ps=0.68u
    I_MXI0_I55_MN7 (VSS I0_pp3_7 XI0_I55_n3 VSS) gpdk090_nmos1v w=0.24u l=0.1u ad=0.1176p as=0.0528p pd=1.22u ps=0.68u
    I_MXI0_I55_MN8 (XI0_I55_n3 I0_cm11_2 VSS VSS) gpdk090_nmos1v w=0.24u l=0.1u ad=0.0528p as=0.1176p pd=0.68u ps=1.22u
    I_MXI0_I55_MN9 (XI0_I55_sn XI0_I55_con XI0_I55_n3 VSS) gpdk090_nmos1v w=0.24u l=0.1u ad=0.0498p as=0.0528p pd=0.68u ps=0.68u
    I_MXI0_I55_MN12_1 (XI0_I55_n5 I0_cm11_2 XI0_I55_sn VSS) gpdk090_nmos1v w=0.18u l=0.1u ad=0.0468p as=0.0498p pd=0.68u ps=0.68u
    I_MXI0_I76_MN12 (XI0_I76_sn I0_rc7 XI0_I76_n5 VSS) gpdk090_nmos1v w=0.18u l=0.1u ad=0.0756p as=0.0468p pd=1.16u ps=0.68u
    I_MXI0_I76_MN25 (MULP_7 XI0_I76_sn VSS VSS) gpdk090_nmos1v w=0.12u l=0.1u ad=0.0696p as=0.0696p pd=1.16u ps=1.16u
    I_MXI0_I76_MN5 (XI0_I76_con I0_rc7 XI0_I76_n2 VSS) gpdk090_nmos1v w=0.24u l=0.1u ad=0.0528p as=0.0816p pd=0.68u ps=1.16u
    I_MXI0_I76_MN2 (XI0_I76_n1 I0_ha17_0 XI0_I76_con VSS) gpdk090_nmos1v w=0.24u l=0.1u ad=0.0528p as=0.0528p pd=0.68u ps=0.68u
    I_MXI0_I76_MN1 (VSS I0_ha16_1 XI0_I76_n1 VSS) gpdk090_nmos1v w=0.24u l=0.1u ad=0.0528p as=0.0528p pd=0.68u ps=0.68u
    I_MXI0_I76_MN3 (XI0_I76_n2 I0_ha16_1 VSS VSS) gpdk090_nmos1v w=0.24u l=0.1u ad=0.0528p as=0.0528p pd=0.68u ps=0.68u
    I_MXI0_I76_MN4 (VSS I0_ha17_0 XI0_I76_n2 VSS) gpdk090_nmos1v w=0.24u l=0.1u ad=0.0468p as=0.0528p pd=0.68u ps=0.68u
    I_MXI0_I76_MN27 (I0_rc8 XI0_I76_con VSS VSS) gpdk090_nmos1v w=0.12u l=0.1u ad=0.0696p as=0.0468p pd=1.16u ps=0.68u
    I_MXI0_I76_MN10 (XI0_I76_n4 I0_ha16_1 VSS VSS) gpdk090_nmos1v w=0.18u l=0.1u ad=0.0468p as=0.0756p pd=0.68u ps=1.16u
    I_MXI0_I76_MN11 (XI0_I76_n5 I0_ha17_0 XI0_I76_n4 VSS) gpdk090_nmos1v w=0.18u l=0.1u ad=0.0468p as=0.0468p pd=0.68u ps=0.68u
    I_MXI0_I76_MN11_1 (XI0_I76_n4 I0_ha17_0 XI0_I76_n5 VSS) gpdk090_nmos1v w=0.18u l=0.1u ad=0.0468p as=0.0468p pd=0.68u ps=0.68u
    I_MXI0_I76_MN10_1 (VSS I0_ha16_1 XI0_I76_n4 VSS) gpdk090_nmos1v w=0.18u l=0.1u ad=0.0498p as=0.0468p pd=0.68u ps=0.68u
    I_MXI0_I76_MN6 (XI0_I76_n3 I0_ha16_1 VSS VSS) gpdk090_nmos1v w=0.24u l=0.1u ad=0.0528p as=0.0498p pd=0.68u ps=0.68u
    I_MXI0_I76_MN7 (VSS I0_ha17_0 XI0_I76_n3 VSS) gpdk090_nmos1v w=0.24u l=0.1u ad=0.1176p as=0.0528p pd=1.22u ps=0.68u
    I_MXI0_I76_MN8 (XI0_I76_n3 I0_rc7 VSS VSS) gpdk090_nmos1v w=0.24u l=0.1u ad=0.0528p as=0.1176p pd=0.68u ps=1.22u
    I_MXI0_I76_MN9 (XI0_I76_sn XI0_I76_con XI0_I76_n3 VSS) gpdk090_nmos1v w=0.24u l=0.1u ad=0.0498p as=0.0528p pd=0.68u ps=0.68u
    I_MXI0_I76_MN12_1 (XI0_I76_n5 I0_rc7 XI0_I76_sn VSS) gpdk090_nmos1v w=0.18u l=0.1u ad=0.0468p as=0.0498p pd=0.68u ps=0.68u
    I_MXI0_I75_MN12 (XI0_I75_sn I0_rc6 XI0_I75_n5 VSS) gpdk090_nmos1v w=0.18u l=0.1u ad=0.0756p as=0.0468p pd=1.16u ps=0.68u
    I_MXI0_I75_MN25 (MULP_6 XI0_I75_sn VSS VSS) gpdk090_nmos1v w=0.12u l=0.1u ad=0.0696p as=0.0696p pd=1.16u ps=1.16u
    I_MXI0_I75_MN5 (XI0_I75_con I0_rc6 XI0_I75_n2 VSS) gpdk090_nmos1v w=0.24u l=0.1u ad=0.0528p as=0.0816p pd=0.68u ps=1.16u
    I_MXI0_I75_MN2 (XI0_I75_n1 I0_ha16_0 XI0_I75_con VSS) gpdk090_nmos1v w=0.24u l=0.1u ad=0.0528p as=0.0528p pd=0.68u ps=0.68u
    I_MXI0_I75_MN1 (VSS I0_ha15_1 XI0_I75_n1 VSS) gpdk090_nmos1v w=0.24u l=0.1u ad=0.0528p as=0.0528p pd=0.68u ps=0.68u
    I_MXI0_I75_MN3 (XI0_I75_n2 I0_ha15_1 VSS VSS) gpdk090_nmos1v w=0.24u l=0.1u ad=0.0528p as=0.0528p pd=0.68u ps=0.68u
    I_MXI0_I75_MN4 (VSS I0_ha16_0 XI0_I75_n2 VSS) gpdk090_nmos1v w=0.24u l=0.1u ad=0.0468p as=0.0528p pd=0.68u ps=0.68u
    I_MXI0_I75_MN27 (I0_rc7 XI0_I75_con VSS VSS) gpdk090_nmos1v w=0.12u l=0.1u ad=0.0696p as=0.0468p pd=1.16u ps=0.68u
    I_MXI0_I75_MN10 (XI0_I75_n4 I0_ha15_1 VSS VSS) gpdk090_nmos1v w=0.18u l=0.1u ad=0.0468p as=0.0756p pd=0.68u ps=1.16u
    I_MXI0_I75_MN11 (XI0_I75_n5 I0_ha16_0 XI0_I75_n4 VSS) gpdk090_nmos1v w=0.18u l=0.1u ad=0.0468p as=0.0468p pd=0.68u ps=0.68u
    I_MXI0_I75_MN11_1 (XI0_I75_n4 I0_ha16_0 XI0_I75_n5 VSS) gpdk090_nmos1v w=0.18u l=0.1u ad=0.0468p as=0.0468p pd=0.68u ps=0.68u
    I_MXI0_I75_MN10_1 (VSS I0_ha15_1 XI0_I75_n4 VSS) gpdk090_nmos1v w=0.18u l=0.1u ad=0.0498p as=0.0468p pd=0.68u ps=0.68u
    I_MXI0_I75_MN6 (XI0_I75_n3 I0_ha15_1 VSS VSS) gpdk090_nmos1v w=0.24u l=0.1u ad=0.0528p as=0.0498p pd=0.68u ps=0.68u
    I_MXI0_I75_MN7 (VSS I0_ha16_0 XI0_I75_n3 VSS) gpdk090_nmos1v w=0.24u l=0.1u ad=0.1176p as=0.0528p pd=1.22u ps=0.68u
    I_MXI0_I75_MN8 (XI0_I75_n3 I0_rc6 VSS VSS) gpdk090_nmos1v w=0.24u l=0.1u ad=0.0528p as=0.1176p pd=0.68u ps=1.22u
    I_MXI0_I75_MN9 (XI0_I75_sn XI0_I75_con XI0_I75_n3 VSS) gpdk090_nmos1v w=0.24u l=0.1u ad=0.0498p as=0.0528p pd=0.68u ps=0.68u
    I_MXI0_I75_MN12_1 (XI0_I75_n5 I0_rc6 XI0_I75_sn VSS) gpdk090_nmos1v w=0.18u l=0.1u ad=0.0468p as=0.0498p pd=0.68u ps=0.68u
    I_MXI0_I47_MN12 (XI0_I47_sn I0_pp2_1 XI0_I47_n5 VSS) gpdk090_nmos1v w=0.18u l=0.1u ad=0.0756p as=0.0468p pd=1.16u ps=0.68u
    I_MXI0_I47_MN25 (I0_fa4_0 XI0_I47_sn VSS VSS) gpdk090_nmos1v w=0.12u l=0.1u ad=0.0696p as=0.0696p pd=1.16u ps=1.16u
    I_MXI0_I47_MN5 (XI0_I47_con I0_pp2_1 XI0_I47_n2 VSS) gpdk090_nmos1v w=0.24u l=0.1u ad=0.0528p as=0.0816p pd=0.68u ps=1.16u
    I_MXI0_I47_MN2 (XI0_I47_n1 I0_pp1_3 XI0_I47_con VSS) gpdk090_nmos1v w=0.24u l=0.1u ad=0.0528p as=0.0528p pd=0.68u ps=0.68u
    I_MXI0_I47_MN1 (VSS I0_pp0_5 XI0_I47_n1 VSS) gpdk090_nmos1v w=0.24u l=0.1u ad=0.0528p as=0.0528p pd=0.68u ps=0.68u
    I_MXI0_I47_MN3 (XI0_I47_n2 I0_pp0_5 VSS VSS) gpdk090_nmos1v w=0.24u l=0.1u ad=0.0528p as=0.0528p pd=0.68u ps=0.68u
    I_MXI0_I47_MN4 (VSS I0_pp1_3 XI0_I47_n2 VSS) gpdk090_nmos1v w=0.24u l=0.1u ad=0.0468p as=0.0528p pd=0.68u ps=0.68u
    I_MXI0_I47_MN27 (I0_fa4_1 XI0_I47_con VSS VSS) gpdk090_nmos1v w=0.12u l=0.1u ad=0.0696p as=0.0468p pd=1.16u ps=0.68u
    I_MXI0_I47_MN10 (XI0_I47_n4 I0_pp0_5 VSS VSS) gpdk090_nmos1v w=0.18u l=0.1u ad=0.0468p as=0.0756p pd=0.68u ps=1.16u
    I_MXI0_I47_MN11 (XI0_I47_n5 I0_pp1_3 XI0_I47_n4 VSS) gpdk090_nmos1v w=0.18u l=0.1u ad=0.0468p as=0.0468p pd=0.68u ps=0.68u
    I_MXI0_I47_MN11_1 (XI0_I47_n4 I0_pp1_3 XI0_I47_n5 VSS) gpdk090_nmos1v w=0.18u l=0.1u ad=0.0468p as=0.0468p pd=0.68u ps=0.68u
    I_MXI0_I47_MN10_1 (VSS I0_pp0_5 XI0_I47_n4 VSS) gpdk090_nmos1v w=0.18u l=0.1u ad=0.0498p as=0.0468p pd=0.68u ps=0.68u
    I_MXI0_I47_MN6 (XI0_I47_n3 I0_pp0_5 VSS VSS) gpdk090_nmos1v w=0.24u l=0.1u ad=0.0528p as=0.0498p pd=0.68u ps=0.68u
    I_MXI0_I47_MN7 (VSS I0_pp1_3 XI0_I47_n3 VSS) gpdk090_nmos1v w=0.24u l=0.1u ad=0.1176p as=0.0528p pd=1.22u ps=0.68u
    I_MXI0_I47_MN8 (XI0_I47_n3 I0_pp2_1 VSS VSS) gpdk090_nmos1v w=0.24u l=0.1u ad=0.0528p as=0.1176p pd=0.68u ps=1.22u
    I_MXI0_I47_MN9 (XI0_I47_sn XI0_I47_con XI0_I47_n3 VSS) gpdk090_nmos1v w=0.24u l=0.1u ad=0.0498p as=0.0528p pd=0.68u ps=0.68u
    I_MXI0_I47_MN12_1 (XI0_I47_n5 I0_pp2_1 XI0_I47_sn VSS) gpdk090_nmos1v w=0.18u l=0.1u ad=0.0468p as=0.0498p pd=0.68u ps=0.68u
    I_MXI0_I74_MN12 (XI0_I74_sn I0_rc5 XI0_I74_n5 VSS) gpdk090_nmos1v w=0.18u l=0.1u ad=0.0756p as=0.0468p pd=1.16u ps=0.68u
    I_MXI0_I74_MN25 (MULP_5 XI0_I74_sn VSS VSS) gpdk090_nmos1v w=0.12u l=0.1u ad=0.0696p as=0.0696p pd=1.16u ps=1.16u
    I_MXI0_I74_MN5 (XI0_I74_con I0_rc5 XI0_I74_n2 VSS) gpdk090_nmos1v w=0.24u l=0.1u ad=0.0528p as=0.0816p pd=0.68u ps=1.16u
    I_MXI0_I74_MN2 (XI0_I74_n1 I0_ha15_0 XI0_I74_con VSS) gpdk090_nmos1v w=0.24u l=0.1u ad=0.0528p as=0.0528p pd=0.68u ps=0.68u
    I_MXI0_I74_MN1 (VSS I0_fa14_1 XI0_I74_n1 VSS) gpdk090_nmos1v w=0.24u l=0.1u ad=0.0528p as=0.0528p pd=0.68u ps=0.68u
    I_MXI0_I74_MN3 (XI0_I74_n2 I0_fa14_1 VSS VSS) gpdk090_nmos1v w=0.24u l=0.1u ad=0.0528p as=0.0528p pd=0.68u ps=0.68u
    I_MXI0_I74_MN4 (VSS I0_ha15_0 XI0_I74_n2 VSS) gpdk090_nmos1v w=0.24u l=0.1u ad=0.0468p as=0.0528p pd=0.68u ps=0.68u
    I_MXI0_I74_MN27 (I0_rc6 XI0_I74_con VSS VSS) gpdk090_nmos1v w=0.12u l=0.1u ad=0.0696p as=0.0468p pd=1.16u ps=0.68u
    I_MXI0_I74_MN10 (XI0_I74_n4 I0_fa14_1 VSS VSS) gpdk090_nmos1v w=0.18u l=0.1u ad=0.0468p as=0.0756p pd=0.68u ps=1.16u
    I_MXI0_I74_MN11 (XI0_I74_n5 I0_ha15_0 XI0_I74_n4 VSS) gpdk090_nmos1v w=0.18u l=0.1u ad=0.0468p as=0.0468p pd=0.68u ps=0.68u
    I_MXI0_I74_MN11_1 (XI0_I74_n4 I0_ha15_0 XI0_I74_n5 VSS) gpdk090_nmos1v w=0.18u l=0.1u ad=0.0468p as=0.0468p pd=0.68u ps=0.68u
    I_MXI0_I74_MN10_1 (VSS I0_fa14_1 XI0_I74_n4 VSS) gpdk090_nmos1v w=0.18u l=0.1u ad=0.0498p as=0.0468p pd=0.68u ps=0.68u
    I_MXI0_I74_MN6 (XI0_I74_n3 I0_fa14_1 VSS VSS) gpdk090_nmos1v w=0.24u l=0.1u ad=0.0528p as=0.0498p pd=0.68u ps=0.68u
    I_MXI0_I74_MN7 (VSS I0_ha15_0 XI0_I74_n3 VSS) gpdk090_nmos1v w=0.24u l=0.1u ad=0.1176p as=0.0528p pd=1.22u ps=0.68u
    I_MXI0_I74_MN8 (XI0_I74_n3 I0_rc5 VSS VSS) gpdk090_nmos1v w=0.24u l=0.1u ad=0.0528p as=0.1176p pd=0.68u ps=1.22u
    I_MXI0_I74_MN9 (XI0_I74_sn XI0_I74_con XI0_I74_n3 VSS) gpdk090_nmos1v w=0.24u l=0.1u ad=0.0498p as=0.0528p pd=0.68u ps=0.68u
    I_MXI0_I74_MN12_1 (XI0_I74_n5 I0_rc5 XI0_I74_sn VSS) gpdk090_nmos1v w=0.18u l=0.1u ad=0.0468p as=0.0498p pd=0.68u ps=0.68u
    I_MXI0_I57_MN12 (XI0_I57_sn B_5 XI0_I57_n5 VSS) gpdk090_nmos1v w=0.18u l=0.1u ad=0.0756p as=0.0468p pd=1.16u ps=0.68u
    I_MXI0_I57_MN25 (I0_fa14_0 XI0_I57_sn VSS VSS) gpdk090_nmos1v w=0.12u l=0.1u ad=0.0696p as=0.0696p pd=1.16u ps=1.16u
    I_MXI0_I57_MN5 (XI0_I57_con B_5 XI0_I57_n2 VSS) gpdk090_nmos1v w=0.24u l=0.1u ad=0.0528p as=0.0816p pd=0.68u ps=1.16u
    I_MXI0_I57_MN2 (XI0_I57_n1 I0_fa3_0 XI0_I57_con VSS) gpdk090_nmos1v w=0.24u l=0.1u ad=0.0528p as=0.0528p pd=0.68u ps=0.68u
    I_MXI0_I57_MN1 (VSS I0_ha2_1 XI0_I57_n1 VSS) gpdk090_nmos1v w=0.24u l=0.1u ad=0.0528p as=0.0528p pd=0.68u ps=0.68u
    I_MXI0_I57_MN3 (XI0_I57_n2 I0_ha2_1 VSS VSS) gpdk090_nmos1v w=0.24u l=0.1u ad=0.0528p as=0.0528p pd=0.68u ps=0.68u
    I_MXI0_I57_MN4 (VSS I0_fa3_0 XI0_I57_n2 VSS) gpdk090_nmos1v w=0.24u l=0.1u ad=0.0468p as=0.0528p pd=0.68u ps=0.68u
    I_MXI0_I57_MN27 (I0_fa14_1 XI0_I57_con VSS VSS) gpdk090_nmos1v w=0.12u l=0.1u ad=0.0696p as=0.0468p pd=1.16u ps=0.68u
    I_MXI0_I57_MN10 (XI0_I57_n4 I0_ha2_1 VSS VSS) gpdk090_nmos1v w=0.18u l=0.1u ad=0.0468p as=0.0756p pd=0.68u ps=1.16u
    I_MXI0_I57_MN11 (XI0_I57_n5 I0_fa3_0 XI0_I57_n4 VSS) gpdk090_nmos1v w=0.18u l=0.1u ad=0.0468p as=0.0468p pd=0.68u ps=0.68u
    I_MXI0_I57_MN11_1 (XI0_I57_n4 I0_fa3_0 XI0_I57_n5 VSS) gpdk090_nmos1v w=0.18u l=0.1u ad=0.0468p as=0.0468p pd=0.68u ps=0.68u
    I_MXI0_I57_MN10_1 (VSS I0_ha2_1 XI0_I57_n4 VSS) gpdk090_nmos1v w=0.18u l=0.1u ad=0.0498p as=0.0468p pd=0.68u ps=0.68u
    I_MXI0_I57_MN6 (XI0_I57_n3 I0_ha2_1 VSS VSS) gpdk090_nmos1v w=0.24u l=0.1u ad=0.0528p as=0.0498p pd=0.68u ps=0.68u
    I_MXI0_I57_MN7 (VSS I0_fa3_0 XI0_I57_n3 VSS) gpdk090_nmos1v w=0.24u l=0.1u ad=0.1176p as=0.0528p pd=1.22u ps=0.68u
    I_MXI0_I57_MN8 (XI0_I57_n3 B_5 VSS VSS) gpdk090_nmos1v w=0.24u l=0.1u ad=0.0528p as=0.1176p pd=0.68u ps=1.22u
    I_MXI0_I57_MN9 (XI0_I57_sn XI0_I57_con XI0_I57_n3 VSS) gpdk090_nmos1v w=0.24u l=0.1u ad=0.0498p as=0.0528p pd=0.68u ps=0.68u
    I_MXI0_I57_MN12_1 (XI0_I57_n5 B_5 XI0_I57_sn VSS) gpdk090_nmos1v w=0.18u l=0.1u ad=0.0468p as=0.0498p pd=0.68u ps=0.68u
    I_MXI0_I46_MN12 (XI0_I46_sn I0_pp2_0 XI0_I46_n5 VSS) gpdk090_nmos1v w=0.18u l=0.1u ad=0.0756p as=0.0468p pd=1.16u ps=0.68u
    I_MXI0_I46_MN25 (I0_fa3_0 XI0_I46_sn VSS VSS) gpdk090_nmos1v w=0.12u l=0.1u ad=0.0696p as=0.0696p pd=1.16u ps=1.16u
    I_MXI0_I46_MN5 (XI0_I46_con I0_pp2_0 XI0_I46_n2 VSS) gpdk090_nmos1v w=0.24u l=0.1u ad=0.0528p as=0.0816p pd=0.68u ps=1.16u
    I_MXI0_I46_MN2 (XI0_I46_n1 I0_pp1_2 XI0_I46_con VSS) gpdk090_nmos1v w=0.24u l=0.1u ad=0.0528p as=0.0528p pd=0.68u ps=0.68u
    I_MXI0_I46_MN1 (VSS I0_pp0_4 XI0_I46_n1 VSS) gpdk090_nmos1v w=0.24u l=0.1u ad=0.0528p as=0.0528p pd=0.68u ps=0.68u
    I_MXI0_I46_MN3 (XI0_I46_n2 I0_pp0_4 VSS VSS) gpdk090_nmos1v w=0.24u l=0.1u ad=0.0528p as=0.0528p pd=0.68u ps=0.68u
    I_MXI0_I46_MN4 (VSS I0_pp1_2 XI0_I46_n2 VSS) gpdk090_nmos1v w=0.24u l=0.1u ad=0.0468p as=0.0528p pd=0.68u ps=0.68u
    I_MXI0_I46_MN27 (I0_fa3_1 XI0_I46_con VSS VSS) gpdk090_nmos1v w=0.12u l=0.1u ad=0.0696p as=0.0468p pd=1.16u ps=0.68u
    I_MXI0_I46_MN10 (XI0_I46_n4 I0_pp0_4 VSS VSS) gpdk090_nmos1v w=0.18u l=0.1u ad=0.0468p as=0.0756p pd=0.68u ps=1.16u
    I_MXI0_I46_MN11 (XI0_I46_n5 I0_pp1_2 XI0_I46_n4 VSS) gpdk090_nmos1v w=0.18u l=0.1u ad=0.0468p as=0.0468p pd=0.68u ps=0.68u
    I_MXI0_I46_MN11_1 (XI0_I46_n4 I0_pp1_2 XI0_I46_n5 VSS) gpdk090_nmos1v w=0.18u l=0.1u ad=0.0468p as=0.0468p pd=0.68u ps=0.68u
    I_MXI0_I46_MN10_1 (VSS I0_pp0_4 XI0_I46_n4 VSS) gpdk090_nmos1v w=0.18u l=0.1u ad=0.0498p as=0.0468p pd=0.68u ps=0.68u
    I_MXI0_I46_MN6 (XI0_I46_n3 I0_pp0_4 VSS VSS) gpdk090_nmos1v w=0.24u l=0.1u ad=0.0528p as=0.0498p pd=0.68u ps=0.68u
    I_MXI0_I46_MN7 (VSS I0_pp1_2 XI0_I46_n3 VSS) gpdk090_nmos1v w=0.24u l=0.1u ad=0.1176p as=0.0528p pd=1.22u ps=0.68u
    I_MXI0_I46_MN8 (XI0_I46_n3 I0_pp2_0 VSS VSS) gpdk090_nmos1v w=0.24u l=0.1u ad=0.0528p as=0.1176p pd=0.68u ps=1.22u
    I_MXI0_I46_MN9 (XI0_I46_sn XI0_I46_con XI0_I46_n3 VSS) gpdk090_nmos1v w=0.24u l=0.1u ad=0.0498p as=0.0528p pd=0.68u ps=0.68u
    I_MXI0_I46_MN12_1 (XI0_I46_n5 I0_pp2_0 XI0_I46_sn VSS) gpdk090_nmos1v w=0.18u l=0.1u ad=0.0468p as=0.0498p pd=0.68u ps=0.68u
    I_MXI0_I72_MN12 (XI0_I72_sn I0_rc3 XI0_I72_n5 VSS) gpdk090_nmos1v w=0.18u l=0.1u ad=0.0756p as=0.0468p pd=1.16u ps=0.68u
    I_MXI0_I72_MN25 (MULP_3 XI0_I72_sn VSS VSS) gpdk090_nmos1v w=0.12u l=0.1u ad=0.0696p as=0.0696p pd=1.16u ps=1.16u
    I_MXI0_I72_MN5 (XI0_I72_con I0_rc3 XI0_I72_n2 VSS) gpdk090_nmos1v w=0.24u l=0.1u ad=0.0528p as=0.0816p pd=0.68u ps=1.16u
    I_MXI0_I72_MN2 (XI0_I72_n1 I0_ha2_0 XI0_I72_con VSS) gpdk090_nmos1v w=0.24u l=0.1u ad=0.0528p as=0.0528p pd=0.68u ps=0.68u
    I_MXI0_I72_MN1 (VSS I0_fa1_1 XI0_I72_n1 VSS) gpdk090_nmos1v w=0.24u l=0.1u ad=0.0528p as=0.0528p pd=0.68u ps=0.68u
    I_MXI0_I72_MN3 (XI0_I72_n2 I0_fa1_1 VSS VSS) gpdk090_nmos1v w=0.24u l=0.1u ad=0.0528p as=0.0528p pd=0.68u ps=0.68u
    I_MXI0_I72_MN4 (VSS I0_ha2_0 XI0_I72_n2 VSS) gpdk090_nmos1v w=0.24u l=0.1u ad=0.0468p as=0.0528p pd=0.68u ps=0.68u
    I_MXI0_I72_MN27 (I0_rc4 XI0_I72_con VSS VSS) gpdk090_nmos1v w=0.12u l=0.1u ad=0.0696p as=0.0468p pd=1.16u ps=0.68u
    I_MXI0_I72_MN10 (XI0_I72_n4 I0_fa1_1 VSS VSS) gpdk090_nmos1v w=0.18u l=0.1u ad=0.0468p as=0.0756p pd=0.68u ps=1.16u
    I_MXI0_I72_MN11 (XI0_I72_n5 I0_ha2_0 XI0_I72_n4 VSS) gpdk090_nmos1v w=0.18u l=0.1u ad=0.0468p as=0.0468p pd=0.68u ps=0.68u
    I_MXI0_I72_MN11_1 (XI0_I72_n4 I0_ha2_0 XI0_I72_n5 VSS) gpdk090_nmos1v w=0.18u l=0.1u ad=0.0468p as=0.0468p pd=0.68u ps=0.68u
    I_MXI0_I72_MN10_1 (VSS I0_fa1_1 XI0_I72_n4 VSS) gpdk090_nmos1v w=0.18u l=0.1u ad=0.0498p as=0.0468p pd=0.68u ps=0.68u
    I_MXI0_I72_MN6 (XI0_I72_n3 I0_fa1_1 VSS VSS) gpdk090_nmos1v w=0.24u l=0.1u ad=0.0528p as=0.0498p pd=0.68u ps=0.68u
    I_MXI0_I72_MN7 (VSS I0_ha2_0 XI0_I72_n3 VSS) gpdk090_nmos1v w=0.24u l=0.1u ad=0.1176p as=0.0528p pd=1.22u ps=0.68u
    I_MXI0_I72_MN8 (XI0_I72_n3 I0_rc3 VSS VSS) gpdk090_nmos1v w=0.24u l=0.1u ad=0.0528p as=0.1176p pd=0.68u ps=1.22u
    I_MXI0_I72_MN9 (XI0_I72_sn XI0_I72_con XI0_I72_n3 VSS) gpdk090_nmos1v w=0.24u l=0.1u ad=0.0498p as=0.0528p pd=0.68u ps=0.68u
    I_MXI0_I72_MN12_1 (XI0_I72_n5 I0_rc3 XI0_I72_sn VSS) gpdk090_nmos1v w=0.18u l=0.1u ad=0.0468p as=0.0498p pd=0.68u ps=0.68u
    I_MXI0_I44_MN12 (XI0_I44_sn B_3 XI0_I44_n5 VSS) gpdk090_nmos1v w=0.18u l=0.1u ad=0.0756p as=0.0468p pd=1.16u ps=0.68u
    I_MXI0_I44_MN25 (I0_fa1_0 XI0_I44_sn VSS VSS) gpdk090_nmos1v w=0.12u l=0.1u ad=0.0696p as=0.0696p pd=1.16u ps=1.16u
    I_MXI0_I44_MN5 (XI0_I44_con B_3 XI0_I44_n2 VSS) gpdk090_nmos1v w=0.24u l=0.1u ad=0.0528p as=0.0816p pd=0.68u ps=1.16u
    I_MXI0_I44_MN2 (XI0_I44_n1 I0_pp1_0 XI0_I44_con VSS) gpdk090_nmos1v w=0.24u l=0.1u ad=0.0528p as=0.0528p pd=0.68u ps=0.68u
    I_MXI0_I44_MN1 (VSS I0_pp0_2 XI0_I44_n1 VSS) gpdk090_nmos1v w=0.24u l=0.1u ad=0.0528p as=0.0528p pd=0.68u ps=0.68u
    I_MXI0_I44_MN3 (XI0_I44_n2 I0_pp0_2 VSS VSS) gpdk090_nmos1v w=0.24u l=0.1u ad=0.0528p as=0.0528p pd=0.68u ps=0.68u
    I_MXI0_I44_MN4 (VSS I0_pp1_0 XI0_I44_n2 VSS) gpdk090_nmos1v w=0.24u l=0.1u ad=0.0468p as=0.0528p pd=0.68u ps=0.68u
    I_MXI0_I44_MN27 (I0_fa1_1 XI0_I44_con VSS VSS) gpdk090_nmos1v w=0.12u l=0.1u ad=0.0696p as=0.0468p pd=1.16u ps=0.68u
    I_MXI0_I44_MN10 (XI0_I44_n4 I0_pp0_2 VSS VSS) gpdk090_nmos1v w=0.18u l=0.1u ad=0.0468p as=0.0756p pd=0.68u ps=1.16u
    I_MXI0_I44_MN11 (XI0_I44_n5 I0_pp1_0 XI0_I44_n4 VSS) gpdk090_nmos1v w=0.18u l=0.1u ad=0.0468p as=0.0468p pd=0.68u ps=0.68u
    I_MXI0_I44_MN11_1 (XI0_I44_n4 I0_pp1_0 XI0_I44_n5 VSS) gpdk090_nmos1v w=0.18u l=0.1u ad=0.0468p as=0.0468p pd=0.68u ps=0.68u
    I_MXI0_I44_MN10_1 (VSS I0_pp0_2 XI0_I44_n4 VSS) gpdk090_nmos1v w=0.18u l=0.1u ad=0.0498p as=0.0468p pd=0.68u ps=0.68u
    I_MXI0_I44_MN6 (XI0_I44_n3 I0_pp0_2 VSS VSS) gpdk090_nmos1v w=0.24u l=0.1u ad=0.0528p as=0.0498p pd=0.68u ps=0.68u
    I_MXI0_I44_MN7 (VSS I0_pp1_0 XI0_I44_n3 VSS) gpdk090_nmos1v w=0.24u l=0.1u ad=0.1176p as=0.0528p pd=1.22u ps=0.68u
    I_MXI0_I44_MN8 (XI0_I44_n3 B_3 VSS VSS) gpdk090_nmos1v w=0.24u l=0.1u ad=0.0528p as=0.1176p pd=0.68u ps=1.22u
    I_MXI0_I44_MN9 (XI0_I44_sn XI0_I44_con XI0_I44_n3 VSS) gpdk090_nmos1v w=0.24u l=0.1u ad=0.0498p as=0.0528p pd=0.68u ps=0.68u
    I_MXI0_I44_MN12_1 (XI0_I44_n5 B_3 XI0_I44_sn VSS) gpdk090_nmos1v w=0.18u l=0.1u ad=0.0468p as=0.0498p pd=0.68u ps=0.68u
    I_MXI1_I190_MN1 (XI1_I190_Bn I1_nrkn6 VSS VSS) gpdk090_nmos1v w=0.12u l=0.1u ad=0.0696p as=0.0696p pd=1.16u ps=1.16u
    I_MXI1_I190_MN5 (XI1_I190_n2 I1_nrkn6 VSS VSS) gpdk090_nmos1v w=0.24u l=0.1u ad=0.0528p as=0.0816p pd=0.68u ps=1.16u
    I_MXI1_I190_MN4 (DIVR_6 XI1_I190_An XI1_I190_n2 VSS) gpdk090_nmos1v w=0.24u l=0.1u ad=0.0528p as=0.0528p pd=0.68u ps=0.68u
    I_MXI1_I190_MN2 (XI1_I190_n1 I1_ru6 DIVR_6 VSS) gpdk090_nmos1v w=0.24u l=0.1u ad=0.0528p as=0.0528p pd=0.68u ps=0.68u
    I_MXI1_I190_MN3 (VSS XI1_I190_Bn XI1_I190_n1 VSS) gpdk090_nmos1v w=0.24u l=0.1u ad=0.0816p as=0.0528p pd=1.16u ps=0.68u
    I_MXI1_I190_MN0 (XI1_I190_An I1_ru6 VSS VSS) gpdk090_nmos1v w=0.12u l=0.1u ad=0.0696p as=0.0696p pd=1.16u ps=1.16u
    I_MXI0_I77_I44_MN1 (XI0_I77_I44_Bn I0_kc7 VSS VSS) gpdk090_nmos1v w=0.12u l=0.1u ad=0.0696p as=0.0696p pd=1.16u ps=1.16u
    I_MXI0_I77_I44_MN5 (XI0_I77_I44_n2 I0_kc7 VSS VSS) gpdk090_nmos1v w=0.24u l=0.1u ad=0.0528p as=0.0816p pd=0.68u ps=1.16u
    I_MXI0_I77_I44_MN4 (MULP_15 XI0_I77_I44_An XI0_I77_I44_n2 VSS) gpdk090_nmos1v w=0.24u l=0.1u ad=0.0528p as=0.0528p pd=0.68u ps=0.68u
    I_MXI0_I77_I44_MN2 (XI0_I77_I44_n1 I0_I77_pn7 MULP_15 VSS) gpdk090_nmos1v w=0.24u l=0.1u ad=0.0528p as=0.0528p pd=0.68u ps=0.68u
    I_MXI0_I77_I44_MN3 (VSS XI0_I77_I44_Bn XI0_I77_I44_n1 VSS) gpdk090_nmos1v w=0.24u l=0.1u ad=0.0816p as=0.0528p pd=1.16u ps=0.68u
    I_MXI0_I77_I44_MN0 (XI0_I77_I44_An I0_I77_pn7 VSS VSS) gpdk090_nmos1v w=0.12u l=0.1u ad=0.0696p as=0.0696p pd=1.16u ps=1.16u
    I_MXI0_I77_I43_MN1 (XI0_I77_I43_Bn I0_I77_G5_0 VSS VSS) gpdk090_nmos1v w=0.12u l=0.1u ad=0.0696p as=0.0696p pd=1.16u ps=1.16u
    I_MXI0_I77_I43_MN5 (XI0_I77_I43_n2 I0_I77_G5_0 VSS VSS) gpdk090_nmos1v w=0.24u l=0.1u ad=0.0528p as=0.0816p pd=0.68u ps=1.16u
    I_MXI0_I77_I43_MN4 (MULP_14 XI0_I77_I43_An XI0_I77_I43_n2 VSS) gpdk090_nmos1v w=0.24u l=0.1u ad=0.0528p as=0.0528p pd=0.68u ps=0.68u
    I_MXI0_I77_I43_MN2 (XI0_I77_I43_n1 I0_I77_pn6 MULP_14 VSS) gpdk090_nmos1v w=0.24u l=0.1u ad=0.0528p as=0.0528p pd=0.68u ps=0.68u
    I_MXI0_I77_I43_MN3 (VSS XI0_I77_I43_Bn XI0_I77_I43_n1 VSS) gpdk090_nmos1v w=0.24u l=0.1u ad=0.0816p as=0.0528p pd=1.16u ps=0.68u
    I_MXI0_I77_I43_MN0 (XI0_I77_I43_An I0_I77_pn6 VSS VSS) gpdk090_nmos1v w=0.12u l=0.1u ad=0.0696p as=0.0696p pd=1.16u ps=1.16u
    I_MXI0_I77_I14_MN1 (XI0_I77_I14_Bn I0_ha24_0 VSS VSS) gpdk090_nmos1v w=0.12u l=0.1u ad=0.0696p as=0.0696p pd=1.16u ps=1.16u
    I_MXI0_I77_I14_MN5 (XI0_I77_I14_n2 I0_ha24_0 VSS VSS) gpdk090_nmos1v w=0.24u l=0.1u ad=0.0528p as=0.0816p pd=0.68u ps=1.16u
    I_MXI0_I77_I14_MN4 (I0_I77_pn6 XI0_I77_I14_An XI0_I77_I14_n2 VSS) gpdk090_nmos1v w=0.24u l=0.1u ad=0.0528p as=0.0528p pd=0.68u ps=0.68u
    I_MXI0_I77_I14_MN2 (XI0_I77_I14_n1 I0_ha23_1 I0_I77_pn6 VSS) gpdk090_nmos1v w=0.24u l=0.1u ad=0.0528p as=0.0528p pd=0.68u ps=0.68u
    I_MXI0_I77_I14_MN3 (VSS XI0_I77_I14_Bn XI0_I77_I14_n1 VSS) gpdk090_nmos1v w=0.24u l=0.1u ad=0.0816p as=0.0528p pd=1.16u ps=0.68u
    I_MXI0_I77_I14_MN0 (XI0_I77_I14_An I0_ha23_1 VSS VSS) gpdk090_nmos1v w=0.12u l=0.1u ad=0.0696p as=0.0696p pd=1.16u ps=1.16u
    I_MXI0_I77_I15_MN1 (XI0_I77_I15_Bn I0_ha25_0 VSS VSS) gpdk090_nmos1v w=0.12u l=0.1u ad=0.0696p as=0.0696p pd=1.16u ps=1.16u
    I_MXI0_I77_I15_MN5 (XI0_I77_I15_n2 I0_ha25_0 VSS VSS) gpdk090_nmos1v w=0.24u l=0.1u ad=0.0528p as=0.0816p pd=0.68u ps=1.16u
    I_MXI0_I77_I15_MN4 (I0_I77_pn7 XI0_I77_I15_An XI0_I77_I15_n2 VSS) gpdk090_nmos1v w=0.24u l=0.1u ad=0.0528p as=0.0528p pd=0.68u ps=0.68u
    I_MXI0_I77_I15_MN2 (XI0_I77_I15_n1 I0_ha24_1 I0_I77_pn7 VSS) gpdk090_nmos1v w=0.24u l=0.1u ad=0.0528p as=0.0528p pd=0.68u ps=0.68u
    I_MXI0_I77_I15_MN3 (VSS XI0_I77_I15_Bn XI0_I77_I15_n1 VSS) gpdk090_nmos1v w=0.24u l=0.1u ad=0.0816p as=0.0528p pd=1.16u ps=0.68u
    I_MXI0_I77_I15_MN0 (XI0_I77_I15_An I0_ha24_1 VSS VSS) gpdk090_nmos1v w=0.12u l=0.1u ad=0.0696p as=0.0696p pd=1.16u ps=1.16u
    I_MXI1_I152_I43_MN1 (XI1_I152_I43_Bn I1_I152_G5_0 VSS VSS) gpdk090_nmos1v w=0.12u l=0.1u ad=0.0696p as=0.0696p pd=1.16u ps=1.16u
    I_MXI1_I152_I43_MN5 (XI1_I152_I43_n2 I1_I152_G5_0 VSS VSS) gpdk090_nmos1v w=0.24u l=0.1u ad=0.0528p as=0.0816p pd=0.68u ps=1.16u
    I_MXI1_I152_I43_MN4 (I1_ru6 XI1_I152_I43_An XI1_I152_I43_n2 VSS) gpdk090_nmos1v w=0.24u l=0.1u ad=0.0528p as=0.0528p pd=0.68u ps=0.68u
    I_MXI1_I152_I43_MN2 (XI1_I152_I43_n1 I1_I152_pn6 I1_ru6 VSS) gpdk090_nmos1v w=0.24u l=0.1u ad=0.0528p as=0.0528p pd=0.68u ps=0.68u
    I_MXI1_I152_I43_MN3 (VSS XI1_I152_I43_Bn XI1_I152_I43_n1 VSS) gpdk090_nmos1v w=0.24u l=0.1u ad=0.0816p as=0.0528p pd=1.16u ps=0.68u
    I_MXI1_I152_I43_MN0 (XI1_I152_I43_An I1_I152_pn6 VSS VSS) gpdk090_nmos1v w=0.12u l=0.1u ad=0.0696p as=0.0696p pd=1.16u ps=1.16u
    I_MXI1_I193_MN1 (XI1_I193_Bn I1_nrkn7 VSS VSS) gpdk090_nmos1v w=0.12u l=0.1u ad=0.0696p as=0.0696p pd=1.16u ps=1.16u
    I_MXI1_I193_MN5 (XI1_I193_n2 I1_nrkn7 VSS VSS) gpdk090_nmos1v w=0.24u l=0.1u ad=0.0528p as=0.0816p pd=0.68u ps=1.16u
    I_MXI1_I193_MN4 (DIVR_7 XI1_I193_An XI1_I193_n2 VSS) gpdk090_nmos1v w=0.24u l=0.1u ad=0.0528p as=0.0528p pd=0.68u ps=0.68u
    I_MXI1_I193_MN2 (XI1_I193_n1 I1_ru7 DIVR_7 VSS) gpdk090_nmos1v w=0.24u l=0.1u ad=0.0528p as=0.0528p pd=0.68u ps=0.68u
    I_MXI1_I193_MN3 (VSS XI1_I193_Bn XI1_I193_n1 VSS) gpdk090_nmos1v w=0.24u l=0.1u ad=0.0816p as=0.0528p pd=1.16u ps=0.68u
    I_MXI1_I193_MN0 (XI1_I193_An I1_ru7 VSS VSS) gpdk090_nmos1v w=0.12u l=0.1u ad=0.0696p as=0.0696p pd=1.16u ps=1.16u
    I_MXI1_I187_MN1 (XI1_I187_Bn I1_nrkn5 VSS VSS) gpdk090_nmos1v w=0.12u l=0.1u ad=0.0696p as=0.0696p pd=1.16u ps=1.16u
    I_MXI1_I187_MN5 (XI1_I187_n2 I1_nrkn5 VSS VSS) gpdk090_nmos1v w=0.24u l=0.1u ad=0.0528p as=0.0816p pd=0.68u ps=1.16u
    I_MXI1_I187_MN4 (DIVR_5 XI1_I187_An XI1_I187_n2 VSS) gpdk090_nmos1v w=0.24u l=0.1u ad=0.0528p as=0.0528p pd=0.68u ps=0.68u
    I_MXI1_I187_MN2 (XI1_I187_n1 I1_ru5 DIVR_5 VSS) gpdk090_nmos1v w=0.24u l=0.1u ad=0.0528p as=0.0528p pd=0.68u ps=0.68u
    I_MXI1_I187_MN3 (VSS XI1_I187_Bn XI1_I187_n1 VSS) gpdk090_nmos1v w=0.24u l=0.1u ad=0.0816p as=0.0528p pd=1.16u ps=0.68u
    I_MXI1_I187_MN0 (XI1_I187_An I1_ru5 VSS VSS) gpdk090_nmos1v w=0.12u l=0.1u ad=0.0696p as=0.0696p pd=1.16u ps=1.16u
    I_MXI0_I77_I13_MN1 (XI0_I77_I13_Bn I0_ha23_0 VSS VSS) gpdk090_nmos1v w=0.12u l=0.1u ad=0.0696p as=0.0696p pd=1.16u ps=1.16u
    I_MXI0_I77_I13_MN5 (XI0_I77_I13_n2 I0_ha23_0 VSS VSS) gpdk090_nmos1v w=0.24u l=0.1u ad=0.0528p as=0.0816p pd=0.68u ps=1.16u
    I_MXI0_I77_I13_MN4 (I0_I77_pn5 XI0_I77_I13_An XI0_I77_I13_n2 VSS) gpdk090_nmos1v w=0.24u l=0.1u ad=0.0528p as=0.0528p pd=0.68u ps=0.68u
    I_MXI0_I77_I13_MN2 (XI0_I77_I13_n1 I0_ha22_1 I0_I77_pn5 VSS) gpdk090_nmos1v w=0.24u l=0.1u ad=0.0528p as=0.0528p pd=0.68u ps=0.68u
    I_MXI0_I77_I13_MN3 (VSS XI0_I77_I13_Bn XI0_I77_I13_n1 VSS) gpdk090_nmos1v w=0.24u l=0.1u ad=0.0816p as=0.0528p pd=1.16u ps=0.68u
    I_MXI0_I77_I13_MN0 (XI0_I77_I13_An I0_ha22_1 VSS VSS) gpdk090_nmos1v w=0.12u l=0.1u ad=0.0696p as=0.0696p pd=1.16u ps=1.16u
    I_MXI1_I184_MN1 (XI1_I184_Bn I1_nrkn4 VSS VSS) gpdk090_nmos1v w=0.12u l=0.1u ad=0.0696p as=0.0696p pd=1.16u ps=1.16u
    I_MXI1_I184_MN5 (XI1_I184_n2 I1_nrkn4 VSS VSS) gpdk090_nmos1v w=0.24u l=0.1u ad=0.0528p as=0.0816p pd=0.68u ps=1.16u
    I_MXI1_I184_MN4 (DIVR_4 XI1_I184_An XI1_I184_n2 VSS) gpdk090_nmos1v w=0.24u l=0.1u ad=0.0528p as=0.0528p pd=0.68u ps=0.68u
    I_MXI1_I184_MN2 (XI1_I184_n1 I1_ru4 DIVR_4 VSS) gpdk090_nmos1v w=0.24u l=0.1u ad=0.0528p as=0.0528p pd=0.68u ps=0.68u
    I_MXI1_I184_MN3 (VSS XI1_I184_Bn XI1_I184_n1 VSS) gpdk090_nmos1v w=0.24u l=0.1u ad=0.0816p as=0.0528p pd=1.16u ps=0.68u
    I_MXI1_I184_MN0 (XI1_I184_An I1_ru4 VSS VSS) gpdk090_nmos1v w=0.12u l=0.1u ad=0.0696p as=0.0696p pd=1.16u ps=1.16u
    I_MXI1_I181_MN1 (XI1_I181_Bn I1_nrkn3 VSS VSS) gpdk090_nmos1v w=0.12u l=0.1u ad=0.0696p as=0.0696p pd=1.16u ps=1.16u
    I_MXI1_I181_MN5 (XI1_I181_n2 I1_nrkn3 VSS VSS) gpdk090_nmos1v w=0.24u l=0.1u ad=0.0528p as=0.0816p pd=0.68u ps=1.16u
    I_MXI1_I181_MN4 (DIVR_3 XI1_I181_An XI1_I181_n2 VSS) gpdk090_nmos1v w=0.24u l=0.1u ad=0.0528p as=0.0528p pd=0.68u ps=0.68u
    I_MXI1_I181_MN2 (XI1_I181_n1 I1_ru3 DIVR_3 VSS) gpdk090_nmos1v w=0.24u l=0.1u ad=0.0528p as=0.0528p pd=0.68u ps=0.68u
    I_MXI1_I181_MN3 (VSS XI1_I181_Bn XI1_I181_n1 VSS) gpdk090_nmos1v w=0.24u l=0.1u ad=0.0816p as=0.0528p pd=1.16u ps=0.68u
    I_MXI1_I181_MN0 (XI1_I181_An I1_ru3 VSS VSS) gpdk090_nmos1v w=0.12u l=0.1u ad=0.0696p as=0.0696p pd=1.16u ps=1.16u
    I_MXI0_I77_I42_MN1 (XI0_I77_I42_Bn I0_I77_G4_0 VSS VSS) gpdk090_nmos1v w=0.12u l=0.1u ad=0.0696p as=0.0696p pd=1.16u ps=1.16u
    I_MXI0_I77_I42_MN5 (XI0_I77_I42_n2 I0_I77_G4_0 VSS VSS) gpdk090_nmos1v w=0.24u l=0.1u ad=0.0528p as=0.0816p pd=0.68u ps=1.16u
    I_MXI0_I77_I42_MN4 (MULP_13 XI0_I77_I42_An XI0_I77_I42_n2 VSS) gpdk090_nmos1v w=0.24u l=0.1u ad=0.0528p as=0.0528p pd=0.68u ps=0.68u
    I_MXI0_I77_I42_MN2 (XI0_I77_I42_n1 I0_I77_pn5 MULP_13 VSS) gpdk090_nmos1v w=0.24u l=0.1u ad=0.0528p as=0.0528p pd=0.68u ps=0.68u
    I_MXI0_I77_I42_MN3 (VSS XI0_I77_I42_Bn XI0_I77_I42_n1 VSS) gpdk090_nmos1v w=0.24u l=0.1u ad=0.0816p as=0.0528p pd=1.16u ps=0.68u
    I_MXI0_I77_I42_MN0 (XI0_I77_I42_An I0_I77_pn5 VSS VSS) gpdk090_nmos1v w=0.12u l=0.1u ad=0.0696p as=0.0696p pd=1.16u ps=1.16u
    I_MXI0_I77_I12_MN1 (XI0_I77_I12_Bn I0_ha22_0 VSS VSS) gpdk090_nmos1v w=0.12u l=0.1u ad=0.0696p as=0.0696p pd=1.16u ps=1.16u
    I_MXI0_I77_I12_MN5 (XI0_I77_I12_n2 I0_ha22_0 VSS VSS) gpdk090_nmos1v w=0.24u l=0.1u ad=0.0528p as=0.0816p pd=0.68u ps=1.16u
    I_MXI0_I77_I12_MN4 (I0_I77_pn4 XI0_I77_I12_An XI0_I77_I12_n2 VSS) gpdk090_nmos1v w=0.24u l=0.1u ad=0.0528p as=0.0528p pd=0.68u ps=0.68u
    I_MXI0_I77_I12_MN2 (XI0_I77_I12_n1 I0_ha21_1 I0_I77_pn4 VSS) gpdk090_nmos1v w=0.24u l=0.1u ad=0.0528p as=0.0528p pd=0.68u ps=0.68u
    I_MXI0_I77_I12_MN3 (VSS XI0_I77_I12_Bn XI0_I77_I12_n1 VSS) gpdk090_nmos1v w=0.24u l=0.1u ad=0.0816p as=0.0528p pd=1.16u ps=0.68u
    I_MXI0_I77_I12_MN0 (XI0_I77_I12_An I0_ha21_1 VSS VSS) gpdk090_nmos1v w=0.12u l=0.1u ad=0.0696p as=0.0696p pd=1.16u ps=1.16u
    I_MXI0_I77_I11_MN1 (XI0_I77_I11_Bn I0_ha21_0 VSS VSS) gpdk090_nmos1v w=0.12u l=0.1u ad=0.0696p as=0.0696p pd=1.16u ps=1.16u
    I_MXI0_I77_I11_MN5 (XI0_I77_I11_n2 I0_ha21_0 VSS VSS) gpdk090_nmos1v w=0.24u l=0.1u ad=0.0528p as=0.0816p pd=0.68u ps=1.16u
    I_MXI0_I77_I11_MN4 (I0_I77_pn3 XI0_I77_I11_An XI0_I77_I11_n2 VSS) gpdk090_nmos1v w=0.24u l=0.1u ad=0.0528p as=0.0528p pd=0.68u ps=0.68u
    I_MXI0_I77_I11_MN2 (XI0_I77_I11_n1 I0_ha20_1 I0_I77_pn3 VSS) gpdk090_nmos1v w=0.24u l=0.1u ad=0.0528p as=0.0528p pd=0.68u ps=0.68u
    I_MXI0_I77_I11_MN3 (VSS XI0_I77_I11_Bn XI0_I77_I11_n1 VSS) gpdk090_nmos1v w=0.24u l=0.1u ad=0.0816p as=0.0528p pd=1.16u ps=0.68u
    I_MXI0_I77_I11_MN0 (XI0_I77_I11_An I0_ha20_1 VSS VSS) gpdk090_nmos1v w=0.12u l=0.1u ad=0.0696p as=0.0696p pd=1.16u ps=1.16u
    I_MXI1_I152_I15_MN1 (XI1_I152_I15_Bn I1_dm7 VSS VSS) gpdk090_nmos1v w=0.12u l=0.1u ad=0.0696p as=0.0696p pd=1.16u ps=1.16u
    I_MXI1_I152_I15_MN5 (XI1_I152_I15_n2 I1_dm7 VSS VSS) gpdk090_nmos1v w=0.24u l=0.1u ad=0.0528p as=0.0816p pd=0.68u ps=1.16u
    I_MXI1_I152_I15_MN4 (I1_I152_pn7 XI1_I152_I15_An XI1_I152_I15_n2 VSS) gpdk090_nmos1v w=0.24u l=0.1u ad=0.0528p as=0.0528p pd=0.68u ps=0.68u
    I_MXI1_I152_I15_MN2 (XI1_I152_I15_n1 I1_p7_7 I1_I152_pn7 VSS) gpdk090_nmos1v w=0.24u l=0.1u ad=0.0528p as=0.0528p pd=0.68u ps=0.68u
    I_MXI1_I152_I15_MN3 (VSS XI1_I152_I15_Bn XI1_I152_I15_n1 VSS) gpdk090_nmos1v w=0.24u l=0.1u ad=0.0816p as=0.0528p pd=1.16u ps=0.68u
    I_MXI1_I152_I15_MN0 (XI1_I152_I15_An I1_p7_7 VSS VSS) gpdk090_nmos1v w=0.12u l=0.1u ad=0.0696p as=0.0696p pd=1.16u ps=1.16u
    I_MXI1_I152_I44_MN1 (XI1_I152_I44_Bn I1_rc6 VSS VSS) gpdk090_nmos1v w=0.12u l=0.1u ad=0.0696p as=0.0696p pd=1.16u ps=1.16u
    I_MXI1_I152_I44_MN5 (XI1_I152_I44_n2 I1_rc6 VSS VSS) gpdk090_nmos1v w=0.24u l=0.1u ad=0.0528p as=0.0816p pd=0.68u ps=1.16u
    I_MXI1_I152_I44_MN4 (I1_ru7 XI1_I152_I44_An XI1_I152_I44_n2 VSS) gpdk090_nmos1v w=0.24u l=0.1u ad=0.0528p as=0.0528p pd=0.68u ps=0.68u
    I_MXI1_I152_I44_MN2 (XI1_I152_I44_n1 I1_I152_pn7 I1_ru7 VSS) gpdk090_nmos1v w=0.24u l=0.1u ad=0.0528p as=0.0528p pd=0.68u ps=0.68u
    I_MXI1_I152_I44_MN3 (VSS XI1_I152_I44_Bn XI1_I152_I44_n1 VSS) gpdk090_nmos1v w=0.24u l=0.1u ad=0.0816p as=0.0528p pd=1.16u ps=0.68u
    I_MXI1_I152_I44_MN0 (XI1_I152_I44_An I1_I152_pn7 VSS VSS) gpdk090_nmos1v w=0.12u l=0.1u ad=0.0696p as=0.0696p pd=1.16u ps=1.16u
    I_MXI1_I152_I42_MN1 (XI1_I152_I42_Bn I1_I152_G4_0 VSS VSS) gpdk090_nmos1v w=0.12u l=0.1u ad=0.0696p as=0.0696p pd=1.16u ps=1.16u
    I_MXI1_I152_I42_MN5 (XI1_I152_I42_n2 I1_I152_G4_0 VSS VSS) gpdk090_nmos1v w=0.24u l=0.1u ad=0.0528p as=0.0816p pd=0.68u ps=1.16u
    I_MXI1_I152_I42_MN4 (I1_ru5 XI1_I152_I42_An XI1_I152_I42_n2 VSS) gpdk090_nmos1v w=0.24u l=0.1u ad=0.0528p as=0.0528p pd=0.68u ps=0.68u
    I_MXI1_I152_I42_MN2 (XI1_I152_I42_n1 I1_I152_pn5 I1_ru5 VSS) gpdk090_nmos1v w=0.24u l=0.1u ad=0.0528p as=0.0528p pd=0.68u ps=0.68u
    I_MXI1_I152_I42_MN3 (VSS XI1_I152_I42_Bn XI1_I152_I42_n1 VSS) gpdk090_nmos1v w=0.24u l=0.1u ad=0.0816p as=0.0528p pd=1.16u ps=0.68u
    I_MXI1_I152_I42_MN0 (XI1_I152_I42_An I1_I152_pn5 VSS VSS) gpdk090_nmos1v w=0.12u l=0.1u ad=0.0696p as=0.0696p pd=1.16u ps=1.16u
    I_MXI1_I152_I39_MN1 (XI1_I152_I39_Bn I1_I152_G1_0 VSS VSS) gpdk090_nmos1v w=0.12u l=0.1u ad=0.0696p as=0.0696p pd=1.16u ps=1.16u
    I_MXI1_I152_I39_MN5 (XI1_I152_I39_n2 I1_I152_G1_0 VSS VSS) gpdk090_nmos1v w=0.24u l=0.1u ad=0.0528p as=0.0816p pd=0.68u ps=1.16u
    I_MXI1_I152_I39_MN4 (I1_ru2 XI1_I152_I39_An XI1_I152_I39_n2 VSS) gpdk090_nmos1v w=0.24u l=0.1u ad=0.0528p as=0.0528p pd=0.68u ps=0.68u
    I_MXI1_I152_I39_MN2 (XI1_I152_I39_n1 I1_I152_pn2 I1_ru2 VSS) gpdk090_nmos1v w=0.24u l=0.1u ad=0.0528p as=0.0528p pd=0.68u ps=0.68u
    I_MXI1_I152_I39_MN3 (VSS XI1_I152_I39_Bn XI1_I152_I39_n1 VSS) gpdk090_nmos1v w=0.24u l=0.1u ad=0.0816p as=0.0528p pd=1.16u ps=0.68u
    I_MXI1_I152_I39_MN0 (XI1_I152_I39_An I1_I152_pn2 VSS VSS) gpdk090_nmos1v w=0.12u l=0.1u ad=0.0696p as=0.0696p pd=1.16u ps=1.16u
    I_MXI1_I178_MN1 (XI1_I178_Bn I1_nrkn2 VSS VSS) gpdk090_nmos1v w=0.12u l=0.1u ad=0.0696p as=0.0696p pd=1.16u ps=1.16u
    I_MXI1_I178_MN5 (XI1_I178_n2 I1_nrkn2 VSS VSS) gpdk090_nmos1v w=0.24u l=0.1u ad=0.0528p as=0.0816p pd=0.68u ps=1.16u
    I_MXI1_I178_MN4 (DIVR_2 XI1_I178_An XI1_I178_n2 VSS) gpdk090_nmos1v w=0.24u l=0.1u ad=0.0528p as=0.0528p pd=0.68u ps=0.68u
    I_MXI1_I178_MN2 (XI1_I178_n1 I1_ru2 DIVR_2 VSS) gpdk090_nmos1v w=0.24u l=0.1u ad=0.0528p as=0.0528p pd=0.68u ps=0.68u
    I_MXI1_I178_MN3 (VSS XI1_I178_Bn XI1_I178_n1 VSS) gpdk090_nmos1v w=0.24u l=0.1u ad=0.0816p as=0.0528p pd=1.16u ps=0.68u
    I_MXI1_I178_MN0 (XI1_I178_An I1_ru2 VSS VSS) gpdk090_nmos1v w=0.12u l=0.1u ad=0.0696p as=0.0696p pd=1.16u ps=1.16u
    I_MXI0_I77_I39_MN1 (XI0_I77_I39_Bn I0_I77_G1_0 VSS VSS) gpdk090_nmos1v w=0.12u l=0.1u ad=0.0696p as=0.0696p pd=1.16u ps=1.16u
    I_MXI0_I77_I39_MN5 (XI0_I77_I39_n2 I0_I77_G1_0 VSS VSS) gpdk090_nmos1v w=0.24u l=0.1u ad=0.0528p as=0.0816p pd=0.68u ps=1.16u
    I_MXI0_I77_I39_MN4 (MULP_10 XI0_I77_I39_An XI0_I77_I39_n2 VSS) gpdk090_nmos1v w=0.24u l=0.1u ad=0.0528p as=0.0528p pd=0.68u ps=0.68u
    I_MXI0_I77_I39_MN2 (XI0_I77_I39_n1 I0_I77_pn2 MULP_10 VSS) gpdk090_nmos1v w=0.24u l=0.1u ad=0.0528p as=0.0528p pd=0.68u ps=0.68u
    I_MXI0_I77_I39_MN3 (VSS XI0_I77_I39_Bn XI0_I77_I39_n1 VSS) gpdk090_nmos1v w=0.24u l=0.1u ad=0.0816p as=0.0528p pd=1.16u ps=0.68u
    I_MXI0_I77_I39_MN0 (XI0_I77_I39_An I0_I77_pn2 VSS VSS) gpdk090_nmos1v w=0.12u l=0.1u ad=0.0696p as=0.0696p pd=1.16u ps=1.16u
    I_MXI0_I77_I10_MN1 (XI0_I77_I10_Bn I0_ha20_0 VSS VSS) gpdk090_nmos1v w=0.12u l=0.1u ad=0.0696p as=0.0696p pd=1.16u ps=1.16u
    I_MXI0_I77_I10_MN5 (XI0_I77_I10_n2 I0_ha20_0 VSS VSS) gpdk090_nmos1v w=0.24u l=0.1u ad=0.0528p as=0.0816p pd=0.68u ps=1.16u
    I_MXI0_I77_I10_MN4 (I0_I77_pn2 XI0_I77_I10_An XI0_I77_I10_n2 VSS) gpdk090_nmos1v w=0.24u l=0.1u ad=0.0528p as=0.0528p pd=0.68u ps=0.68u
    I_MXI0_I77_I10_MN2 (XI0_I77_I10_n1 I0_ha19_1 I0_I77_pn2 VSS) gpdk090_nmos1v w=0.24u l=0.1u ad=0.0528p as=0.0528p pd=0.68u ps=0.68u
    I_MXI0_I77_I10_MN3 (VSS XI0_I77_I10_Bn XI0_I77_I10_n1 VSS) gpdk090_nmos1v w=0.24u l=0.1u ad=0.0816p as=0.0528p pd=1.16u ps=0.68u
    I_MXI0_I77_I10_MN0 (XI0_I77_I10_An I0_ha19_1 VSS VSS) gpdk090_nmos1v w=0.12u l=0.1u ad=0.0696p as=0.0696p pd=1.16u ps=1.16u
    I_MXI1_I152_I14_MN1 (XI1_I152_I14_Bn I1_dm6 VSS VSS) gpdk090_nmos1v w=0.12u l=0.1u ad=0.0696p as=0.0696p pd=1.16u ps=1.16u
    I_MXI1_I152_I14_MN5 (XI1_I152_I14_n2 I1_dm6 VSS VSS) gpdk090_nmos1v w=0.24u l=0.1u ad=0.0528p as=0.0816p pd=0.68u ps=1.16u
    I_MXI1_I152_I14_MN4 (I1_I152_pn6 XI1_I152_I14_An XI1_I152_I14_n2 VSS) gpdk090_nmos1v w=0.24u l=0.1u ad=0.0528p as=0.0528p pd=0.68u ps=0.68u
    I_MXI1_I152_I14_MN2 (XI1_I152_I14_n1 I1_p7_6 I1_I152_pn6 VSS) gpdk090_nmos1v w=0.24u l=0.1u ad=0.0528p as=0.0528p pd=0.68u ps=0.68u
    I_MXI1_I152_I14_MN3 (VSS XI1_I152_I14_Bn XI1_I152_I14_n1 VSS) gpdk090_nmos1v w=0.24u l=0.1u ad=0.0816p as=0.0528p pd=1.16u ps=0.68u
    I_MXI1_I152_I14_MN0 (XI1_I152_I14_An I1_p7_6 VSS VSS) gpdk090_nmos1v w=0.12u l=0.1u ad=0.0696p as=0.0696p pd=1.16u ps=1.16u
    I_MXI1_I175_MN1 (XI1_I175_Bn I1_nrkn1 VSS VSS) gpdk090_nmos1v w=0.12u l=0.1u ad=0.0696p as=0.0696p pd=1.16u ps=1.16u
    I_MXI1_I175_MN5 (XI1_I175_n2 I1_nrkn1 VSS VSS) gpdk090_nmos1v w=0.24u l=0.1u ad=0.0528p as=0.0816p pd=0.68u ps=1.16u
    I_MXI1_I175_MN4 (DIVR_1 XI1_I175_An XI1_I175_n2 VSS) gpdk090_nmos1v w=0.24u l=0.1u ad=0.0528p as=0.0528p pd=0.68u ps=0.68u
    I_MXI1_I175_MN2 (XI1_I175_n1 I1_ru1 DIVR_1 VSS) gpdk090_nmos1v w=0.24u l=0.1u ad=0.0528p as=0.0528p pd=0.68u ps=0.68u
    I_MXI1_I175_MN3 (VSS XI1_I175_Bn XI1_I175_n1 VSS) gpdk090_nmos1v w=0.24u l=0.1u ad=0.0816p as=0.0528p pd=1.16u ps=0.68u
    I_MXI1_I175_MN0 (XI1_I175_An I1_ru1 VSS VSS) gpdk090_nmos1v w=0.12u l=0.1u ad=0.0696p as=0.0696p pd=1.16u ps=1.16u
    I_MXI0_I77_I38_MN1 (XI0_I77_I38_Bn I0_I77_G0_0 VSS VSS) gpdk090_nmos1v w=0.12u l=0.1u ad=0.0696p as=0.0696p pd=1.16u ps=1.16u
    I_MXI0_I77_I38_MN5 (XI0_I77_I38_n2 I0_I77_G0_0 VSS VSS) gpdk090_nmos1v w=0.24u l=0.1u ad=0.0528p as=0.0816p pd=0.68u ps=1.16u
    I_MXI0_I77_I38_MN4 (MULP_9 XI0_I77_I38_An XI0_I77_I38_n2 VSS) gpdk090_nmos1v w=0.24u l=0.1u ad=0.0528p as=0.0528p pd=0.68u ps=0.68u
    I_MXI0_I77_I38_MN2 (XI0_I77_I38_n1 I0_I77_pn1 MULP_9 VSS) gpdk090_nmos1v w=0.24u l=0.1u ad=0.0528p as=0.0528p pd=0.68u ps=0.68u
    I_MXI0_I77_I38_MN3 (VSS XI0_I77_I38_Bn XI0_I77_I38_n1 VSS) gpdk090_nmos1v w=0.24u l=0.1u ad=0.0816p as=0.0528p pd=1.16u ps=0.68u
    I_MXI0_I77_I38_MN0 (XI0_I77_I38_An I0_I77_pn1 VSS VSS) gpdk090_nmos1v w=0.12u l=0.1u ad=0.0696p as=0.0696p pd=1.16u ps=1.16u
    I_MXI0_I77_I9_MN1 (XI0_I77_I9_Bn I0_ha19_0 VSS VSS) gpdk090_nmos1v w=0.12u l=0.1u ad=0.0696p as=0.0696p pd=1.16u ps=1.16u
    I_MXI0_I77_I9_MN5 (XI0_I77_I9_n2 I0_ha19_0 VSS VSS) gpdk090_nmos1v w=0.24u l=0.1u ad=0.0528p as=0.0816p pd=0.68u ps=1.16u
    I_MXI0_I77_I9_MN4 (I0_I77_pn1 XI0_I77_I9_An XI0_I77_I9_n2 VSS) gpdk090_nmos1v w=0.24u l=0.1u ad=0.0528p as=0.0528p pd=0.68u ps=0.68u
    I_MXI0_I77_I9_MN2 (XI0_I77_I9_n1 I0_ha18_1 I0_I77_pn1 VSS) gpdk090_nmos1v w=0.24u l=0.1u ad=0.0528p as=0.0528p pd=0.68u ps=0.68u
    I_MXI0_I77_I9_MN3 (VSS XI0_I77_I9_Bn XI0_I77_I9_n1 VSS) gpdk090_nmos1v w=0.24u l=0.1u ad=0.0816p as=0.0528p pd=1.16u ps=0.68u
    I_MXI0_I77_I9_MN0 (XI0_I77_I9_An I0_ha18_1 VSS VSS) gpdk090_nmos1v w=0.12u l=0.1u ad=0.0696p as=0.0696p pd=1.16u ps=1.16u
    I_MXI2_I1_I8_I15_MN1 (XI2_I1_I8_I15_Bn I2_I1_bx7 VSS VSS) gpdk090_nmos1v w=0.12u l=0.1u ad=0.0696p as=0.0696p pd=1.16u ps=1.16u
    I_MXI2_I1_I8_I15_MN5 (XI2_I1_I8_I15_n2 I2_I1_bx7 VSS VSS) gpdk090_nmos1v w=0.24u l=0.1u ad=0.0528p as=0.0816p pd=0.68u ps=1.16u
    I_MXI2_I1_I8_I15_MN4 (I2_I1_I8_pn7 XI2_I1_I8_I15_An XI2_I1_I8_I15_n2 VSS) gpdk090_nmos1v w=0.24u l=0.1u ad=0.0528p as=0.0528p pd=0.68u ps=0.68u
    I_MXI2_I1_I8_I15_MN2 (XI2_I1_I8_I15_n1 A_7 I2_I1_I8_pn7 VSS) gpdk090_nmos1v w=0.24u l=0.1u ad=0.0528p as=0.0528p pd=0.68u ps=0.68u
    I_MXI2_I1_I8_I15_MN3 (VSS XI2_I1_I8_I15_Bn XI2_I1_I8_I15_n1 VSS) gpdk090_nmos1v w=0.24u l=0.1u ad=0.0816p as=0.0528p pd=1.16u ps=0.68u
    I_MXI2_I1_I8_I15_MN0 (XI2_I1_I8_I15_An A_7 VSS VSS) gpdk090_nmos1v w=0.12u l=0.1u ad=0.0696p as=0.0696p pd=1.16u ps=1.16u
    I_MXI1_I132_I43_MN1 (XI1_I132_I43_Bn I1_I132_G5_0 VSS VSS) gpdk090_nmos1v w=0.12u l=0.1u ad=0.0696p as=0.0696p pd=1.16u ps=1.16u
    I_MXI1_I132_I43_MN5 (XI1_I132_I43_n2 I1_I132_G5_0 VSS VSS) gpdk090_nmos1v w=0.24u l=0.1u ad=0.0528p as=0.0816p pd=0.68u ps=1.16u
    I_MXI1_I132_I43_MN4 (I1_p7_6 XI1_I132_I43_An XI1_I132_I43_n2 VSS) gpdk090_nmos1v w=0.24u l=0.1u ad=0.0528p as=0.0528p pd=0.68u ps=0.68u
    I_MXI1_I132_I43_MN2 (XI1_I132_I43_n1 I1_I132_pn6 I1_p7_6 VSS) gpdk090_nmos1v w=0.24u l=0.1u ad=0.0528p as=0.0528p pd=0.68u ps=0.68u
    I_MXI1_I132_I43_MN3 (VSS XI1_I132_I43_Bn XI1_I132_I43_n1 VSS) gpdk090_nmos1v w=0.24u l=0.1u ad=0.0816p as=0.0528p pd=1.16u ps=0.68u
    I_MXI1_I132_I43_MN0 (XI1_I132_I43_An I1_I132_pn6 VSS VSS) gpdk090_nmos1v w=0.12u l=0.1u ad=0.0696p as=0.0696p pd=1.16u ps=1.16u
    I_MXI1_I152_I13_MN1 (XI1_I152_I13_Bn I1_dm5 VSS VSS) gpdk090_nmos1v w=0.12u l=0.1u ad=0.0696p as=0.0696p pd=1.16u ps=1.16u
    I_MXI1_I152_I13_MN5 (XI1_I152_I13_n2 I1_dm5 VSS VSS) gpdk090_nmos1v w=0.24u l=0.1u ad=0.0528p as=0.0816p pd=0.68u ps=1.16u
    I_MXI1_I152_I13_MN4 (I1_I152_pn5 XI1_I152_I13_An XI1_I152_I13_n2 VSS) gpdk090_nmos1v w=0.24u l=0.1u ad=0.0528p as=0.0528p pd=0.68u ps=0.68u
    I_MXI1_I152_I13_MN2 (XI1_I152_I13_n1 I1_p7_5 I1_I152_pn5 VSS) gpdk090_nmos1v w=0.24u l=0.1u ad=0.0528p as=0.0528p pd=0.68u ps=0.68u
    I_MXI1_I152_I13_MN3 (VSS XI1_I152_I13_Bn XI1_I152_I13_n1 VSS) gpdk090_nmos1v w=0.24u l=0.1u ad=0.0816p as=0.0528p pd=1.16u ps=0.68u
    I_MXI1_I152_I13_MN0 (XI1_I152_I13_An I1_p7_5 VSS VSS) gpdk090_nmos1v w=0.12u l=0.1u ad=0.0696p as=0.0696p pd=1.16u ps=1.16u
    I_MXI1_I152_I12_MN1 (XI1_I152_I12_Bn I1_dm4 VSS VSS) gpdk090_nmos1v w=0.12u l=0.1u ad=0.0696p as=0.0696p pd=1.16u ps=1.16u
    I_MXI1_I152_I12_MN5 (XI1_I152_I12_n2 I1_dm4 VSS VSS) gpdk090_nmos1v w=0.24u l=0.1u ad=0.0528p as=0.0816p pd=0.68u ps=1.16u
    I_MXI1_I152_I12_MN4 (I1_I152_pn4 XI1_I152_I12_An XI1_I152_I12_n2 VSS) gpdk090_nmos1v w=0.24u l=0.1u ad=0.0528p as=0.0528p pd=0.68u ps=0.68u
    I_MXI1_I152_I12_MN2 (XI1_I152_I12_n1 I1_p7_4 I1_I152_pn4 VSS) gpdk090_nmos1v w=0.24u l=0.1u ad=0.0528p as=0.0528p pd=0.68u ps=0.68u
    I_MXI1_I152_I12_MN3 (VSS XI1_I152_I12_Bn XI1_I152_I12_n1 VSS) gpdk090_nmos1v w=0.24u l=0.1u ad=0.0816p as=0.0528p pd=1.16u ps=0.68u
    I_MXI1_I152_I12_MN0 (XI1_I152_I12_An I1_p7_4 VSS VSS) gpdk090_nmos1v w=0.12u l=0.1u ad=0.0696p as=0.0696p pd=1.16u ps=1.16u
    I_MXI1_I152_I11_MN1 (XI1_I152_I11_Bn I1_dm3 VSS VSS) gpdk090_nmos1v w=0.12u l=0.1u ad=0.0696p as=0.0696p pd=1.16u ps=1.16u
    I_MXI1_I152_I11_MN5 (XI1_I152_I11_n2 I1_dm3 VSS VSS) gpdk090_nmos1v w=0.24u l=0.1u ad=0.0528p as=0.0816p pd=0.68u ps=1.16u
    I_MXI1_I152_I11_MN4 (I1_I152_pn3 XI1_I152_I11_An XI1_I152_I11_n2 VSS) gpdk090_nmos1v w=0.24u l=0.1u ad=0.0528p as=0.0528p pd=0.68u ps=0.68u
    I_MXI1_I152_I11_MN2 (XI1_I152_I11_n1 I1_p7_3 I1_I152_pn3 VSS) gpdk090_nmos1v w=0.24u l=0.1u ad=0.0528p as=0.0528p pd=0.68u ps=0.68u
    I_MXI1_I152_I11_MN3 (VSS XI1_I152_I11_Bn XI1_I152_I11_n1 VSS) gpdk090_nmos1v w=0.24u l=0.1u ad=0.0816p as=0.0528p pd=1.16u ps=0.68u
    I_MXI1_I152_I11_MN0 (XI1_I152_I11_An I1_p7_3 VSS VSS) gpdk090_nmos1v w=0.12u l=0.1u ad=0.0696p as=0.0696p pd=1.16u ps=1.16u
    I_MXI1_I152_I10_MN1 (XI1_I152_I10_Bn I1_dm2 VSS VSS) gpdk090_nmos1v w=0.12u l=0.1u ad=0.0696p as=0.0696p pd=1.16u ps=1.16u
    I_MXI1_I152_I10_MN5 (XI1_I152_I10_n2 I1_dm2 VSS VSS) gpdk090_nmos1v w=0.24u l=0.1u ad=0.0528p as=0.0816p pd=0.68u ps=1.16u
    I_MXI1_I152_I10_MN4 (I1_I152_pn2 XI1_I152_I10_An XI1_I152_I10_n2 VSS) gpdk090_nmos1v w=0.24u l=0.1u ad=0.0528p as=0.0528p pd=0.68u ps=0.68u
    I_MXI1_I152_I10_MN2 (XI1_I152_I10_n1 I1_p7_2 I1_I152_pn2 VSS) gpdk090_nmos1v w=0.24u l=0.1u ad=0.0528p as=0.0528p pd=0.68u ps=0.68u
    I_MXI1_I152_I10_MN3 (VSS XI1_I152_I10_Bn XI1_I152_I10_n1 VSS) gpdk090_nmos1v w=0.24u l=0.1u ad=0.0816p as=0.0528p pd=1.16u ps=0.68u
    I_MXI1_I152_I10_MN0 (XI1_I152_I10_An I1_p7_2 VSS VSS) gpdk090_nmos1v w=0.12u l=0.1u ad=0.0696p as=0.0696p pd=1.16u ps=1.16u
    I_MXI1_I152_I38_MN1 (XI1_I152_I38_Bn I1_I152_G0_0 VSS VSS) gpdk090_nmos1v w=0.12u l=0.1u ad=0.0696p as=0.0696p pd=1.16u ps=1.16u
    I_MXI1_I152_I38_MN5 (XI1_I152_I38_n2 I1_I152_G0_0 VSS VSS) gpdk090_nmos1v w=0.24u l=0.1u ad=0.0528p as=0.0816p pd=0.68u ps=1.16u
    I_MXI1_I152_I38_MN4 (I1_ru1 XI1_I152_I38_An XI1_I152_I38_n2 VSS) gpdk090_nmos1v w=0.24u l=0.1u ad=0.0528p as=0.0528p pd=0.68u ps=0.68u
    I_MXI1_I152_I38_MN2 (XI1_I152_I38_n1 I1_I152_pn1 I1_ru1 VSS) gpdk090_nmos1v w=0.24u l=0.1u ad=0.0528p as=0.0528p pd=0.68u ps=0.68u
    I_MXI1_I152_I38_MN3 (VSS XI1_I152_I38_Bn XI1_I152_I38_n1 VSS) gpdk090_nmos1v w=0.24u l=0.1u ad=0.0816p as=0.0528p pd=1.16u ps=0.68u
    I_MXI1_I152_I38_MN0 (XI1_I152_I38_An I1_I152_pn1 VSS VSS) gpdk090_nmos1v w=0.12u l=0.1u ad=0.0696p as=0.0696p pd=1.16u ps=1.16u
    I_MXI1_I152_I37_MN1 (XI1_I152_I37_Bn VSS VSS VSS) gpdk090_nmos1v w=0.12u l=0.1u ad=0.0696p as=0.0696p pd=1.16u ps=1.16u
    I_MXI1_I152_I37_MN5 (XI1_I152_I37_n2 VSS VSS VSS) gpdk090_nmos1v w=0.24u l=0.1u ad=0.0528p as=0.0816p pd=0.68u ps=1.16u
    I_MXI1_I152_I37_MN4 (DIVR_0 XI1_I152_I37_An XI1_I152_I37_n2 VSS) gpdk090_nmos1v w=0.24u l=0.1u ad=0.0528p as=0.0528p pd=0.68u ps=0.68u
    I_MXI1_I152_I37_MN2 (XI1_I152_I37_n1 I1_I152_pn0 DIVR_0 VSS) gpdk090_nmos1v w=0.24u l=0.1u ad=0.0528p as=0.0528p pd=0.68u ps=0.68u
    I_MXI1_I152_I37_MN3 (VSS XI1_I152_I37_Bn XI1_I152_I37_n1 VSS) gpdk090_nmos1v w=0.24u l=0.1u ad=0.0816p as=0.0528p pd=1.16u ps=0.68u
    I_MXI1_I152_I37_MN0 (XI1_I152_I37_An I1_I152_pn0 VSS VSS) gpdk090_nmos1v w=0.12u l=0.1u ad=0.0696p as=0.0696p pd=1.16u ps=1.16u
    I_MXI0_I77_I37_MN1 (XI0_I77_I37_Bn I0_rc8 VSS VSS) gpdk090_nmos1v w=0.12u l=0.1u ad=0.0696p as=0.0696p pd=1.16u ps=1.16u
    I_MXI0_I77_I37_MN5 (XI0_I77_I37_n2 I0_rc8 VSS VSS) gpdk090_nmos1v w=0.24u l=0.1u ad=0.0528p as=0.0816p pd=0.68u ps=1.16u
    I_MXI0_I77_I37_MN4 (MULP_8 XI0_I77_I37_An XI0_I77_I37_n2 VSS) gpdk090_nmos1v w=0.24u l=0.1u ad=0.0528p as=0.0528p pd=0.68u ps=0.68u
    I_MXI0_I77_I37_MN2 (XI0_I77_I37_n1 I0_I77_pn0 MULP_8 VSS) gpdk090_nmos1v w=0.24u l=0.1u ad=0.0528p as=0.0528p pd=0.68u ps=0.68u
    I_MXI0_I77_I37_MN3 (VSS XI0_I77_I37_Bn XI0_I77_I37_n1 VSS) gpdk090_nmos1v w=0.24u l=0.1u ad=0.0816p as=0.0528p pd=1.16u ps=0.68u
    I_MXI0_I77_I37_MN0 (XI0_I77_I37_An I0_I77_pn0 VSS VSS) gpdk090_nmos1v w=0.12u l=0.1u ad=0.0696p as=0.0696p pd=1.16u ps=1.16u
    I_MXI0_I77_I8_MN1 (XI0_I77_I8_Bn I0_ha18_0 VSS VSS) gpdk090_nmos1v w=0.12u l=0.1u ad=0.0696p as=0.0696p pd=1.16u ps=1.16u
    I_MXI0_I77_I8_MN5 (XI0_I77_I8_n2 I0_ha18_0 VSS VSS) gpdk090_nmos1v w=0.24u l=0.1u ad=0.0528p as=0.0816p pd=0.68u ps=1.16u
    I_MXI0_I77_I8_MN4 (I0_I77_pn0 XI0_I77_I8_An XI0_I77_I8_n2 VSS) gpdk090_nmos1v w=0.24u l=0.1u ad=0.0528p as=0.0528p pd=0.68u ps=0.68u
    I_MXI0_I77_I8_MN2 (XI0_I77_I8_n1 I0_ha17_1 I0_I77_pn0 VSS) gpdk090_nmos1v w=0.24u l=0.1u ad=0.0528p as=0.0528p pd=0.68u ps=0.68u
    I_MXI0_I77_I8_MN3 (VSS XI0_I77_I8_Bn XI0_I77_I8_n1 VSS) gpdk090_nmos1v w=0.24u l=0.1u ad=0.0816p as=0.0528p pd=1.16u ps=0.68u
    I_MXI0_I77_I8_MN0 (XI0_I77_I8_An I0_ha17_1 VSS VSS) gpdk090_nmos1v w=0.12u l=0.1u ad=0.0696p as=0.0696p pd=1.16u ps=1.16u
    I_MXI2_I1_I8_I14_MN1 (XI2_I1_I8_I14_Bn I2_I1_bx6 VSS VSS) gpdk090_nmos1v w=0.12u l=0.1u ad=0.0696p as=0.0696p pd=1.16u ps=1.16u
    I_MXI2_I1_I8_I14_MN5 (XI2_I1_I8_I14_n2 I2_I1_bx6 VSS VSS) gpdk090_nmos1v w=0.24u l=0.1u ad=0.0528p as=0.0816p pd=0.68u ps=1.16u
    I_MXI2_I1_I8_I14_MN4 (I2_I1_I8_pn6 XI2_I1_I8_I14_An XI2_I1_I8_I14_n2 VSS) gpdk090_nmos1v w=0.24u l=0.1u ad=0.0528p as=0.0528p pd=0.68u ps=0.68u
    I_MXI2_I1_I8_I14_MN2 (XI2_I1_I8_I14_n1 A_6 I2_I1_I8_pn6 VSS) gpdk090_nmos1v w=0.24u l=0.1u ad=0.0528p as=0.0528p pd=0.68u ps=0.68u
    I_MXI2_I1_I8_I14_MN3 (VSS XI2_I1_I8_I14_Bn XI2_I1_I8_I14_n1 VSS) gpdk090_nmos1v w=0.24u l=0.1u ad=0.0816p as=0.0528p pd=1.16u ps=0.68u
    I_MXI2_I1_I8_I14_MN0 (XI2_I1_I8_I14_An A_6 VSS VSS) gpdk090_nmos1v w=0.12u l=0.1u ad=0.0696p as=0.0696p pd=1.16u ps=1.16u
    I_MXI2_I1_I8_I13_MN1 (XI2_I1_I8_I13_Bn I2_I1_bx5 VSS VSS) gpdk090_nmos1v w=0.12u l=0.1u ad=0.0696p as=0.0696p pd=1.16u ps=1.16u
    I_MXI2_I1_I8_I13_MN5 (XI2_I1_I8_I13_n2 I2_I1_bx5 VSS VSS) gpdk090_nmos1v w=0.24u l=0.1u ad=0.0528p as=0.0816p pd=0.68u ps=1.16u
    I_MXI2_I1_I8_I13_MN4 (I2_I1_I8_pn5 XI2_I1_I8_I13_An XI2_I1_I8_I13_n2 VSS) gpdk090_nmos1v w=0.24u l=0.1u ad=0.0528p as=0.0528p pd=0.68u ps=0.68u
    I_MXI2_I1_I8_I13_MN2 (XI2_I1_I8_I13_n1 A_5 I2_I1_I8_pn5 VSS) gpdk090_nmos1v w=0.24u l=0.1u ad=0.0528p as=0.0528p pd=0.68u ps=0.68u
    I_MXI2_I1_I8_I13_MN3 (VSS XI2_I1_I8_I13_Bn XI2_I1_I8_I13_n1 VSS) gpdk090_nmos1v w=0.24u l=0.1u ad=0.0816p as=0.0528p pd=1.16u ps=0.68u
    I_MXI2_I1_I8_I13_MN0 (XI2_I1_I8_I13_An A_5 VSS VSS) gpdk090_nmos1v w=0.12u l=0.1u ad=0.0696p as=0.0696p pd=1.16u ps=1.16u
    I_MXI1_I132_I44_MN1 (XI1_I132_I44_Bn I1_c7_7 VSS VSS) gpdk090_nmos1v w=0.12u l=0.1u ad=0.0696p as=0.0696p pd=1.16u ps=1.16u
    I_MXI1_I132_I44_MN5 (XI1_I132_I44_n2 I1_c7_7 VSS VSS) gpdk090_nmos1v w=0.24u l=0.1u ad=0.0528p as=0.0816p pd=0.68u ps=1.16u
    I_MXI1_I132_I44_MN4 (I1_p7_7 XI1_I132_I44_An XI1_I132_I44_n2 VSS) gpdk090_nmos1v w=0.24u l=0.1u ad=0.0528p as=0.0528p pd=0.68u ps=0.68u
    I_MXI1_I132_I44_MN2 (XI1_I132_I44_n1 I1_I132_pn7 I1_p7_7 VSS) gpdk090_nmos1v w=0.24u l=0.1u ad=0.0528p as=0.0528p pd=0.68u ps=0.68u
    I_MXI1_I132_I44_MN3 (VSS XI1_I132_I44_Bn XI1_I132_I44_n1 VSS) gpdk090_nmos1v w=0.24u l=0.1u ad=0.0816p as=0.0528p pd=1.16u ps=0.68u
    I_MXI1_I132_I44_MN0 (XI1_I132_I44_An I1_I132_pn7 VSS VSS) gpdk090_nmos1v w=0.12u l=0.1u ad=0.0696p as=0.0696p pd=1.16u ps=1.16u
    I_MXI1_I132_I42_MN1 (XI1_I132_I42_Bn I1_I132_G4_0 VSS VSS) gpdk090_nmos1v w=0.12u l=0.1u ad=0.0696p as=0.0696p pd=1.16u ps=1.16u
    I_MXI1_I132_I42_MN5 (XI1_I132_I42_n2 I1_I132_G4_0 VSS VSS) gpdk090_nmos1v w=0.24u l=0.1u ad=0.0528p as=0.0816p pd=0.68u ps=1.16u
    I_MXI1_I132_I42_MN4 (I1_p7_5 XI1_I132_I42_An XI1_I132_I42_n2 VSS) gpdk090_nmos1v w=0.24u l=0.1u ad=0.0528p as=0.0528p pd=0.68u ps=0.68u
    I_MXI1_I132_I42_MN2 (XI1_I132_I42_n1 I1_I132_pn5 I1_p7_5 VSS) gpdk090_nmos1v w=0.24u l=0.1u ad=0.0528p as=0.0528p pd=0.68u ps=0.68u
    I_MXI1_I132_I42_MN3 (VSS XI1_I132_I42_Bn XI1_I132_I42_n1 VSS) gpdk090_nmos1v w=0.24u l=0.1u ad=0.0816p as=0.0528p pd=1.16u ps=0.68u
    I_MXI1_I132_I42_MN0 (XI1_I132_I42_An I1_I132_pn5 VSS VSS) gpdk090_nmos1v w=0.12u l=0.1u ad=0.0696p as=0.0696p pd=1.16u ps=1.16u
    I_MXI1_I132_I39_MN1 (XI1_I132_I39_Bn I1_I132_G1_0 VSS VSS) gpdk090_nmos1v w=0.12u l=0.1u ad=0.0696p as=0.0696p pd=1.16u ps=1.16u
    I_MXI1_I132_I39_MN5 (XI1_I132_I39_n2 I1_I132_G1_0 VSS VSS) gpdk090_nmos1v w=0.24u l=0.1u ad=0.0528p as=0.0816p pd=0.68u ps=1.16u
    I_MXI1_I132_I39_MN4 (I1_p7_2 XI1_I132_I39_An XI1_I132_I39_n2 VSS) gpdk090_nmos1v w=0.24u l=0.1u ad=0.0528p as=0.0528p pd=0.68u ps=0.68u
    I_MXI1_I132_I39_MN2 (XI1_I132_I39_n1 I1_I132_pn2 I1_p7_2 VSS) gpdk090_nmos1v w=0.24u l=0.1u ad=0.0528p as=0.0528p pd=0.68u ps=0.68u
    I_MXI1_I132_I39_MN3 (VSS XI1_I132_I39_Bn XI1_I132_I39_n1 VSS) gpdk090_nmos1v w=0.24u l=0.1u ad=0.0816p as=0.0528p pd=1.16u ps=0.68u
    I_MXI1_I132_I39_MN0 (XI1_I132_I39_An I1_I132_pn2 VSS VSS) gpdk090_nmos1v w=0.12u l=0.1u ad=0.0696p as=0.0696p pd=1.16u ps=1.16u
    I_MXI1_I152_I9_MN1 (XI1_I152_I9_Bn I1_dm1 VSS VSS) gpdk090_nmos1v w=0.12u l=0.1u ad=0.0696p as=0.0696p pd=1.16u ps=1.16u
    I_MXI1_I152_I9_MN5 (XI1_I152_I9_n2 I1_dm1 VSS VSS) gpdk090_nmos1v w=0.24u l=0.1u ad=0.0528p as=0.0816p pd=0.68u ps=1.16u
    I_MXI1_I152_I9_MN4 (I1_I152_pn1 XI1_I152_I9_An XI1_I152_I9_n2 VSS) gpdk090_nmos1v w=0.24u l=0.1u ad=0.0528p as=0.0528p pd=0.68u ps=0.68u
    I_MXI1_I152_I9_MN2 (XI1_I152_I9_n1 I1_p7_1 I1_I152_pn1 VSS) gpdk090_nmos1v w=0.24u l=0.1u ad=0.0528p as=0.0528p pd=0.68u ps=0.68u
    I_MXI1_I152_I9_MN3 (VSS XI1_I152_I9_Bn XI1_I152_I9_n1 VSS) gpdk090_nmos1v w=0.24u l=0.1u ad=0.0816p as=0.0528p pd=1.16u ps=0.68u
    I_MXI1_I152_I9_MN0 (XI1_I152_I9_An I1_p7_1 VSS VSS) gpdk090_nmos1v w=0.12u l=0.1u ad=0.0696p as=0.0696p pd=1.16u ps=1.16u
    I_MXI1_I152_I8_MN1 (XI1_I152_I8_Bn I1_dm0 VSS VSS) gpdk090_nmos1v w=0.12u l=0.1u ad=0.0696p as=0.0696p pd=1.16u ps=1.16u
    I_MXI1_I152_I8_MN5 (XI1_I152_I8_n2 I1_dm0 VSS VSS) gpdk090_nmos1v w=0.24u l=0.1u ad=0.0528p as=0.0816p pd=0.68u ps=1.16u
    I_MXI1_I152_I8_MN4 (I1_I152_pn0 XI1_I152_I8_An XI1_I152_I8_n2 VSS) gpdk090_nmos1v w=0.24u l=0.1u ad=0.0528p as=0.0528p pd=0.68u ps=0.68u
    I_MXI1_I152_I8_MN2 (XI1_I152_I8_n1 I1_p7_0 I1_I152_pn0 VSS) gpdk090_nmos1v w=0.24u l=0.1u ad=0.0528p as=0.0528p pd=0.68u ps=0.68u
    I_MXI1_I152_I8_MN3 (VSS XI1_I152_I8_Bn XI1_I152_I8_n1 VSS) gpdk090_nmos1v w=0.24u l=0.1u ad=0.0816p as=0.0528p pd=1.16u ps=0.68u
    I_MXI1_I152_I8_MN0 (XI1_I152_I8_An I1_p7_0 VSS VSS) gpdk090_nmos1v w=0.12u l=0.1u ad=0.0696p as=0.0696p pd=1.16u ps=1.16u
    I_MXI2_I1_I8_I44_MN1 (XI2_I1_I8_I44_Bn I2_C7 VSS VSS) gpdk090_nmos1v w=0.12u l=0.1u ad=0.0696p as=0.0696p pd=1.16u ps=1.16u
    I_MXI2_I1_I8_I44_MN5 (XI2_I1_I8_I44_n2 I2_C7 VSS VSS) gpdk090_nmos1v w=0.24u l=0.1u ad=0.0528p as=0.0816p pd=0.68u ps=1.16u
    I_MXI2_I1_I8_I44_MN4 (I2_S_7 XI2_I1_I8_I44_An XI2_I1_I8_I44_n2 VSS) gpdk090_nmos1v w=0.24u l=0.1u ad=0.0528p as=0.0528p pd=0.68u ps=0.68u
    I_MXI2_I1_I8_I44_MN2 (XI2_I1_I8_I44_n1 I2_I1_I8_pn7 I2_S_7 VSS) gpdk090_nmos1v w=0.24u l=0.1u ad=0.0528p as=0.0528p pd=0.68u ps=0.68u
    I_MXI2_I1_I8_I44_MN3 (VSS XI2_I1_I8_I44_Bn XI2_I1_I8_I44_n1 VSS) gpdk090_nmos1v w=0.24u l=0.1u ad=0.0816p as=0.0528p pd=1.16u ps=0.68u
    I_MXI2_I1_I8_I44_MN0 (XI2_I1_I8_I44_An I2_I1_I8_pn7 VSS VSS) gpdk090_nmos1v w=0.12u l=0.1u ad=0.0696p as=0.0696p pd=1.16u ps=1.16u
    I_MXI2_I1_I8_I43_MN1 (XI2_I1_I8_I43_Bn I2_I1_I8_G5_0 VSS VSS) gpdk090_nmos1v w=0.12u l=0.1u ad=0.0696p as=0.0696p pd=1.16u ps=1.16u
    I_MXI2_I1_I8_I43_MN5 (XI2_I1_I8_I43_n2 I2_I1_I8_G5_0 VSS VSS) gpdk090_nmos1v w=0.24u l=0.1u ad=0.0528p as=0.0816p pd=0.68u ps=1.16u
    I_MXI2_I1_I8_I43_MN4 (I2_S_6 XI2_I1_I8_I43_An XI2_I1_I8_I43_n2 VSS) gpdk090_nmos1v w=0.24u l=0.1u ad=0.0528p as=0.0528p pd=0.68u ps=0.68u
    I_MXI2_I1_I8_I43_MN2 (XI2_I1_I8_I43_n1 I2_I1_I8_pn6 I2_S_6 VSS) gpdk090_nmos1v w=0.24u l=0.1u ad=0.0528p as=0.0528p pd=0.68u ps=0.68u
    I_MXI2_I1_I8_I43_MN3 (VSS XI2_I1_I8_I43_Bn XI2_I1_I8_I43_n1 VSS) gpdk090_nmos1v w=0.24u l=0.1u ad=0.0816p as=0.0528p pd=1.16u ps=0.68u
    I_MXI2_I1_I8_I43_MN0 (XI2_I1_I8_I43_An I2_I1_I8_pn6 VSS VSS) gpdk090_nmos1v w=0.12u l=0.1u ad=0.0696p as=0.0696p pd=1.16u ps=1.16u
    I_MXI1_I132_I9_MN1 (XI1_I132_I9_Bn I1_b7_1 VSS VSS) gpdk090_nmos1v w=0.12u l=0.1u ad=0.0696p as=0.0696p pd=1.16u ps=1.16u
    I_MXI1_I132_I9_MN5 (XI1_I132_I9_n2 I1_b7_1 VSS VSS) gpdk090_nmos1v w=0.24u l=0.1u ad=0.0528p as=0.0816p pd=0.68u ps=1.16u
    I_MXI1_I132_I9_MN4 (I1_I132_pn1 XI1_I132_I9_An XI1_I132_I9_n2 VSS) gpdk090_nmos1v w=0.24u l=0.1u ad=0.0528p as=0.0528p pd=0.68u ps=0.68u
    I_MXI1_I132_I9_MN2 (XI1_I132_I9_n1 I1_p6_0 I1_I132_pn1 VSS) gpdk090_nmos1v w=0.24u l=0.1u ad=0.0528p as=0.0528p pd=0.68u ps=0.68u
    I_MXI1_I132_I9_MN3 (VSS XI1_I132_I9_Bn XI1_I132_I9_n1 VSS) gpdk090_nmos1v w=0.24u l=0.1u ad=0.0816p as=0.0528p pd=1.16u ps=0.68u
    I_MXI1_I132_I9_MN0 (XI1_I132_I9_An I1_p6_0 VSS VSS) gpdk090_nmos1v w=0.12u l=0.1u ad=0.0696p as=0.0696p pd=1.16u ps=1.16u
    I_MXI1_I132_I37_MN1 (XI1_I132_I37_Bn I1_qu1 VSS VSS) gpdk090_nmos1v w=0.12u l=0.1u ad=0.0696p as=0.0696p pd=1.16u ps=1.16u
    I_MXI1_I132_I37_MN5 (XI1_I132_I37_n2 I1_qu1 VSS VSS) gpdk090_nmos1v w=0.24u l=0.1u ad=0.0528p as=0.0816p pd=0.68u ps=1.16u
    I_MXI1_I132_I37_MN4 (I1_p7_0 XI1_I132_I37_An XI1_I132_I37_n2 VSS) gpdk090_nmos1v w=0.24u l=0.1u ad=0.0528p as=0.0528p pd=0.68u ps=0.68u
    I_MXI1_I132_I37_MN2 (XI1_I132_I37_n1 I1_I132_pn0 I1_p7_0 VSS) gpdk090_nmos1v w=0.24u l=0.1u ad=0.0528p as=0.0528p pd=0.68u ps=0.68u
    I_MXI1_I132_I37_MN3 (VSS XI1_I132_I37_Bn XI1_I132_I37_n1 VSS) gpdk090_nmos1v w=0.24u l=0.1u ad=0.0816p as=0.0528p pd=1.16u ps=0.68u
    I_MXI1_I132_I37_MN0 (XI1_I132_I37_An I1_I132_pn0 VSS VSS) gpdk090_nmos1v w=0.12u l=0.1u ad=0.0696p as=0.0696p pd=1.16u ps=1.16u
    I_MXI1_I132_I38_MN1 (XI1_I132_I38_Bn I1_I132_G0_0 VSS VSS) gpdk090_nmos1v w=0.12u l=0.1u ad=0.0696p as=0.0696p pd=1.16u ps=1.16u
    I_MXI1_I132_I38_MN5 (XI1_I132_I38_n2 I1_I132_G0_0 VSS VSS) gpdk090_nmos1v w=0.24u l=0.1u ad=0.0528p as=0.0816p pd=0.68u ps=1.16u
    I_MXI1_I132_I38_MN4 (I1_p7_1 XI1_I132_I38_An XI1_I132_I38_n2 VSS) gpdk090_nmos1v w=0.24u l=0.1u ad=0.0528p as=0.0528p pd=0.68u ps=0.68u
    I_MXI1_I132_I38_MN2 (XI1_I132_I38_n1 I1_I132_pn1 I1_p7_1 VSS) gpdk090_nmos1v w=0.24u l=0.1u ad=0.0528p as=0.0528p pd=0.68u ps=0.68u
    I_MXI1_I132_I38_MN3 (VSS XI1_I132_I38_Bn XI1_I132_I38_n1 VSS) gpdk090_nmos1v w=0.24u l=0.1u ad=0.0816p as=0.0528p pd=1.16u ps=0.68u
    I_MXI1_I132_I38_MN0 (XI1_I132_I38_An I1_I132_pn1 VSS VSS) gpdk090_nmos1v w=0.12u l=0.1u ad=0.0696p as=0.0696p pd=1.16u ps=1.16u
    I_MXI1_I132_I8_MN1 (XI1_I132_I8_Bn I1_b7_0 VSS VSS) gpdk090_nmos1v w=0.12u l=0.1u ad=0.0696p as=0.0696p pd=1.16u ps=1.16u
    I_MXI1_I132_I8_MN5 (XI1_I132_I8_n2 I1_b7_0 VSS VSS) gpdk090_nmos1v w=0.24u l=0.1u ad=0.0528p as=0.0816p pd=0.68u ps=1.16u
    I_MXI1_I132_I8_MN4 (I1_I132_pn0 XI1_I132_I8_An XI1_I132_I8_n2 VSS) gpdk090_nmos1v w=0.24u l=0.1u ad=0.0528p as=0.0528p pd=0.68u ps=0.68u
    I_MXI1_I132_I8_MN2 (XI1_I132_I8_n1 A_0 I1_I132_pn0 VSS) gpdk090_nmos1v w=0.24u l=0.1u ad=0.0528p as=0.0528p pd=0.68u ps=0.68u
    I_MXI1_I132_I8_MN3 (VSS XI1_I132_I8_Bn XI1_I132_I8_n1 VSS) gpdk090_nmos1v w=0.24u l=0.1u ad=0.0816p as=0.0528p pd=1.16u ps=0.68u
    I_MXI1_I132_I8_MN0 (XI1_I132_I8_An A_0 VSS VSS) gpdk090_nmos1v w=0.12u l=0.1u ad=0.0696p as=0.0696p pd=1.16u ps=1.16u
    I_MXI1_I39_MN1 (XI1_I39_Bn I1_nbkn7 VSS VSS) gpdk090_nmos1v w=0.12u l=0.1u ad=0.0696p as=0.0696p pd=1.16u ps=1.16u
    I_MXI1_I39_MN5 (XI1_I39_n2 I1_nbkn7 VSS VSS) gpdk090_nmos1v w=0.24u l=0.1u ad=0.0528p as=0.0816p pd=0.68u ps=1.16u
    I_MXI1_I39_MN4 (I1_dd7 XI1_I39_An XI1_I39_n2 VSS) gpdk090_nmos1v w=0.24u l=0.1u ad=0.0528p as=0.0528p pd=0.68u ps=0.68u
    I_MXI1_I39_MN2 (XI1_I39_n1 B_7 I1_dd7 VSS) gpdk090_nmos1v w=0.24u l=0.1u ad=0.0528p as=0.0528p pd=0.68u ps=0.68u
    I_MXI1_I39_MN3 (VSS XI1_I39_Bn XI1_I39_n1 VSS) gpdk090_nmos1v w=0.24u l=0.1u ad=0.0816p as=0.0528p pd=1.16u ps=0.68u
    I_MXI1_I39_MN0 (XI1_I39_An B_7 VSS VSS) gpdk090_nmos1v w=0.12u l=0.1u ad=0.0696p as=0.0696p pd=1.16u ps=1.16u
    I_MXI2_I1_I8_I11_MN1 (XI2_I1_I8_I11_Bn I2_I1_bx3 VSS VSS) gpdk090_nmos1v w=0.12u l=0.1u ad=0.0696p as=0.0696p pd=1.16u ps=1.16u
    I_MXI2_I1_I8_I11_MN5 (XI2_I1_I8_I11_n2 I2_I1_bx3 VSS VSS) gpdk090_nmos1v w=0.24u l=0.1u ad=0.0528p as=0.0816p pd=0.68u ps=1.16u
    I_MXI2_I1_I8_I11_MN4 (I2_I1_I8_pn3 XI2_I1_I8_I11_An XI2_I1_I8_I11_n2 VSS) gpdk090_nmos1v w=0.24u l=0.1u ad=0.0528p as=0.0528p pd=0.68u ps=0.68u
    I_MXI2_I1_I8_I11_MN2 (XI2_I1_I8_I11_n1 A_3 I2_I1_I8_pn3 VSS) gpdk090_nmos1v w=0.24u l=0.1u ad=0.0528p as=0.0528p pd=0.68u ps=0.68u
    I_MXI2_I1_I8_I11_MN3 (VSS XI2_I1_I8_I11_Bn XI2_I1_I8_I11_n1 VSS) gpdk090_nmos1v w=0.24u l=0.1u ad=0.0816p as=0.0528p pd=1.16u ps=0.68u
    I_MXI2_I1_I8_I11_MN0 (XI2_I1_I8_I11_An A_3 VSS VSS) gpdk090_nmos1v w=0.12u l=0.1u ad=0.0696p as=0.0696p pd=1.16u ps=1.16u
    I_MXI2_I1_I8_I12_MN1 (XI2_I1_I8_I12_Bn I2_I1_bx4 VSS VSS) gpdk090_nmos1v w=0.12u l=0.1u ad=0.0696p as=0.0696p pd=1.16u ps=1.16u
    I_MXI2_I1_I8_I12_MN5 (XI2_I1_I8_I12_n2 I2_I1_bx4 VSS VSS) gpdk090_nmos1v w=0.24u l=0.1u ad=0.0528p as=0.0816p pd=0.68u ps=1.16u
    I_MXI2_I1_I8_I12_MN4 (I2_I1_I8_pn4 XI2_I1_I8_I12_An XI2_I1_I8_I12_n2 VSS) gpdk090_nmos1v w=0.24u l=0.1u ad=0.0528p as=0.0528p pd=0.68u ps=0.68u
    I_MXI2_I1_I8_I12_MN2 (XI2_I1_I8_I12_n1 A_4 I2_I1_I8_pn4 VSS) gpdk090_nmos1v w=0.24u l=0.1u ad=0.0528p as=0.0528p pd=0.68u ps=0.68u
    I_MXI2_I1_I8_I12_MN3 (VSS XI2_I1_I8_I12_Bn XI2_I1_I8_I12_n1 VSS) gpdk090_nmos1v w=0.24u l=0.1u ad=0.0816p as=0.0528p pd=1.16u ps=0.68u
    I_MXI2_I1_I8_I12_MN0 (XI2_I1_I8_I12_An A_4 VSS VSS) gpdk090_nmos1v w=0.12u l=0.1u ad=0.0696p as=0.0696p pd=1.16u ps=1.16u
    I_MXI1_I132_I15_MN1 (XI1_I132_I15_Bn I1_b7_7 VSS VSS) gpdk090_nmos1v w=0.12u l=0.1u ad=0.0696p as=0.0696p pd=1.16u ps=1.16u
    I_MXI1_I132_I15_MN5 (XI1_I132_I15_n2 I1_b7_7 VSS VSS) gpdk090_nmos1v w=0.24u l=0.1u ad=0.0528p as=0.0816p pd=0.68u ps=1.16u
    I_MXI1_I132_I15_MN4 (I1_I132_pn7 XI1_I132_I15_An XI1_I132_I15_n2 VSS) gpdk090_nmos1v w=0.24u l=0.1u ad=0.0528p as=0.0528p pd=0.68u ps=0.68u
    I_MXI1_I132_I15_MN2 (XI1_I132_I15_n1 I1_p6_6 I1_I132_pn7 VSS) gpdk090_nmos1v w=0.24u l=0.1u ad=0.0528p as=0.0528p pd=0.68u ps=0.68u
    I_MXI1_I132_I15_MN3 (VSS XI1_I132_I15_Bn XI1_I132_I15_n1 VSS) gpdk090_nmos1v w=0.24u l=0.1u ad=0.0816p as=0.0528p pd=1.16u ps=0.68u
    I_MXI1_I132_I15_MN0 (XI1_I132_I15_An I1_p6_6 VSS VSS) gpdk090_nmos1v w=0.12u l=0.1u ad=0.0696p as=0.0696p pd=1.16u ps=1.16u
    I_MXI1_I132_I14_MN1 (XI1_I132_I14_Bn I1_b7_6 VSS VSS) gpdk090_nmos1v w=0.12u l=0.1u ad=0.0696p as=0.0696p pd=1.16u ps=1.16u
    I_MXI1_I132_I14_MN5 (XI1_I132_I14_n2 I1_b7_6 VSS VSS) gpdk090_nmos1v w=0.24u l=0.1u ad=0.0528p as=0.0816p pd=0.68u ps=1.16u
    I_MXI1_I132_I14_MN4 (I1_I132_pn6 XI1_I132_I14_An XI1_I132_I14_n2 VSS) gpdk090_nmos1v w=0.24u l=0.1u ad=0.0528p as=0.0528p pd=0.68u ps=0.68u
    I_MXI1_I132_I14_MN2 (XI1_I132_I14_n1 I1_p6_5 I1_I132_pn6 VSS) gpdk090_nmos1v w=0.24u l=0.1u ad=0.0528p as=0.0528p pd=0.68u ps=0.68u
    I_MXI1_I132_I14_MN3 (VSS XI1_I132_I14_Bn XI1_I132_I14_n1 VSS) gpdk090_nmos1v w=0.24u l=0.1u ad=0.0816p as=0.0528p pd=1.16u ps=0.68u
    I_MXI1_I132_I14_MN0 (XI1_I132_I14_An I1_p6_5 VSS VSS) gpdk090_nmos1v w=0.12u l=0.1u ad=0.0696p as=0.0696p pd=1.16u ps=1.16u
    I_MXI1_I132_I12_MN1 (XI1_I132_I12_Bn I1_b7_4 VSS VSS) gpdk090_nmos1v w=0.12u l=0.1u ad=0.0696p as=0.0696p pd=1.16u ps=1.16u
    I_MXI1_I132_I12_MN5 (XI1_I132_I12_n2 I1_b7_4 VSS VSS) gpdk090_nmos1v w=0.24u l=0.1u ad=0.0528p as=0.0816p pd=0.68u ps=1.16u
    I_MXI1_I132_I12_MN4 (I1_I132_pn4 XI1_I132_I12_An XI1_I132_I12_n2 VSS) gpdk090_nmos1v w=0.24u l=0.1u ad=0.0528p as=0.0528p pd=0.68u ps=0.68u
    I_MXI1_I132_I12_MN2 (XI1_I132_I12_n1 I1_p6_3 I1_I132_pn4 VSS) gpdk090_nmos1v w=0.24u l=0.1u ad=0.0528p as=0.0528p pd=0.68u ps=0.68u
    I_MXI1_I132_I12_MN3 (VSS XI1_I132_I12_Bn XI1_I132_I12_n1 VSS) gpdk090_nmos1v w=0.24u l=0.1u ad=0.0816p as=0.0528p pd=1.16u ps=0.68u
    I_MXI1_I132_I12_MN0 (XI1_I132_I12_An I1_p6_3 VSS VSS) gpdk090_nmos1v w=0.12u l=0.1u ad=0.0696p as=0.0696p pd=1.16u ps=1.16u
    I_MXI1_I132_I11_MN1 (XI1_I132_I11_Bn I1_b7_3 VSS VSS) gpdk090_nmos1v w=0.12u l=0.1u ad=0.0696p as=0.0696p pd=1.16u ps=1.16u
    I_MXI1_I132_I11_MN5 (XI1_I132_I11_n2 I1_b7_3 VSS VSS) gpdk090_nmos1v w=0.24u l=0.1u ad=0.0528p as=0.0816p pd=0.68u ps=1.16u
    I_MXI1_I132_I11_MN4 (I1_I132_pn3 XI1_I132_I11_An XI1_I132_I11_n2 VSS) gpdk090_nmos1v w=0.24u l=0.1u ad=0.0528p as=0.0528p pd=0.68u ps=0.68u
    I_MXI1_I132_I11_MN2 (XI1_I132_I11_n1 I1_p6_2 I1_I132_pn3 VSS) gpdk090_nmos1v w=0.24u l=0.1u ad=0.0528p as=0.0528p pd=0.68u ps=0.68u
    I_MXI1_I132_I11_MN3 (VSS XI1_I132_I11_Bn XI1_I132_I11_n1 VSS) gpdk090_nmos1v w=0.24u l=0.1u ad=0.0816p as=0.0528p pd=1.16u ps=0.68u
    I_MXI1_I132_I11_MN0 (XI1_I132_I11_An I1_p6_2 VSS VSS) gpdk090_nmos1v w=0.12u l=0.1u ad=0.0696p as=0.0696p pd=1.16u ps=1.16u
    I_MXI1_I132_I10_MN1 (XI1_I132_I10_Bn I1_b7_2 VSS VSS) gpdk090_nmos1v w=0.12u l=0.1u ad=0.0696p as=0.0696p pd=1.16u ps=1.16u
    I_MXI1_I132_I10_MN5 (XI1_I132_I10_n2 I1_b7_2 VSS VSS) gpdk090_nmos1v w=0.24u l=0.1u ad=0.0528p as=0.0816p pd=0.68u ps=1.16u
    I_MXI1_I132_I10_MN4 (I1_I132_pn2 XI1_I132_I10_An XI1_I132_I10_n2 VSS) gpdk090_nmos1v w=0.24u l=0.1u ad=0.0528p as=0.0528p pd=0.68u ps=0.68u
    I_MXI1_I132_I10_MN2 (XI1_I132_I10_n1 I1_p6_1 I1_I132_pn2 VSS) gpdk090_nmos1v w=0.24u l=0.1u ad=0.0528p as=0.0528p pd=0.68u ps=0.68u
    I_MXI1_I132_I10_MN3 (VSS XI1_I132_I10_Bn XI1_I132_I10_n1 VSS) gpdk090_nmos1v w=0.24u l=0.1u ad=0.0816p as=0.0528p pd=1.16u ps=0.68u
    I_MXI1_I132_I10_MN0 (XI1_I132_I10_An I1_p6_1 VSS VSS) gpdk090_nmos1v w=0.12u l=0.1u ad=0.0696p as=0.0696p pd=1.16u ps=1.16u
    I_MXI1_I36_MN1 (XI1_I36_Bn I1_nbkn6 VSS VSS) gpdk090_nmos1v w=0.12u l=0.1u ad=0.0696p as=0.0696p pd=1.16u ps=1.16u
    I_MXI1_I36_MN5 (XI1_I36_n2 I1_nbkn6 VSS VSS) gpdk090_nmos1v w=0.24u l=0.1u ad=0.0528p as=0.0816p pd=0.68u ps=1.16u
    I_MXI1_I36_MN4 (I1_dd6 XI1_I36_An XI1_I36_n2 VSS) gpdk090_nmos1v w=0.24u l=0.1u ad=0.0528p as=0.0528p pd=0.68u ps=0.68u
    I_MXI1_I36_MN2 (XI1_I36_n1 B_6 I1_dd6 VSS) gpdk090_nmos1v w=0.24u l=0.1u ad=0.0528p as=0.0528p pd=0.68u ps=0.68u
    I_MXI1_I36_MN3 (VSS XI1_I36_Bn XI1_I36_n1 VSS) gpdk090_nmos1v w=0.24u l=0.1u ad=0.0816p as=0.0528p pd=1.16u ps=0.68u
    I_MXI1_I36_MN0 (XI1_I36_An B_6 VSS VSS) gpdk090_nmos1v w=0.12u l=0.1u ad=0.0696p as=0.0696p pd=1.16u ps=1.16u
    I_MXI2_I1_I8_I42_MN1 (XI2_I1_I8_I42_Bn I2_I1_I8_G4_0 VSS VSS) gpdk090_nmos1v w=0.12u l=0.1u ad=0.0696p as=0.0696p pd=1.16u ps=1.16u
    I_MXI2_I1_I8_I42_MN5 (XI2_I1_I8_I42_n2 I2_I1_I8_G4_0 VSS VSS) gpdk090_nmos1v w=0.24u l=0.1u ad=0.0528p as=0.0816p pd=0.68u ps=1.16u
    I_MXI2_I1_I8_I42_MN4 (I2_S_5 XI2_I1_I8_I42_An XI2_I1_I8_I42_n2 VSS) gpdk090_nmos1v w=0.24u l=0.1u ad=0.0528p as=0.0528p pd=0.68u ps=0.68u
    I_MXI2_I1_I8_I42_MN2 (XI2_I1_I8_I42_n1 I2_I1_I8_pn5 I2_S_5 VSS) gpdk090_nmos1v w=0.24u l=0.1u ad=0.0528p as=0.0528p pd=0.68u ps=0.68u
    I_MXI2_I1_I8_I42_MN3 (VSS XI2_I1_I8_I42_Bn XI2_I1_I8_I42_n1 VSS) gpdk090_nmos1v w=0.24u l=0.1u ad=0.0816p as=0.0528p pd=1.16u ps=0.68u
    I_MXI2_I1_I8_I42_MN0 (XI2_I1_I8_I42_An I2_I1_I8_pn5 VSS VSS) gpdk090_nmos1v w=0.12u l=0.1u ad=0.0696p as=0.0696p pd=1.16u ps=1.16u
    I_MXI1_I120_I44_MN1 (XI1_I120_I44_Bn I1_c6_7 VSS VSS) gpdk090_nmos1v w=0.12u l=0.1u ad=0.0696p as=0.0696p pd=1.16u ps=1.16u
    I_MXI1_I120_I44_MN5 (XI1_I120_I44_n2 I1_c6_7 VSS VSS) gpdk090_nmos1v w=0.24u l=0.1u ad=0.0528p as=0.0816p pd=0.68u ps=1.16u
    I_MXI1_I120_I44_MN4 (I1_p6_7 XI1_I120_I44_An XI1_I120_I44_n2 VSS) gpdk090_nmos1v w=0.24u l=0.1u ad=0.0528p as=0.0528p pd=0.68u ps=0.68u
    I_MXI1_I120_I44_MN2 (XI1_I120_I44_n1 I1_I120_pn7 I1_p6_7 VSS) gpdk090_nmos1v w=0.24u l=0.1u ad=0.0528p as=0.0528p pd=0.68u ps=0.68u
    I_MXI1_I120_I44_MN3 (VSS XI1_I120_I44_Bn XI1_I120_I44_n1 VSS) gpdk090_nmos1v w=0.24u l=0.1u ad=0.0816p as=0.0528p pd=1.16u ps=0.68u
    I_MXI1_I120_I44_MN0 (XI1_I120_I44_An I1_I120_pn7 VSS VSS) gpdk090_nmos1v w=0.12u l=0.1u ad=0.0696p as=0.0696p pd=1.16u ps=1.16u
    I_MXI1_I120_I42_MN1 (XI1_I120_I42_Bn I1_I120_G4_0 VSS VSS) gpdk090_nmos1v w=0.12u l=0.1u ad=0.0696p as=0.0696p pd=1.16u ps=1.16u
    I_MXI1_I120_I42_MN5 (XI1_I120_I42_n2 I1_I120_G4_0 VSS VSS) gpdk090_nmos1v w=0.24u l=0.1u ad=0.0528p as=0.0816p pd=0.68u ps=1.16u
    I_MXI1_I120_I42_MN4 (I1_p6_5 XI1_I120_I42_An XI1_I120_I42_n2 VSS) gpdk090_nmos1v w=0.24u l=0.1u ad=0.0528p as=0.0528p pd=0.68u ps=0.68u
    I_MXI1_I120_I42_MN2 (XI1_I120_I42_n1 I1_I120_pn5 I1_p6_5 VSS) gpdk090_nmos1v w=0.24u l=0.1u ad=0.0528p as=0.0528p pd=0.68u ps=0.68u
    I_MXI1_I120_I42_MN3 (VSS XI1_I120_I42_Bn XI1_I120_I42_n1 VSS) gpdk090_nmos1v w=0.24u l=0.1u ad=0.0816p as=0.0528p pd=1.16u ps=0.68u
    I_MXI1_I120_I42_MN0 (XI1_I120_I42_An I1_I120_pn5 VSS VSS) gpdk090_nmos1v w=0.12u l=0.1u ad=0.0696p as=0.0696p pd=1.16u ps=1.16u
    I_MXI1_I132_I13_MN1 (XI1_I132_I13_Bn I1_b7_5 VSS VSS) gpdk090_nmos1v w=0.12u l=0.1u ad=0.0696p as=0.0696p pd=1.16u ps=1.16u
    I_MXI1_I132_I13_MN5 (XI1_I132_I13_n2 I1_b7_5 VSS VSS) gpdk090_nmos1v w=0.24u l=0.1u ad=0.0528p as=0.0816p pd=0.68u ps=1.16u
    I_MXI1_I132_I13_MN4 (I1_I132_pn5 XI1_I132_I13_An XI1_I132_I13_n2 VSS) gpdk090_nmos1v w=0.24u l=0.1u ad=0.0528p as=0.0528p pd=0.68u ps=0.68u
    I_MXI1_I132_I13_MN2 (XI1_I132_I13_n1 I1_p6_4 I1_I132_pn5 VSS) gpdk090_nmos1v w=0.24u l=0.1u ad=0.0528p as=0.0528p pd=0.68u ps=0.68u
    I_MXI1_I132_I13_MN3 (VSS XI1_I132_I13_Bn XI1_I132_I13_n1 VSS) gpdk090_nmos1v w=0.24u l=0.1u ad=0.0816p as=0.0528p pd=1.16u ps=0.68u
    I_MXI1_I132_I13_MN0 (XI1_I132_I13_An I1_p6_4 VSS VSS) gpdk090_nmos1v w=0.12u l=0.1u ad=0.0696p as=0.0696p pd=1.16u ps=1.16u
    I_MXI1_I120_I39_MN1 (XI1_I120_I39_Bn I1_I120_G1_0 VSS VSS) gpdk090_nmos1v w=0.12u l=0.1u ad=0.0696p as=0.0696p pd=1.16u ps=1.16u
    I_MXI1_I120_I39_MN5 (XI1_I120_I39_n2 I1_I120_G1_0 VSS VSS) gpdk090_nmos1v w=0.24u l=0.1u ad=0.0528p as=0.0816p pd=0.68u ps=1.16u
    I_MXI1_I120_I39_MN4 (I1_p6_2 XI1_I120_I39_An XI1_I120_I39_n2 VSS) gpdk090_nmos1v w=0.24u l=0.1u ad=0.0528p as=0.0528p pd=0.68u ps=0.68u
    I_MXI1_I120_I39_MN2 (XI1_I120_I39_n1 I1_I120_pn2 I1_p6_2 VSS) gpdk090_nmos1v w=0.24u l=0.1u ad=0.0528p as=0.0528p pd=0.68u ps=0.68u
    I_MXI1_I120_I39_MN3 (VSS XI1_I120_I39_Bn XI1_I120_I39_n1 VSS) gpdk090_nmos1v w=0.24u l=0.1u ad=0.0816p as=0.0528p pd=1.16u ps=0.68u
    I_MXI1_I120_I39_MN0 (XI1_I120_I39_An I1_I120_pn2 VSS VSS) gpdk090_nmos1v w=0.12u l=0.1u ad=0.0696p as=0.0696p pd=1.16u ps=1.16u
    I_MXI1_I120_I37_MN1 (XI1_I120_I37_Bn I1_qu2 VSS VSS) gpdk090_nmos1v w=0.12u l=0.1u ad=0.0696p as=0.0696p pd=1.16u ps=1.16u
    I_MXI1_I120_I37_MN5 (XI1_I120_I37_n2 I1_qu2 VSS VSS) gpdk090_nmos1v w=0.24u l=0.1u ad=0.0528p as=0.0816p pd=0.68u ps=1.16u
    I_MXI1_I120_I37_MN4 (I1_p6_0 XI1_I120_I37_An XI1_I120_I37_n2 VSS) gpdk090_nmos1v w=0.24u l=0.1u ad=0.0528p as=0.0528p pd=0.68u ps=0.68u
    I_MXI1_I120_I37_MN2 (XI1_I120_I37_n1 I1_I120_pn0 I1_p6_0 VSS) gpdk090_nmos1v w=0.24u l=0.1u ad=0.0528p as=0.0528p pd=0.68u ps=0.68u
    I_MXI1_I120_I37_MN3 (VSS XI1_I120_I37_Bn XI1_I120_I37_n1 VSS) gpdk090_nmos1v w=0.24u l=0.1u ad=0.0816p as=0.0528p pd=1.16u ps=0.68u
    I_MXI1_I120_I37_MN0 (XI1_I120_I37_An I1_I120_pn0 VSS VSS) gpdk090_nmos1v w=0.12u l=0.1u ad=0.0696p as=0.0696p pd=1.16u ps=1.16u
    I_MXI1_I33_MN1 (XI1_I33_Bn I1_nbkn5 VSS VSS) gpdk090_nmos1v w=0.12u l=0.1u ad=0.0696p as=0.0696p pd=1.16u ps=1.16u
    I_MXI1_I33_MN5 (XI1_I33_n2 I1_nbkn5 VSS VSS) gpdk090_nmos1v w=0.24u l=0.1u ad=0.0528p as=0.0816p pd=0.68u ps=1.16u
    I_MXI1_I33_MN4 (I1_dd5 XI1_I33_An XI1_I33_n2 VSS) gpdk090_nmos1v w=0.24u l=0.1u ad=0.0528p as=0.0528p pd=0.68u ps=0.68u
    I_MXI1_I33_MN2 (XI1_I33_n1 B_5 I1_dd5 VSS) gpdk090_nmos1v w=0.24u l=0.1u ad=0.0528p as=0.0528p pd=0.68u ps=0.68u
    I_MXI1_I33_MN3 (VSS XI1_I33_Bn XI1_I33_n1 VSS) gpdk090_nmos1v w=0.24u l=0.1u ad=0.0816p as=0.0528p pd=1.16u ps=0.68u
    I_MXI1_I33_MN0 (XI1_I33_An B_5 VSS VSS) gpdk090_nmos1v w=0.12u l=0.1u ad=0.0696p as=0.0696p pd=1.16u ps=1.16u
    I_MXI2_I1_I8_I9_MN1 (XI2_I1_I8_I9_Bn I2_I1_bx1 VSS VSS) gpdk090_nmos1v w=0.12u l=0.1u ad=0.0696p as=0.0696p pd=1.16u ps=1.16u
    I_MXI2_I1_I8_I9_MN5 (XI2_I1_I8_I9_n2 I2_I1_bx1 VSS VSS) gpdk090_nmos1v w=0.24u l=0.1u ad=0.0528p as=0.0816p pd=0.68u ps=1.16u
    I_MXI2_I1_I8_I9_MN4 (I2_I1_I8_pn1 XI2_I1_I8_I9_An XI2_I1_I8_I9_n2 VSS) gpdk090_nmos1v w=0.24u l=0.1u ad=0.0528p as=0.0528p pd=0.68u ps=0.68u
    I_MXI2_I1_I8_I9_MN2 (XI2_I1_I8_I9_n1 A_1 I2_I1_I8_pn1 VSS) gpdk090_nmos1v w=0.24u l=0.1u ad=0.0528p as=0.0528p pd=0.68u ps=0.68u
    I_MXI2_I1_I8_I9_MN3 (VSS XI2_I1_I8_I9_Bn XI2_I1_I8_I9_n1 VSS) gpdk090_nmos1v w=0.24u l=0.1u ad=0.0816p as=0.0528p pd=1.16u ps=0.68u
    I_MXI2_I1_I8_I9_MN0 (XI2_I1_I8_I9_An A_1 VSS VSS) gpdk090_nmos1v w=0.12u l=0.1u ad=0.0696p as=0.0696p pd=1.16u ps=1.16u
    I_MXI2_I1_I8_I10_MN1 (XI2_I1_I8_I10_Bn I2_I1_bx2 VSS VSS) gpdk090_nmos1v w=0.12u l=0.1u ad=0.0696p as=0.0696p pd=1.16u ps=1.16u
    I_MXI2_I1_I8_I10_MN5 (XI2_I1_I8_I10_n2 I2_I1_bx2 VSS VSS) gpdk090_nmos1v w=0.24u l=0.1u ad=0.0528p as=0.0816p pd=0.68u ps=1.16u
    I_MXI2_I1_I8_I10_MN4 (I2_I1_I8_pn2 XI2_I1_I8_I10_An XI2_I1_I8_I10_n2 VSS) gpdk090_nmos1v w=0.24u l=0.1u ad=0.0528p as=0.0528p pd=0.68u ps=0.68u
    I_MXI2_I1_I8_I10_MN2 (XI2_I1_I8_I10_n1 A_2 I2_I1_I8_pn2 VSS) gpdk090_nmos1v w=0.24u l=0.1u ad=0.0528p as=0.0528p pd=0.68u ps=0.68u
    I_MXI2_I1_I8_I10_MN3 (VSS XI2_I1_I8_I10_Bn XI2_I1_I8_I10_n1 VSS) gpdk090_nmos1v w=0.24u l=0.1u ad=0.0816p as=0.0528p pd=1.16u ps=0.68u
    I_MXI2_I1_I8_I10_MN0 (XI2_I1_I8_I10_An A_2 VSS VSS) gpdk090_nmos1v w=0.12u l=0.1u ad=0.0696p as=0.0696p pd=1.16u ps=1.16u
    I_MXI1_I120_I43_MN1 (XI1_I120_I43_Bn I1_I120_G5_0 VSS VSS) gpdk090_nmos1v w=0.12u l=0.1u ad=0.0696p as=0.0696p pd=1.16u ps=1.16u
    I_MXI1_I120_I43_MN5 (XI1_I120_I43_n2 I1_I120_G5_0 VSS VSS) gpdk090_nmos1v w=0.24u l=0.1u ad=0.0528p as=0.0816p pd=0.68u ps=1.16u
    I_MXI1_I120_I43_MN4 (I1_p6_6 XI1_I120_I43_An XI1_I120_I43_n2 VSS) gpdk090_nmos1v w=0.24u l=0.1u ad=0.0528p as=0.0528p pd=0.68u ps=0.68u
    I_MXI1_I120_I43_MN2 (XI1_I120_I43_n1 I1_I120_pn6 I1_p6_6 VSS) gpdk090_nmos1v w=0.24u l=0.1u ad=0.0528p as=0.0528p pd=0.68u ps=0.68u
    I_MXI1_I120_I43_MN3 (VSS XI1_I120_I43_Bn XI1_I120_I43_n1 VSS) gpdk090_nmos1v w=0.24u l=0.1u ad=0.0816p as=0.0528p pd=1.16u ps=0.68u
    I_MXI1_I120_I43_MN0 (XI1_I120_I43_An I1_I120_pn6 VSS VSS) gpdk090_nmos1v w=0.12u l=0.1u ad=0.0696p as=0.0696p pd=1.16u ps=1.16u
    I_MXI1_I120_I38_MN1 (XI1_I120_I38_Bn I1_I120_G0_0 VSS VSS) gpdk090_nmos1v w=0.12u l=0.1u ad=0.0696p as=0.0696p pd=1.16u ps=1.16u
    I_MXI1_I120_I38_MN5 (XI1_I120_I38_n2 I1_I120_G0_0 VSS VSS) gpdk090_nmos1v w=0.24u l=0.1u ad=0.0528p as=0.0816p pd=0.68u ps=1.16u
    I_MXI1_I120_I38_MN4 (I1_p6_1 XI1_I120_I38_An XI1_I120_I38_n2 VSS) gpdk090_nmos1v w=0.24u l=0.1u ad=0.0528p as=0.0528p pd=0.68u ps=0.68u
    I_MXI1_I120_I38_MN2 (XI1_I120_I38_n1 I1_I120_pn1 I1_p6_1 VSS) gpdk090_nmos1v w=0.24u l=0.1u ad=0.0528p as=0.0528p pd=0.68u ps=0.68u
    I_MXI1_I120_I38_MN3 (VSS XI1_I120_I38_Bn XI1_I120_I38_n1 VSS) gpdk090_nmos1v w=0.24u l=0.1u ad=0.0816p as=0.0528p pd=1.16u ps=0.68u
    I_MXI1_I120_I38_MN0 (XI1_I120_I38_An I1_I120_pn1 VSS VSS) gpdk090_nmos1v w=0.12u l=0.1u ad=0.0696p as=0.0696p pd=1.16u ps=1.16u
    I_MXI1_I120_I9_MN1 (XI1_I120_I9_Bn I1_b6_1 VSS VSS) gpdk090_nmos1v w=0.12u l=0.1u ad=0.0696p as=0.0696p pd=1.16u ps=1.16u
    I_MXI1_I120_I9_MN5 (XI1_I120_I9_n2 I1_b6_1 VSS VSS) gpdk090_nmos1v w=0.24u l=0.1u ad=0.0528p as=0.0816p pd=0.68u ps=1.16u
    I_MXI1_I120_I9_MN4 (I1_I120_pn1 XI1_I120_I9_An XI1_I120_I9_n2 VSS) gpdk090_nmos1v w=0.24u l=0.1u ad=0.0528p as=0.0528p pd=0.68u ps=0.68u
    I_MXI1_I120_I9_MN2 (XI1_I120_I9_n1 I1_p5_0 I1_I120_pn1 VSS) gpdk090_nmos1v w=0.24u l=0.1u ad=0.0528p as=0.0528p pd=0.68u ps=0.68u
    I_MXI1_I120_I9_MN3 (VSS XI1_I120_I9_Bn XI1_I120_I9_n1 VSS) gpdk090_nmos1v w=0.24u l=0.1u ad=0.0816p as=0.0528p pd=1.16u ps=0.68u
    I_MXI1_I120_I9_MN0 (XI1_I120_I9_An I1_p5_0 VSS VSS) gpdk090_nmos1v w=0.12u l=0.1u ad=0.0696p as=0.0696p pd=1.16u ps=1.16u
    I_MXI1_I155_MN1 (XI1_I155_Bn I1_nqkn1 VSS VSS) gpdk090_nmos1v w=0.12u l=0.1u ad=0.0696p as=0.0696p pd=1.16u ps=1.16u
    I_MXI1_I155_MN5 (XI1_I155_n2 I1_nqkn1 VSS VSS) gpdk090_nmos1v w=0.24u l=0.1u ad=0.0528p as=0.0816p pd=0.68u ps=1.16u
    I_MXI1_I155_MN4 (DIVQ_1 XI1_I155_An XI1_I155_n2 VSS) gpdk090_nmos1v w=0.24u l=0.1u ad=0.0528p as=0.0528p pd=0.68u ps=0.68u
    I_MXI1_I155_MN2 (XI1_I155_n1 I1_qu1 DIVQ_1 VSS) gpdk090_nmos1v w=0.24u l=0.1u ad=0.0528p as=0.0528p pd=0.68u ps=0.68u
    I_MXI1_I155_MN3 (VSS XI1_I155_Bn XI1_I155_n1 VSS) gpdk090_nmos1v w=0.24u l=0.1u ad=0.0816p as=0.0528p pd=1.16u ps=0.68u
    I_MXI1_I155_MN0 (XI1_I155_An I1_qu1 VSS VSS) gpdk090_nmos1v w=0.12u l=0.1u ad=0.0696p as=0.0696p pd=1.16u ps=1.16u
    I_MXI1_I158_MN1 (XI1_I158_Bn I1_nqkn2 VSS VSS) gpdk090_nmos1v w=0.12u l=0.1u ad=0.0696p as=0.0696p pd=1.16u ps=1.16u
    I_MXI1_I158_MN5 (XI1_I158_n2 I1_nqkn2 VSS VSS) gpdk090_nmos1v w=0.24u l=0.1u ad=0.0528p as=0.0816p pd=0.68u ps=1.16u
    I_MXI1_I158_MN4 (DIVQ_2 XI1_I158_An XI1_I158_n2 VSS) gpdk090_nmos1v w=0.24u l=0.1u ad=0.0528p as=0.0528p pd=0.68u ps=0.68u
    I_MXI1_I158_MN2 (XI1_I158_n1 I1_qu2 DIVQ_2 VSS) gpdk090_nmos1v w=0.24u l=0.1u ad=0.0528p as=0.0528p pd=0.68u ps=0.68u
    I_MXI1_I158_MN3 (VSS XI1_I158_Bn XI1_I158_n1 VSS) gpdk090_nmos1v w=0.24u l=0.1u ad=0.0816p as=0.0528p pd=1.16u ps=0.68u
    I_MXI1_I158_MN0 (XI1_I158_An I1_qu2 VSS VSS) gpdk090_nmos1v w=0.12u l=0.1u ad=0.0696p as=0.0696p pd=1.16u ps=1.16u
    I_MXI2_I1_I8_I38_MN1 (XI2_I1_I8_I38_Bn I2_I1_I8_G0_0 VSS VSS) gpdk090_nmos1v w=0.12u l=0.1u ad=0.0696p as=0.0696p pd=1.16u ps=1.16u
    I_MXI2_I1_I8_I38_MN5 (XI2_I1_I8_I38_n2 I2_I1_I8_G0_0 VSS VSS) gpdk090_nmos1v w=0.24u l=0.1u ad=0.0528p as=0.0816p pd=0.68u ps=1.16u
    I_MXI2_I1_I8_I38_MN4 (I2_S_1 XI2_I1_I8_I38_An XI2_I1_I8_I38_n2 VSS) gpdk090_nmos1v w=0.24u l=0.1u ad=0.0528p as=0.0528p pd=0.68u ps=0.68u
    I_MXI2_I1_I8_I38_MN2 (XI2_I1_I8_I38_n1 I2_I1_I8_pn1 I2_S_1 VSS) gpdk090_nmos1v w=0.24u l=0.1u ad=0.0528p as=0.0528p pd=0.68u ps=0.68u
    I_MXI2_I1_I8_I38_MN3 (VSS XI2_I1_I8_I38_Bn XI2_I1_I8_I38_n1 VSS) gpdk090_nmos1v w=0.24u l=0.1u ad=0.0816p as=0.0528p pd=1.16u ps=0.68u
    I_MXI2_I1_I8_I38_MN0 (XI2_I1_I8_I38_An I2_I1_I8_pn1 VSS VSS) gpdk090_nmos1v w=0.12u l=0.1u ad=0.0696p as=0.0696p pd=1.16u ps=1.16u
    I_MXI2_I1_I8_I8_MN1 (XI2_I1_I8_I8_Bn I2_I1_bx0 VSS VSS) gpdk090_nmos1v w=0.12u l=0.1u ad=0.0696p as=0.0696p pd=1.16u ps=1.16u
    I_MXI2_I1_I8_I8_MN5 (XI2_I1_I8_I8_n2 I2_I1_bx0 VSS VSS) gpdk090_nmos1v w=0.24u l=0.1u ad=0.0528p as=0.0816p pd=0.68u ps=1.16u
    I_MXI2_I1_I8_I8_MN4 (I2_I1_I8_pn0 XI2_I1_I8_I8_An XI2_I1_I8_I8_n2 VSS) gpdk090_nmos1v w=0.24u l=0.1u ad=0.0528p as=0.0528p pd=0.68u ps=0.68u
    I_MXI2_I1_I8_I8_MN2 (XI2_I1_I8_I8_n1 A_0 I2_I1_I8_pn0 VSS) gpdk090_nmos1v w=0.24u l=0.1u ad=0.0528p as=0.0528p pd=0.68u ps=0.68u
    I_MXI2_I1_I8_I8_MN3 (VSS XI2_I1_I8_I8_Bn XI2_I1_I8_I8_n1 VSS) gpdk090_nmos1v w=0.24u l=0.1u ad=0.0816p as=0.0528p pd=1.16u ps=0.68u
    I_MXI2_I1_I8_I8_MN0 (XI2_I1_I8_I8_An A_0 VSS VSS) gpdk090_nmos1v w=0.12u l=0.1u ad=0.0696p as=0.0696p pd=1.16u ps=1.16u
    I_MXI2_I1_I8_I37_MN1 (XI2_I1_I8_I37_Bn OP_0 VSS VSS) gpdk090_nmos1v w=0.12u l=0.1u ad=0.0696p as=0.0696p pd=1.16u ps=1.16u
    I_MXI2_I1_I8_I37_MN5 (XI2_I1_I8_I37_n2 OP_0 VSS VSS) gpdk090_nmos1v w=0.24u l=0.1u ad=0.0528p as=0.0816p pd=0.68u ps=1.16u
    I_MXI2_I1_I8_I37_MN4 (I2_S_0 XI2_I1_I8_I37_An XI2_I1_I8_I37_n2 VSS) gpdk090_nmos1v w=0.24u l=0.1u ad=0.0528p as=0.0528p pd=0.68u ps=0.68u
    I_MXI2_I1_I8_I37_MN2 (XI2_I1_I8_I37_n1 I2_I1_I8_pn0 I2_S_0 VSS) gpdk090_nmos1v w=0.24u l=0.1u ad=0.0528p as=0.0528p pd=0.68u ps=0.68u
    I_MXI2_I1_I8_I37_MN3 (VSS XI2_I1_I8_I37_Bn XI2_I1_I8_I37_n1 VSS) gpdk090_nmos1v w=0.24u l=0.1u ad=0.0816p as=0.0528p pd=1.16u ps=0.68u
    I_MXI2_I1_I8_I37_MN0 (XI2_I1_I8_I37_An I2_I1_I8_pn0 VSS VSS) gpdk090_nmos1v w=0.12u l=0.1u ad=0.0696p as=0.0696p pd=1.16u ps=1.16u
    I_MXI2_I1_I8_I39_MN1 (XI2_I1_I8_I39_Bn I2_I1_I8_G1_0 VSS VSS) gpdk090_nmos1v w=0.12u l=0.1u ad=0.0696p as=0.0696p pd=1.16u ps=1.16u
    I_MXI2_I1_I8_I39_MN5 (XI2_I1_I8_I39_n2 I2_I1_I8_G1_0 VSS VSS) gpdk090_nmos1v w=0.24u l=0.1u ad=0.0528p as=0.0816p pd=0.68u ps=1.16u
    I_MXI2_I1_I8_I39_MN4 (I2_S_2 XI2_I1_I8_I39_An XI2_I1_I8_I39_n2 VSS) gpdk090_nmos1v w=0.24u l=0.1u ad=0.0528p as=0.0528p pd=0.68u ps=0.68u
    I_MXI2_I1_I8_I39_MN2 (XI2_I1_I8_I39_n1 I2_I1_I8_pn2 I2_S_2 VSS) gpdk090_nmos1v w=0.24u l=0.1u ad=0.0528p as=0.0528p pd=0.68u ps=0.68u
    I_MXI2_I1_I8_I39_MN3 (VSS XI2_I1_I8_I39_Bn XI2_I1_I8_I39_n1 VSS) gpdk090_nmos1v w=0.24u l=0.1u ad=0.0816p as=0.0528p pd=1.16u ps=0.68u
    I_MXI2_I1_I8_I39_MN0 (XI2_I1_I8_I39_An I2_I1_I8_pn2 VSS VSS) gpdk090_nmos1v w=0.12u l=0.1u ad=0.0696p as=0.0696p pd=1.16u ps=1.16u
    I_MXI1_I120_I10_MN1 (XI1_I120_I10_Bn I1_b6_2 VSS VSS) gpdk090_nmos1v w=0.12u l=0.1u ad=0.0696p as=0.0696p pd=1.16u ps=1.16u
    I_MXI1_I120_I10_MN5 (XI1_I120_I10_n2 I1_b6_2 VSS VSS) gpdk090_nmos1v w=0.24u l=0.1u ad=0.0528p as=0.0816p pd=0.68u ps=1.16u
    I_MXI1_I120_I10_MN4 (I1_I120_pn2 XI1_I120_I10_An XI1_I120_I10_n2 VSS) gpdk090_nmos1v w=0.24u l=0.1u ad=0.0528p as=0.0528p pd=0.68u ps=0.68u
    I_MXI1_I120_I10_MN2 (XI1_I120_I10_n1 I1_p5_1 I1_I120_pn2 VSS) gpdk090_nmos1v w=0.24u l=0.1u ad=0.0528p as=0.0528p pd=0.68u ps=0.68u
    I_MXI1_I120_I10_MN3 (VSS XI1_I120_I10_Bn XI1_I120_I10_n1 VSS) gpdk090_nmos1v w=0.24u l=0.1u ad=0.0816p as=0.0528p pd=1.16u ps=0.68u
    I_MXI1_I120_I10_MN0 (XI1_I120_I10_An I1_p5_1 VSS VSS) gpdk090_nmos1v w=0.12u l=0.1u ad=0.0696p as=0.0696p pd=1.16u ps=1.16u
    I_MXI1_I120_I8_MN1 (XI1_I120_I8_Bn I1_b6_0 VSS VSS) gpdk090_nmos1v w=0.12u l=0.1u ad=0.0696p as=0.0696p pd=1.16u ps=1.16u
    I_MXI1_I120_I8_MN5 (XI1_I120_I8_n2 I1_b6_0 VSS VSS) gpdk090_nmos1v w=0.24u l=0.1u ad=0.0528p as=0.0816p pd=0.68u ps=1.16u
    I_MXI1_I120_I8_MN4 (I1_I120_pn0 XI1_I120_I8_An XI1_I120_I8_n2 VSS) gpdk090_nmos1v w=0.24u l=0.1u ad=0.0528p as=0.0528p pd=0.68u ps=0.68u
    I_MXI1_I120_I8_MN2 (XI1_I120_I8_n1 I1_aa1 I1_I120_pn0 VSS) gpdk090_nmos1v w=0.24u l=0.1u ad=0.0528p as=0.0528p pd=0.68u ps=0.68u
    I_MXI1_I120_I8_MN3 (VSS XI1_I120_I8_Bn XI1_I120_I8_n1 VSS) gpdk090_nmos1v w=0.24u l=0.1u ad=0.0816p as=0.0528p pd=1.16u ps=0.68u
    I_MXI1_I120_I8_MN0 (XI1_I120_I8_An I1_aa1 VSS VSS) gpdk090_nmos1v w=0.12u l=0.1u ad=0.0696p as=0.0696p pd=1.16u ps=1.16u
    I_MXI1_I1_MN1 (XI1_I1_Bn I1_nakn1 VSS VSS) gpdk090_nmos1v w=0.12u l=0.1u ad=0.0696p as=0.0696p pd=1.16u ps=1.16u
    I_MXI1_I1_MN5 (XI1_I1_n2 I1_nakn1 VSS VSS) gpdk090_nmos1v w=0.24u l=0.1u ad=0.0528p as=0.0816p pd=0.68u ps=1.16u
    I_MXI1_I1_MN4 (I1_aa1 XI1_I1_An XI1_I1_n2 VSS) gpdk090_nmos1v w=0.24u l=0.1u ad=0.0528p as=0.0528p pd=0.68u ps=0.68u
    I_MXI1_I1_MN2 (XI1_I1_n1 A_1 I1_aa1 VSS) gpdk090_nmos1v w=0.24u l=0.1u ad=0.0528p as=0.0528p pd=0.68u ps=0.68u
    I_MXI1_I1_MN3 (VSS XI1_I1_Bn XI1_I1_n1 VSS) gpdk090_nmos1v w=0.24u l=0.1u ad=0.0816p as=0.0528p pd=1.16u ps=0.68u
    I_MXI1_I1_MN0 (XI1_I1_An A_1 VSS VSS) gpdk090_nmos1v w=0.12u l=0.1u ad=0.0696p as=0.0696p pd=1.16u ps=1.16u
    I_MXI1_I27_MN1 (XI1_I27_Bn I1_nbkn3 VSS VSS) gpdk090_nmos1v w=0.12u l=0.1u ad=0.0696p as=0.0696p pd=1.16u ps=1.16u
    I_MXI1_I27_MN5 (XI1_I27_n2 I1_nbkn3 VSS VSS) gpdk090_nmos1v w=0.24u l=0.1u ad=0.0528p as=0.0816p pd=0.68u ps=1.16u
    I_MXI1_I27_MN4 (I1_dd3 XI1_I27_An XI1_I27_n2 VSS) gpdk090_nmos1v w=0.24u l=0.1u ad=0.0528p as=0.0528p pd=0.68u ps=0.68u
    I_MXI1_I27_MN2 (XI1_I27_n1 B_3 I1_dd3 VSS) gpdk090_nmos1v w=0.24u l=0.1u ad=0.0528p as=0.0528p pd=0.68u ps=0.68u
    I_MXI1_I27_MN3 (VSS XI1_I27_Bn XI1_I27_n1 VSS) gpdk090_nmos1v w=0.24u l=0.1u ad=0.0816p as=0.0528p pd=1.16u ps=0.68u
    I_MXI1_I27_MN0 (XI1_I27_An B_3 VSS VSS) gpdk090_nmos1v w=0.12u l=0.1u ad=0.0696p as=0.0696p pd=1.16u ps=1.16u
    I_MXI1_I30_MN1 (XI1_I30_Bn I1_nbkn4 VSS VSS) gpdk090_nmos1v w=0.12u l=0.1u ad=0.0696p as=0.0696p pd=1.16u ps=1.16u
    I_MXI1_I30_MN5 (XI1_I30_n2 I1_nbkn4 VSS VSS) gpdk090_nmos1v w=0.24u l=0.1u ad=0.0528p as=0.0816p pd=0.68u ps=1.16u
    I_MXI1_I30_MN4 (I1_dd4 XI1_I30_An XI1_I30_n2 VSS) gpdk090_nmos1v w=0.24u l=0.1u ad=0.0528p as=0.0528p pd=0.68u ps=0.68u
    I_MXI1_I30_MN2 (XI1_I30_n1 B_4 I1_dd4 VSS) gpdk090_nmos1v w=0.24u l=0.1u ad=0.0528p as=0.0528p pd=0.68u ps=0.68u
    I_MXI1_I30_MN3 (VSS XI1_I30_Bn XI1_I30_n1 VSS) gpdk090_nmos1v w=0.24u l=0.1u ad=0.0816p as=0.0528p pd=1.16u ps=0.68u
    I_MXI1_I30_MN0 (XI1_I30_An B_4 VSS VSS) gpdk090_nmos1v w=0.12u l=0.1u ad=0.0696p as=0.0696p pd=1.16u ps=1.16u
    I_MXI1_I120_I15_MN1 (XI1_I120_I15_Bn I1_b6_7 VSS VSS) gpdk090_nmos1v w=0.12u l=0.1u ad=0.0696p as=0.0696p pd=1.16u ps=1.16u
    I_MXI1_I120_I15_MN5 (XI1_I120_I15_n2 I1_b6_7 VSS VSS) gpdk090_nmos1v w=0.24u l=0.1u ad=0.0528p as=0.0816p pd=0.68u ps=1.16u
    I_MXI1_I120_I15_MN4 (I1_I120_pn7 XI1_I120_I15_An XI1_I120_I15_n2 VSS) gpdk090_nmos1v w=0.24u l=0.1u ad=0.0528p as=0.0528p pd=0.68u ps=0.68u
    I_MXI1_I120_I15_MN2 (XI1_I120_I15_n1 I1_p5_6 I1_I120_pn7 VSS) gpdk090_nmos1v w=0.24u l=0.1u ad=0.0528p as=0.0528p pd=0.68u ps=0.68u
    I_MXI1_I120_I15_MN3 (VSS XI1_I120_I15_Bn XI1_I120_I15_n1 VSS) gpdk090_nmos1v w=0.24u l=0.1u ad=0.0816p as=0.0528p pd=1.16u ps=0.68u
    I_MXI1_I120_I15_MN0 (XI1_I120_I15_An I1_p5_6 VSS VSS) gpdk090_nmos1v w=0.12u l=0.1u ad=0.0696p as=0.0696p pd=1.16u ps=1.16u
    I_MXI1_I120_I13_MN1 (XI1_I120_I13_Bn I1_b6_5 VSS VSS) gpdk090_nmos1v w=0.12u l=0.1u ad=0.0696p as=0.0696p pd=1.16u ps=1.16u
    I_MXI1_I120_I13_MN5 (XI1_I120_I13_n2 I1_b6_5 VSS VSS) gpdk090_nmos1v w=0.24u l=0.1u ad=0.0528p as=0.0816p pd=0.68u ps=1.16u
    I_MXI1_I120_I13_MN4 (I1_I120_pn5 XI1_I120_I13_An XI1_I120_I13_n2 VSS) gpdk090_nmos1v w=0.24u l=0.1u ad=0.0528p as=0.0528p pd=0.68u ps=0.68u
    I_MXI1_I120_I13_MN2 (XI1_I120_I13_n1 I1_p5_4 I1_I120_pn5 VSS) gpdk090_nmos1v w=0.24u l=0.1u ad=0.0528p as=0.0528p pd=0.68u ps=0.68u
    I_MXI1_I120_I13_MN3 (VSS XI1_I120_I13_Bn XI1_I120_I13_n1 VSS) gpdk090_nmos1v w=0.24u l=0.1u ad=0.0816p as=0.0528p pd=1.16u ps=0.68u
    I_MXI1_I120_I13_MN0 (XI1_I120_I13_An I1_p5_4 VSS VSS) gpdk090_nmos1v w=0.12u l=0.1u ad=0.0696p as=0.0696p pd=1.16u ps=1.16u
    I_MXI1_I120_I12_MN1 (XI1_I120_I12_Bn I1_b6_4 VSS VSS) gpdk090_nmos1v w=0.12u l=0.1u ad=0.0696p as=0.0696p pd=1.16u ps=1.16u
    I_MXI1_I120_I12_MN5 (XI1_I120_I12_n2 I1_b6_4 VSS VSS) gpdk090_nmos1v w=0.24u l=0.1u ad=0.0528p as=0.0816p pd=0.68u ps=1.16u
    I_MXI1_I120_I12_MN4 (I1_I120_pn4 XI1_I120_I12_An XI1_I120_I12_n2 VSS) gpdk090_nmos1v w=0.24u l=0.1u ad=0.0528p as=0.0528p pd=0.68u ps=0.68u
    I_MXI1_I120_I12_MN2 (XI1_I120_I12_n1 I1_p5_3 I1_I120_pn4 VSS) gpdk090_nmos1v w=0.24u l=0.1u ad=0.0528p as=0.0528p pd=0.68u ps=0.68u
    I_MXI1_I120_I12_MN3 (VSS XI1_I120_I12_Bn XI1_I120_I12_n1 VSS) gpdk090_nmos1v w=0.24u l=0.1u ad=0.0816p as=0.0528p pd=1.16u ps=0.68u
    I_MXI1_I120_I12_MN0 (XI1_I120_I12_An I1_p5_3 VSS VSS) gpdk090_nmos1v w=0.12u l=0.1u ad=0.0696p as=0.0696p pd=1.16u ps=1.16u
    I_MXI1_I120_I11_MN1 (XI1_I120_I11_Bn I1_b6_3 VSS VSS) gpdk090_nmos1v w=0.12u l=0.1u ad=0.0696p as=0.0696p pd=1.16u ps=1.16u
    I_MXI1_I120_I11_MN5 (XI1_I120_I11_n2 I1_b6_3 VSS VSS) gpdk090_nmos1v w=0.24u l=0.1u ad=0.0528p as=0.0816p pd=0.68u ps=1.16u
    I_MXI1_I120_I11_MN4 (I1_I120_pn3 XI1_I120_I11_An XI1_I120_I11_n2 VSS) gpdk090_nmos1v w=0.24u l=0.1u ad=0.0528p as=0.0528p pd=0.68u ps=0.68u
    I_MXI1_I120_I11_MN2 (XI1_I120_I11_n1 I1_p5_2 I1_I120_pn3 VSS) gpdk090_nmos1v w=0.24u l=0.1u ad=0.0528p as=0.0528p pd=0.68u ps=0.68u
    I_MXI1_I120_I11_MN3 (VSS XI1_I120_I11_Bn XI1_I120_I11_n1 VSS) gpdk090_nmos1v w=0.24u l=0.1u ad=0.0816p as=0.0528p pd=1.16u ps=0.68u
    I_MXI1_I120_I11_MN0 (XI1_I120_I11_An I1_p5_2 VSS VSS) gpdk090_nmos1v w=0.12u l=0.1u ad=0.0696p as=0.0696p pd=1.16u ps=1.16u
    I_MXI1_I108_I38_MN1 (XI1_I108_I38_Bn I1_I108_G0_0 VSS VSS) gpdk090_nmos1v w=0.12u l=0.1u ad=0.0696p as=0.0696p pd=1.16u ps=1.16u
    I_MXI1_I108_I38_MN5 (XI1_I108_I38_n2 I1_I108_G0_0 VSS VSS) gpdk090_nmos1v w=0.24u l=0.1u ad=0.0528p as=0.0816p pd=0.68u ps=1.16u
    I_MXI1_I108_I38_MN4 (I1_p5_1 XI1_I108_I38_An XI1_I108_I38_n2 VSS) gpdk090_nmos1v w=0.24u l=0.1u ad=0.0528p as=0.0528p pd=0.68u ps=0.68u
    I_MXI1_I108_I38_MN2 (XI1_I108_I38_n1 I1_I108_pn1 I1_p5_1 VSS) gpdk090_nmos1v w=0.24u l=0.1u ad=0.0528p as=0.0528p pd=0.68u ps=0.68u
    I_MXI1_I108_I38_MN3 (VSS XI1_I108_I38_Bn XI1_I108_I38_n1 VSS) gpdk090_nmos1v w=0.24u l=0.1u ad=0.0816p as=0.0528p pd=1.16u ps=0.68u
    I_MXI1_I108_I38_MN0 (XI1_I108_I38_An I1_I108_pn1 VSS VSS) gpdk090_nmos1v w=0.12u l=0.1u ad=0.0696p as=0.0696p pd=1.16u ps=1.16u
    I_MXI1_I108_I37_MN1 (XI1_I108_I37_Bn I1_qu3 VSS VSS) gpdk090_nmos1v w=0.12u l=0.1u ad=0.0696p as=0.0696p pd=1.16u ps=1.16u
    I_MXI1_I108_I37_MN5 (XI1_I108_I37_n2 I1_qu3 VSS VSS) gpdk090_nmos1v w=0.24u l=0.1u ad=0.0528p as=0.0816p pd=0.68u ps=1.16u
    I_MXI1_I108_I37_MN4 (I1_p5_0 XI1_I108_I37_An XI1_I108_I37_n2 VSS) gpdk090_nmos1v w=0.24u l=0.1u ad=0.0528p as=0.0528p pd=0.68u ps=0.68u
    I_MXI1_I108_I37_MN2 (XI1_I108_I37_n1 I1_I108_pn0 I1_p5_0 VSS) gpdk090_nmos1v w=0.24u l=0.1u ad=0.0528p as=0.0528p pd=0.68u ps=0.68u
    I_MXI1_I108_I37_MN3 (VSS XI1_I108_I37_Bn XI1_I108_I37_n1 VSS) gpdk090_nmos1v w=0.24u l=0.1u ad=0.0816p as=0.0528p pd=1.16u ps=0.68u
    I_MXI1_I108_I37_MN0 (XI1_I108_I37_An I1_I108_pn0 VSS VSS) gpdk090_nmos1v w=0.12u l=0.1u ad=0.0696p as=0.0696p pd=1.16u ps=1.16u
    I_MXI1_I108_I8_MN1 (XI1_I108_I8_Bn I1_b5_0 VSS VSS) gpdk090_nmos1v w=0.12u l=0.1u ad=0.0696p as=0.0696p pd=1.16u ps=1.16u
    I_MXI1_I108_I8_MN5 (XI1_I108_I8_n2 I1_b5_0 VSS VSS) gpdk090_nmos1v w=0.24u l=0.1u ad=0.0528p as=0.0816p pd=0.68u ps=1.16u
    I_MXI1_I108_I8_MN4 (I1_I108_pn0 XI1_I108_I8_An XI1_I108_I8_n2 VSS) gpdk090_nmos1v w=0.24u l=0.1u ad=0.0528p as=0.0528p pd=0.68u ps=0.68u
    I_MXI1_I108_I8_MN2 (XI1_I108_I8_n1 I1_aa2 I1_I108_pn0 VSS) gpdk090_nmos1v w=0.24u l=0.1u ad=0.0528p as=0.0528p pd=0.68u ps=0.68u
    I_MXI1_I108_I8_MN3 (VSS XI1_I108_I8_Bn XI1_I108_I8_n1 VSS) gpdk090_nmos1v w=0.24u l=0.1u ad=0.0816p as=0.0528p pd=1.16u ps=0.68u
    I_MXI1_I108_I8_MN0 (XI1_I108_I8_An I1_aa2 VSS VSS) gpdk090_nmos1v w=0.12u l=0.1u ad=0.0696p as=0.0696p pd=1.16u ps=1.16u
    I_MXI1_I164_MN1 (XI1_I164_Bn I1_nqkn4 VSS VSS) gpdk090_nmos1v w=0.12u l=0.1u ad=0.0696p as=0.0696p pd=1.16u ps=1.16u
    I_MXI1_I164_MN5 (XI1_I164_n2 I1_nqkn4 VSS VSS) gpdk090_nmos1v w=0.24u l=0.1u ad=0.0528p as=0.0816p pd=0.68u ps=1.16u
    I_MXI1_I164_MN4 (DIVQ_4 XI1_I164_An XI1_I164_n2 VSS) gpdk090_nmos1v w=0.24u l=0.1u ad=0.0528p as=0.0528p pd=0.68u ps=0.68u
    I_MXI1_I164_MN2 (XI1_I164_n1 I1_qu4 DIVQ_4 VSS) gpdk090_nmos1v w=0.24u l=0.1u ad=0.0528p as=0.0528p pd=0.68u ps=0.68u
    I_MXI1_I164_MN3 (VSS XI1_I164_Bn XI1_I164_n1 VSS) gpdk090_nmos1v w=0.24u l=0.1u ad=0.0816p as=0.0528p pd=1.16u ps=0.68u
    I_MXI1_I164_MN0 (XI1_I164_An I1_qu4 VSS VSS) gpdk090_nmos1v w=0.12u l=0.1u ad=0.0696p as=0.0696p pd=1.16u ps=1.16u
    I_MXI1_I161_MN1 (XI1_I161_Bn I1_nqkn3 VSS VSS) gpdk090_nmos1v w=0.12u l=0.1u ad=0.0696p as=0.0696p pd=1.16u ps=1.16u
    I_MXI1_I161_MN5 (XI1_I161_n2 I1_nqkn3 VSS VSS) gpdk090_nmos1v w=0.24u l=0.1u ad=0.0528p as=0.0816p pd=0.68u ps=1.16u
    I_MXI1_I161_MN4 (DIVQ_3 XI1_I161_An XI1_I161_n2 VSS) gpdk090_nmos1v w=0.24u l=0.1u ad=0.0528p as=0.0528p pd=0.68u ps=0.68u
    I_MXI1_I161_MN2 (XI1_I161_n1 I1_qu3 DIVQ_3 VSS) gpdk090_nmos1v w=0.24u l=0.1u ad=0.0528p as=0.0528p pd=0.68u ps=0.68u
    I_MXI1_I161_MN3 (VSS XI1_I161_Bn XI1_I161_n1 VSS) gpdk090_nmos1v w=0.24u l=0.1u ad=0.0816p as=0.0528p pd=1.16u ps=0.68u
    I_MXI1_I161_MN0 (XI1_I161_An I1_qu3 VSS VSS) gpdk090_nmos1v w=0.12u l=0.1u ad=0.0696p as=0.0696p pd=1.16u ps=1.16u
    I_MXI1_I4_MN1 (XI1_I4_Bn I1_nakn2 VSS VSS) gpdk090_nmos1v w=0.12u l=0.1u ad=0.0696p as=0.0696p pd=1.16u ps=1.16u
    I_MXI1_I4_MN5 (XI1_I4_n2 I1_nakn2 VSS VSS) gpdk090_nmos1v w=0.24u l=0.1u ad=0.0528p as=0.0816p pd=0.68u ps=1.16u
    I_MXI1_I4_MN4 (I1_aa2 XI1_I4_An XI1_I4_n2 VSS) gpdk090_nmos1v w=0.24u l=0.1u ad=0.0528p as=0.0528p pd=0.68u ps=0.68u
    I_MXI1_I4_MN2 (XI1_I4_n1 A_2 I1_aa2 VSS) gpdk090_nmos1v w=0.24u l=0.1u ad=0.0528p as=0.0528p pd=0.68u ps=0.68u
    I_MXI1_I4_MN3 (VSS XI1_I4_Bn XI1_I4_n1 VSS) gpdk090_nmos1v w=0.24u l=0.1u ad=0.0816p as=0.0528p pd=1.16u ps=0.68u
    I_MXI1_I4_MN0 (XI1_I4_An A_2 VSS VSS) gpdk090_nmos1v w=0.12u l=0.1u ad=0.0696p as=0.0696p pd=1.16u ps=1.16u
    I_MXI1_I7_MN1 (XI1_I7_Bn I1_nakn3 VSS VSS) gpdk090_nmos1v w=0.12u l=0.1u ad=0.0696p as=0.0696p pd=1.16u ps=1.16u
    I_MXI1_I7_MN5 (XI1_I7_n2 I1_nakn3 VSS VSS) gpdk090_nmos1v w=0.24u l=0.1u ad=0.0528p as=0.0816p pd=0.68u ps=1.16u
    I_MXI1_I7_MN4 (I1_aa3 XI1_I7_An XI1_I7_n2 VSS) gpdk090_nmos1v w=0.24u l=0.1u ad=0.0528p as=0.0528p pd=0.68u ps=0.68u
    I_MXI1_I7_MN2 (XI1_I7_n1 A_3 I1_aa3 VSS) gpdk090_nmos1v w=0.24u l=0.1u ad=0.0528p as=0.0528p pd=0.68u ps=0.68u
    I_MXI1_I7_MN3 (VSS XI1_I7_Bn XI1_I7_n1 VSS) gpdk090_nmos1v w=0.24u l=0.1u ad=0.0816p as=0.0528p pd=1.16u ps=0.68u
    I_MXI1_I7_MN0 (XI1_I7_An A_3 VSS VSS) gpdk090_nmos1v w=0.12u l=0.1u ad=0.0696p as=0.0696p pd=1.16u ps=1.16u
    I_MXI1_I10_MN1 (XI1_I10_Bn I1_nakn4 VSS VSS) gpdk090_nmos1v w=0.12u l=0.1u ad=0.0696p as=0.0696p pd=1.16u ps=1.16u
    I_MXI1_I10_MN5 (XI1_I10_n2 I1_nakn4 VSS VSS) gpdk090_nmos1v w=0.24u l=0.1u ad=0.0528p as=0.0816p pd=0.68u ps=1.16u
    I_MXI1_I10_MN4 (I1_aa4 XI1_I10_An XI1_I10_n2 VSS) gpdk090_nmos1v w=0.24u l=0.1u ad=0.0528p as=0.0528p pd=0.68u ps=0.68u
    I_MXI1_I10_MN2 (XI1_I10_n1 A_4 I1_aa4 VSS) gpdk090_nmos1v w=0.24u l=0.1u ad=0.0528p as=0.0528p pd=0.68u ps=0.68u
    I_MXI1_I10_MN3 (VSS XI1_I10_Bn XI1_I10_n1 VSS) gpdk090_nmos1v w=0.24u l=0.1u ad=0.0816p as=0.0528p pd=1.16u ps=0.68u
    I_MXI1_I10_MN0 (XI1_I10_An A_4 VSS VSS) gpdk090_nmos1v w=0.12u l=0.1u ad=0.0696p as=0.0696p pd=1.16u ps=1.16u
    I_MXI1_I173_MN1 (XI1_I173_Bn I1_nqkn7 VSS VSS) gpdk090_nmos1v w=0.12u l=0.1u ad=0.0696p as=0.0696p pd=1.16u ps=1.16u
    I_MXI1_I173_MN5 (XI1_I173_n2 I1_nqkn7 VSS VSS) gpdk090_nmos1v w=0.24u l=0.1u ad=0.0528p as=0.0816p pd=0.68u ps=1.16u
    I_MXI1_I173_MN4 (DIVQ_7 XI1_I173_An XI1_I173_n2 VSS) gpdk090_nmos1v w=0.24u l=0.1u ad=0.0528p as=0.0528p pd=0.68u ps=0.68u
    I_MXI1_I173_MN2 (XI1_I173_n1 I1_qu7 DIVQ_7 VSS) gpdk090_nmos1v w=0.24u l=0.1u ad=0.0528p as=0.0528p pd=0.68u ps=0.68u
    I_MXI1_I173_MN3 (VSS XI1_I173_Bn XI1_I173_n1 VSS) gpdk090_nmos1v w=0.24u l=0.1u ad=0.0816p as=0.0528p pd=1.16u ps=0.68u
    I_MXI1_I173_MN0 (XI1_I173_An I1_qu7 VSS VSS) gpdk090_nmos1v w=0.12u l=0.1u ad=0.0696p as=0.0696p pd=1.16u ps=1.16u
    I_MXI1_I21_MN1 (XI1_I21_Bn I1_nbkn1 VSS VSS) gpdk090_nmos1v w=0.12u l=0.1u ad=0.0696p as=0.0696p pd=1.16u ps=1.16u
    I_MXI1_I21_MN5 (XI1_I21_n2 I1_nbkn1 VSS VSS) gpdk090_nmos1v w=0.24u l=0.1u ad=0.0528p as=0.0816p pd=0.68u ps=1.16u
    I_MXI1_I21_MN4 (I1_dd1 XI1_I21_An XI1_I21_n2 VSS) gpdk090_nmos1v w=0.24u l=0.1u ad=0.0528p as=0.0528p pd=0.68u ps=0.68u
    I_MXI1_I21_MN2 (XI1_I21_n1 B_1 I1_dd1 VSS) gpdk090_nmos1v w=0.24u l=0.1u ad=0.0528p as=0.0528p pd=0.68u ps=0.68u
    I_MXI1_I21_MN3 (VSS XI1_I21_Bn XI1_I21_n1 VSS) gpdk090_nmos1v w=0.24u l=0.1u ad=0.0816p as=0.0528p pd=1.16u ps=0.68u
    I_MXI1_I21_MN0 (XI1_I21_An B_1 VSS VSS) gpdk090_nmos1v w=0.12u l=0.1u ad=0.0696p as=0.0696p pd=1.16u ps=1.16u
    I_MXI1_I24_MN1 (XI1_I24_Bn I1_nbkn2 VSS VSS) gpdk090_nmos1v w=0.12u l=0.1u ad=0.0696p as=0.0696p pd=1.16u ps=1.16u
    I_MXI1_I24_MN5 (XI1_I24_n2 I1_nbkn2 VSS VSS) gpdk090_nmos1v w=0.24u l=0.1u ad=0.0528p as=0.0816p pd=0.68u ps=1.16u
    I_MXI1_I24_MN4 (I1_dd2 XI1_I24_An XI1_I24_n2 VSS) gpdk090_nmos1v w=0.24u l=0.1u ad=0.0528p as=0.0528p pd=0.68u ps=0.68u
    I_MXI1_I24_MN2 (XI1_I24_n1 B_2 I1_dd2 VSS) gpdk090_nmos1v w=0.24u l=0.1u ad=0.0528p as=0.0528p pd=0.68u ps=0.68u
    I_MXI1_I24_MN3 (VSS XI1_I24_Bn XI1_I24_n1 VSS) gpdk090_nmos1v w=0.24u l=0.1u ad=0.0816p as=0.0528p pd=1.16u ps=0.68u
    I_MXI1_I24_MN0 (XI1_I24_An B_2 VSS VSS) gpdk090_nmos1v w=0.12u l=0.1u ad=0.0696p as=0.0696p pd=1.16u ps=1.16u
    I_MXI1_I120_I14_MN1 (XI1_I120_I14_Bn I1_b6_6 VSS VSS) gpdk090_nmos1v w=0.12u l=0.1u ad=0.0696p as=0.0696p pd=1.16u ps=1.16u
    I_MXI1_I120_I14_MN5 (XI1_I120_I14_n2 I1_b6_6 VSS VSS) gpdk090_nmos1v w=0.24u l=0.1u ad=0.0528p as=0.0816p pd=0.68u ps=1.16u
    I_MXI1_I120_I14_MN4 (I1_I120_pn6 XI1_I120_I14_An XI1_I120_I14_n2 VSS) gpdk090_nmos1v w=0.24u l=0.1u ad=0.0528p as=0.0528p pd=0.68u ps=0.68u
    I_MXI1_I120_I14_MN2 (XI1_I120_I14_n1 I1_p5_5 I1_I120_pn6 VSS) gpdk090_nmos1v w=0.24u l=0.1u ad=0.0528p as=0.0528p pd=0.68u ps=0.68u
    I_MXI1_I120_I14_MN3 (VSS XI1_I120_I14_Bn XI1_I120_I14_n1 VSS) gpdk090_nmos1v w=0.24u l=0.1u ad=0.0816p as=0.0528p pd=1.16u ps=0.68u
    I_MXI1_I120_I14_MN0 (XI1_I120_I14_An I1_p5_5 VSS VSS) gpdk090_nmos1v w=0.12u l=0.1u ad=0.0696p as=0.0696p pd=1.16u ps=1.16u
    I_MXI1_I108_I39_MN1 (XI1_I108_I39_Bn I1_I108_G1_0 VSS VSS) gpdk090_nmos1v w=0.12u l=0.1u ad=0.0696p as=0.0696p pd=1.16u ps=1.16u
    I_MXI1_I108_I39_MN5 (XI1_I108_I39_n2 I1_I108_G1_0 VSS VSS) gpdk090_nmos1v w=0.24u l=0.1u ad=0.0528p as=0.0816p pd=0.68u ps=1.16u
    I_MXI1_I108_I39_MN4 (I1_p5_2 XI1_I108_I39_An XI1_I108_I39_n2 VSS) gpdk090_nmos1v w=0.24u l=0.1u ad=0.0528p as=0.0528p pd=0.68u ps=0.68u
    I_MXI1_I108_I39_MN2 (XI1_I108_I39_n1 I1_I108_pn2 I1_p5_2 VSS) gpdk090_nmos1v w=0.24u l=0.1u ad=0.0528p as=0.0528p pd=0.68u ps=0.68u
    I_MXI1_I108_I39_MN3 (VSS XI1_I108_I39_Bn XI1_I108_I39_n1 VSS) gpdk090_nmos1v w=0.24u l=0.1u ad=0.0816p as=0.0528p pd=1.16u ps=0.68u
    I_MXI1_I108_I39_MN0 (XI1_I108_I39_An I1_I108_pn2 VSS VSS) gpdk090_nmos1v w=0.12u l=0.1u ad=0.0696p as=0.0696p pd=1.16u ps=1.16u
    I_MXI1_I108_I9_MN1 (XI1_I108_I9_Bn I1_b5_1 VSS VSS) gpdk090_nmos1v w=0.12u l=0.1u ad=0.0696p as=0.0696p pd=1.16u ps=1.16u
    I_MXI1_I108_I9_MN5 (XI1_I108_I9_n2 I1_b5_1 VSS VSS) gpdk090_nmos1v w=0.24u l=0.1u ad=0.0528p as=0.0816p pd=0.68u ps=1.16u
    I_MXI1_I108_I9_MN4 (I1_I108_pn1 XI1_I108_I9_An XI1_I108_I9_n2 VSS) gpdk090_nmos1v w=0.24u l=0.1u ad=0.0528p as=0.0528p pd=0.68u ps=0.68u
    I_MXI1_I108_I9_MN2 (XI1_I108_I9_n1 I1_p4_0 I1_I108_pn1 VSS) gpdk090_nmos1v w=0.24u l=0.1u ad=0.0528p as=0.0528p pd=0.68u ps=0.68u
    I_MXI1_I108_I9_MN3 (VSS XI1_I108_I9_Bn XI1_I108_I9_n1 VSS) gpdk090_nmos1v w=0.24u l=0.1u ad=0.0816p as=0.0528p pd=1.16u ps=0.68u
    I_MXI1_I108_I9_MN0 (XI1_I108_I9_An I1_p4_0 VSS VSS) gpdk090_nmos1v w=0.12u l=0.1u ad=0.0696p as=0.0696p pd=1.16u ps=1.16u
    I_MXI1_I96_I37_MN1 (XI1_I96_I37_Bn I1_qu4 VSS VSS) gpdk090_nmos1v w=0.12u l=0.1u ad=0.0696p as=0.0696p pd=1.16u ps=1.16u
    I_MXI1_I96_I37_MN5 (XI1_I96_I37_n2 I1_qu4 VSS VSS) gpdk090_nmos1v w=0.24u l=0.1u ad=0.0528p as=0.0816p pd=0.68u ps=1.16u
    I_MXI1_I96_I37_MN4 (I1_p4_0 XI1_I96_I37_An XI1_I96_I37_n2 VSS) gpdk090_nmos1v w=0.24u l=0.1u ad=0.0528p as=0.0528p pd=0.68u ps=0.68u
    I_MXI1_I96_I37_MN2 (XI1_I96_I37_n1 I1_I96_pn0 I1_p4_0 VSS) gpdk090_nmos1v w=0.24u l=0.1u ad=0.0528p as=0.0528p pd=0.68u ps=0.68u
    I_MXI1_I96_I37_MN3 (VSS XI1_I96_I37_Bn XI1_I96_I37_n1 VSS) gpdk090_nmos1v w=0.24u l=0.1u ad=0.0816p as=0.0528p pd=1.16u ps=0.68u
    I_MXI1_I96_I37_MN0 (XI1_I96_I37_An I1_I96_pn0 VSS VSS) gpdk090_nmos1v w=0.12u l=0.1u ad=0.0696p as=0.0696p pd=1.16u ps=1.16u
    I_MXI1_I96_I8_MN1 (XI1_I96_I8_Bn I1_b4_0 VSS VSS) gpdk090_nmos1v w=0.12u l=0.1u ad=0.0696p as=0.0696p pd=1.16u ps=1.16u
    I_MXI1_I96_I8_MN5 (XI1_I96_I8_n2 I1_b4_0 VSS VSS) gpdk090_nmos1v w=0.24u l=0.1u ad=0.0528p as=0.0816p pd=0.68u ps=1.16u
    I_MXI1_I96_I8_MN4 (I1_I96_pn0 XI1_I96_I8_An XI1_I96_I8_n2 VSS) gpdk090_nmos1v w=0.24u l=0.1u ad=0.0528p as=0.0528p pd=0.68u ps=0.68u
    I_MXI1_I96_I8_MN2 (XI1_I96_I8_n1 I1_aa3 I1_I96_pn0 VSS) gpdk090_nmos1v w=0.24u l=0.1u ad=0.0528p as=0.0528p pd=0.68u ps=0.68u
    I_MXI1_I96_I8_MN3 (VSS XI1_I96_I8_Bn XI1_I96_I8_n1 VSS) gpdk090_nmos1v w=0.24u l=0.1u ad=0.0816p as=0.0528p pd=1.16u ps=0.68u
    I_MXI1_I96_I8_MN0 (XI1_I96_I8_An I1_aa3 VSS VSS) gpdk090_nmos1v w=0.12u l=0.1u ad=0.0696p as=0.0696p pd=1.16u ps=1.16u
    I_MXI1_I167_MN1 (XI1_I167_Bn I1_nqkn5 VSS VSS) gpdk090_nmos1v w=0.12u l=0.1u ad=0.0696p as=0.0696p pd=1.16u ps=1.16u
    I_MXI1_I167_MN5 (XI1_I167_n2 I1_nqkn5 VSS VSS) gpdk090_nmos1v w=0.24u l=0.1u ad=0.0528p as=0.0816p pd=0.68u ps=1.16u
    I_MXI1_I167_MN4 (DIVQ_5 XI1_I167_An XI1_I167_n2 VSS) gpdk090_nmos1v w=0.24u l=0.1u ad=0.0528p as=0.0528p pd=0.68u ps=0.68u
    I_MXI1_I167_MN2 (XI1_I167_n1 I1_qu5 DIVQ_5 VSS) gpdk090_nmos1v w=0.24u l=0.1u ad=0.0528p as=0.0528p pd=0.68u ps=0.68u
    I_MXI1_I167_MN3 (VSS XI1_I167_Bn XI1_I167_n1 VSS) gpdk090_nmos1v w=0.24u l=0.1u ad=0.0816p as=0.0528p pd=1.16u ps=0.68u
    I_MXI1_I167_MN0 (XI1_I167_An I1_qu5 VSS VSS) gpdk090_nmos1v w=0.12u l=0.1u ad=0.0696p as=0.0696p pd=1.16u ps=1.16u
    I_MXI1_I84_I8_MN1 (XI1_I84_I8_Bn I1_b3_0 VSS VSS) gpdk090_nmos1v w=0.12u l=0.1u ad=0.0696p as=0.0696p pd=1.16u ps=1.16u
    I_MXI1_I84_I8_MN5 (XI1_I84_I8_n2 I1_b3_0 VSS VSS) gpdk090_nmos1v w=0.24u l=0.1u ad=0.0528p as=0.0816p pd=0.68u ps=1.16u
    I_MXI1_I84_I8_MN4 (I1_I84_pn0 XI1_I84_I8_An XI1_I84_I8_n2 VSS) gpdk090_nmos1v w=0.24u l=0.1u ad=0.0528p as=0.0528p pd=0.68u ps=0.68u
    I_MXI1_I84_I8_MN2 (XI1_I84_I8_n1 I1_aa4 I1_I84_pn0 VSS) gpdk090_nmos1v w=0.24u l=0.1u ad=0.0528p as=0.0528p pd=0.68u ps=0.68u
    I_MXI1_I84_I8_MN3 (VSS XI1_I84_I8_Bn XI1_I84_I8_n1 VSS) gpdk090_nmos1v w=0.24u l=0.1u ad=0.0816p as=0.0528p pd=1.16u ps=0.68u
    I_MXI1_I84_I8_MN0 (XI1_I84_I8_An I1_aa4 VSS VSS) gpdk090_nmos1v w=0.12u l=0.1u ad=0.0696p as=0.0696p pd=1.16u ps=1.16u
    I_MXI1_I170_MN1 (XI1_I170_Bn I1_nqkn6 VSS VSS) gpdk090_nmos1v w=0.12u l=0.1u ad=0.0696p as=0.0696p pd=1.16u ps=1.16u
    I_MXI1_I170_MN5 (XI1_I170_n2 I1_nqkn6 VSS VSS) gpdk090_nmos1v w=0.24u l=0.1u ad=0.0528p as=0.0816p pd=0.68u ps=1.16u
    I_MXI1_I170_MN4 (DIVQ_6 XI1_I170_An XI1_I170_n2 VSS) gpdk090_nmos1v w=0.24u l=0.1u ad=0.0528p as=0.0528p pd=0.68u ps=0.68u
    I_MXI1_I170_MN2 (XI1_I170_n1 I1_qu6 DIVQ_6 VSS) gpdk090_nmos1v w=0.24u l=0.1u ad=0.0528p as=0.0528p pd=0.68u ps=0.68u
    I_MXI1_I170_MN3 (VSS XI1_I170_Bn XI1_I170_n1 VSS) gpdk090_nmos1v w=0.24u l=0.1u ad=0.0816p as=0.0528p pd=1.16u ps=0.68u
    I_MXI1_I170_MN0 (XI1_I170_An I1_qu6 VSS VSS) gpdk090_nmos1v w=0.12u l=0.1u ad=0.0696p as=0.0696p pd=1.16u ps=1.16u
    I_MXI1_I13_MN1 (XI1_I13_Bn I1_nakn5 VSS VSS) gpdk090_nmos1v w=0.12u l=0.1u ad=0.0696p as=0.0696p pd=1.16u ps=1.16u
    I_MXI1_I13_MN5 (XI1_I13_n2 I1_nakn5 VSS VSS) gpdk090_nmos1v w=0.24u l=0.1u ad=0.0528p as=0.0816p pd=0.68u ps=1.16u
    I_MXI1_I13_MN4 (I1_aa5 XI1_I13_An XI1_I13_n2 VSS) gpdk090_nmos1v w=0.24u l=0.1u ad=0.0528p as=0.0528p pd=0.68u ps=0.68u
    I_MXI1_I13_MN2 (XI1_I13_n1 A_5 I1_aa5 VSS) gpdk090_nmos1v w=0.24u l=0.1u ad=0.0528p as=0.0528p pd=0.68u ps=0.68u
    I_MXI1_I13_MN3 (VSS XI1_I13_Bn XI1_I13_n1 VSS) gpdk090_nmos1v w=0.24u l=0.1u ad=0.0816p as=0.0528p pd=1.16u ps=0.68u
    I_MXI1_I13_MN0 (XI1_I13_An A_5 VSS VSS) gpdk090_nmos1v w=0.12u l=0.1u ad=0.0696p as=0.0696p pd=1.16u ps=1.16u
    I_MXI1_I16_MN1 (XI1_I16_Bn I1_nakn6 VSS VSS) gpdk090_nmos1v w=0.12u l=0.1u ad=0.0696p as=0.0696p pd=1.16u ps=1.16u
    I_MXI1_I16_MN5 (XI1_I16_n2 I1_nakn6 VSS VSS) gpdk090_nmos1v w=0.24u l=0.1u ad=0.0528p as=0.0816p pd=0.68u ps=1.16u
    I_MXI1_I16_MN4 (I1_aa6 XI1_I16_An XI1_I16_n2 VSS) gpdk090_nmos1v w=0.24u l=0.1u ad=0.0528p as=0.0528p pd=0.68u ps=0.68u
    I_MXI1_I16_MN2 (XI1_I16_n1 A_6 I1_aa6 VSS) gpdk090_nmos1v w=0.24u l=0.1u ad=0.0528p as=0.0528p pd=0.68u ps=0.68u
    I_MXI1_I16_MN3 (VSS XI1_I16_Bn XI1_I16_n1 VSS) gpdk090_nmos1v w=0.24u l=0.1u ad=0.0816p as=0.0528p pd=1.16u ps=0.68u
    I_MXI1_I16_MN0 (XI1_I16_An A_6 VSS VSS) gpdk090_nmos1v w=0.12u l=0.1u ad=0.0696p as=0.0696p pd=1.16u ps=1.16u
    I_MXI1_I19_MN1 (XI1_I19_Bn I1_nakn7 VSS VSS) gpdk090_nmos1v w=0.12u l=0.1u ad=0.0696p as=0.0696p pd=1.16u ps=1.16u
    I_MXI1_I19_MN5 (XI1_I19_n2 I1_nakn7 VSS VSS) gpdk090_nmos1v w=0.24u l=0.1u ad=0.0528p as=0.0816p pd=0.68u ps=1.16u
    I_MXI1_I19_MN4 (I1_aa7 XI1_I19_An XI1_I19_n2 VSS) gpdk090_nmos1v w=0.24u l=0.1u ad=0.0528p as=0.0528p pd=0.68u ps=0.68u
    I_MXI1_I19_MN2 (XI1_I19_n1 A_7 I1_aa7 VSS) gpdk090_nmos1v w=0.24u l=0.1u ad=0.0528p as=0.0528p pd=0.68u ps=0.68u
    I_MXI1_I19_MN3 (VSS XI1_I19_Bn XI1_I19_n1 VSS) gpdk090_nmos1v w=0.24u l=0.1u ad=0.0816p as=0.0528p pd=1.16u ps=0.68u
    I_MXI1_I19_MN0 (XI1_I19_An A_7 VSS VSS) gpdk090_nmos1v w=0.12u l=0.1u ad=0.0696p as=0.0696p pd=1.16u ps=1.16u
    I_MXI1_I48_I8_MN1 (XI1_I48_I8_Bn I1_b0_0 VSS VSS) gpdk090_nmos1v w=0.12u l=0.1u ad=0.0696p as=0.0696p pd=1.16u ps=1.16u
    I_MXI1_I48_I8_MN5 (XI1_I48_I8_n2 I1_b0_0 VSS VSS) gpdk090_nmos1v w=0.24u l=0.1u ad=0.0528p as=0.0816p pd=0.68u ps=1.16u
    I_MXI1_I48_I8_MN4 (I1_I48_pn0 XI1_I48_I8_An XI1_I48_I8_n2 VSS) gpdk090_nmos1v w=0.24u l=0.1u ad=0.0528p as=0.0528p pd=0.68u ps=0.68u
    I_MXI1_I48_I8_MN2 (XI1_I48_I8_n1 I1_aa7 I1_I48_pn0 VSS) gpdk090_nmos1v w=0.24u l=0.1u ad=0.0528p as=0.0528p pd=0.68u ps=0.68u
    I_MXI1_I48_I8_MN3 (VSS XI1_I48_I8_Bn XI1_I48_I8_n1 VSS) gpdk090_nmos1v w=0.24u l=0.1u ad=0.0816p as=0.0528p pd=1.16u ps=0.68u
    I_MXI1_I48_I8_MN0 (XI1_I48_I8_An I1_aa7 VSS VSS) gpdk090_nmos1v w=0.12u l=0.1u ad=0.0696p as=0.0696p pd=1.16u ps=1.16u
    I_MXI1_I108_I44_MN1 (XI1_I108_I44_Bn I1_c5_7 VSS VSS) gpdk090_nmos1v w=0.12u l=0.1u ad=0.0696p as=0.0696p pd=1.16u ps=1.16u
    I_MXI1_I108_I44_MN5 (XI1_I108_I44_n2 I1_c5_7 VSS VSS) gpdk090_nmos1v w=0.24u l=0.1u ad=0.0528p as=0.0816p pd=0.68u ps=1.16u
    I_MXI1_I108_I44_MN4 (I1_p5_7 XI1_I108_I44_An XI1_I108_I44_n2 VSS) gpdk090_nmos1v w=0.24u l=0.1u ad=0.0528p as=0.0528p pd=0.68u ps=0.68u
    I_MXI1_I108_I44_MN2 (XI1_I108_I44_n1 I1_I108_pn7 I1_p5_7 VSS) gpdk090_nmos1v w=0.24u l=0.1u ad=0.0528p as=0.0528p pd=0.68u ps=0.68u
    I_MXI1_I108_I44_MN3 (VSS XI1_I108_I44_Bn XI1_I108_I44_n1 VSS) gpdk090_nmos1v w=0.24u l=0.1u ad=0.0816p as=0.0528p pd=1.16u ps=0.68u
    I_MXI1_I108_I44_MN0 (XI1_I108_I44_An I1_I108_pn7 VSS VSS) gpdk090_nmos1v w=0.12u l=0.1u ad=0.0696p as=0.0696p pd=1.16u ps=1.16u
    I_MXI1_I108_I42_MN1 (XI1_I108_I42_Bn I1_I108_G4_0 VSS VSS) gpdk090_nmos1v w=0.12u l=0.1u ad=0.0696p as=0.0696p pd=1.16u ps=1.16u
    I_MXI1_I108_I42_MN5 (XI1_I108_I42_n2 I1_I108_G4_0 VSS VSS) gpdk090_nmos1v w=0.24u l=0.1u ad=0.0528p as=0.0816p pd=0.68u ps=1.16u
    I_MXI1_I108_I42_MN4 (I1_p5_5 XI1_I108_I42_An XI1_I108_I42_n2 VSS) gpdk090_nmos1v w=0.24u l=0.1u ad=0.0528p as=0.0528p pd=0.68u ps=0.68u
    I_MXI1_I108_I42_MN2 (XI1_I108_I42_n1 I1_I108_pn5 I1_p5_5 VSS) gpdk090_nmos1v w=0.24u l=0.1u ad=0.0528p as=0.0528p pd=0.68u ps=0.68u
    I_MXI1_I108_I42_MN3 (VSS XI1_I108_I42_Bn XI1_I108_I42_n1 VSS) gpdk090_nmos1v w=0.24u l=0.1u ad=0.0816p as=0.0528p pd=1.16u ps=0.68u
    I_MXI1_I108_I42_MN0 (XI1_I108_I42_An I1_I108_pn5 VSS VSS) gpdk090_nmos1v w=0.12u l=0.1u ad=0.0696p as=0.0696p pd=1.16u ps=1.16u
    I_MXI1_I108_I10_MN1 (XI1_I108_I10_Bn I1_b5_2 VSS VSS) gpdk090_nmos1v w=0.12u l=0.1u ad=0.0696p as=0.0696p pd=1.16u ps=1.16u
    I_MXI1_I108_I10_MN5 (XI1_I108_I10_n2 I1_b5_2 VSS VSS) gpdk090_nmos1v w=0.24u l=0.1u ad=0.0528p as=0.0816p pd=0.68u ps=1.16u
    I_MXI1_I108_I10_MN4 (I1_I108_pn2 XI1_I108_I10_An XI1_I108_I10_n2 VSS) gpdk090_nmos1v w=0.24u l=0.1u ad=0.0528p as=0.0528p pd=0.68u ps=0.68u
    I_MXI1_I108_I10_MN2 (XI1_I108_I10_n1 I1_p4_1 I1_I108_pn2 VSS) gpdk090_nmos1v w=0.24u l=0.1u ad=0.0528p as=0.0528p pd=0.68u ps=0.68u
    I_MXI1_I108_I10_MN3 (VSS XI1_I108_I10_Bn XI1_I108_I10_n1 VSS) gpdk090_nmos1v w=0.24u l=0.1u ad=0.0816p as=0.0528p pd=1.16u ps=0.68u
    I_MXI1_I108_I10_MN0 (XI1_I108_I10_An I1_p4_1 VSS VSS) gpdk090_nmos1v w=0.12u l=0.1u ad=0.0696p as=0.0696p pd=1.16u ps=1.16u
    I_MXI1_I96_I9_MN1 (XI1_I96_I9_Bn I1_b4_1 VSS VSS) gpdk090_nmos1v w=0.12u l=0.1u ad=0.0696p as=0.0696p pd=1.16u ps=1.16u
    I_MXI1_I96_I9_MN5 (XI1_I96_I9_n2 I1_b4_1 VSS VSS) gpdk090_nmos1v w=0.24u l=0.1u ad=0.0528p as=0.0816p pd=0.68u ps=1.16u
    I_MXI1_I96_I9_MN4 (I1_I96_pn1 XI1_I96_I9_An XI1_I96_I9_n2 VSS) gpdk090_nmos1v w=0.24u l=0.1u ad=0.0528p as=0.0528p pd=0.68u ps=0.68u
    I_MXI1_I96_I9_MN2 (XI1_I96_I9_n1 I1_p3_0 I1_I96_pn1 VSS) gpdk090_nmos1v w=0.24u l=0.1u ad=0.0528p as=0.0528p pd=0.68u ps=0.68u
    I_MXI1_I96_I9_MN3 (VSS XI1_I96_I9_Bn XI1_I96_I9_n1 VSS) gpdk090_nmos1v w=0.24u l=0.1u ad=0.0816p as=0.0528p pd=1.16u ps=0.68u
    I_MXI1_I96_I9_MN0 (XI1_I96_I9_An I1_p3_0 VSS VSS) gpdk090_nmos1v w=0.12u l=0.1u ad=0.0696p as=0.0696p pd=1.16u ps=1.16u
    I_MXI1_I84_I37_MN1 (XI1_I84_I37_Bn I1_qu5 VSS VSS) gpdk090_nmos1v w=0.12u l=0.1u ad=0.0696p as=0.0696p pd=1.16u ps=1.16u
    I_MXI1_I84_I37_MN5 (XI1_I84_I37_n2 I1_qu5 VSS VSS) gpdk090_nmos1v w=0.24u l=0.1u ad=0.0528p as=0.0816p pd=0.68u ps=1.16u
    I_MXI1_I84_I37_MN4 (I1_p3_0 XI1_I84_I37_An XI1_I84_I37_n2 VSS) gpdk090_nmos1v w=0.24u l=0.1u ad=0.0528p as=0.0528p pd=0.68u ps=0.68u
    I_MXI1_I84_I37_MN2 (XI1_I84_I37_n1 I1_I84_pn0 I1_p3_0 VSS) gpdk090_nmos1v w=0.24u l=0.1u ad=0.0528p as=0.0528p pd=0.68u ps=0.68u
    I_MXI1_I84_I37_MN3 (VSS XI1_I84_I37_Bn XI1_I84_I37_n1 VSS) gpdk090_nmos1v w=0.24u l=0.1u ad=0.0816p as=0.0528p pd=1.16u ps=0.68u
    I_MXI1_I84_I37_MN0 (XI1_I84_I37_An I1_I84_pn0 VSS VSS) gpdk090_nmos1v w=0.12u l=0.1u ad=0.0696p as=0.0696p pd=1.16u ps=1.16u
    I_MXI1_I84_I9_MN1 (XI1_I84_I9_Bn I1_b3_1 VSS VSS) gpdk090_nmos1v w=0.12u l=0.1u ad=0.0696p as=0.0696p pd=1.16u ps=1.16u
    I_MXI1_I84_I9_MN5 (XI1_I84_I9_n2 I1_b3_1 VSS VSS) gpdk090_nmos1v w=0.24u l=0.1u ad=0.0528p as=0.0816p pd=0.68u ps=1.16u
    I_MXI1_I84_I9_MN4 (I1_I84_pn1 XI1_I84_I9_An XI1_I84_I9_n2 VSS) gpdk090_nmos1v w=0.24u l=0.1u ad=0.0528p as=0.0528p pd=0.68u ps=0.68u
    I_MXI1_I84_I9_MN2 (XI1_I84_I9_n1 I1_p2_0 I1_I84_pn1 VSS) gpdk090_nmos1v w=0.24u l=0.1u ad=0.0528p as=0.0528p pd=0.68u ps=0.68u
    I_MXI1_I84_I9_MN3 (VSS XI1_I84_I9_Bn XI1_I84_I9_n1 VSS) gpdk090_nmos1v w=0.24u l=0.1u ad=0.0816p as=0.0528p pd=1.16u ps=0.68u
    I_MXI1_I84_I9_MN0 (XI1_I84_I9_An I1_p2_0 VSS VSS) gpdk090_nmos1v w=0.12u l=0.1u ad=0.0696p as=0.0696p pd=1.16u ps=1.16u
    I_MXI1_I72_I37_MN1 (XI1_I72_I37_Bn I1_qu6 VSS VSS) gpdk090_nmos1v w=0.12u l=0.1u ad=0.0696p as=0.0696p pd=1.16u ps=1.16u
    I_MXI1_I72_I37_MN5 (XI1_I72_I37_n2 I1_qu6 VSS VSS) gpdk090_nmos1v w=0.24u l=0.1u ad=0.0528p as=0.0816p pd=0.68u ps=1.16u
    I_MXI1_I72_I37_MN4 (I1_p2_0 XI1_I72_I37_An XI1_I72_I37_n2 VSS) gpdk090_nmos1v w=0.24u l=0.1u ad=0.0528p as=0.0528p pd=0.68u ps=0.68u
    I_MXI1_I72_I37_MN2 (XI1_I72_I37_n1 I1_I72_pn0 I1_p2_0 VSS) gpdk090_nmos1v w=0.24u l=0.1u ad=0.0528p as=0.0528p pd=0.68u ps=0.68u
    I_MXI1_I72_I37_MN3 (VSS XI1_I72_I37_Bn XI1_I72_I37_n1 VSS) gpdk090_nmos1v w=0.24u l=0.1u ad=0.0816p as=0.0528p pd=1.16u ps=0.68u
    I_MXI1_I72_I37_MN0 (XI1_I72_I37_An I1_I72_pn0 VSS VSS) gpdk090_nmos1v w=0.12u l=0.1u ad=0.0696p as=0.0696p pd=1.16u ps=1.16u
    I_MXI1_I72_I8_MN1 (XI1_I72_I8_Bn I1_b2_0 VSS VSS) gpdk090_nmos1v w=0.12u l=0.1u ad=0.0696p as=0.0696p pd=1.16u ps=1.16u
    I_MXI1_I72_I8_MN5 (XI1_I72_I8_n2 I1_b2_0 VSS VSS) gpdk090_nmos1v w=0.24u l=0.1u ad=0.0528p as=0.0816p pd=0.68u ps=1.16u
    I_MXI1_I72_I8_MN4 (I1_I72_pn0 XI1_I72_I8_An XI1_I72_I8_n2 VSS) gpdk090_nmos1v w=0.24u l=0.1u ad=0.0528p as=0.0528p pd=0.68u ps=0.68u
    I_MXI1_I72_I8_MN2 (XI1_I72_I8_n1 I1_aa5 I1_I72_pn0 VSS) gpdk090_nmos1v w=0.24u l=0.1u ad=0.0528p as=0.0528p pd=0.68u ps=0.68u
    I_MXI1_I72_I8_MN3 (VSS XI1_I72_I8_Bn XI1_I72_I8_n1 VSS) gpdk090_nmos1v w=0.24u l=0.1u ad=0.0816p as=0.0528p pd=1.16u ps=0.68u
    I_MXI1_I72_I8_MN0 (XI1_I72_I8_An I1_aa5 VSS VSS) gpdk090_nmos1v w=0.12u l=0.1u ad=0.0696p as=0.0696p pd=1.16u ps=1.16u
    I_MXI1_I60_I8_MN1 (XI1_I60_I8_Bn I1_b1_0 VSS VSS) gpdk090_nmos1v w=0.12u l=0.1u ad=0.0696p as=0.0696p pd=1.16u ps=1.16u
    I_MXI1_I60_I8_MN5 (XI1_I60_I8_n2 I1_b1_0 VSS VSS) gpdk090_nmos1v w=0.24u l=0.1u ad=0.0528p as=0.0816p pd=0.68u ps=1.16u
    I_MXI1_I60_I8_MN4 (I1_I60_pn0 XI1_I60_I8_An XI1_I60_I8_n2 VSS) gpdk090_nmos1v w=0.24u l=0.1u ad=0.0528p as=0.0528p pd=0.68u ps=0.68u
    I_MXI1_I60_I8_MN2 (XI1_I60_I8_n1 I1_aa6 I1_I60_pn0 VSS) gpdk090_nmos1v w=0.24u l=0.1u ad=0.0528p as=0.0528p pd=0.68u ps=0.68u
    I_MXI1_I60_I8_MN3 (VSS XI1_I60_I8_Bn XI1_I60_I8_n1 VSS) gpdk090_nmos1v w=0.24u l=0.1u ad=0.0816p as=0.0528p pd=1.16u ps=0.68u
    I_MXI1_I60_I8_MN0 (XI1_I60_I8_An I1_aa6 VSS VSS) gpdk090_nmos1v w=0.12u l=0.1u ad=0.0696p as=0.0696p pd=1.16u ps=1.16u
    I_MXI1_I48_I37_MN1 (XI1_I48_I37_Bn VDD VSS VSS) gpdk090_nmos1v w=0.12u l=0.1u ad=0.0696p as=0.0696p pd=1.16u ps=1.16u
    I_MXI1_I48_I37_MN5 (XI1_I48_I37_n2 VDD VSS VSS) gpdk090_nmos1v w=0.24u l=0.1u ad=0.0528p as=0.0816p pd=0.68u ps=1.16u
    I_MXI1_I48_I37_MN4 (I1_p0_0 XI1_I48_I37_An XI1_I48_I37_n2 VSS) gpdk090_nmos1v w=0.24u l=0.1u ad=0.0528p as=0.0528p pd=0.68u ps=0.68u
    I_MXI1_I48_I37_MN2 (XI1_I48_I37_n1 I1_I48_pn0 I1_p0_0 VSS) gpdk090_nmos1v w=0.24u l=0.1u ad=0.0528p as=0.0528p pd=0.68u ps=0.68u
    I_MXI1_I48_I37_MN3 (VSS XI1_I48_I37_Bn XI1_I48_I37_n1 VSS) gpdk090_nmos1v w=0.24u l=0.1u ad=0.0816p as=0.0528p pd=1.16u ps=0.68u
    I_MXI1_I48_I37_MN0 (XI1_I48_I37_An I1_I48_pn0 VSS VSS) gpdk090_nmos1v w=0.12u l=0.1u ad=0.0696p as=0.0696p pd=1.16u ps=1.16u
    I_MXI1_I60_I37_MN1 (XI1_I60_I37_Bn I1_qu7 VSS VSS) gpdk090_nmos1v w=0.12u l=0.1u ad=0.0696p as=0.0696p pd=1.16u ps=1.16u
    I_MXI1_I60_I37_MN5 (XI1_I60_I37_n2 I1_qu7 VSS VSS) gpdk090_nmos1v w=0.24u l=0.1u ad=0.0528p as=0.0816p pd=0.68u ps=1.16u
    I_MXI1_I60_I37_MN4 (I1_p1_0 XI1_I60_I37_An XI1_I60_I37_n2 VSS) gpdk090_nmos1v w=0.24u l=0.1u ad=0.0528p as=0.0528p pd=0.68u ps=0.68u
    I_MXI1_I60_I37_MN2 (XI1_I60_I37_n1 I1_I60_pn0 I1_p1_0 VSS) gpdk090_nmos1v w=0.24u l=0.1u ad=0.0528p as=0.0528p pd=0.68u ps=0.68u
    I_MXI1_I60_I37_MN3 (VSS XI1_I60_I37_Bn XI1_I60_I37_n1 VSS) gpdk090_nmos1v w=0.24u l=0.1u ad=0.0816p as=0.0528p pd=1.16u ps=0.68u
    I_MXI1_I60_I37_MN0 (XI1_I60_I37_An I1_I60_pn0 VSS VSS) gpdk090_nmos1v w=0.12u l=0.1u ad=0.0696p as=0.0696p pd=1.16u ps=1.16u
    I_MXI1_I48_I10_MN1 (XI1_I48_I10_Bn I1_b0_2 VSS VSS) gpdk090_nmos1v w=0.12u l=0.1u ad=0.0696p as=0.0696p pd=1.16u ps=1.16u
    I_MXI1_I48_I10_MN5 (XI1_I48_I10_n2 I1_b0_2 VSS VSS) gpdk090_nmos1v w=0.24u l=0.1u ad=0.0528p as=0.0816p pd=0.68u ps=1.16u
    I_MXI1_I48_I10_MN4 (I1_I48_pn2 XI1_I48_I10_An XI1_I48_I10_n2 VSS) gpdk090_nmos1v w=0.24u l=0.1u ad=0.0528p as=0.0528p pd=0.68u ps=0.68u
    I_MXI1_I48_I10_MN2 (XI1_I48_I10_n1 VSS I1_I48_pn2 VSS) gpdk090_nmos1v w=0.24u l=0.1u ad=0.0528p as=0.0528p pd=0.68u ps=0.68u
    I_MXI1_I48_I10_MN3 (VSS XI1_I48_I10_Bn XI1_I48_I10_n1 VSS) gpdk090_nmos1v w=0.24u l=0.1u ad=0.0816p as=0.0528p pd=1.16u ps=0.68u
    I_MXI1_I48_I10_MN0 (XI1_I48_I10_An VSS VSS VSS) gpdk090_nmos1v w=0.12u l=0.1u ad=0.0696p as=0.0696p pd=1.16u ps=1.16u
    I_MXI1_I108_I43_MN1 (XI1_I108_I43_Bn I1_I108_G5_0 VSS VSS) gpdk090_nmos1v w=0.12u l=0.1u ad=0.0696p as=0.0696p pd=1.16u ps=1.16u
    I_MXI1_I108_I43_MN5 (XI1_I108_I43_n2 I1_I108_G5_0 VSS VSS) gpdk090_nmos1v w=0.24u l=0.1u ad=0.0528p as=0.0816p pd=0.68u ps=1.16u
    I_MXI1_I108_I43_MN4 (I1_p5_6 XI1_I108_I43_An XI1_I108_I43_n2 VSS) gpdk090_nmos1v w=0.24u l=0.1u ad=0.0528p as=0.0528p pd=0.68u ps=0.68u
    I_MXI1_I108_I43_MN2 (XI1_I108_I43_n1 I1_I108_pn6 I1_p5_6 VSS) gpdk090_nmos1v w=0.24u l=0.1u ad=0.0528p as=0.0528p pd=0.68u ps=0.68u
    I_MXI1_I108_I43_MN3 (VSS XI1_I108_I43_Bn XI1_I108_I43_n1 VSS) gpdk090_nmos1v w=0.24u l=0.1u ad=0.0816p as=0.0528p pd=1.16u ps=0.68u
    I_MXI1_I108_I43_MN0 (XI1_I108_I43_An I1_I108_pn6 VSS VSS) gpdk090_nmos1v w=0.12u l=0.1u ad=0.0696p as=0.0696p pd=1.16u ps=1.16u
    I_MXI1_I96_I38_MN1 (XI1_I96_I38_Bn I1_I96_G0_0 VSS VSS) gpdk090_nmos1v w=0.12u l=0.1u ad=0.0696p as=0.0696p pd=1.16u ps=1.16u
    I_MXI1_I96_I38_MN5 (XI1_I96_I38_n2 I1_I96_G0_0 VSS VSS) gpdk090_nmos1v w=0.24u l=0.1u ad=0.0528p as=0.0816p pd=0.68u ps=1.16u
    I_MXI1_I96_I38_MN4 (I1_p4_1 XI1_I96_I38_An XI1_I96_I38_n2 VSS) gpdk090_nmos1v w=0.24u l=0.1u ad=0.0528p as=0.0528p pd=0.68u ps=0.68u
    I_MXI1_I96_I38_MN2 (XI1_I96_I38_n1 I1_I96_pn1 I1_p4_1 VSS) gpdk090_nmos1v w=0.24u l=0.1u ad=0.0528p as=0.0528p pd=0.68u ps=0.68u
    I_MXI1_I96_I38_MN3 (VSS XI1_I96_I38_Bn XI1_I96_I38_n1 VSS) gpdk090_nmos1v w=0.24u l=0.1u ad=0.0816p as=0.0528p pd=1.16u ps=0.68u
    I_MXI1_I96_I38_MN0 (XI1_I96_I38_An I1_I96_pn1 VSS VSS) gpdk090_nmos1v w=0.12u l=0.1u ad=0.0696p as=0.0696p pd=1.16u ps=1.16u
    I_MXI1_I108_I11_MN1 (XI1_I108_I11_Bn I1_b5_3 VSS VSS) gpdk090_nmos1v w=0.12u l=0.1u ad=0.0696p as=0.0696p pd=1.16u ps=1.16u
    I_MXI1_I108_I11_MN5 (XI1_I108_I11_n2 I1_b5_3 VSS VSS) gpdk090_nmos1v w=0.24u l=0.1u ad=0.0528p as=0.0816p pd=0.68u ps=1.16u
    I_MXI1_I108_I11_MN4 (I1_I108_pn3 XI1_I108_I11_An XI1_I108_I11_n2 VSS) gpdk090_nmos1v w=0.24u l=0.1u ad=0.0528p as=0.0528p pd=0.68u ps=0.68u
    I_MXI1_I108_I11_MN2 (XI1_I108_I11_n1 I1_p4_2 I1_I108_pn3 VSS) gpdk090_nmos1v w=0.24u l=0.1u ad=0.0528p as=0.0528p pd=0.68u ps=0.68u
    I_MXI1_I108_I11_MN3 (VSS XI1_I108_I11_Bn XI1_I108_I11_n1 VSS) gpdk090_nmos1v w=0.24u l=0.1u ad=0.0816p as=0.0528p pd=1.16u ps=0.68u
    I_MXI1_I108_I11_MN0 (XI1_I108_I11_An I1_p4_2 VSS VSS) gpdk090_nmos1v w=0.12u l=0.1u ad=0.0696p as=0.0696p pd=1.16u ps=1.16u
    I_MXI1_I96_I10_MN1 (XI1_I96_I10_Bn I1_b4_2 VSS VSS) gpdk090_nmos1v w=0.12u l=0.1u ad=0.0696p as=0.0696p pd=1.16u ps=1.16u
    I_MXI1_I96_I10_MN5 (XI1_I96_I10_n2 I1_b4_2 VSS VSS) gpdk090_nmos1v w=0.24u l=0.1u ad=0.0528p as=0.0816p pd=0.68u ps=1.16u
    I_MXI1_I96_I10_MN4 (I1_I96_pn2 XI1_I96_I10_An XI1_I96_I10_n2 VSS) gpdk090_nmos1v w=0.24u l=0.1u ad=0.0528p as=0.0528p pd=0.68u ps=0.68u
    I_MXI1_I96_I10_MN2 (XI1_I96_I10_n1 I1_p3_1 I1_I96_pn2 VSS) gpdk090_nmos1v w=0.24u l=0.1u ad=0.0528p as=0.0528p pd=0.68u ps=0.68u
    I_MXI1_I96_I10_MN3 (VSS XI1_I96_I10_Bn XI1_I96_I10_n1 VSS) gpdk090_nmos1v w=0.24u l=0.1u ad=0.0816p as=0.0528p pd=1.16u ps=0.68u
    I_MXI1_I96_I10_MN0 (XI1_I96_I10_An I1_p3_1 VSS VSS) gpdk090_nmos1v w=0.12u l=0.1u ad=0.0696p as=0.0696p pd=1.16u ps=1.16u
    I_MXI1_I84_I38_MN1 (XI1_I84_I38_Bn I1_I84_G0_0 VSS VSS) gpdk090_nmos1v w=0.12u l=0.1u ad=0.0696p as=0.0696p pd=1.16u ps=1.16u
    I_MXI1_I84_I38_MN5 (XI1_I84_I38_n2 I1_I84_G0_0 VSS VSS) gpdk090_nmos1v w=0.24u l=0.1u ad=0.0528p as=0.0816p pd=0.68u ps=1.16u
    I_MXI1_I84_I38_MN4 (I1_p3_1 XI1_I84_I38_An XI1_I84_I38_n2 VSS) gpdk090_nmos1v w=0.24u l=0.1u ad=0.0528p as=0.0528p pd=0.68u ps=0.68u
    I_MXI1_I84_I38_MN2 (XI1_I84_I38_n1 I1_I84_pn1 I1_p3_1 VSS) gpdk090_nmos1v w=0.24u l=0.1u ad=0.0528p as=0.0528p pd=0.68u ps=0.68u
    I_MXI1_I84_I38_MN3 (VSS XI1_I84_I38_Bn XI1_I84_I38_n1 VSS) gpdk090_nmos1v w=0.24u l=0.1u ad=0.0816p as=0.0528p pd=1.16u ps=0.68u
    I_MXI1_I84_I38_MN0 (XI1_I84_I38_An I1_I84_pn1 VSS VSS) gpdk090_nmos1v w=0.12u l=0.1u ad=0.0696p as=0.0696p pd=1.16u ps=1.16u
    I_MXI1_I84_I10_MN1 (XI1_I84_I10_Bn I1_b3_2 VSS VSS) gpdk090_nmos1v w=0.12u l=0.1u ad=0.0696p as=0.0696p pd=1.16u ps=1.16u
    I_MXI1_I84_I10_MN5 (XI1_I84_I10_n2 I1_b3_2 VSS VSS) gpdk090_nmos1v w=0.24u l=0.1u ad=0.0528p as=0.0816p pd=0.68u ps=1.16u
    I_MXI1_I84_I10_MN4 (I1_I84_pn2 XI1_I84_I10_An XI1_I84_I10_n2 VSS) gpdk090_nmos1v w=0.24u l=0.1u ad=0.0528p as=0.0528p pd=0.68u ps=0.68u
    I_MXI1_I84_I10_MN2 (XI1_I84_I10_n1 I1_p2_1 I1_I84_pn2 VSS) gpdk090_nmos1v w=0.24u l=0.1u ad=0.0528p as=0.0528p pd=0.68u ps=0.68u
    I_MXI1_I84_I10_MN3 (VSS XI1_I84_I10_Bn XI1_I84_I10_n1 VSS) gpdk090_nmos1v w=0.24u l=0.1u ad=0.0816p as=0.0528p pd=1.16u ps=0.68u
    I_MXI1_I84_I10_MN0 (XI1_I84_I10_An I1_p2_1 VSS VSS) gpdk090_nmos1v w=0.12u l=0.1u ad=0.0696p as=0.0696p pd=1.16u ps=1.16u
    I_MXI1_I72_I38_MN1 (XI1_I72_I38_Bn I1_I72_G0_0 VSS VSS) gpdk090_nmos1v w=0.12u l=0.1u ad=0.0696p as=0.0696p pd=1.16u ps=1.16u
    I_MXI1_I72_I38_MN5 (XI1_I72_I38_n2 I1_I72_G0_0 VSS VSS) gpdk090_nmos1v w=0.24u l=0.1u ad=0.0528p as=0.0816p pd=0.68u ps=1.16u
    I_MXI1_I72_I38_MN4 (I1_p2_1 XI1_I72_I38_An XI1_I72_I38_n2 VSS) gpdk090_nmos1v w=0.24u l=0.1u ad=0.0528p as=0.0528p pd=0.68u ps=0.68u
    I_MXI1_I72_I38_MN2 (XI1_I72_I38_n1 I1_I72_pn1 I1_p2_1 VSS) gpdk090_nmos1v w=0.24u l=0.1u ad=0.0528p as=0.0528p pd=0.68u ps=0.68u
    I_MXI1_I72_I38_MN3 (VSS XI1_I72_I38_Bn XI1_I72_I38_n1 VSS) gpdk090_nmos1v w=0.24u l=0.1u ad=0.0816p as=0.0528p pd=1.16u ps=0.68u
    I_MXI1_I72_I38_MN0 (XI1_I72_I38_An I1_I72_pn1 VSS VSS) gpdk090_nmos1v w=0.12u l=0.1u ad=0.0696p as=0.0696p pd=1.16u ps=1.16u
    I_MXI1_I72_I9_MN1 (XI1_I72_I9_Bn I1_b2_1 VSS VSS) gpdk090_nmos1v w=0.12u l=0.1u ad=0.0696p as=0.0696p pd=1.16u ps=1.16u
    I_MXI1_I72_I9_MN5 (XI1_I72_I9_n2 I1_b2_1 VSS VSS) gpdk090_nmos1v w=0.24u l=0.1u ad=0.0528p as=0.0816p pd=0.68u ps=1.16u
    I_MXI1_I72_I9_MN4 (I1_I72_pn1 XI1_I72_I9_An XI1_I72_I9_n2 VSS) gpdk090_nmos1v w=0.24u l=0.1u ad=0.0528p as=0.0528p pd=0.68u ps=0.68u
    I_MXI1_I72_I9_MN2 (XI1_I72_I9_n1 I1_p1_0 I1_I72_pn1 VSS) gpdk090_nmos1v w=0.24u l=0.1u ad=0.0528p as=0.0528p pd=0.68u ps=0.68u
    I_MXI1_I72_I9_MN3 (VSS XI1_I72_I9_Bn XI1_I72_I9_n1 VSS) gpdk090_nmos1v w=0.24u l=0.1u ad=0.0816p as=0.0528p pd=1.16u ps=0.68u
    I_MXI1_I72_I9_MN0 (XI1_I72_I9_An I1_p1_0 VSS VSS) gpdk090_nmos1v w=0.12u l=0.1u ad=0.0696p as=0.0696p pd=1.16u ps=1.16u
    I_MXI1_I72_I10_MN1 (XI1_I72_I10_Bn I1_b2_2 VSS VSS) gpdk090_nmos1v w=0.12u l=0.1u ad=0.0696p as=0.0696p pd=1.16u ps=1.16u
    I_MXI1_I72_I10_MN5 (XI1_I72_I10_n2 I1_b2_2 VSS VSS) gpdk090_nmos1v w=0.24u l=0.1u ad=0.0528p as=0.0816p pd=0.68u ps=1.16u
    I_MXI1_I72_I10_MN4 (I1_I72_pn2 XI1_I72_I10_An XI1_I72_I10_n2 VSS) gpdk090_nmos1v w=0.24u l=0.1u ad=0.0528p as=0.0528p pd=0.68u ps=0.68u
    I_MXI1_I72_I10_MN2 (XI1_I72_I10_n1 I1_p1_1 I1_I72_pn2 VSS) gpdk090_nmos1v w=0.24u l=0.1u ad=0.0528p as=0.0528p pd=0.68u ps=0.68u
    I_MXI1_I72_I10_MN3 (VSS XI1_I72_I10_Bn XI1_I72_I10_n1 VSS) gpdk090_nmos1v w=0.24u l=0.1u ad=0.0816p as=0.0528p pd=1.16u ps=0.68u
    I_MXI1_I72_I10_MN0 (XI1_I72_I10_An I1_p1_1 VSS VSS) gpdk090_nmos1v w=0.12u l=0.1u ad=0.0696p as=0.0696p pd=1.16u ps=1.16u
    I_MXI1_I60_I38_MN1 (XI1_I60_I38_Bn I1_I60_G0_0 VSS VSS) gpdk090_nmos1v w=0.12u l=0.1u ad=0.0696p as=0.0696p pd=1.16u ps=1.16u
    I_MXI1_I60_I38_MN5 (XI1_I60_I38_n2 I1_I60_G0_0 VSS VSS) gpdk090_nmos1v w=0.24u l=0.1u ad=0.0528p as=0.0816p pd=0.68u ps=1.16u
    I_MXI1_I60_I38_MN4 (I1_p1_1 XI1_I60_I38_An XI1_I60_I38_n2 VSS) gpdk090_nmos1v w=0.24u l=0.1u ad=0.0528p as=0.0528p pd=0.68u ps=0.68u
    I_MXI1_I60_I38_MN2 (XI1_I60_I38_n1 I1_I60_pn1 I1_p1_1 VSS) gpdk090_nmos1v w=0.24u l=0.1u ad=0.0528p as=0.0528p pd=0.68u ps=0.68u
    I_MXI1_I60_I38_MN3 (VSS XI1_I60_I38_Bn XI1_I60_I38_n1 VSS) gpdk090_nmos1v w=0.24u l=0.1u ad=0.0816p as=0.0528p pd=1.16u ps=0.68u
    I_MXI1_I60_I38_MN0 (XI1_I60_I38_An I1_I60_pn1 VSS VSS) gpdk090_nmos1v w=0.12u l=0.1u ad=0.0696p as=0.0696p pd=1.16u ps=1.16u
    I_MXI1_I60_I9_MN1 (XI1_I60_I9_Bn I1_b1_1 VSS VSS) gpdk090_nmos1v w=0.12u l=0.1u ad=0.0696p as=0.0696p pd=1.16u ps=1.16u
    I_MXI1_I60_I9_MN5 (XI1_I60_I9_n2 I1_b1_1 VSS VSS) gpdk090_nmos1v w=0.24u l=0.1u ad=0.0528p as=0.0816p pd=0.68u ps=1.16u
    I_MXI1_I60_I9_MN4 (I1_I60_pn1 XI1_I60_I9_An XI1_I60_I9_n2 VSS) gpdk090_nmos1v w=0.24u l=0.1u ad=0.0528p as=0.0528p pd=0.68u ps=0.68u
    I_MXI1_I60_I9_MN2 (XI1_I60_I9_n1 I1_p0_0 I1_I60_pn1 VSS) gpdk090_nmos1v w=0.24u l=0.1u ad=0.0528p as=0.0528p pd=0.68u ps=0.68u
    I_MXI1_I60_I9_MN3 (VSS XI1_I60_I9_Bn XI1_I60_I9_n1 VSS) gpdk090_nmos1v w=0.24u l=0.1u ad=0.0816p as=0.0528p pd=1.16u ps=0.68u
    I_MXI1_I60_I9_MN0 (XI1_I60_I9_An I1_p0_0 VSS VSS) gpdk090_nmos1v w=0.12u l=0.1u ad=0.0696p as=0.0696p pd=1.16u ps=1.16u
    I_MXI1_I48_I38_MN1 (XI1_I48_I38_Bn I1_I48_G0_0 VSS VSS) gpdk090_nmos1v w=0.12u l=0.1u ad=0.0696p as=0.0696p pd=1.16u ps=1.16u
    I_MXI1_I48_I38_MN5 (XI1_I48_I38_n2 I1_I48_G0_0 VSS VSS) gpdk090_nmos1v w=0.24u l=0.1u ad=0.0528p as=0.0816p pd=0.68u ps=1.16u
    I_MXI1_I48_I38_MN4 (I1_p0_1 XI1_I48_I38_An XI1_I48_I38_n2 VSS) gpdk090_nmos1v w=0.24u l=0.1u ad=0.0528p as=0.0528p pd=0.68u ps=0.68u
    I_MXI1_I48_I38_MN2 (XI1_I48_I38_n1 I1_I48_pn1 I1_p0_1 VSS) gpdk090_nmos1v w=0.24u l=0.1u ad=0.0528p as=0.0528p pd=0.68u ps=0.68u
    I_MXI1_I48_I38_MN3 (VSS XI1_I48_I38_Bn XI1_I48_I38_n1 VSS) gpdk090_nmos1v w=0.24u l=0.1u ad=0.0816p as=0.0528p pd=1.16u ps=0.68u
    I_MXI1_I48_I38_MN0 (XI1_I48_I38_An I1_I48_pn1 VSS VSS) gpdk090_nmos1v w=0.12u l=0.1u ad=0.0696p as=0.0696p pd=1.16u ps=1.16u
    I_MXI1_I60_I10_MN1 (XI1_I60_I10_Bn I1_b1_2 VSS VSS) gpdk090_nmos1v w=0.12u l=0.1u ad=0.0696p as=0.0696p pd=1.16u ps=1.16u
    I_MXI1_I60_I10_MN5 (XI1_I60_I10_n2 I1_b1_2 VSS VSS) gpdk090_nmos1v w=0.24u l=0.1u ad=0.0528p as=0.0816p pd=0.68u ps=1.16u
    I_MXI1_I60_I10_MN4 (I1_I60_pn2 XI1_I60_I10_An XI1_I60_I10_n2 VSS) gpdk090_nmos1v w=0.24u l=0.1u ad=0.0528p as=0.0528p pd=0.68u ps=0.68u
    I_MXI1_I60_I10_MN2 (XI1_I60_I10_n1 I1_p0_1 I1_I60_pn2 VSS) gpdk090_nmos1v w=0.24u l=0.1u ad=0.0528p as=0.0528p pd=0.68u ps=0.68u
    I_MXI1_I60_I10_MN3 (VSS XI1_I60_I10_Bn XI1_I60_I10_n1 VSS) gpdk090_nmos1v w=0.24u l=0.1u ad=0.0816p as=0.0528p pd=1.16u ps=0.68u
    I_MXI1_I60_I10_MN0 (XI1_I60_I10_An I1_p0_1 VSS VSS) gpdk090_nmos1v w=0.12u l=0.1u ad=0.0696p as=0.0696p pd=1.16u ps=1.16u
    I_MXI1_I48_I9_MN1 (XI1_I48_I9_Bn I1_b0_1 VSS VSS) gpdk090_nmos1v w=0.12u l=0.1u ad=0.0696p as=0.0696p pd=1.16u ps=1.16u
    I_MXI1_I48_I9_MN5 (XI1_I48_I9_n2 I1_b0_1 VSS VSS) gpdk090_nmos1v w=0.24u l=0.1u ad=0.0528p as=0.0816p pd=0.68u ps=1.16u
    I_MXI1_I48_I9_MN4 (I1_I48_pn1 XI1_I48_I9_An XI1_I48_I9_n2 VSS) gpdk090_nmos1v w=0.24u l=0.1u ad=0.0528p as=0.0528p pd=0.68u ps=0.68u
    I_MXI1_I48_I9_MN2 (XI1_I48_I9_n1 VSS I1_I48_pn1 VSS) gpdk090_nmos1v w=0.24u l=0.1u ad=0.0528p as=0.0528p pd=0.68u ps=0.68u
    I_MXI1_I48_I9_MN3 (VSS XI1_I48_I9_Bn XI1_I48_I9_n1 VSS) gpdk090_nmos1v w=0.24u l=0.1u ad=0.0816p as=0.0528p pd=1.16u ps=0.68u
    I_MXI1_I48_I9_MN0 (XI1_I48_I9_An VSS VSS VSS) gpdk090_nmos1v w=0.12u l=0.1u ad=0.0696p as=0.0696p pd=1.16u ps=1.16u
    I_MXI1_I48_I11_MN1 (XI1_I48_I11_Bn I1_b0_3 VSS VSS) gpdk090_nmos1v w=0.12u l=0.1u ad=0.0696p as=0.0696p pd=1.16u ps=1.16u
    I_MXI1_I48_I11_MN5 (XI1_I48_I11_n2 I1_b0_3 VSS VSS) gpdk090_nmos1v w=0.24u l=0.1u ad=0.0528p as=0.0816p pd=0.68u ps=1.16u
    I_MXI1_I48_I11_MN4 (I1_I48_pn3 XI1_I48_I11_An XI1_I48_I11_n2 VSS) gpdk090_nmos1v w=0.24u l=0.1u ad=0.0528p as=0.0528p pd=0.68u ps=0.68u
    I_MXI1_I48_I11_MN2 (XI1_I48_I11_n1 VSS I1_I48_pn3 VSS) gpdk090_nmos1v w=0.24u l=0.1u ad=0.0528p as=0.0528p pd=0.68u ps=0.68u
    I_MXI1_I48_I11_MN3 (VSS XI1_I48_I11_Bn XI1_I48_I11_n1 VSS) gpdk090_nmos1v w=0.24u l=0.1u ad=0.0816p as=0.0528p pd=1.16u ps=0.68u
    I_MXI1_I48_I11_MN0 (XI1_I48_I11_An VSS VSS VSS) gpdk090_nmos1v w=0.12u l=0.1u ad=0.0696p as=0.0696p pd=1.16u ps=1.16u
    I_MXI1_I108_I12_MN1 (XI1_I108_I12_Bn I1_b5_4 VSS VSS) gpdk090_nmos1v w=0.12u l=0.1u ad=0.0696p as=0.0696p pd=1.16u ps=1.16u
    I_MXI1_I108_I12_MN5 (XI1_I108_I12_n2 I1_b5_4 VSS VSS) gpdk090_nmos1v w=0.24u l=0.1u ad=0.0528p as=0.0816p pd=0.68u ps=1.16u
    I_MXI1_I108_I12_MN4 (I1_I108_pn4 XI1_I108_I12_An XI1_I108_I12_n2 VSS) gpdk090_nmos1v w=0.24u l=0.1u ad=0.0528p as=0.0528p pd=0.68u ps=0.68u
    I_MXI1_I108_I12_MN2 (XI1_I108_I12_n1 I1_p4_3 I1_I108_pn4 VSS) gpdk090_nmos1v w=0.24u l=0.1u ad=0.0528p as=0.0528p pd=0.68u ps=0.68u
    I_MXI1_I108_I12_MN3 (VSS XI1_I108_I12_Bn XI1_I108_I12_n1 VSS) gpdk090_nmos1v w=0.24u l=0.1u ad=0.0816p as=0.0528p pd=1.16u ps=0.68u
    I_MXI1_I108_I12_MN0 (XI1_I108_I12_An I1_p4_3 VSS VSS) gpdk090_nmos1v w=0.12u l=0.1u ad=0.0696p as=0.0696p pd=1.16u ps=1.16u
    I_MXI1_I96_I39_MN1 (XI1_I96_I39_Bn I1_I96_G1_0 VSS VSS) gpdk090_nmos1v w=0.12u l=0.1u ad=0.0696p as=0.0696p pd=1.16u ps=1.16u
    I_MXI1_I96_I39_MN5 (XI1_I96_I39_n2 I1_I96_G1_0 VSS VSS) gpdk090_nmos1v w=0.24u l=0.1u ad=0.0528p as=0.0816p pd=0.68u ps=1.16u
    I_MXI1_I96_I39_MN4 (I1_p4_2 XI1_I96_I39_An XI1_I96_I39_n2 VSS) gpdk090_nmos1v w=0.24u l=0.1u ad=0.0528p as=0.0528p pd=0.68u ps=0.68u
    I_MXI1_I96_I39_MN2 (XI1_I96_I39_n1 I1_I96_pn2 I1_p4_2 VSS) gpdk090_nmos1v w=0.24u l=0.1u ad=0.0528p as=0.0528p pd=0.68u ps=0.68u
    I_MXI1_I96_I39_MN3 (VSS XI1_I96_I39_Bn XI1_I96_I39_n1 VSS) gpdk090_nmos1v w=0.24u l=0.1u ad=0.0816p as=0.0528p pd=1.16u ps=0.68u
    I_MXI1_I96_I39_MN0 (XI1_I96_I39_An I1_I96_pn2 VSS VSS) gpdk090_nmos1v w=0.12u l=0.1u ad=0.0696p as=0.0696p pd=1.16u ps=1.16u
    I_MXI1_I96_I11_MN1 (XI1_I96_I11_Bn I1_b4_3 VSS VSS) gpdk090_nmos1v w=0.12u l=0.1u ad=0.0696p as=0.0696p pd=1.16u ps=1.16u
    I_MXI1_I96_I11_MN5 (XI1_I96_I11_n2 I1_b4_3 VSS VSS) gpdk090_nmos1v w=0.24u l=0.1u ad=0.0528p as=0.0816p pd=0.68u ps=1.16u
    I_MXI1_I96_I11_MN4 (I1_I96_pn3 XI1_I96_I11_An XI1_I96_I11_n2 VSS) gpdk090_nmos1v w=0.24u l=0.1u ad=0.0528p as=0.0528p pd=0.68u ps=0.68u
    I_MXI1_I96_I11_MN2 (XI1_I96_I11_n1 I1_p3_2 I1_I96_pn3 VSS) gpdk090_nmos1v w=0.24u l=0.1u ad=0.0528p as=0.0528p pd=0.68u ps=0.68u
    I_MXI1_I96_I11_MN3 (VSS XI1_I96_I11_Bn XI1_I96_I11_n1 VSS) gpdk090_nmos1v w=0.24u l=0.1u ad=0.0816p as=0.0528p pd=1.16u ps=0.68u
    I_MXI1_I96_I11_MN0 (XI1_I96_I11_An I1_p3_2 VSS VSS) gpdk090_nmos1v w=0.12u l=0.1u ad=0.0696p as=0.0696p pd=1.16u ps=1.16u
    I_MXI1_I84_I39_MN1 (XI1_I84_I39_Bn I1_I84_G1_0 VSS VSS) gpdk090_nmos1v w=0.12u l=0.1u ad=0.0696p as=0.0696p pd=1.16u ps=1.16u
    I_MXI1_I84_I39_MN5 (XI1_I84_I39_n2 I1_I84_G1_0 VSS VSS) gpdk090_nmos1v w=0.24u l=0.1u ad=0.0528p as=0.0816p pd=0.68u ps=1.16u
    I_MXI1_I84_I39_MN4 (I1_p3_2 XI1_I84_I39_An XI1_I84_I39_n2 VSS) gpdk090_nmos1v w=0.24u l=0.1u ad=0.0528p as=0.0528p pd=0.68u ps=0.68u
    I_MXI1_I84_I39_MN2 (XI1_I84_I39_n1 I1_I84_pn2 I1_p3_2 VSS) gpdk090_nmos1v w=0.24u l=0.1u ad=0.0528p as=0.0528p pd=0.68u ps=0.68u
    I_MXI1_I84_I39_MN3 (VSS XI1_I84_I39_Bn XI1_I84_I39_n1 VSS) gpdk090_nmos1v w=0.24u l=0.1u ad=0.0816p as=0.0528p pd=1.16u ps=0.68u
    I_MXI1_I84_I39_MN0 (XI1_I84_I39_An I1_I84_pn2 VSS VSS) gpdk090_nmos1v w=0.12u l=0.1u ad=0.0696p as=0.0696p pd=1.16u ps=1.16u
    I_MXI1_I84_I11_MN1 (XI1_I84_I11_Bn I1_b3_3 VSS VSS) gpdk090_nmos1v w=0.12u l=0.1u ad=0.0696p as=0.0696p pd=1.16u ps=1.16u
    I_MXI1_I84_I11_MN5 (XI1_I84_I11_n2 I1_b3_3 VSS VSS) gpdk090_nmos1v w=0.24u l=0.1u ad=0.0528p as=0.0816p pd=0.68u ps=1.16u
    I_MXI1_I84_I11_MN4 (I1_I84_pn3 XI1_I84_I11_An XI1_I84_I11_n2 VSS) gpdk090_nmos1v w=0.24u l=0.1u ad=0.0528p as=0.0528p pd=0.68u ps=0.68u
    I_MXI1_I84_I11_MN2 (XI1_I84_I11_n1 I1_p2_2 I1_I84_pn3 VSS) gpdk090_nmos1v w=0.24u l=0.1u ad=0.0528p as=0.0528p pd=0.68u ps=0.68u
    I_MXI1_I84_I11_MN3 (VSS XI1_I84_I11_Bn XI1_I84_I11_n1 VSS) gpdk090_nmos1v w=0.24u l=0.1u ad=0.0816p as=0.0528p pd=1.16u ps=0.68u
    I_MXI1_I84_I11_MN0 (XI1_I84_I11_An I1_p2_2 VSS VSS) gpdk090_nmos1v w=0.12u l=0.1u ad=0.0696p as=0.0696p pd=1.16u ps=1.16u
    I_MXI1_I72_I39_MN1 (XI1_I72_I39_Bn I1_I72_G1_0 VSS VSS) gpdk090_nmos1v w=0.12u l=0.1u ad=0.0696p as=0.0696p pd=1.16u ps=1.16u
    I_MXI1_I72_I39_MN5 (XI1_I72_I39_n2 I1_I72_G1_0 VSS VSS) gpdk090_nmos1v w=0.24u l=0.1u ad=0.0528p as=0.0816p pd=0.68u ps=1.16u
    I_MXI1_I72_I39_MN4 (I1_p2_2 XI1_I72_I39_An XI1_I72_I39_n2 VSS) gpdk090_nmos1v w=0.24u l=0.1u ad=0.0528p as=0.0528p pd=0.68u ps=0.68u
    I_MXI1_I72_I39_MN2 (XI1_I72_I39_n1 I1_I72_pn2 I1_p2_2 VSS) gpdk090_nmos1v w=0.24u l=0.1u ad=0.0528p as=0.0528p pd=0.68u ps=0.68u
    I_MXI1_I72_I39_MN3 (VSS XI1_I72_I39_Bn XI1_I72_I39_n1 VSS) gpdk090_nmos1v w=0.24u l=0.1u ad=0.0816p as=0.0528p pd=1.16u ps=0.68u
    I_MXI1_I72_I39_MN0 (XI1_I72_I39_An I1_I72_pn2 VSS VSS) gpdk090_nmos1v w=0.12u l=0.1u ad=0.0696p as=0.0696p pd=1.16u ps=1.16u
    I_MXI1_I72_I11_MN1 (XI1_I72_I11_Bn I1_b2_3 VSS VSS) gpdk090_nmos1v w=0.12u l=0.1u ad=0.0696p as=0.0696p pd=1.16u ps=1.16u
    I_MXI1_I72_I11_MN5 (XI1_I72_I11_n2 I1_b2_3 VSS VSS) gpdk090_nmos1v w=0.24u l=0.1u ad=0.0528p as=0.0816p pd=0.68u ps=1.16u
    I_MXI1_I72_I11_MN4 (I1_I72_pn3 XI1_I72_I11_An XI1_I72_I11_n2 VSS) gpdk090_nmos1v w=0.24u l=0.1u ad=0.0528p as=0.0528p pd=0.68u ps=0.68u
    I_MXI1_I72_I11_MN2 (XI1_I72_I11_n1 I1_p1_2 I1_I72_pn3 VSS) gpdk090_nmos1v w=0.24u l=0.1u ad=0.0528p as=0.0528p pd=0.68u ps=0.68u
    I_MXI1_I72_I11_MN3 (VSS XI1_I72_I11_Bn XI1_I72_I11_n1 VSS) gpdk090_nmos1v w=0.24u l=0.1u ad=0.0816p as=0.0528p pd=1.16u ps=0.68u
    I_MXI1_I72_I11_MN0 (XI1_I72_I11_An I1_p1_2 VSS VSS) gpdk090_nmos1v w=0.12u l=0.1u ad=0.0696p as=0.0696p pd=1.16u ps=1.16u
    I_MXI1_I60_I39_MN1 (XI1_I60_I39_Bn I1_I60_G1_0 VSS VSS) gpdk090_nmos1v w=0.12u l=0.1u ad=0.0696p as=0.0696p pd=1.16u ps=1.16u
    I_MXI1_I60_I39_MN5 (XI1_I60_I39_n2 I1_I60_G1_0 VSS VSS) gpdk090_nmos1v w=0.24u l=0.1u ad=0.0528p as=0.0816p pd=0.68u ps=1.16u
    I_MXI1_I60_I39_MN4 (I1_p1_2 XI1_I60_I39_An XI1_I60_I39_n2 VSS) gpdk090_nmos1v w=0.24u l=0.1u ad=0.0528p as=0.0528p pd=0.68u ps=0.68u
    I_MXI1_I60_I39_MN2 (XI1_I60_I39_n1 I1_I60_pn2 I1_p1_2 VSS) gpdk090_nmos1v w=0.24u l=0.1u ad=0.0528p as=0.0528p pd=0.68u ps=0.68u
    I_MXI1_I60_I39_MN3 (VSS XI1_I60_I39_Bn XI1_I60_I39_n1 VSS) gpdk090_nmos1v w=0.24u l=0.1u ad=0.0816p as=0.0528p pd=1.16u ps=0.68u
    I_MXI1_I60_I39_MN0 (XI1_I60_I39_An I1_I60_pn2 VSS VSS) gpdk090_nmos1v w=0.12u l=0.1u ad=0.0696p as=0.0696p pd=1.16u ps=1.16u
    I_MXI1_I60_I11_MN1 (XI1_I60_I11_Bn I1_b1_3 VSS VSS) gpdk090_nmos1v w=0.12u l=0.1u ad=0.0696p as=0.0696p pd=1.16u ps=1.16u
    I_MXI1_I60_I11_MN5 (XI1_I60_I11_n2 I1_b1_3 VSS VSS) gpdk090_nmos1v w=0.24u l=0.1u ad=0.0528p as=0.0816p pd=0.68u ps=1.16u
    I_MXI1_I60_I11_MN4 (I1_I60_pn3 XI1_I60_I11_An XI1_I60_I11_n2 VSS) gpdk090_nmos1v w=0.24u l=0.1u ad=0.0528p as=0.0528p pd=0.68u ps=0.68u
    I_MXI1_I60_I11_MN2 (XI1_I60_I11_n1 I1_p0_2 I1_I60_pn3 VSS) gpdk090_nmos1v w=0.24u l=0.1u ad=0.0528p as=0.0528p pd=0.68u ps=0.68u
    I_MXI1_I60_I11_MN3 (VSS XI1_I60_I11_Bn XI1_I60_I11_n1 VSS) gpdk090_nmos1v w=0.24u l=0.1u ad=0.0816p as=0.0528p pd=1.16u ps=0.68u
    I_MXI1_I60_I11_MN0 (XI1_I60_I11_An I1_p0_2 VSS VSS) gpdk090_nmos1v w=0.12u l=0.1u ad=0.0696p as=0.0696p pd=1.16u ps=1.16u
    I_MXI1_I48_I39_MN1 (XI1_I48_I39_Bn I1_I48_G1_0 VSS VSS) gpdk090_nmos1v w=0.12u l=0.1u ad=0.0696p as=0.0696p pd=1.16u ps=1.16u
    I_MXI1_I48_I39_MN5 (XI1_I48_I39_n2 I1_I48_G1_0 VSS VSS) gpdk090_nmos1v w=0.24u l=0.1u ad=0.0528p as=0.0816p pd=0.68u ps=1.16u
    I_MXI1_I48_I39_MN4 (I1_p0_2 XI1_I48_I39_An XI1_I48_I39_n2 VSS) gpdk090_nmos1v w=0.24u l=0.1u ad=0.0528p as=0.0528p pd=0.68u ps=0.68u
    I_MXI1_I48_I39_MN2 (XI1_I48_I39_n1 I1_I48_pn2 I1_p0_2 VSS) gpdk090_nmos1v w=0.24u l=0.1u ad=0.0528p as=0.0528p pd=0.68u ps=0.68u
    I_MXI1_I48_I39_MN3 (VSS XI1_I48_I39_Bn XI1_I48_I39_n1 VSS) gpdk090_nmos1v w=0.24u l=0.1u ad=0.0816p as=0.0528p pd=1.16u ps=0.68u
    I_MXI1_I48_I39_MN0 (XI1_I48_I39_An I1_I48_pn2 VSS VSS) gpdk090_nmos1v w=0.12u l=0.1u ad=0.0696p as=0.0696p pd=1.16u ps=1.16u
    I_MXI1_I48_I12_MN1 (XI1_I48_I12_Bn I1_b0_4 VSS VSS) gpdk090_nmos1v w=0.12u l=0.1u ad=0.0696p as=0.0696p pd=1.16u ps=1.16u
    I_MXI1_I48_I12_MN5 (XI1_I48_I12_n2 I1_b0_4 VSS VSS) gpdk090_nmos1v w=0.24u l=0.1u ad=0.0528p as=0.0816p pd=0.68u ps=1.16u
    I_MXI1_I48_I12_MN4 (I1_I48_pn4 XI1_I48_I12_An XI1_I48_I12_n2 VSS) gpdk090_nmos1v w=0.24u l=0.1u ad=0.0528p as=0.0528p pd=0.68u ps=0.68u
    I_MXI1_I48_I12_MN2 (XI1_I48_I12_n1 VSS I1_I48_pn4 VSS) gpdk090_nmos1v w=0.24u l=0.1u ad=0.0528p as=0.0528p pd=0.68u ps=0.68u
    I_MXI1_I48_I12_MN3 (VSS XI1_I48_I12_Bn XI1_I48_I12_n1 VSS) gpdk090_nmos1v w=0.24u l=0.1u ad=0.0816p as=0.0528p pd=1.16u ps=0.68u
    I_MXI1_I48_I12_MN0 (XI1_I48_I12_An VSS VSS VSS) gpdk090_nmos1v w=0.12u l=0.1u ad=0.0696p as=0.0696p pd=1.16u ps=1.16u
    I_MXI1_I108_I13_MN1 (XI1_I108_I13_Bn I1_b5_5 VSS VSS) gpdk090_nmos1v w=0.12u l=0.1u ad=0.0696p as=0.0696p pd=1.16u ps=1.16u
    I_MXI1_I108_I13_MN5 (XI1_I108_I13_n2 I1_b5_5 VSS VSS) gpdk090_nmos1v w=0.24u l=0.1u ad=0.0528p as=0.0816p pd=0.68u ps=1.16u
    I_MXI1_I108_I13_MN4 (I1_I108_pn5 XI1_I108_I13_An XI1_I108_I13_n2 VSS) gpdk090_nmos1v w=0.24u l=0.1u ad=0.0528p as=0.0528p pd=0.68u ps=0.68u
    I_MXI1_I108_I13_MN2 (XI1_I108_I13_n1 I1_p4_4 I1_I108_pn5 VSS) gpdk090_nmos1v w=0.24u l=0.1u ad=0.0528p as=0.0528p pd=0.68u ps=0.68u
    I_MXI1_I108_I13_MN3 (VSS XI1_I108_I13_Bn XI1_I108_I13_n1 VSS) gpdk090_nmos1v w=0.24u l=0.1u ad=0.0816p as=0.0528p pd=1.16u ps=0.68u
    I_MXI1_I108_I13_MN0 (XI1_I108_I13_An I1_p4_4 VSS VSS) gpdk090_nmos1v w=0.12u l=0.1u ad=0.0696p as=0.0696p pd=1.16u ps=1.16u
    I_MXI1_I96_I12_MN1 (XI1_I96_I12_Bn I1_b4_4 VSS VSS) gpdk090_nmos1v w=0.12u l=0.1u ad=0.0696p as=0.0696p pd=1.16u ps=1.16u
    I_MXI1_I96_I12_MN5 (XI1_I96_I12_n2 I1_b4_4 VSS VSS) gpdk090_nmos1v w=0.24u l=0.1u ad=0.0528p as=0.0816p pd=0.68u ps=1.16u
    I_MXI1_I96_I12_MN4 (I1_I96_pn4 XI1_I96_I12_An XI1_I96_I12_n2 VSS) gpdk090_nmos1v w=0.24u l=0.1u ad=0.0528p as=0.0528p pd=0.68u ps=0.68u
    I_MXI1_I96_I12_MN2 (XI1_I96_I12_n1 I1_p3_3 I1_I96_pn4 VSS) gpdk090_nmos1v w=0.24u l=0.1u ad=0.0528p as=0.0528p pd=0.68u ps=0.68u
    I_MXI1_I96_I12_MN3 (VSS XI1_I96_I12_Bn XI1_I96_I12_n1 VSS) gpdk090_nmos1v w=0.24u l=0.1u ad=0.0816p as=0.0528p pd=1.16u ps=0.68u
    I_MXI1_I96_I12_MN0 (XI1_I96_I12_An I1_p3_3 VSS VSS) gpdk090_nmos1v w=0.12u l=0.1u ad=0.0696p as=0.0696p pd=1.16u ps=1.16u
    I_MXI1_I84_I12_MN1 (XI1_I84_I12_Bn I1_b3_4 VSS VSS) gpdk090_nmos1v w=0.12u l=0.1u ad=0.0696p as=0.0696p pd=1.16u ps=1.16u
    I_MXI1_I84_I12_MN5 (XI1_I84_I12_n2 I1_b3_4 VSS VSS) gpdk090_nmos1v w=0.24u l=0.1u ad=0.0528p as=0.0816p pd=0.68u ps=1.16u
    I_MXI1_I84_I12_MN4 (I1_I84_pn4 XI1_I84_I12_An XI1_I84_I12_n2 VSS) gpdk090_nmos1v w=0.24u l=0.1u ad=0.0528p as=0.0528p pd=0.68u ps=0.68u
    I_MXI1_I84_I12_MN2 (XI1_I84_I12_n1 I1_p2_3 I1_I84_pn4 VSS) gpdk090_nmos1v w=0.24u l=0.1u ad=0.0528p as=0.0528p pd=0.68u ps=0.68u
    I_MXI1_I84_I12_MN3 (VSS XI1_I84_I12_Bn XI1_I84_I12_n1 VSS) gpdk090_nmos1v w=0.24u l=0.1u ad=0.0816p as=0.0528p pd=1.16u ps=0.68u
    I_MXI1_I84_I12_MN0 (XI1_I84_I12_An I1_p2_3 VSS VSS) gpdk090_nmos1v w=0.12u l=0.1u ad=0.0696p as=0.0696p pd=1.16u ps=1.16u
    I_MXI1_I72_I12_MN1 (XI1_I72_I12_Bn I1_b2_4 VSS VSS) gpdk090_nmos1v w=0.12u l=0.1u ad=0.0696p as=0.0696p pd=1.16u ps=1.16u
    I_MXI1_I72_I12_MN5 (XI1_I72_I12_n2 I1_b2_4 VSS VSS) gpdk090_nmos1v w=0.24u l=0.1u ad=0.0528p as=0.0816p pd=0.68u ps=1.16u
    I_MXI1_I72_I12_MN4 (I1_I72_pn4 XI1_I72_I12_An XI1_I72_I12_n2 VSS) gpdk090_nmos1v w=0.24u l=0.1u ad=0.0528p as=0.0528p pd=0.68u ps=0.68u
    I_MXI1_I72_I12_MN2 (XI1_I72_I12_n1 I1_p1_3 I1_I72_pn4 VSS) gpdk090_nmos1v w=0.24u l=0.1u ad=0.0528p as=0.0528p pd=0.68u ps=0.68u
    I_MXI1_I72_I12_MN3 (VSS XI1_I72_I12_Bn XI1_I72_I12_n1 VSS) gpdk090_nmos1v w=0.24u l=0.1u ad=0.0816p as=0.0528p pd=1.16u ps=0.68u
    I_MXI1_I72_I12_MN0 (XI1_I72_I12_An I1_p1_3 VSS VSS) gpdk090_nmos1v w=0.12u l=0.1u ad=0.0696p as=0.0696p pd=1.16u ps=1.16u
    I_MXI1_I60_I12_MN1 (XI1_I60_I12_Bn I1_b1_4 VSS VSS) gpdk090_nmos1v w=0.12u l=0.1u ad=0.0696p as=0.0696p pd=1.16u ps=1.16u
    I_MXI1_I60_I12_MN5 (XI1_I60_I12_n2 I1_b1_4 VSS VSS) gpdk090_nmos1v w=0.24u l=0.1u ad=0.0528p as=0.0816p pd=0.68u ps=1.16u
    I_MXI1_I60_I12_MN4 (I1_I60_pn4 XI1_I60_I12_An XI1_I60_I12_n2 VSS) gpdk090_nmos1v w=0.24u l=0.1u ad=0.0528p as=0.0528p pd=0.68u ps=0.68u
    I_MXI1_I60_I12_MN2 (XI1_I60_I12_n1 I1_p0_3 I1_I60_pn4 VSS) gpdk090_nmos1v w=0.24u l=0.1u ad=0.0528p as=0.0528p pd=0.68u ps=0.68u
    I_MXI1_I60_I12_MN3 (VSS XI1_I60_I12_Bn XI1_I60_I12_n1 VSS) gpdk090_nmos1v w=0.24u l=0.1u ad=0.0816p as=0.0528p pd=1.16u ps=0.68u
    I_MXI1_I60_I12_MN0 (XI1_I60_I12_An I1_p0_3 VSS VSS) gpdk090_nmos1v w=0.12u l=0.1u ad=0.0696p as=0.0696p pd=1.16u ps=1.16u
    I_MXI1_I48_I42_MN1 (XI1_I48_I42_Bn I1_I48_G4_0 VSS VSS) gpdk090_nmos1v w=0.12u l=0.1u ad=0.0696p as=0.0696p pd=1.16u ps=1.16u
    I_MXI1_I48_I42_MN5 (XI1_I48_I42_n2 I1_I48_G4_0 VSS VSS) gpdk090_nmos1v w=0.24u l=0.1u ad=0.0528p as=0.0816p pd=0.68u ps=1.16u
    I_MXI1_I48_I42_MN4 (I1_p0_5 XI1_I48_I42_An XI1_I48_I42_n2 VSS) gpdk090_nmos1v w=0.24u l=0.1u ad=0.0528p as=0.0528p pd=0.68u ps=0.68u
    I_MXI1_I48_I42_MN2 (XI1_I48_I42_n1 I1_I48_pn5 I1_p0_5 VSS) gpdk090_nmos1v w=0.24u l=0.1u ad=0.0528p as=0.0528p pd=0.68u ps=0.68u
    I_MXI1_I48_I42_MN3 (VSS XI1_I48_I42_Bn XI1_I48_I42_n1 VSS) gpdk090_nmos1v w=0.24u l=0.1u ad=0.0816p as=0.0528p pd=1.16u ps=0.68u
    I_MXI1_I48_I42_MN0 (XI1_I48_I42_An I1_I48_pn5 VSS VSS) gpdk090_nmos1v w=0.12u l=0.1u ad=0.0696p as=0.0696p pd=1.16u ps=1.16u
    I_MXI1_I108_I14_MN1 (XI1_I108_I14_Bn I1_b5_6 VSS VSS) gpdk090_nmos1v w=0.12u l=0.1u ad=0.0696p as=0.0696p pd=1.16u ps=1.16u
    I_MXI1_I108_I14_MN5 (XI1_I108_I14_n2 I1_b5_6 VSS VSS) gpdk090_nmos1v w=0.24u l=0.1u ad=0.0528p as=0.0816p pd=0.68u ps=1.16u
    I_MXI1_I108_I14_MN4 (I1_I108_pn6 XI1_I108_I14_An XI1_I108_I14_n2 VSS) gpdk090_nmos1v w=0.24u l=0.1u ad=0.0528p as=0.0528p pd=0.68u ps=0.68u
    I_MXI1_I108_I14_MN2 (XI1_I108_I14_n1 I1_p4_5 I1_I108_pn6 VSS) gpdk090_nmos1v w=0.24u l=0.1u ad=0.0528p as=0.0528p pd=0.68u ps=0.68u
    I_MXI1_I108_I14_MN3 (VSS XI1_I108_I14_Bn XI1_I108_I14_n1 VSS) gpdk090_nmos1v w=0.24u l=0.1u ad=0.0816p as=0.0528p pd=1.16u ps=0.68u
    I_MXI1_I108_I14_MN0 (XI1_I108_I14_An I1_p4_5 VSS VSS) gpdk090_nmos1v w=0.12u l=0.1u ad=0.0696p as=0.0696p pd=1.16u ps=1.16u
    I_MXI1_I96_I42_MN1 (XI1_I96_I42_Bn I1_I96_G4_0 VSS VSS) gpdk090_nmos1v w=0.12u l=0.1u ad=0.0696p as=0.0696p pd=1.16u ps=1.16u
    I_MXI1_I96_I42_MN5 (XI1_I96_I42_n2 I1_I96_G4_0 VSS VSS) gpdk090_nmos1v w=0.24u l=0.1u ad=0.0528p as=0.0816p pd=0.68u ps=1.16u
    I_MXI1_I96_I42_MN4 (I1_p4_5 XI1_I96_I42_An XI1_I96_I42_n2 VSS) gpdk090_nmos1v w=0.24u l=0.1u ad=0.0528p as=0.0528p pd=0.68u ps=0.68u
    I_MXI1_I96_I42_MN2 (XI1_I96_I42_n1 I1_I96_pn5 I1_p4_5 VSS) gpdk090_nmos1v w=0.24u l=0.1u ad=0.0528p as=0.0528p pd=0.68u ps=0.68u
    I_MXI1_I96_I42_MN3 (VSS XI1_I96_I42_Bn XI1_I96_I42_n1 VSS) gpdk090_nmos1v w=0.24u l=0.1u ad=0.0816p as=0.0528p pd=1.16u ps=0.68u
    I_MXI1_I96_I42_MN0 (XI1_I96_I42_An I1_I96_pn5 VSS VSS) gpdk090_nmos1v w=0.12u l=0.1u ad=0.0696p as=0.0696p pd=1.16u ps=1.16u
    I_MXI1_I96_I13_MN1 (XI1_I96_I13_Bn I1_b4_5 VSS VSS) gpdk090_nmos1v w=0.12u l=0.1u ad=0.0696p as=0.0696p pd=1.16u ps=1.16u
    I_MXI1_I96_I13_MN5 (XI1_I96_I13_n2 I1_b4_5 VSS VSS) gpdk090_nmos1v w=0.24u l=0.1u ad=0.0528p as=0.0816p pd=0.68u ps=1.16u
    I_MXI1_I96_I13_MN4 (I1_I96_pn5 XI1_I96_I13_An XI1_I96_I13_n2 VSS) gpdk090_nmos1v w=0.24u l=0.1u ad=0.0528p as=0.0528p pd=0.68u ps=0.68u
    I_MXI1_I96_I13_MN2 (XI1_I96_I13_n1 I1_p3_4 I1_I96_pn5 VSS) gpdk090_nmos1v w=0.24u l=0.1u ad=0.0528p as=0.0528p pd=0.68u ps=0.68u
    I_MXI1_I96_I13_MN3 (VSS XI1_I96_I13_Bn XI1_I96_I13_n1 VSS) gpdk090_nmos1v w=0.24u l=0.1u ad=0.0816p as=0.0528p pd=1.16u ps=0.68u
    I_MXI1_I96_I13_MN0 (XI1_I96_I13_An I1_p3_4 VSS VSS) gpdk090_nmos1v w=0.12u l=0.1u ad=0.0696p as=0.0696p pd=1.16u ps=1.16u
    I_MXI1_I84_I42_MN1 (XI1_I84_I42_Bn I1_I84_G4_0 VSS VSS) gpdk090_nmos1v w=0.12u l=0.1u ad=0.0696p as=0.0696p pd=1.16u ps=1.16u
    I_MXI1_I84_I42_MN5 (XI1_I84_I42_n2 I1_I84_G4_0 VSS VSS) gpdk090_nmos1v w=0.24u l=0.1u ad=0.0528p as=0.0816p pd=0.68u ps=1.16u
    I_MXI1_I84_I42_MN4 (I1_p3_5 XI1_I84_I42_An XI1_I84_I42_n2 VSS) gpdk090_nmos1v w=0.24u l=0.1u ad=0.0528p as=0.0528p pd=0.68u ps=0.68u
    I_MXI1_I84_I42_MN2 (XI1_I84_I42_n1 I1_I84_pn5 I1_p3_5 VSS) gpdk090_nmos1v w=0.24u l=0.1u ad=0.0528p as=0.0528p pd=0.68u ps=0.68u
    I_MXI1_I84_I42_MN3 (VSS XI1_I84_I42_Bn XI1_I84_I42_n1 VSS) gpdk090_nmos1v w=0.24u l=0.1u ad=0.0816p as=0.0528p pd=1.16u ps=0.68u
    I_MXI1_I84_I42_MN0 (XI1_I84_I42_An I1_I84_pn5 VSS VSS) gpdk090_nmos1v w=0.12u l=0.1u ad=0.0696p as=0.0696p pd=1.16u ps=1.16u
    I_MXI1_I84_I13_MN1 (XI1_I84_I13_Bn I1_b3_5 VSS VSS) gpdk090_nmos1v w=0.12u l=0.1u ad=0.0696p as=0.0696p pd=1.16u ps=1.16u
    I_MXI1_I84_I13_MN5 (XI1_I84_I13_n2 I1_b3_5 VSS VSS) gpdk090_nmos1v w=0.24u l=0.1u ad=0.0528p as=0.0816p pd=0.68u ps=1.16u
    I_MXI1_I84_I13_MN4 (I1_I84_pn5 XI1_I84_I13_An XI1_I84_I13_n2 VSS) gpdk090_nmos1v w=0.24u l=0.1u ad=0.0528p as=0.0528p pd=0.68u ps=0.68u
    I_MXI1_I84_I13_MN2 (XI1_I84_I13_n1 I1_p2_4 I1_I84_pn5 VSS) gpdk090_nmos1v w=0.24u l=0.1u ad=0.0528p as=0.0528p pd=0.68u ps=0.68u
    I_MXI1_I84_I13_MN3 (VSS XI1_I84_I13_Bn XI1_I84_I13_n1 VSS) gpdk090_nmos1v w=0.24u l=0.1u ad=0.0816p as=0.0528p pd=1.16u ps=0.68u
    I_MXI1_I84_I13_MN0 (XI1_I84_I13_An I1_p2_4 VSS VSS) gpdk090_nmos1v w=0.12u l=0.1u ad=0.0696p as=0.0696p pd=1.16u ps=1.16u
    I_MXI1_I72_I42_MN1 (XI1_I72_I42_Bn I1_I72_G4_0 VSS VSS) gpdk090_nmos1v w=0.12u l=0.1u ad=0.0696p as=0.0696p pd=1.16u ps=1.16u
    I_MXI1_I72_I42_MN5 (XI1_I72_I42_n2 I1_I72_G4_0 VSS VSS) gpdk090_nmos1v w=0.24u l=0.1u ad=0.0528p as=0.0816p pd=0.68u ps=1.16u
    I_MXI1_I72_I42_MN4 (I1_p2_5 XI1_I72_I42_An XI1_I72_I42_n2 VSS) gpdk090_nmos1v w=0.24u l=0.1u ad=0.0528p as=0.0528p pd=0.68u ps=0.68u
    I_MXI1_I72_I42_MN2 (XI1_I72_I42_n1 I1_I72_pn5 I1_p2_5 VSS) gpdk090_nmos1v w=0.24u l=0.1u ad=0.0528p as=0.0528p pd=0.68u ps=0.68u
    I_MXI1_I72_I42_MN3 (VSS XI1_I72_I42_Bn XI1_I72_I42_n1 VSS) gpdk090_nmos1v w=0.24u l=0.1u ad=0.0816p as=0.0528p pd=1.16u ps=0.68u
    I_MXI1_I72_I42_MN0 (XI1_I72_I42_An I1_I72_pn5 VSS VSS) gpdk090_nmos1v w=0.12u l=0.1u ad=0.0696p as=0.0696p pd=1.16u ps=1.16u
    I_MXI1_I72_I13_MN1 (XI1_I72_I13_Bn I1_b2_5 VSS VSS) gpdk090_nmos1v w=0.12u l=0.1u ad=0.0696p as=0.0696p pd=1.16u ps=1.16u
    I_MXI1_I72_I13_MN5 (XI1_I72_I13_n2 I1_b2_5 VSS VSS) gpdk090_nmos1v w=0.24u l=0.1u ad=0.0528p as=0.0816p pd=0.68u ps=1.16u
    I_MXI1_I72_I13_MN4 (I1_I72_pn5 XI1_I72_I13_An XI1_I72_I13_n2 VSS) gpdk090_nmos1v w=0.24u l=0.1u ad=0.0528p as=0.0528p pd=0.68u ps=0.68u
    I_MXI1_I72_I13_MN2 (XI1_I72_I13_n1 I1_p1_4 I1_I72_pn5 VSS) gpdk090_nmos1v w=0.24u l=0.1u ad=0.0528p as=0.0528p pd=0.68u ps=0.68u
    I_MXI1_I72_I13_MN3 (VSS XI1_I72_I13_Bn XI1_I72_I13_n1 VSS) gpdk090_nmos1v w=0.24u l=0.1u ad=0.0816p as=0.0528p pd=1.16u ps=0.68u
    I_MXI1_I72_I13_MN0 (XI1_I72_I13_An I1_p1_4 VSS VSS) gpdk090_nmos1v w=0.12u l=0.1u ad=0.0696p as=0.0696p pd=1.16u ps=1.16u
    I_MXI1_I60_I42_MN1 (XI1_I60_I42_Bn I1_I60_G4_0 VSS VSS) gpdk090_nmos1v w=0.12u l=0.1u ad=0.0696p as=0.0696p pd=1.16u ps=1.16u
    I_MXI1_I60_I42_MN5 (XI1_I60_I42_n2 I1_I60_G4_0 VSS VSS) gpdk090_nmos1v w=0.24u l=0.1u ad=0.0528p as=0.0816p pd=0.68u ps=1.16u
    I_MXI1_I60_I42_MN4 (I1_p1_5 XI1_I60_I42_An XI1_I60_I42_n2 VSS) gpdk090_nmos1v w=0.24u l=0.1u ad=0.0528p as=0.0528p pd=0.68u ps=0.68u
    I_MXI1_I60_I42_MN2 (XI1_I60_I42_n1 I1_I60_pn5 I1_p1_5 VSS) gpdk090_nmos1v w=0.24u l=0.1u ad=0.0528p as=0.0528p pd=0.68u ps=0.68u
    I_MXI1_I60_I42_MN3 (VSS XI1_I60_I42_Bn XI1_I60_I42_n1 VSS) gpdk090_nmos1v w=0.24u l=0.1u ad=0.0816p as=0.0528p pd=1.16u ps=0.68u
    I_MXI1_I60_I42_MN0 (XI1_I60_I42_An I1_I60_pn5 VSS VSS) gpdk090_nmos1v w=0.12u l=0.1u ad=0.0696p as=0.0696p pd=1.16u ps=1.16u
    I_MXI1_I60_I13_MN1 (XI1_I60_I13_Bn I1_b1_5 VSS VSS) gpdk090_nmos1v w=0.12u l=0.1u ad=0.0696p as=0.0696p pd=1.16u ps=1.16u
    I_MXI1_I60_I13_MN5 (XI1_I60_I13_n2 I1_b1_5 VSS VSS) gpdk090_nmos1v w=0.24u l=0.1u ad=0.0528p as=0.0816p pd=0.68u ps=1.16u
    I_MXI1_I60_I13_MN4 (I1_I60_pn5 XI1_I60_I13_An XI1_I60_I13_n2 VSS) gpdk090_nmos1v w=0.24u l=0.1u ad=0.0528p as=0.0528p pd=0.68u ps=0.68u
    I_MXI1_I60_I13_MN2 (XI1_I60_I13_n1 I1_p0_4 I1_I60_pn5 VSS) gpdk090_nmos1v w=0.24u l=0.1u ad=0.0528p as=0.0528p pd=0.68u ps=0.68u
    I_MXI1_I60_I13_MN3 (VSS XI1_I60_I13_Bn XI1_I60_I13_n1 VSS) gpdk090_nmos1v w=0.24u l=0.1u ad=0.0816p as=0.0528p pd=1.16u ps=0.68u
    I_MXI1_I60_I13_MN0 (XI1_I60_I13_An I1_p0_4 VSS VSS) gpdk090_nmos1v w=0.12u l=0.1u ad=0.0696p as=0.0696p pd=1.16u ps=1.16u
    I_MXI1_I48_I13_MN1 (XI1_I48_I13_Bn I1_b0_5 VSS VSS) gpdk090_nmos1v w=0.12u l=0.1u ad=0.0696p as=0.0696p pd=1.16u ps=1.16u
    I_MXI1_I48_I13_MN5 (XI1_I48_I13_n2 I1_b0_5 VSS VSS) gpdk090_nmos1v w=0.24u l=0.1u ad=0.0528p as=0.0816p pd=0.68u ps=1.16u
    I_MXI1_I48_I13_MN4 (I1_I48_pn5 XI1_I48_I13_An XI1_I48_I13_n2 VSS) gpdk090_nmos1v w=0.24u l=0.1u ad=0.0528p as=0.0528p pd=0.68u ps=0.68u
    I_MXI1_I48_I13_MN2 (XI1_I48_I13_n1 VSS I1_I48_pn5 VSS) gpdk090_nmos1v w=0.24u l=0.1u ad=0.0528p as=0.0528p pd=0.68u ps=0.68u
    I_MXI1_I48_I13_MN3 (VSS XI1_I48_I13_Bn XI1_I48_I13_n1 VSS) gpdk090_nmos1v w=0.24u l=0.1u ad=0.0816p as=0.0528p pd=1.16u ps=0.68u
    I_MXI1_I48_I13_MN0 (XI1_I48_I13_An VSS VSS VSS) gpdk090_nmos1v w=0.12u l=0.1u ad=0.0696p as=0.0696p pd=1.16u ps=1.16u
    I_MXI1_I48_I14_MN1 (XI1_I48_I14_Bn I1_b0_6 VSS VSS) gpdk090_nmos1v w=0.12u l=0.1u ad=0.0696p as=0.0696p pd=1.16u ps=1.16u
    I_MXI1_I48_I14_MN5 (XI1_I48_I14_n2 I1_b0_6 VSS VSS) gpdk090_nmos1v w=0.24u l=0.1u ad=0.0528p as=0.0816p pd=0.68u ps=1.16u
    I_MXI1_I48_I14_MN4 (I1_I48_pn6 XI1_I48_I14_An XI1_I48_I14_n2 VSS) gpdk090_nmos1v w=0.24u l=0.1u ad=0.0528p as=0.0528p pd=0.68u ps=0.68u
    I_MXI1_I48_I14_MN2 (XI1_I48_I14_n1 VSS I1_I48_pn6 VSS) gpdk090_nmos1v w=0.24u l=0.1u ad=0.0528p as=0.0528p pd=0.68u ps=0.68u
    I_MXI1_I48_I14_MN3 (VSS XI1_I48_I14_Bn XI1_I48_I14_n1 VSS) gpdk090_nmos1v w=0.24u l=0.1u ad=0.0816p as=0.0528p pd=1.16u ps=0.68u
    I_MXI1_I48_I14_MN0 (XI1_I48_I14_An VSS VSS VSS) gpdk090_nmos1v w=0.12u l=0.1u ad=0.0696p as=0.0696p pd=1.16u ps=1.16u
    I_MXI1_I48_I43_MN1 (XI1_I48_I43_Bn I1_I48_G5_0 VSS VSS) gpdk090_nmos1v w=0.12u l=0.1u ad=0.0696p as=0.0696p pd=1.16u ps=1.16u
    I_MXI1_I48_I43_MN5 (XI1_I48_I43_n2 I1_I48_G5_0 VSS VSS) gpdk090_nmos1v w=0.24u l=0.1u ad=0.0528p as=0.0816p pd=0.68u ps=1.16u
    I_MXI1_I48_I43_MN4 (I1_p0_6 XI1_I48_I43_An XI1_I48_I43_n2 VSS) gpdk090_nmos1v w=0.24u l=0.1u ad=0.0528p as=0.0528p pd=0.68u ps=0.68u
    I_MXI1_I48_I43_MN2 (XI1_I48_I43_n1 I1_I48_pn6 I1_p0_6 VSS) gpdk090_nmos1v w=0.24u l=0.1u ad=0.0528p as=0.0528p pd=0.68u ps=0.68u
    I_MXI1_I48_I43_MN3 (VSS XI1_I48_I43_Bn XI1_I48_I43_n1 VSS) gpdk090_nmos1v w=0.24u l=0.1u ad=0.0816p as=0.0528p pd=1.16u ps=0.68u
    I_MXI1_I48_I43_MN0 (XI1_I48_I43_An I1_I48_pn6 VSS VSS) gpdk090_nmos1v w=0.12u l=0.1u ad=0.0696p as=0.0696p pd=1.16u ps=1.16u
    I_MXI1_I108_I15_MN1 (XI1_I108_I15_Bn I1_b5_7 VSS VSS) gpdk090_nmos1v w=0.12u l=0.1u ad=0.0696p as=0.0696p pd=1.16u ps=1.16u
    I_MXI1_I108_I15_MN5 (XI1_I108_I15_n2 I1_b5_7 VSS VSS) gpdk090_nmos1v w=0.24u l=0.1u ad=0.0528p as=0.0816p pd=0.68u ps=1.16u
    I_MXI1_I108_I15_MN4 (I1_I108_pn7 XI1_I108_I15_An XI1_I108_I15_n2 VSS) gpdk090_nmos1v w=0.24u l=0.1u ad=0.0528p as=0.0528p pd=0.68u ps=0.68u
    I_MXI1_I108_I15_MN2 (XI1_I108_I15_n1 I1_p4_6 I1_I108_pn7 VSS) gpdk090_nmos1v w=0.24u l=0.1u ad=0.0528p as=0.0528p pd=0.68u ps=0.68u
    I_MXI1_I108_I15_MN3 (VSS XI1_I108_I15_Bn XI1_I108_I15_n1 VSS) gpdk090_nmos1v w=0.24u l=0.1u ad=0.0816p as=0.0528p pd=1.16u ps=0.68u
    I_MXI1_I108_I15_MN0 (XI1_I108_I15_An I1_p4_6 VSS VSS) gpdk090_nmos1v w=0.12u l=0.1u ad=0.0696p as=0.0696p pd=1.16u ps=1.16u
    I_MXI1_I96_I43_MN1 (XI1_I96_I43_Bn I1_I96_G5_0 VSS VSS) gpdk090_nmos1v w=0.12u l=0.1u ad=0.0696p as=0.0696p pd=1.16u ps=1.16u
    I_MXI1_I96_I43_MN5 (XI1_I96_I43_n2 I1_I96_G5_0 VSS VSS) gpdk090_nmos1v w=0.24u l=0.1u ad=0.0528p as=0.0816p pd=0.68u ps=1.16u
    I_MXI1_I96_I43_MN4 (I1_p4_6 XI1_I96_I43_An XI1_I96_I43_n2 VSS) gpdk090_nmos1v w=0.24u l=0.1u ad=0.0528p as=0.0528p pd=0.68u ps=0.68u
    I_MXI1_I96_I43_MN2 (XI1_I96_I43_n1 I1_I96_pn6 I1_p4_6 VSS) gpdk090_nmos1v w=0.24u l=0.1u ad=0.0528p as=0.0528p pd=0.68u ps=0.68u
    I_MXI1_I96_I43_MN3 (VSS XI1_I96_I43_Bn XI1_I96_I43_n1 VSS) gpdk090_nmos1v w=0.24u l=0.1u ad=0.0816p as=0.0528p pd=1.16u ps=0.68u
    I_MXI1_I96_I43_MN0 (XI1_I96_I43_An I1_I96_pn6 VSS VSS) gpdk090_nmos1v w=0.12u l=0.1u ad=0.0696p as=0.0696p pd=1.16u ps=1.16u
    I_MXI1_I96_I44_MN1 (XI1_I96_I44_Bn I1_c4_7 VSS VSS) gpdk090_nmos1v w=0.12u l=0.1u ad=0.0696p as=0.0696p pd=1.16u ps=1.16u
    I_MXI1_I96_I44_MN5 (XI1_I96_I44_n2 I1_c4_7 VSS VSS) gpdk090_nmos1v w=0.24u l=0.1u ad=0.0528p as=0.0816p pd=0.68u ps=1.16u
    I_MXI1_I96_I44_MN4 (I1_p4_7 XI1_I96_I44_An XI1_I96_I44_n2 VSS) gpdk090_nmos1v w=0.24u l=0.1u ad=0.0528p as=0.0528p pd=0.68u ps=0.68u
    I_MXI1_I96_I44_MN2 (XI1_I96_I44_n1 I1_I96_pn7 I1_p4_7 VSS) gpdk090_nmos1v w=0.24u l=0.1u ad=0.0528p as=0.0528p pd=0.68u ps=0.68u
    I_MXI1_I96_I44_MN3 (VSS XI1_I96_I44_Bn XI1_I96_I44_n1 VSS) gpdk090_nmos1v w=0.24u l=0.1u ad=0.0816p as=0.0528p pd=1.16u ps=0.68u
    I_MXI1_I96_I44_MN0 (XI1_I96_I44_An I1_I96_pn7 VSS VSS) gpdk090_nmos1v w=0.12u l=0.1u ad=0.0696p as=0.0696p pd=1.16u ps=1.16u
    I_MXI1_I96_I14_MN1 (XI1_I96_I14_Bn I1_b4_6 VSS VSS) gpdk090_nmos1v w=0.12u l=0.1u ad=0.0696p as=0.0696p pd=1.16u ps=1.16u
    I_MXI1_I96_I14_MN5 (XI1_I96_I14_n2 I1_b4_6 VSS VSS) gpdk090_nmos1v w=0.24u l=0.1u ad=0.0528p as=0.0816p pd=0.68u ps=1.16u
    I_MXI1_I96_I14_MN4 (I1_I96_pn6 XI1_I96_I14_An XI1_I96_I14_n2 VSS) gpdk090_nmos1v w=0.24u l=0.1u ad=0.0528p as=0.0528p pd=0.68u ps=0.68u
    I_MXI1_I96_I14_MN2 (XI1_I96_I14_n1 I1_p3_5 I1_I96_pn6 VSS) gpdk090_nmos1v w=0.24u l=0.1u ad=0.0528p as=0.0528p pd=0.68u ps=0.68u
    I_MXI1_I96_I14_MN3 (VSS XI1_I96_I14_Bn XI1_I96_I14_n1 VSS) gpdk090_nmos1v w=0.24u l=0.1u ad=0.0816p as=0.0528p pd=1.16u ps=0.68u
    I_MXI1_I96_I14_MN0 (XI1_I96_I14_An I1_p3_5 VSS VSS) gpdk090_nmos1v w=0.12u l=0.1u ad=0.0696p as=0.0696p pd=1.16u ps=1.16u
    I_MXI1_I84_I43_MN1 (XI1_I84_I43_Bn I1_I84_G5_0 VSS VSS) gpdk090_nmos1v w=0.12u l=0.1u ad=0.0696p as=0.0696p pd=1.16u ps=1.16u
    I_MXI1_I84_I43_MN5 (XI1_I84_I43_n2 I1_I84_G5_0 VSS VSS) gpdk090_nmos1v w=0.24u l=0.1u ad=0.0528p as=0.0816p pd=0.68u ps=1.16u
    I_MXI1_I84_I43_MN4 (I1_p3_6 XI1_I84_I43_An XI1_I84_I43_n2 VSS) gpdk090_nmos1v w=0.24u l=0.1u ad=0.0528p as=0.0528p pd=0.68u ps=0.68u
    I_MXI1_I84_I43_MN2 (XI1_I84_I43_n1 I1_I84_pn6 I1_p3_6 VSS) gpdk090_nmos1v w=0.24u l=0.1u ad=0.0528p as=0.0528p pd=0.68u ps=0.68u
    I_MXI1_I84_I43_MN3 (VSS XI1_I84_I43_Bn XI1_I84_I43_n1 VSS) gpdk090_nmos1v w=0.24u l=0.1u ad=0.0816p as=0.0528p pd=1.16u ps=0.68u
    I_MXI1_I84_I43_MN0 (XI1_I84_I43_An I1_I84_pn6 VSS VSS) gpdk090_nmos1v w=0.12u l=0.1u ad=0.0696p as=0.0696p pd=1.16u ps=1.16u
    I_MXI1_I84_I14_MN1 (XI1_I84_I14_Bn I1_b3_6 VSS VSS) gpdk090_nmos1v w=0.12u l=0.1u ad=0.0696p as=0.0696p pd=1.16u ps=1.16u
    I_MXI1_I84_I14_MN5 (XI1_I84_I14_n2 I1_b3_6 VSS VSS) gpdk090_nmos1v w=0.24u l=0.1u ad=0.0528p as=0.0816p pd=0.68u ps=1.16u
    I_MXI1_I84_I14_MN4 (I1_I84_pn6 XI1_I84_I14_An XI1_I84_I14_n2 VSS) gpdk090_nmos1v w=0.24u l=0.1u ad=0.0528p as=0.0528p pd=0.68u ps=0.68u
    I_MXI1_I84_I14_MN2 (XI1_I84_I14_n1 I1_p2_5 I1_I84_pn6 VSS) gpdk090_nmos1v w=0.24u l=0.1u ad=0.0528p as=0.0528p pd=0.68u ps=0.68u
    I_MXI1_I84_I14_MN3 (VSS XI1_I84_I14_Bn XI1_I84_I14_n1 VSS) gpdk090_nmos1v w=0.24u l=0.1u ad=0.0816p as=0.0528p pd=1.16u ps=0.68u
    I_MXI1_I84_I14_MN0 (XI1_I84_I14_An I1_p2_5 VSS VSS) gpdk090_nmos1v w=0.12u l=0.1u ad=0.0696p as=0.0696p pd=1.16u ps=1.16u
    I_MXI1_I72_I44_MN1 (XI1_I72_I44_Bn I1_c2_7 VSS VSS) gpdk090_nmos1v w=0.12u l=0.1u ad=0.0696p as=0.0696p pd=1.16u ps=1.16u
    I_MXI1_I72_I44_MN5 (XI1_I72_I44_n2 I1_c2_7 VSS VSS) gpdk090_nmos1v w=0.24u l=0.1u ad=0.0528p as=0.0816p pd=0.68u ps=1.16u
    I_MXI1_I72_I44_MN4 (I1_p2_7 XI1_I72_I44_An XI1_I72_I44_n2 VSS) gpdk090_nmos1v w=0.24u l=0.1u ad=0.0528p as=0.0528p pd=0.68u ps=0.68u
    I_MXI1_I72_I44_MN2 (XI1_I72_I44_n1 I1_I72_pn7 I1_p2_7 VSS) gpdk090_nmos1v w=0.24u l=0.1u ad=0.0528p as=0.0528p pd=0.68u ps=0.68u
    I_MXI1_I72_I44_MN3 (VSS XI1_I72_I44_Bn XI1_I72_I44_n1 VSS) gpdk090_nmos1v w=0.24u l=0.1u ad=0.0816p as=0.0528p pd=1.16u ps=0.68u
    I_MXI1_I72_I44_MN0 (XI1_I72_I44_An I1_I72_pn7 VSS VSS) gpdk090_nmos1v w=0.12u l=0.1u ad=0.0696p as=0.0696p pd=1.16u ps=1.16u
    I_MXI1_I72_I14_MN1 (XI1_I72_I14_Bn I1_b2_6 VSS VSS) gpdk090_nmos1v w=0.12u l=0.1u ad=0.0696p as=0.0696p pd=1.16u ps=1.16u
    I_MXI1_I72_I14_MN5 (XI1_I72_I14_n2 I1_b2_6 VSS VSS) gpdk090_nmos1v w=0.24u l=0.1u ad=0.0528p as=0.0816p pd=0.68u ps=1.16u
    I_MXI1_I72_I14_MN4 (I1_I72_pn6 XI1_I72_I14_An XI1_I72_I14_n2 VSS) gpdk090_nmos1v w=0.24u l=0.1u ad=0.0528p as=0.0528p pd=0.68u ps=0.68u
    I_MXI1_I72_I14_MN2 (XI1_I72_I14_n1 I1_p1_5 I1_I72_pn6 VSS) gpdk090_nmos1v w=0.24u l=0.1u ad=0.0528p as=0.0528p pd=0.68u ps=0.68u
    I_MXI1_I72_I14_MN3 (VSS XI1_I72_I14_Bn XI1_I72_I14_n1 VSS) gpdk090_nmos1v w=0.24u l=0.1u ad=0.0816p as=0.0528p pd=1.16u ps=0.68u
    I_MXI1_I72_I14_MN0 (XI1_I72_I14_An I1_p1_5 VSS VSS) gpdk090_nmos1v w=0.12u l=0.1u ad=0.0696p as=0.0696p pd=1.16u ps=1.16u
    I_MXI1_I60_I43_MN1 (XI1_I60_I43_Bn I1_I60_G5_0 VSS VSS) gpdk090_nmos1v w=0.12u l=0.1u ad=0.0696p as=0.0696p pd=1.16u ps=1.16u
    I_MXI1_I60_I43_MN5 (XI1_I60_I43_n2 I1_I60_G5_0 VSS VSS) gpdk090_nmos1v w=0.24u l=0.1u ad=0.0528p as=0.0816p pd=0.68u ps=1.16u
    I_MXI1_I60_I43_MN4 (I1_p1_6 XI1_I60_I43_An XI1_I60_I43_n2 VSS) gpdk090_nmos1v w=0.24u l=0.1u ad=0.0528p as=0.0528p pd=0.68u ps=0.68u
    I_MXI1_I60_I43_MN2 (XI1_I60_I43_n1 I1_I60_pn6 I1_p1_6 VSS) gpdk090_nmos1v w=0.24u l=0.1u ad=0.0528p as=0.0528p pd=0.68u ps=0.68u
    I_MXI1_I60_I43_MN3 (VSS XI1_I60_I43_Bn XI1_I60_I43_n1 VSS) gpdk090_nmos1v w=0.24u l=0.1u ad=0.0816p as=0.0528p pd=1.16u ps=0.68u
    I_MXI1_I60_I43_MN0 (XI1_I60_I43_An I1_I60_pn6 VSS VSS) gpdk090_nmos1v w=0.12u l=0.1u ad=0.0696p as=0.0696p pd=1.16u ps=1.16u
    I_MXI1_I60_I14_MN1 (XI1_I60_I14_Bn I1_b1_6 VSS VSS) gpdk090_nmos1v w=0.12u l=0.1u ad=0.0696p as=0.0696p pd=1.16u ps=1.16u
    I_MXI1_I60_I14_MN5 (XI1_I60_I14_n2 I1_b1_6 VSS VSS) gpdk090_nmos1v w=0.24u l=0.1u ad=0.0528p as=0.0816p pd=0.68u ps=1.16u
    I_MXI1_I60_I14_MN4 (I1_I60_pn6 XI1_I60_I14_An XI1_I60_I14_n2 VSS) gpdk090_nmos1v w=0.24u l=0.1u ad=0.0528p as=0.0528p pd=0.68u ps=0.68u
    I_MXI1_I60_I14_MN2 (XI1_I60_I14_n1 I1_p0_5 I1_I60_pn6 VSS) gpdk090_nmos1v w=0.24u l=0.1u ad=0.0528p as=0.0528p pd=0.68u ps=0.68u
    I_MXI1_I60_I14_MN3 (VSS XI1_I60_I14_Bn XI1_I60_I14_n1 VSS) gpdk090_nmos1v w=0.24u l=0.1u ad=0.0816p as=0.0528p pd=1.16u ps=0.68u
    I_MXI1_I60_I14_MN0 (XI1_I60_I14_An I1_p0_5 VSS VSS) gpdk090_nmos1v w=0.12u l=0.1u ad=0.0696p as=0.0696p pd=1.16u ps=1.16u
    I_MXI1_I48_I44_MN1 (XI1_I48_I44_Bn I1_c0_7 VSS VSS) gpdk090_nmos1v w=0.12u l=0.1u ad=0.0696p as=0.0696p pd=1.16u ps=1.16u
    I_MXI1_I48_I44_MN5 (XI1_I48_I44_n2 I1_c0_7 VSS VSS) gpdk090_nmos1v w=0.24u l=0.1u ad=0.0528p as=0.0816p pd=0.68u ps=1.16u
    I_MXI1_I48_I44_MN4 (I1_p0_7 XI1_I48_I44_An XI1_I48_I44_n2 VSS) gpdk090_nmos1v w=0.24u l=0.1u ad=0.0528p as=0.0528p pd=0.68u ps=0.68u
    I_MXI1_I48_I44_MN2 (XI1_I48_I44_n1 I1_I48_pn7 I1_p0_7 VSS) gpdk090_nmos1v w=0.24u l=0.1u ad=0.0528p as=0.0528p pd=0.68u ps=0.68u
    I_MXI1_I48_I44_MN3 (VSS XI1_I48_I44_Bn XI1_I48_I44_n1 VSS) gpdk090_nmos1v w=0.24u l=0.1u ad=0.0816p as=0.0528p pd=1.16u ps=0.68u
    I_MXI1_I48_I44_MN0 (XI1_I48_I44_An I1_I48_pn7 VSS VSS) gpdk090_nmos1v w=0.12u l=0.1u ad=0.0696p as=0.0696p pd=1.16u ps=1.16u
    I_MXI1_I96_I15_MN1 (XI1_I96_I15_Bn I1_b4_7 VSS VSS) gpdk090_nmos1v w=0.12u l=0.1u ad=0.0696p as=0.0696p pd=1.16u ps=1.16u
    I_MXI1_I96_I15_MN5 (XI1_I96_I15_n2 I1_b4_7 VSS VSS) gpdk090_nmos1v w=0.24u l=0.1u ad=0.0528p as=0.0816p pd=0.68u ps=1.16u
    I_MXI1_I96_I15_MN4 (I1_I96_pn7 XI1_I96_I15_An XI1_I96_I15_n2 VSS) gpdk090_nmos1v w=0.24u l=0.1u ad=0.0528p as=0.0528p pd=0.68u ps=0.68u
    I_MXI1_I96_I15_MN2 (XI1_I96_I15_n1 I1_p3_6 I1_I96_pn7 VSS) gpdk090_nmos1v w=0.24u l=0.1u ad=0.0528p as=0.0528p pd=0.68u ps=0.68u
    I_MXI1_I96_I15_MN3 (VSS XI1_I96_I15_Bn XI1_I96_I15_n1 VSS) gpdk090_nmos1v w=0.24u l=0.1u ad=0.0816p as=0.0528p pd=1.16u ps=0.68u
    I_MXI1_I96_I15_MN0 (XI1_I96_I15_An I1_p3_6 VSS VSS) gpdk090_nmos1v w=0.12u l=0.1u ad=0.0696p as=0.0696p pd=1.16u ps=1.16u
    I_MXI1_I84_I44_MN1 (XI1_I84_I44_Bn I1_c3_7 VSS VSS) gpdk090_nmos1v w=0.12u l=0.1u ad=0.0696p as=0.0696p pd=1.16u ps=1.16u
    I_MXI1_I84_I44_MN5 (XI1_I84_I44_n2 I1_c3_7 VSS VSS) gpdk090_nmos1v w=0.24u l=0.1u ad=0.0528p as=0.0816p pd=0.68u ps=1.16u
    I_MXI1_I84_I44_MN4 (I1_p3_7 XI1_I84_I44_An XI1_I84_I44_n2 VSS) gpdk090_nmos1v w=0.24u l=0.1u ad=0.0528p as=0.0528p pd=0.68u ps=0.68u
    I_MXI1_I84_I44_MN2 (XI1_I84_I44_n1 I1_I84_pn7 I1_p3_7 VSS) gpdk090_nmos1v w=0.24u l=0.1u ad=0.0528p as=0.0528p pd=0.68u ps=0.68u
    I_MXI1_I84_I44_MN3 (VSS XI1_I84_I44_Bn XI1_I84_I44_n1 VSS) gpdk090_nmos1v w=0.24u l=0.1u ad=0.0816p as=0.0528p pd=1.16u ps=0.68u
    I_MXI1_I84_I44_MN0 (XI1_I84_I44_An I1_I84_pn7 VSS VSS) gpdk090_nmos1v w=0.12u l=0.1u ad=0.0696p as=0.0696p pd=1.16u ps=1.16u
    I_MXI1_I84_I15_MN1 (XI1_I84_I15_Bn I1_b3_7 VSS VSS) gpdk090_nmos1v w=0.12u l=0.1u ad=0.0696p as=0.0696p pd=1.16u ps=1.16u
    I_MXI1_I84_I15_MN5 (XI1_I84_I15_n2 I1_b3_7 VSS VSS) gpdk090_nmos1v w=0.24u l=0.1u ad=0.0528p as=0.0816p pd=0.68u ps=1.16u
    I_MXI1_I84_I15_MN4 (I1_I84_pn7 XI1_I84_I15_An XI1_I84_I15_n2 VSS) gpdk090_nmos1v w=0.24u l=0.1u ad=0.0528p as=0.0528p pd=0.68u ps=0.68u
    I_MXI1_I84_I15_MN2 (XI1_I84_I15_n1 I1_p2_6 I1_I84_pn7 VSS) gpdk090_nmos1v w=0.24u l=0.1u ad=0.0528p as=0.0528p pd=0.68u ps=0.68u
    I_MXI1_I84_I15_MN3 (VSS XI1_I84_I15_Bn XI1_I84_I15_n1 VSS) gpdk090_nmos1v w=0.24u l=0.1u ad=0.0816p as=0.0528p pd=1.16u ps=0.68u
    I_MXI1_I84_I15_MN0 (XI1_I84_I15_An I1_p2_6 VSS VSS) gpdk090_nmos1v w=0.12u l=0.1u ad=0.0696p as=0.0696p pd=1.16u ps=1.16u
    I_MXI1_I72_I43_MN1 (XI1_I72_I43_Bn I1_I72_G5_0 VSS VSS) gpdk090_nmos1v w=0.12u l=0.1u ad=0.0696p as=0.0696p pd=1.16u ps=1.16u
    I_MXI1_I72_I43_MN5 (XI1_I72_I43_n2 I1_I72_G5_0 VSS VSS) gpdk090_nmos1v w=0.24u l=0.1u ad=0.0528p as=0.0816p pd=0.68u ps=1.16u
    I_MXI1_I72_I43_MN4 (I1_p2_6 XI1_I72_I43_An XI1_I72_I43_n2 VSS) gpdk090_nmos1v w=0.24u l=0.1u ad=0.0528p as=0.0528p pd=0.68u ps=0.68u
    I_MXI1_I72_I43_MN2 (XI1_I72_I43_n1 I1_I72_pn6 I1_p2_6 VSS) gpdk090_nmos1v w=0.24u l=0.1u ad=0.0528p as=0.0528p pd=0.68u ps=0.68u
    I_MXI1_I72_I43_MN3 (VSS XI1_I72_I43_Bn XI1_I72_I43_n1 VSS) gpdk090_nmos1v w=0.24u l=0.1u ad=0.0816p as=0.0528p pd=1.16u ps=0.68u
    I_MXI1_I72_I43_MN0 (XI1_I72_I43_An I1_I72_pn6 VSS VSS) gpdk090_nmos1v w=0.12u l=0.1u ad=0.0696p as=0.0696p pd=1.16u ps=1.16u
    I_MXI1_I72_I15_MN1 (XI1_I72_I15_Bn I1_b2_7 VSS VSS) gpdk090_nmos1v w=0.12u l=0.1u ad=0.0696p as=0.0696p pd=1.16u ps=1.16u
    I_MXI1_I72_I15_MN5 (XI1_I72_I15_n2 I1_b2_7 VSS VSS) gpdk090_nmos1v w=0.24u l=0.1u ad=0.0528p as=0.0816p pd=0.68u ps=1.16u
    I_MXI1_I72_I15_MN4 (I1_I72_pn7 XI1_I72_I15_An XI1_I72_I15_n2 VSS) gpdk090_nmos1v w=0.24u l=0.1u ad=0.0528p as=0.0528p pd=0.68u ps=0.68u
    I_MXI1_I72_I15_MN2 (XI1_I72_I15_n1 I1_p1_6 I1_I72_pn7 VSS) gpdk090_nmos1v w=0.24u l=0.1u ad=0.0528p as=0.0528p pd=0.68u ps=0.68u
    I_MXI1_I72_I15_MN3 (VSS XI1_I72_I15_Bn XI1_I72_I15_n1 VSS) gpdk090_nmos1v w=0.24u l=0.1u ad=0.0816p as=0.0528p pd=1.16u ps=0.68u
    I_MXI1_I72_I15_MN0 (XI1_I72_I15_An I1_p1_6 VSS VSS) gpdk090_nmos1v w=0.12u l=0.1u ad=0.0696p as=0.0696p pd=1.16u ps=1.16u
    I_MXI1_I60_I44_MN1 (XI1_I60_I44_Bn I1_c1_7 VSS VSS) gpdk090_nmos1v w=0.12u l=0.1u ad=0.0696p as=0.0696p pd=1.16u ps=1.16u
    I_MXI1_I60_I44_MN5 (XI1_I60_I44_n2 I1_c1_7 VSS VSS) gpdk090_nmos1v w=0.24u l=0.1u ad=0.0528p as=0.0816p pd=0.68u ps=1.16u
    I_MXI1_I60_I44_MN4 (I1_p1_7 XI1_I60_I44_An XI1_I60_I44_n2 VSS) gpdk090_nmos1v w=0.24u l=0.1u ad=0.0528p as=0.0528p pd=0.68u ps=0.68u
    I_MXI1_I60_I44_MN2 (XI1_I60_I44_n1 I1_I60_pn7 I1_p1_7 VSS) gpdk090_nmos1v w=0.24u l=0.1u ad=0.0528p as=0.0528p pd=0.68u ps=0.68u
    I_MXI1_I60_I44_MN3 (VSS XI1_I60_I44_Bn XI1_I60_I44_n1 VSS) gpdk090_nmos1v w=0.24u l=0.1u ad=0.0816p as=0.0528p pd=1.16u ps=0.68u
    I_MXI1_I60_I44_MN0 (XI1_I60_I44_An I1_I60_pn7 VSS VSS) gpdk090_nmos1v w=0.12u l=0.1u ad=0.0696p as=0.0696p pd=1.16u ps=1.16u
    I_MXI1_I60_I15_MN1 (XI1_I60_I15_Bn I1_b1_7 VSS VSS) gpdk090_nmos1v w=0.12u l=0.1u ad=0.0696p as=0.0696p pd=1.16u ps=1.16u
    I_MXI1_I60_I15_MN5 (XI1_I60_I15_n2 I1_b1_7 VSS VSS) gpdk090_nmos1v w=0.24u l=0.1u ad=0.0528p as=0.0816p pd=0.68u ps=1.16u
    I_MXI1_I60_I15_MN4 (I1_I60_pn7 XI1_I60_I15_An XI1_I60_I15_n2 VSS) gpdk090_nmos1v w=0.24u l=0.1u ad=0.0528p as=0.0528p pd=0.68u ps=0.68u
    I_MXI1_I60_I15_MN2 (XI1_I60_I15_n1 I1_p0_6 I1_I60_pn7 VSS) gpdk090_nmos1v w=0.24u l=0.1u ad=0.0528p as=0.0528p pd=0.68u ps=0.68u
    I_MXI1_I60_I15_MN3 (VSS XI1_I60_I15_Bn XI1_I60_I15_n1 VSS) gpdk090_nmos1v w=0.24u l=0.1u ad=0.0816p as=0.0528p pd=1.16u ps=0.68u
    I_MXI1_I60_I15_MN0 (XI1_I60_I15_An I1_p0_6 VSS VSS) gpdk090_nmos1v w=0.12u l=0.1u ad=0.0696p as=0.0696p pd=1.16u ps=1.16u
    I_MXI1_I48_I15_MN1 (XI1_I48_I15_Bn I1_b0_7 VSS VSS) gpdk090_nmos1v w=0.12u l=0.1u ad=0.0696p as=0.0696p pd=1.16u ps=1.16u
    I_MXI1_I48_I15_MN5 (XI1_I48_I15_n2 I1_b0_7 VSS VSS) gpdk090_nmos1v w=0.24u l=0.1u ad=0.0528p as=0.0816p pd=0.68u ps=1.16u
    I_MXI1_I48_I15_MN4 (I1_I48_pn7 XI1_I48_I15_An XI1_I48_I15_n2 VSS) gpdk090_nmos1v w=0.24u l=0.1u ad=0.0528p as=0.0528p pd=0.68u ps=0.68u
    I_MXI1_I48_I15_MN2 (XI1_I48_I15_n1 VSS I1_I48_pn7 VSS) gpdk090_nmos1v w=0.24u l=0.1u ad=0.0528p as=0.0528p pd=0.68u ps=0.68u
    I_MXI1_I48_I15_MN3 (VSS XI1_I48_I15_Bn XI1_I48_I15_n1 VSS) gpdk090_nmos1v w=0.24u l=0.1u ad=0.0816p as=0.0528p pd=1.16u ps=0.68u
    I_MXI1_I48_I15_MN0 (XI1_I48_I15_An VSS VSS VSS) gpdk090_nmos1v w=0.12u l=0.1u ad=0.0696p as=0.0696p pd=1.16u ps=1.16u
    I_MXI1_I123_MN1 (I1_qu1 I1_p6_8 VSS VSS) gpdk090_nmos1v w=0.24u l=0.1u ad=0.0528p as=0.0816p pd=0.68u ps=1.16u
    I_MXI1_I123_MN1_1 (VSS I1_p6_8 I1_qu1 VSS) gpdk090_nmos1v w=0.24u l=0.1u ad=0.0816p as=0.0528p pd=1.16u ps=0.68u
    I_MXI1_I111_MN1 (I1_qu2 I1_p5_8 VSS VSS) gpdk090_nmos1v w=0.24u l=0.1u ad=0.0528p as=0.0816p pd=0.68u ps=1.16u
    I_MXI1_I111_MN1_1 (VSS I1_p5_8 I1_qu2 VSS) gpdk090_nmos1v w=0.24u l=0.1u ad=0.0816p as=0.0528p pd=1.16u ps=0.68u
    I_MXI1_I99_MN1 (I1_qu3 I1_p4_8 VSS VSS) gpdk090_nmos1v w=0.24u l=0.1u ad=0.0528p as=0.0816p pd=0.68u ps=1.16u
    I_MXI1_I99_MN1_1 (VSS I1_p4_8 I1_qu3 VSS) gpdk090_nmos1v w=0.24u l=0.1u ad=0.0816p as=0.0528p pd=1.16u ps=0.68u
    I_MXI1_I51_MN1 (I1_qu7 I1_p0_8 VSS VSS) gpdk090_nmos1v w=0.24u l=0.1u ad=0.0528p as=0.0816p pd=0.68u ps=1.16u
    I_MXI1_I51_MN1_1 (VSS I1_p0_8 I1_qu7 VSS) gpdk090_nmos1v w=0.24u l=0.1u ad=0.0816p as=0.0528p pd=1.16u ps=0.68u
    I_MXI1_I87_MN1 (I1_qu4 I1_p3_8 VSS VSS) gpdk090_nmos1v w=0.24u l=0.1u ad=0.0528p as=0.0816p pd=0.68u ps=1.16u
    I_MXI1_I87_MN1_1 (VSS I1_p3_8 I1_qu4 VSS) gpdk090_nmos1v w=0.24u l=0.1u ad=0.0816p as=0.0528p pd=1.16u ps=0.68u
    I_MXI1_I75_MN1 (I1_qu5 I1_p2_8 VSS VSS) gpdk090_nmos1v w=0.24u l=0.1u ad=0.0528p as=0.0816p pd=0.68u ps=1.16u
    I_MXI1_I75_MN1_1 (VSS I1_p2_8 I1_qu5 VSS) gpdk090_nmos1v w=0.24u l=0.1u ad=0.0816p as=0.0528p pd=1.16u ps=0.68u
    I_MXI1_I63_MN1 (I1_qu6 I1_p1_8 VSS VSS) gpdk090_nmos1v w=0.24u l=0.1u ad=0.0528p as=0.0816p pd=0.68u ps=1.16u
    I_MXI1_I63_MN1_1 (VSS I1_p1_8 I1_qu6 VSS) gpdk090_nmos1v w=0.24u l=0.1u ad=0.0816p as=0.0528p pd=1.16u ps=0.68u
    I_MXI0_I68_MN5 (I0_ha25_0 I0_ha13_1 XI0_I68_xn1 VSS) gpdk090_nmos1v w=0.24u l=0.1u ad=0.0528p as=0.0816p pd=0.68u ps=1.16u
    I_MXI0_I68_MN7 (XI0_I68_xn2 XI0_I68_xan I0_ha25_0 VSS) gpdk090_nmos1v w=0.24u l=0.1u ad=0.0528p as=0.0528p pd=0.68u ps=0.68u
    I_MXI0_I68_MN8 (VSS XI0_I68_xbn XI0_I68_xn2 VSS) gpdk090_nmos1v w=0.24u l=0.1u ad=0.0528p as=0.0528p pd=0.68u ps=0.68u
    I_MXI0_I68_MN6 (XI0_I68_xn1 I0_sn3 VSS VSS) gpdk090_nmos1v w=0.24u l=0.1u ad=0.0816p as=0.0528p pd=1.16u ps=0.68u
    I_MXI0_I68_MN1 (VSS I0_ha13_1 XI0_I68_xan VSS) gpdk090_nmos1v w=0.12u l=0.1u ad=0.0468p as=0.0696p pd=0.68u ps=1.16u
    I_MXI0_I68_MN14 (XI0_I68_an I0_sn3 VSS VSS) gpdk090_nmos1v w=0.24u l=0.1u ad=0.0528p as=0.0468p pd=0.68u ps=0.68u
    I_MXI0_I68_MN13 (XI0_I68_con I0_ha13_1 XI0_I68_an VSS) gpdk090_nmos1v w=0.24u l=0.1u ad=0.0816p as=0.0528p pd=1.16u ps=0.68u
    I_MXI0_I68_MN17 (I0_ha25_1 XI0_I68_con VSS VSS) gpdk090_nmos1v w=0.12u l=0.1u ad=0.0696p as=0.0696p pd=1.16u ps=1.16u
    I_MXI0_I68_MN3 (VSS I0_sn3 XI0_I68_xbn VSS) gpdk090_nmos1v w=0.12u l=0.1u ad=0.0696p as=0.0696p pd=1.16u ps=1.16u
    I_MXI0_I65_MN5 (I0_ha22_0 I0_cm10_1 XI0_I65_xn1 VSS) gpdk090_nmos1v w=0.24u l=0.1u ad=0.0528p as=0.0816p pd=0.68u ps=1.16u
    I_MXI0_I65_MN7 (XI0_I65_xn2 XI0_I65_xan I0_ha22_0 VSS) gpdk090_nmos1v w=0.24u l=0.1u ad=0.0528p as=0.0528p pd=0.68u ps=0.68u
    I_MXI0_I65_MN8 (VSS XI0_I65_xbn XI0_I65_xn2 VSS) gpdk090_nmos1v w=0.24u l=0.1u ad=0.0528p as=0.0528p pd=0.68u ps=0.68u
    I_MXI0_I65_MN6 (XI0_I65_xn1 I0_cm11_0 VSS VSS) gpdk090_nmos1v w=0.24u l=0.1u ad=0.0816p as=0.0528p pd=1.16u ps=0.68u
    I_MXI0_I65_MN1 (VSS I0_cm10_1 XI0_I65_xan VSS) gpdk090_nmos1v w=0.12u l=0.1u ad=0.0468p as=0.0696p pd=0.68u ps=1.16u
    I_MXI0_I65_MN14 (XI0_I65_an I0_cm11_0 VSS VSS) gpdk090_nmos1v w=0.24u l=0.1u ad=0.0528p as=0.0468p pd=0.68u ps=0.68u
    I_MXI0_I65_MN13 (XI0_I65_con I0_cm10_1 XI0_I65_an VSS) gpdk090_nmos1v w=0.24u l=0.1u ad=0.0816p as=0.0528p pd=1.16u ps=0.68u
    I_MXI0_I65_MN17 (I0_ha22_1 XI0_I65_con VSS VSS) gpdk090_nmos1v w=0.12u l=0.1u ad=0.0696p as=0.0696p pd=1.16u ps=1.16u
    I_MXI0_I65_MN3 (VSS I0_cm11_0 XI0_I65_xbn VSS) gpdk090_nmos1v w=0.12u l=0.1u ad=0.0696p as=0.0696p pd=1.16u ps=1.16u
    I_MXI0_I66_MN5 (I0_ha23_0 I0_cm11_1 XI0_I66_xn1 VSS) gpdk090_nmos1v w=0.24u l=0.1u ad=0.0528p as=0.0816p pd=0.68u ps=1.16u
    I_MXI0_I66_MN7 (XI0_I66_xn2 XI0_I66_xan I0_ha23_0 VSS) gpdk090_nmos1v w=0.24u l=0.1u ad=0.0528p as=0.0528p pd=0.68u ps=0.68u
    I_MXI0_I66_MN8 (VSS XI0_I66_xbn XI0_I66_xn2 VSS) gpdk090_nmos1v w=0.24u l=0.1u ad=0.0528p as=0.0528p pd=0.68u ps=0.68u
    I_MXI0_I66_MN6 (XI0_I66_xn1 I0_fa12_0 VSS VSS) gpdk090_nmos1v w=0.24u l=0.1u ad=0.0816p as=0.0528p pd=1.16u ps=0.68u
    I_MXI0_I66_MN1 (VSS I0_cm11_1 XI0_I66_xan VSS) gpdk090_nmos1v w=0.12u l=0.1u ad=0.0468p as=0.0696p pd=0.68u ps=1.16u
    I_MXI0_I66_MN14 (XI0_I66_an I0_fa12_0 VSS VSS) gpdk090_nmos1v w=0.24u l=0.1u ad=0.0528p as=0.0468p pd=0.68u ps=0.68u
    I_MXI0_I66_MN13 (XI0_I66_con I0_cm11_1 XI0_I66_an VSS) gpdk090_nmos1v w=0.24u l=0.1u ad=0.0816p as=0.0528p pd=1.16u ps=0.68u
    I_MXI0_I66_MN17 (I0_ha23_1 XI0_I66_con VSS VSS) gpdk090_nmos1v w=0.12u l=0.1u ad=0.0696p as=0.0696p pd=1.16u ps=1.16u
    I_MXI0_I66_MN3 (VSS I0_fa12_0 XI0_I66_xbn VSS) gpdk090_nmos1v w=0.12u l=0.1u ad=0.0696p as=0.0696p pd=1.16u ps=1.16u
    I_MXI0_I67_MN5 (I0_ha24_0 I0_fa12_1 XI0_I67_xn1 VSS) gpdk090_nmos1v w=0.24u l=0.1u ad=0.0528p as=0.0816p pd=0.68u ps=1.16u
    I_MXI0_I67_MN7 (XI0_I67_xn2 XI0_I67_xan I0_ha24_0 VSS) gpdk090_nmos1v w=0.24u l=0.1u ad=0.0528p as=0.0528p pd=0.68u ps=0.68u
    I_MXI0_I67_MN8 (VSS XI0_I67_xbn XI0_I67_xn2 VSS) gpdk090_nmos1v w=0.24u l=0.1u ad=0.0528p as=0.0528p pd=0.68u ps=0.68u
    I_MXI0_I67_MN6 (XI0_I67_xn1 I0_ha13_0 VSS VSS) gpdk090_nmos1v w=0.24u l=0.1u ad=0.0816p as=0.0528p pd=1.16u ps=0.68u
    I_MXI0_I67_MN1 (VSS I0_fa12_1 XI0_I67_xan VSS) gpdk090_nmos1v w=0.12u l=0.1u ad=0.0468p as=0.0696p pd=0.68u ps=1.16u
    I_MXI0_I67_MN14 (XI0_I67_an I0_ha13_0 VSS VSS) gpdk090_nmos1v w=0.24u l=0.1u ad=0.0528p as=0.0468p pd=0.68u ps=0.68u
    I_MXI0_I67_MN13 (XI0_I67_con I0_fa12_1 XI0_I67_an VSS) gpdk090_nmos1v w=0.24u l=0.1u ad=0.0816p as=0.0528p pd=1.16u ps=0.68u
    I_MXI0_I67_MN17 (I0_ha24_1 XI0_I67_con VSS VSS) gpdk090_nmos1v w=0.12u l=0.1u ad=0.0696p as=0.0696p pd=1.16u ps=1.16u
    I_MXI0_I67_MN3 (VSS I0_ha13_0 XI0_I67_xbn VSS) gpdk090_nmos1v w=0.12u l=0.1u ad=0.0696p as=0.0696p pd=1.16u ps=1.16u
    I_MXI0_I56_MN5 (I0_ha13_0 VDD XI0_I56_xn1 VSS) gpdk090_nmos1v w=0.24u l=0.1u ad=0.0528p as=0.0816p pd=0.68u ps=1.16u
    I_MXI0_I56_MN7 (XI0_I56_xn2 XI0_I56_xan I0_ha13_0 VSS) gpdk090_nmos1v w=0.24u l=0.1u ad=0.0528p as=0.0528p pd=0.68u ps=0.68u
    I_MXI0_I56_MN8 (VSS XI0_I56_xbn XI0_I56_xn2 VSS) gpdk090_nmos1v w=0.24u l=0.1u ad=0.0528p as=0.0528p pd=0.68u ps=0.68u
    I_MXI0_I56_MN6 (XI0_I56_xn1 I0_pp3_8 VSS VSS) gpdk090_nmos1v w=0.24u l=0.1u ad=0.0816p as=0.0528p pd=1.16u ps=0.68u
    I_MXI0_I56_MN1 (VSS VDD XI0_I56_xan VSS) gpdk090_nmos1v w=0.12u l=0.1u ad=0.0468p as=0.0696p pd=0.68u ps=1.16u
    I_MXI0_I56_MN14 (XI0_I56_an I0_pp3_8 VSS VSS) gpdk090_nmos1v w=0.24u l=0.1u ad=0.0528p as=0.0468p pd=0.68u ps=0.68u
    I_MXI0_I56_MN13 (XI0_I56_con VDD XI0_I56_an VSS) gpdk090_nmos1v w=0.24u l=0.1u ad=0.0816p as=0.0528p pd=1.16u ps=0.68u
    I_MXI0_I56_MN17 (I0_ha13_1 XI0_I56_con VSS VSS) gpdk090_nmos1v w=0.12u l=0.1u ad=0.0696p as=0.0696p pd=1.16u ps=1.16u
    I_MXI0_I56_MN3 (VSS I0_pp3_8 XI0_I56_xbn VSS) gpdk090_nmos1v w=0.12u l=0.1u ad=0.0696p as=0.0696p pd=1.16u ps=1.16u
    I_MXI0_I64_MN5 (I0_ha21_0 I0_cm9_1 XI0_I64_xn1 VSS) gpdk090_nmos1v w=0.24u l=0.1u ad=0.0528p as=0.0816p pd=0.68u ps=1.16u
    I_MXI0_I64_MN7 (XI0_I64_xn2 XI0_I64_xan I0_ha21_0 VSS) gpdk090_nmos1v w=0.24u l=0.1u ad=0.0528p as=0.0528p pd=0.68u ps=0.68u
    I_MXI0_I64_MN8 (VSS XI0_I64_xbn XI0_I64_xn2 VSS) gpdk090_nmos1v w=0.24u l=0.1u ad=0.0528p as=0.0528p pd=0.68u ps=0.68u
    I_MXI0_I64_MN6 (XI0_I64_xn1 I0_cm10_0 VSS VSS) gpdk090_nmos1v w=0.24u l=0.1u ad=0.0816p as=0.0528p pd=1.16u ps=0.68u
    I_MXI0_I64_MN1 (VSS I0_cm9_1 XI0_I64_xan VSS) gpdk090_nmos1v w=0.12u l=0.1u ad=0.0468p as=0.0696p pd=0.68u ps=1.16u
    I_MXI0_I64_MN14 (XI0_I64_an I0_cm10_0 VSS VSS) gpdk090_nmos1v w=0.24u l=0.1u ad=0.0528p as=0.0468p pd=0.68u ps=0.68u
    I_MXI0_I64_MN13 (XI0_I64_con I0_cm9_1 XI0_I64_an VSS) gpdk090_nmos1v w=0.24u l=0.1u ad=0.0816p as=0.0528p pd=1.16u ps=0.68u
    I_MXI0_I64_MN17 (I0_ha21_1 XI0_I64_con VSS VSS) gpdk090_nmos1v w=0.12u l=0.1u ad=0.0696p as=0.0696p pd=1.16u ps=1.16u
    I_MXI0_I64_MN3 (VSS I0_cm10_0 XI0_I64_xbn VSS) gpdk090_nmos1v w=0.12u l=0.1u ad=0.0696p as=0.0696p pd=1.16u ps=1.16u
    I_MXI0_I63_MN5 (I0_ha20_0 I0_cm8_1 XI0_I63_xn1 VSS) gpdk090_nmos1v w=0.24u l=0.1u ad=0.0528p as=0.0816p pd=0.68u ps=1.16u
    I_MXI0_I63_MN7 (XI0_I63_xn2 XI0_I63_xan I0_ha20_0 VSS) gpdk090_nmos1v w=0.24u l=0.1u ad=0.0528p as=0.0528p pd=0.68u ps=0.68u
    I_MXI0_I63_MN8 (VSS XI0_I63_xbn XI0_I63_xn2 VSS) gpdk090_nmos1v w=0.24u l=0.1u ad=0.0528p as=0.0528p pd=0.68u ps=0.68u
    I_MXI0_I63_MN6 (XI0_I63_xn1 I0_cm9_0 VSS VSS) gpdk090_nmos1v w=0.24u l=0.1u ad=0.0816p as=0.0528p pd=1.16u ps=0.68u
    I_MXI0_I63_MN1 (VSS I0_cm8_1 XI0_I63_xan VSS) gpdk090_nmos1v w=0.12u l=0.1u ad=0.0468p as=0.0696p pd=0.68u ps=1.16u
    I_MXI0_I63_MN14 (XI0_I63_an I0_cm9_0 VSS VSS) gpdk090_nmos1v w=0.24u l=0.1u ad=0.0528p as=0.0468p pd=0.68u ps=0.68u
    I_MXI0_I63_MN13 (XI0_I63_con I0_cm8_1 XI0_I63_an VSS) gpdk090_nmos1v w=0.24u l=0.1u ad=0.0816p as=0.0528p pd=1.16u ps=0.68u
    I_MXI0_I63_MN17 (I0_ha20_1 XI0_I63_con VSS VSS) gpdk090_nmos1v w=0.12u l=0.1u ad=0.0696p as=0.0696p pd=1.16u ps=1.16u
    I_MXI0_I63_MN3 (VSS I0_cm9_0 XI0_I63_xbn VSS) gpdk090_nmos1v w=0.12u l=0.1u ad=0.0696p as=0.0696p pd=1.16u ps=1.16u
    I_MXI0_I62_MN5 (I0_ha19_0 I0_cm7_1 XI0_I62_xn1 VSS) gpdk090_nmos1v w=0.24u l=0.1u ad=0.0528p as=0.0816p pd=0.68u ps=1.16u
    I_MXI0_I62_MN7 (XI0_I62_xn2 XI0_I62_xan I0_ha19_0 VSS) gpdk090_nmos1v w=0.24u l=0.1u ad=0.0528p as=0.0528p pd=0.68u ps=0.68u
    I_MXI0_I62_MN8 (VSS XI0_I62_xbn XI0_I62_xn2 VSS) gpdk090_nmos1v w=0.24u l=0.1u ad=0.0528p as=0.0528p pd=0.68u ps=0.68u
    I_MXI0_I62_MN6 (XI0_I62_xn1 I0_cm8_0 VSS VSS) gpdk090_nmos1v w=0.24u l=0.1u ad=0.0816p as=0.0528p pd=1.16u ps=0.68u
    I_MXI0_I62_MN1 (VSS I0_cm7_1 XI0_I62_xan VSS) gpdk090_nmos1v w=0.12u l=0.1u ad=0.0468p as=0.0696p pd=0.68u ps=1.16u
    I_MXI0_I62_MN14 (XI0_I62_an I0_cm8_0 VSS VSS) gpdk090_nmos1v w=0.24u l=0.1u ad=0.0528p as=0.0468p pd=0.68u ps=0.68u
    I_MXI0_I62_MN13 (XI0_I62_con I0_cm7_1 XI0_I62_an VSS) gpdk090_nmos1v w=0.24u l=0.1u ad=0.0816p as=0.0528p pd=1.16u ps=0.68u
    I_MXI0_I62_MN17 (I0_ha19_1 XI0_I62_con VSS VSS) gpdk090_nmos1v w=0.12u l=0.1u ad=0.0696p as=0.0696p pd=1.16u ps=1.16u
    I_MXI0_I62_MN3 (VSS I0_cm8_0 XI0_I62_xbn VSS) gpdk090_nmos1v w=0.12u l=0.1u ad=0.0696p as=0.0696p pd=1.16u ps=1.16u
    I_MXI0_I61_MN5 (I0_ha18_0 I0_cm6_1 XI0_I61_xn1 VSS) gpdk090_nmos1v w=0.24u l=0.1u ad=0.0528p as=0.0816p pd=0.68u ps=1.16u
    I_MXI0_I61_MN7 (XI0_I61_xn2 XI0_I61_xan I0_ha18_0 VSS) gpdk090_nmos1v w=0.24u l=0.1u ad=0.0528p as=0.0528p pd=0.68u ps=0.68u
    I_MXI0_I61_MN8 (VSS XI0_I61_xbn XI0_I61_xn2 VSS) gpdk090_nmos1v w=0.24u l=0.1u ad=0.0528p as=0.0528p pd=0.68u ps=0.68u
    I_MXI0_I61_MN6 (XI0_I61_xn1 I0_cm7_0 VSS VSS) gpdk090_nmos1v w=0.24u l=0.1u ad=0.0816p as=0.0528p pd=1.16u ps=0.68u
    I_MXI0_I61_MN1 (VSS I0_cm6_1 XI0_I61_xan VSS) gpdk090_nmos1v w=0.12u l=0.1u ad=0.0468p as=0.0696p pd=0.68u ps=1.16u
    I_MXI0_I61_MN14 (XI0_I61_an I0_cm7_0 VSS VSS) gpdk090_nmos1v w=0.24u l=0.1u ad=0.0528p as=0.0468p pd=0.68u ps=0.68u
    I_MXI0_I61_MN13 (XI0_I61_con I0_cm6_1 XI0_I61_an VSS) gpdk090_nmos1v w=0.24u l=0.1u ad=0.0816p as=0.0528p pd=1.16u ps=0.68u
    I_MXI0_I61_MN17 (I0_ha18_1 XI0_I61_con VSS VSS) gpdk090_nmos1v w=0.12u l=0.1u ad=0.0696p as=0.0696p pd=1.16u ps=1.16u
    I_MXI0_I61_MN3 (VSS I0_cm7_0 XI0_I61_xbn VSS) gpdk090_nmos1v w=0.12u l=0.1u ad=0.0696p as=0.0696p pd=1.16u ps=1.16u
    I_MXI0_I59_MN5 (I0_ha16_0 I0_fa4_1 XI0_I59_xn1 VSS) gpdk090_nmos1v w=0.24u l=0.1u ad=0.0528p as=0.0816p pd=0.68u ps=1.16u
    I_MXI0_I59_MN7 (XI0_I59_xn2 XI0_I59_xan I0_ha16_0 VSS) gpdk090_nmos1v w=0.24u l=0.1u ad=0.0528p as=0.0528p pd=0.68u ps=0.68u
    I_MXI0_I59_MN8 (VSS XI0_I59_xbn XI0_I59_xn2 VSS) gpdk090_nmos1v w=0.24u l=0.1u ad=0.0528p as=0.0528p pd=0.68u ps=0.68u
    I_MXI0_I59_MN6 (XI0_I59_xn1 I0_cm5_0 VSS VSS) gpdk090_nmos1v w=0.24u l=0.1u ad=0.0816p as=0.0528p pd=1.16u ps=0.68u
    I_MXI0_I59_MN1 (VSS I0_fa4_1 XI0_I59_xan VSS) gpdk090_nmos1v w=0.12u l=0.1u ad=0.0468p as=0.0696p pd=0.68u ps=1.16u
    I_MXI0_I59_MN14 (XI0_I59_an I0_cm5_0 VSS VSS) gpdk090_nmos1v w=0.24u l=0.1u ad=0.0528p as=0.0468p pd=0.68u ps=0.68u
    I_MXI0_I59_MN13 (XI0_I59_con I0_fa4_1 XI0_I59_an VSS) gpdk090_nmos1v w=0.24u l=0.1u ad=0.0816p as=0.0528p pd=1.16u ps=0.68u
    I_MXI0_I59_MN17 (I0_ha16_1 XI0_I59_con VSS VSS) gpdk090_nmos1v w=0.12u l=0.1u ad=0.0696p as=0.0696p pd=1.16u ps=1.16u
    I_MXI0_I59_MN3 (VSS I0_cm5_0 XI0_I59_xbn VSS) gpdk090_nmos1v w=0.12u l=0.1u ad=0.0696p as=0.0696p pd=1.16u ps=1.16u
    I_MXI0_I60_MN5 (I0_ha17_0 I0_cm5_1 XI0_I60_xn1 VSS) gpdk090_nmos1v w=0.24u l=0.1u ad=0.0528p as=0.0816p pd=0.68u ps=1.16u
    I_MXI0_I60_MN7 (XI0_I60_xn2 XI0_I60_xan I0_ha17_0 VSS) gpdk090_nmos1v w=0.24u l=0.1u ad=0.0528p as=0.0528p pd=0.68u ps=0.68u
    I_MXI0_I60_MN8 (VSS XI0_I60_xbn XI0_I60_xn2 VSS) gpdk090_nmos1v w=0.24u l=0.1u ad=0.0528p as=0.0528p pd=0.68u ps=0.68u
    I_MXI0_I60_MN6 (XI0_I60_xn1 I0_cm6_0 VSS VSS) gpdk090_nmos1v w=0.24u l=0.1u ad=0.0816p as=0.0528p pd=1.16u ps=0.68u
    I_MXI0_I60_MN1 (VSS I0_cm5_1 XI0_I60_xan VSS) gpdk090_nmos1v w=0.12u l=0.1u ad=0.0468p as=0.0696p pd=0.68u ps=1.16u
    I_MXI0_I60_MN14 (XI0_I60_an I0_cm6_0 VSS VSS) gpdk090_nmos1v w=0.24u l=0.1u ad=0.0528p as=0.0468p pd=0.68u ps=0.68u
    I_MXI0_I60_MN13 (XI0_I60_con I0_cm5_1 XI0_I60_an VSS) gpdk090_nmos1v w=0.24u l=0.1u ad=0.0816p as=0.0528p pd=1.16u ps=0.68u
    I_MXI0_I60_MN17 (I0_ha17_1 XI0_I60_con VSS VSS) gpdk090_nmos1v w=0.12u l=0.1u ad=0.0696p as=0.0696p pd=1.16u ps=1.16u
    I_MXI0_I60_MN3 (VSS I0_cm6_0 XI0_I60_xbn VSS) gpdk090_nmos1v w=0.12u l=0.1u ad=0.0696p as=0.0696p pd=1.16u ps=1.16u
    I_MXI0_I58_MN5 (I0_ha15_0 I0_fa3_1 XI0_I58_xn1 VSS) gpdk090_nmos1v w=0.24u l=0.1u ad=0.0528p as=0.0816p pd=0.68u ps=1.16u
    I_MXI0_I58_MN7 (XI0_I58_xn2 XI0_I58_xan I0_ha15_0 VSS) gpdk090_nmos1v w=0.24u l=0.1u ad=0.0528p as=0.0528p pd=0.68u ps=0.68u
    I_MXI0_I58_MN8 (VSS XI0_I58_xbn XI0_I58_xn2 VSS) gpdk090_nmos1v w=0.24u l=0.1u ad=0.0528p as=0.0528p pd=0.68u ps=0.68u
    I_MXI0_I58_MN6 (XI0_I58_xn1 I0_fa4_0 VSS VSS) gpdk090_nmos1v w=0.24u l=0.1u ad=0.0816p as=0.0528p pd=1.16u ps=0.68u
    I_MXI0_I58_MN1 (VSS I0_fa3_1 XI0_I58_xan VSS) gpdk090_nmos1v w=0.12u l=0.1u ad=0.0468p as=0.0696p pd=0.68u ps=1.16u
    I_MXI0_I58_MN14 (XI0_I58_an I0_fa4_0 VSS VSS) gpdk090_nmos1v w=0.24u l=0.1u ad=0.0528p as=0.0468p pd=0.68u ps=0.68u
    I_MXI0_I58_MN13 (XI0_I58_con I0_fa3_1 XI0_I58_an VSS) gpdk090_nmos1v w=0.24u l=0.1u ad=0.0816p as=0.0528p pd=1.16u ps=0.68u
    I_MXI0_I58_MN17 (I0_ha15_1 XI0_I58_con VSS VSS) gpdk090_nmos1v w=0.12u l=0.1u ad=0.0696p as=0.0696p pd=1.16u ps=1.16u
    I_MXI0_I58_MN3 (VSS I0_fa4_0 XI0_I58_xbn VSS) gpdk090_nmos1v w=0.12u l=0.1u ad=0.0696p as=0.0696p pd=1.16u ps=1.16u
    I_MXI0_I73_MN5 (MULP_4 I0_fa14_0 XI0_I73_xn1 VSS) gpdk090_nmos1v w=0.24u l=0.1u ad=0.0528p as=0.0816p pd=0.68u ps=1.16u
    I_MXI0_I73_MN7 (XI0_I73_xn2 XI0_I73_xan MULP_4 VSS) gpdk090_nmos1v w=0.24u l=0.1u ad=0.0528p as=0.0528p pd=0.68u ps=0.68u
    I_MXI0_I73_MN8 (VSS XI0_I73_xbn XI0_I73_xn2 VSS) gpdk090_nmos1v w=0.24u l=0.1u ad=0.0528p as=0.0528p pd=0.68u ps=0.68u
    I_MXI0_I73_MN6 (XI0_I73_xn1 I0_rc4 VSS VSS) gpdk090_nmos1v w=0.24u l=0.1u ad=0.0816p as=0.0528p pd=1.16u ps=0.68u
    I_MXI0_I73_MN1 (VSS I0_fa14_0 XI0_I73_xan VSS) gpdk090_nmos1v w=0.12u l=0.1u ad=0.0468p as=0.0696p pd=0.68u ps=1.16u
    I_MXI0_I73_MN14 (XI0_I73_an I0_rc4 VSS VSS) gpdk090_nmos1v w=0.24u l=0.1u ad=0.0528p as=0.0468p pd=0.68u ps=0.68u
    I_MXI0_I73_MN13 (XI0_I73_con I0_fa14_0 XI0_I73_an VSS) gpdk090_nmos1v w=0.24u l=0.1u ad=0.0816p as=0.0528p pd=1.16u ps=0.68u
    I_MXI0_I73_MN17 (I0_rc5 XI0_I73_con VSS VSS) gpdk090_nmos1v w=0.12u l=0.1u ad=0.0696p as=0.0696p pd=1.16u ps=1.16u
    I_MXI0_I73_MN3 (VSS I0_rc4 XI0_I73_xbn VSS) gpdk090_nmos1v w=0.12u l=0.1u ad=0.0696p as=0.0696p pd=1.16u ps=1.16u
    I_MXI0_I45_MN5 (I0_ha2_0 I0_pp0_3 XI0_I45_xn1 VSS) gpdk090_nmos1v w=0.24u l=0.1u ad=0.0528p as=0.0816p pd=0.68u ps=1.16u
    I_MXI0_I45_MN7 (XI0_I45_xn2 XI0_I45_xan I0_ha2_0 VSS) gpdk090_nmos1v w=0.24u l=0.1u ad=0.0528p as=0.0528p pd=0.68u ps=0.68u
    I_MXI0_I45_MN8 (VSS XI0_I45_xbn XI0_I45_xn2 VSS) gpdk090_nmos1v w=0.24u l=0.1u ad=0.0528p as=0.0528p pd=0.68u ps=0.68u
    I_MXI0_I45_MN6 (XI0_I45_xn1 I0_pp1_1 VSS VSS) gpdk090_nmos1v w=0.24u l=0.1u ad=0.0816p as=0.0528p pd=1.16u ps=0.68u
    I_MXI0_I45_MN1 (VSS I0_pp0_3 XI0_I45_xan VSS) gpdk090_nmos1v w=0.12u l=0.1u ad=0.0468p as=0.0696p pd=0.68u ps=1.16u
    I_MXI0_I45_MN14 (XI0_I45_an I0_pp1_1 VSS VSS) gpdk090_nmos1v w=0.24u l=0.1u ad=0.0528p as=0.0468p pd=0.68u ps=0.68u
    I_MXI0_I45_MN13 (XI0_I45_con I0_pp0_3 XI0_I45_an VSS) gpdk090_nmos1v w=0.24u l=0.1u ad=0.0816p as=0.0528p pd=1.16u ps=0.68u
    I_MXI0_I45_MN17 (I0_ha2_1 XI0_I45_con VSS VSS) gpdk090_nmos1v w=0.12u l=0.1u ad=0.0696p as=0.0696p pd=1.16u ps=1.16u
    I_MXI0_I45_MN3 (VSS I0_pp1_1 XI0_I45_xbn VSS) gpdk090_nmos1v w=0.12u l=0.1u ad=0.0696p as=0.0696p pd=1.16u ps=1.16u
    I_MXI0_I70_MN5 (MULP_1 I0_pp0_1 XI0_I70_xn1 VSS) gpdk090_nmos1v w=0.24u l=0.1u ad=0.0528p as=0.0816p pd=0.68u ps=1.16u
    I_MXI0_I70_MN7 (XI0_I70_xn2 XI0_I70_xan MULP_1 VSS) gpdk090_nmos1v w=0.24u l=0.1u ad=0.0528p as=0.0528p pd=0.68u ps=0.68u
    I_MXI0_I70_MN8 (VSS XI0_I70_xbn XI0_I70_xn2 VSS) gpdk090_nmos1v w=0.24u l=0.1u ad=0.0528p as=0.0528p pd=0.68u ps=0.68u
    I_MXI0_I70_MN6 (XI0_I70_xn1 I0_rc1 VSS VSS) gpdk090_nmos1v w=0.24u l=0.1u ad=0.0816p as=0.0528p pd=1.16u ps=0.68u
    I_MXI0_I70_MN1 (VSS I0_pp0_1 XI0_I70_xan VSS) gpdk090_nmos1v w=0.12u l=0.1u ad=0.0468p as=0.0696p pd=0.68u ps=1.16u
    I_MXI0_I70_MN14 (XI0_I70_an I0_rc1 VSS VSS) gpdk090_nmos1v w=0.24u l=0.1u ad=0.0528p as=0.0468p pd=0.68u ps=0.68u
    I_MXI0_I70_MN13 (XI0_I70_con I0_pp0_1 XI0_I70_an VSS) gpdk090_nmos1v w=0.24u l=0.1u ad=0.0816p as=0.0528p pd=1.16u ps=0.68u
    I_MXI0_I70_MN17 (I0_rc2 XI0_I70_con VSS VSS) gpdk090_nmos1v w=0.12u l=0.1u ad=0.0696p as=0.0696p pd=1.16u ps=1.16u
    I_MXI0_I70_MN3 (VSS I0_rc1 XI0_I70_xbn VSS) gpdk090_nmos1v w=0.12u l=0.1u ad=0.0696p as=0.0696p pd=1.16u ps=1.16u
    I_MXI0_I69_MN5 (MULP_0 I0_pp0_0 XI0_I69_xn1 VSS) gpdk090_nmos1v w=0.24u l=0.1u ad=0.0528p as=0.0816p pd=0.68u ps=1.16u
    I_MXI0_I69_MN7 (XI0_I69_xn2 XI0_I69_xan MULP_0 VSS) gpdk090_nmos1v w=0.24u l=0.1u ad=0.0528p as=0.0528p pd=0.68u ps=0.68u
    I_MXI0_I69_MN8 (VSS XI0_I69_xbn XI0_I69_xn2 VSS) gpdk090_nmos1v w=0.24u l=0.1u ad=0.0528p as=0.0528p pd=0.68u ps=0.68u
    I_MXI0_I69_MN6 (XI0_I69_xn1 B_1 VSS VSS) gpdk090_nmos1v w=0.24u l=0.1u ad=0.0816p as=0.0528p pd=1.16u ps=0.68u
    I_MXI0_I69_MN1 (VSS I0_pp0_0 XI0_I69_xan VSS) gpdk090_nmos1v w=0.12u l=0.1u ad=0.0468p as=0.0696p pd=0.68u ps=1.16u
    I_MXI0_I69_MN14 (XI0_I69_an B_1 VSS VSS) gpdk090_nmos1v w=0.24u l=0.1u ad=0.0528p as=0.0468p pd=0.68u ps=0.68u
    I_MXI0_I69_MN13 (XI0_I69_con I0_pp0_0 XI0_I69_an VSS) gpdk090_nmos1v w=0.24u l=0.1u ad=0.0816p as=0.0528p pd=1.16u ps=0.68u
    I_MXI0_I69_MN17 (I0_rc1 XI0_I69_con VSS VSS) gpdk090_nmos1v w=0.12u l=0.1u ad=0.0696p as=0.0696p pd=1.16u ps=1.16u
    I_MXI0_I69_MN3 (VSS B_1 XI0_I69_xbn VSS) gpdk090_nmos1v w=0.12u l=0.1u ad=0.0696p as=0.0696p pd=1.16u ps=1.16u
    I_MXI0_I71_MN5 (MULP_2 I0_fa1_0 XI0_I71_xn1 VSS) gpdk090_nmos1v w=0.24u l=0.1u ad=0.0528p as=0.0816p pd=0.68u ps=1.16u
    I_MXI0_I71_MN7 (XI0_I71_xn2 XI0_I71_xan MULP_2 VSS) gpdk090_nmos1v w=0.24u l=0.1u ad=0.0528p as=0.0528p pd=0.68u ps=0.68u
    I_MXI0_I71_MN8 (VSS XI0_I71_xbn XI0_I71_xn2 VSS) gpdk090_nmos1v w=0.24u l=0.1u ad=0.0528p as=0.0528p pd=0.68u ps=0.68u
    I_MXI0_I71_MN6 (XI0_I71_xn1 I0_rc2 VSS VSS) gpdk090_nmos1v w=0.24u l=0.1u ad=0.0816p as=0.0528p pd=1.16u ps=0.68u
    I_MXI0_I71_MN1 (VSS I0_fa1_0 XI0_I71_xan VSS) gpdk090_nmos1v w=0.12u l=0.1u ad=0.0468p as=0.0696p pd=0.68u ps=1.16u
    I_MXI0_I71_MN14 (XI0_I71_an I0_rc2 VSS VSS) gpdk090_nmos1v w=0.24u l=0.1u ad=0.0528p as=0.0468p pd=0.68u ps=0.68u
    I_MXI0_I71_MN13 (XI0_I71_con I0_fa1_0 XI0_I71_an VSS) gpdk090_nmos1v w=0.24u l=0.1u ad=0.0816p as=0.0528p pd=1.16u ps=0.68u
    I_MXI0_I71_MN17 (I0_rc3 XI0_I71_con VSS VSS) gpdk090_nmos1v w=0.12u l=0.1u ad=0.0696p as=0.0696p pd=1.16u ps=1.16u
    I_MXI0_I71_MN3 (VSS I0_rc2 XI0_I71_xbn VSS) gpdk090_nmos1v w=0.12u l=0.1u ad=0.0696p as=0.0696p pd=1.16u ps=1.16u
    I_MXI0_I77_I31_XG_MN2 (I0_I77_G7_4n I0_I77_G7_6 VSS VSS) gpdk090_nmos1v w=0.12u l=0.1u ad=0.0468p as=0.0696p pd=0.68u ps=1.16u
    I_MXI0_I77_I31_XG_MN0 (XI0_I77_I31_XG_n1 I0_I77_P7_6 I0_I77_G7_4n VSS) gpdk090_nmos1v w=0.24u l=0.1u ad=0.0528p as=0.0468p pd=0.68u ps=0.68u
    I_MXI0_I77_I31_XG_MN1 (VSS I0_I77_G5_4 XI0_I77_I31_XG_n1 VSS) gpdk090_nmos1v w=0.24u l=0.1u ad=0.0816p as=0.0528p pd=1.16u ps=0.68u
    I_MXI1_I189_MN2 (I1_nrkn6 I1_nrk5 VSS VSS) gpdk090_nmos1v w=0.12u l=0.1u ad=0.0468p as=0.0696p pd=0.68u ps=1.16u
    I_MXI1_I189_MN0 (XI1_I189_n1 A_7 I1_nrkn6 VSS) gpdk090_nmos1v w=0.24u l=0.1u ad=0.0528p as=0.0468p pd=0.68u ps=0.68u
    I_MXI1_I189_MN1 (VSS I1_ru5 XI1_I189_n1 VSS) gpdk090_nmos1v w=0.24u l=0.1u ad=0.0816p as=0.0528p pd=1.16u ps=0.68u
    I_MXI1_I192_MN2 (I1_nrkn7 I1_nrk6 VSS VSS) gpdk090_nmos1v w=0.12u l=0.1u ad=0.0468p as=0.0696p pd=0.68u ps=1.16u
    I_MXI1_I192_MN0 (XI1_I192_n1 A_7 I1_nrkn7 VSS) gpdk090_nmos1v w=0.24u l=0.1u ad=0.0528p as=0.0468p pd=0.68u ps=0.68u
    I_MXI1_I192_MN1 (VSS I1_ru6 XI1_I192_n1 VSS) gpdk090_nmos1v w=0.24u l=0.1u ad=0.0816p as=0.0528p pd=1.16u ps=0.68u
    I_MXI0_I77_I30_XG_MN2 (I0_I77_G6_3n I0_I77_G6_5 VSS VSS) gpdk090_nmos1v w=0.12u l=0.1u ad=0.0468p as=0.0696p pd=0.68u ps=1.16u
    I_MXI0_I77_I30_XG_MN0 (XI0_I77_I30_XG_n1 I0_I77_P6_5 I0_I77_G6_3n VSS) gpdk090_nmos1v w=0.24u l=0.1u ad=0.0528p as=0.0468p pd=0.68u ps=0.68u
    I_MXI0_I77_I30_XG_MN1 (VSS I0_I77_G4_3 XI0_I77_I30_XG_n1 VSS) gpdk090_nmos1v w=0.24u l=0.1u ad=0.0816p as=0.0528p pd=1.16u ps=0.68u
    I_MXI0_I77_I27_XG_MN2 (I0_I77_G3_0n I0_I77_G3_2 VSS VSS) gpdk090_nmos1v w=0.12u l=0.1u ad=0.0468p as=0.0696p pd=0.68u ps=1.16u
    I_MXI0_I77_I27_XG_MN0 (XI0_I77_I27_XG_n1 I0_I77_P3_2 I0_I77_G3_0n VSS) gpdk090_nmos1v w=0.24u l=0.1u ad=0.0528p as=0.0468p pd=0.68u ps=0.68u
    I_MXI0_I77_I27_XG_MN1 (VSS I0_I77_G1_0 XI0_I77_I27_XG_n1 VSS) gpdk090_nmos1v w=0.24u l=0.1u ad=0.0816p as=0.0528p pd=1.16u ps=0.68u
    I_MXI0_I77_I29_XG_MN2 (I0_I77_G5_2n I0_I77_G5_4 VSS VSS) gpdk090_nmos1v w=0.12u l=0.1u ad=0.0468p as=0.0696p pd=0.68u ps=1.16u
    I_MXI0_I77_I29_XG_MN0 (XI0_I77_I29_XG_n1 I0_I77_P5_4 I0_I77_G5_2n VSS) gpdk090_nmos1v w=0.24u l=0.1u ad=0.0528p as=0.0468p pd=0.68u ps=0.68u
    I_MXI0_I77_I29_XG_MN1 (VSS I0_I77_G3_2 XI0_I77_I29_XG_n1 VSS) gpdk090_nmos1v w=0.24u l=0.1u ad=0.0816p as=0.0528p pd=1.16u ps=0.68u
    I_MXI1_I152_I29_XG_MN2 (I1_I152_G5_2n I1_I152_G5_4 VSS VSS) gpdk090_nmos1v w=0.12u l=0.1u ad=0.0468p as=0.0696p pd=0.68u ps=1.16u
    I_MXI1_I152_I29_XG_MN0 (XI1_I152_I29_XG_n1 I1_I152_P5_4 I1_I152_G5_2n VSS) gpdk090_nmos1v w=0.24u l=0.1u ad=0.0528p as=0.0468p pd=0.68u ps=0.68u
    I_MXI1_I152_I29_XG_MN1 (VSS I1_I152_G3_2 XI1_I152_I29_XG_n1 VSS) gpdk090_nmos1v w=0.24u l=0.1u ad=0.0816p as=0.0528p pd=1.16u ps=0.68u
    I_MXI1_I186_MN2 (I1_nrkn5 I1_nrk4 VSS VSS) gpdk090_nmos1v w=0.12u l=0.1u ad=0.0468p as=0.0696p pd=0.68u ps=1.16u
    I_MXI1_I186_MN0 (XI1_I186_n1 A_7 I1_nrkn5 VSS) gpdk090_nmos1v w=0.24u l=0.1u ad=0.0528p as=0.0468p pd=0.68u ps=0.68u
    I_MXI1_I186_MN1 (VSS I1_ru4 XI1_I186_n1 VSS) gpdk090_nmos1v w=0.24u l=0.1u ad=0.0816p as=0.0528p pd=1.16u ps=0.68u
    I_MXI1_I183_MN2 (I1_nrkn4 I1_nrk3 VSS VSS) gpdk090_nmos1v w=0.12u l=0.1u ad=0.0468p as=0.0696p pd=0.68u ps=1.16u
    I_MXI1_I183_MN0 (XI1_I183_n1 A_7 I1_nrkn4 VSS) gpdk090_nmos1v w=0.24u l=0.1u ad=0.0528p as=0.0468p pd=0.68u ps=0.68u
    I_MXI1_I183_MN1 (VSS I1_ru3 XI1_I183_n1 VSS) gpdk090_nmos1v w=0.24u l=0.1u ad=0.0816p as=0.0528p pd=1.16u ps=0.68u
    I_MXI0_I77_I28_XG_MN2 (I0_I77_G4_1n I0_I77_G4_3 VSS VSS) gpdk090_nmos1v w=0.12u l=0.1u ad=0.0468p as=0.0696p pd=0.68u ps=1.16u
    I_MXI0_I77_I28_XG_MN0 (XI0_I77_I28_XG_n1 I0_I77_P4_3 I0_I77_G4_1n VSS) gpdk090_nmos1v w=0.24u l=0.1u ad=0.0528p as=0.0468p pd=0.68u ps=0.68u
    I_MXI0_I77_I28_XG_MN1 (VSS I0_I77_G2_1 XI0_I77_I28_XG_n1 VSS) gpdk090_nmos1v w=0.24u l=0.1u ad=0.0816p as=0.0528p pd=1.16u ps=0.68u
    I_MXI1_I152_I31_XG_MN2 (I1_I152_G7_4n I1_I152_G7_6 VSS VSS) gpdk090_nmos1v w=0.12u l=0.1u ad=0.0468p as=0.0696p pd=0.68u ps=1.16u
    I_MXI1_I152_I31_XG_MN0 (XI1_I152_I31_XG_n1 I1_I152_P7_6 I1_I152_G7_4n VSS) gpdk090_nmos1v w=0.24u l=0.1u ad=0.0528p as=0.0468p pd=0.68u ps=0.68u
    I_MXI1_I152_I31_XG_MN1 (VSS I1_I152_G5_4 XI1_I152_I31_XG_n1 VSS) gpdk090_nmos1v w=0.24u l=0.1u ad=0.0816p as=0.0528p pd=1.16u ps=0.68u
    I_MXI1_I152_I27_XG_MN2 (I1_I152_G3_0n I1_I152_G3_2 VSS VSS) gpdk090_nmos1v w=0.12u l=0.1u ad=0.0468p as=0.0696p pd=0.68u ps=1.16u
    I_MXI1_I152_I27_XG_MN0 (XI1_I152_I27_XG_n1 I1_I152_P3_2 I1_I152_G3_0n VSS) gpdk090_nmos1v w=0.24u l=0.1u ad=0.0528p as=0.0468p pd=0.68u ps=0.68u
    I_MXI1_I152_I27_XG_MN1 (VSS I1_I152_G1_0 XI1_I152_I27_XG_n1 VSS) gpdk090_nmos1v w=0.24u l=0.1u ad=0.0816p as=0.0528p pd=1.16u ps=0.68u
    I_MXI1_I180_MN2 (I1_nrkn3 I1_nrk2 VSS VSS) gpdk090_nmos1v w=0.12u l=0.1u ad=0.0468p as=0.0696p pd=0.68u ps=1.16u
    I_MXI1_I180_MN0 (XI1_I180_n1 A_7 I1_nrkn3 VSS) gpdk090_nmos1v w=0.24u l=0.1u ad=0.0528p as=0.0468p pd=0.68u ps=0.68u
    I_MXI1_I180_MN1 (VSS I1_ru2 XI1_I180_n1 VSS) gpdk090_nmos1v w=0.24u l=0.1u ad=0.0816p as=0.0528p pd=1.16u ps=0.68u
    I_MXI0_I77_I26_XG_MN2 (I0_I77_G2_0n I0_I77_G2_1 VSS VSS) gpdk090_nmos1v w=0.12u l=0.1u ad=0.0468p as=0.0696p pd=0.68u ps=1.16u
    I_MXI0_I77_I26_XG_MN0 (XI0_I77_I26_XG_n1 I0_I77_P2_1 I0_I77_G2_0n VSS) gpdk090_nmos1v w=0.24u l=0.1u ad=0.0528p as=0.0468p pd=0.68u ps=0.68u
    I_MXI0_I77_I26_XG_MN1 (VSS I0_I77_G0_0 XI0_I77_I26_XG_n1 VSS) gpdk090_nmos1v w=0.24u l=0.1u ad=0.0816p as=0.0528p pd=1.16u ps=0.68u
    I_MXI1_I152_I30_XG_MN2 (I1_I152_G6_3n I1_I152_G6_5 VSS VSS) gpdk090_nmos1v w=0.12u l=0.1u ad=0.0468p as=0.0696p pd=0.68u ps=1.16u
    I_MXI1_I152_I30_XG_MN0 (XI1_I152_I30_XG_n1 I1_I152_P6_5 I1_I152_G6_3n VSS) gpdk090_nmos1v w=0.24u l=0.1u ad=0.0528p as=0.0468p pd=0.68u ps=0.68u
    I_MXI1_I152_I30_XG_MN1 (VSS I1_I152_G4_3 XI1_I152_I30_XG_n1 VSS) gpdk090_nmos1v w=0.24u l=0.1u ad=0.0816p as=0.0528p pd=1.16u ps=0.68u
    I_MXI1_I152_I28_XG_MN2 (I1_I152_G4_1n I1_I152_G4_3 VSS VSS) gpdk090_nmos1v w=0.12u l=0.1u ad=0.0468p as=0.0696p pd=0.68u ps=1.16u
    I_MXI1_I152_I28_XG_MN0 (XI1_I152_I28_XG_n1 I1_I152_P4_3 I1_I152_G4_1n VSS) gpdk090_nmos1v w=0.24u l=0.1u ad=0.0528p as=0.0468p pd=0.68u ps=0.68u
    I_MXI1_I152_I28_XG_MN1 (VSS I1_I152_G2_1 XI1_I152_I28_XG_n1 VSS) gpdk090_nmos1v w=0.24u l=0.1u ad=0.0816p as=0.0528p pd=1.16u ps=0.68u
    I_MXI1_I152_I26_XG_MN2 (I1_I152_G2_0n I1_I152_G2_1 VSS VSS) gpdk090_nmos1v w=0.12u l=0.1u ad=0.0468p as=0.0696p pd=0.68u ps=1.16u
    I_MXI1_I152_I26_XG_MN0 (XI1_I152_I26_XG_n1 I1_I152_P2_1 I1_I152_G2_0n VSS) gpdk090_nmos1v w=0.24u l=0.1u ad=0.0528p as=0.0468p pd=0.68u ps=0.68u
    I_MXI1_I152_I26_XG_MN1 (VSS I1_I152_G0_0 XI1_I152_I26_XG_n1 VSS) gpdk090_nmos1v w=0.24u l=0.1u ad=0.0816p as=0.0528p pd=1.16u ps=0.68u
    I_MXI1_I177_MN2 (I1_nrkn2 I1_nrk1 VSS VSS) gpdk090_nmos1v w=0.12u l=0.1u ad=0.0468p as=0.0696p pd=0.68u ps=1.16u
    I_MXI1_I177_MN0 (XI1_I177_n1 A_7 I1_nrkn2 VSS) gpdk090_nmos1v w=0.24u l=0.1u ad=0.0528p as=0.0468p pd=0.68u ps=0.68u
    I_MXI1_I177_MN1 (VSS I1_ru1 XI1_I177_n1 VSS) gpdk090_nmos1v w=0.24u l=0.1u ad=0.0816p as=0.0528p pd=1.16u ps=0.68u
    I_MXI2_I3_I94_MN2 (I2_I3_q7_2 I2_I3_o7_2 VSS VSS) gpdk090_nmos1v w=0.12u l=0.1u ad=0.0468p as=0.0696p pd=0.68u ps=1.16u
    I_MXI2_I3_I94_MN0 (XI2_I3_I94_n1 I2_SEL_AS I2_I3_q7_2 VSS) gpdk090_nmos1v w=0.24u l=0.1u ad=0.0528p as=0.0468p pd=0.68u ps=0.68u
    I_MXI2_I3_I94_MN1 (VSS I2_S_7 XI2_I3_I94_n1 VSS) gpdk090_nmos1v w=0.24u l=0.1u ad=0.0816p as=0.0528p pd=1.16u ps=0.68u
    I_MXI1_I132_I29_XG_MN2 (I1_I132_G5_2n I1_I132_G5_4 VSS VSS) gpdk090_nmos1v w=0.12u l=0.1u ad=0.0468p as=0.0696p pd=0.68u ps=1.16u
    I_MXI1_I132_I29_XG_MN0 (XI1_I132_I29_XG_n1 I1_I132_P5_4 I1_I132_G5_2n VSS) gpdk090_nmos1v w=0.24u l=0.1u ad=0.0528p as=0.0468p pd=0.68u ps=0.68u
    I_MXI1_I132_I29_XG_MN1 (VSS I1_I132_G3_2 XI1_I132_I29_XG_n1 VSS) gpdk090_nmos1v w=0.24u l=0.1u ad=0.0816p as=0.0528p pd=1.16u ps=0.68u
    I_MXI1_I132_I27_XG_MN2 (I1_I132_G3_0n I1_I132_G3_2 VSS VSS) gpdk090_nmos1v w=0.12u l=0.1u ad=0.0468p as=0.0696p pd=0.68u ps=1.16u
    I_MXI1_I132_I27_XG_MN0 (XI1_I132_I27_XG_n1 I1_I132_P3_2 I1_I132_G3_0n VSS) gpdk090_nmos1v w=0.24u l=0.1u ad=0.0528p as=0.0468p pd=0.68u ps=0.68u
    I_MXI1_I132_I27_XG_MN1 (VSS I1_I132_G1_0 XI1_I132_I27_XG_n1 VSS) gpdk090_nmos1v w=0.24u l=0.1u ad=0.0816p as=0.0528p pd=1.16u ps=0.68u
    I_MXI2_I3_I82_MN2 (I2_I3_q6_2 I2_I3_o6_2 VSS VSS) gpdk090_nmos1v w=0.12u l=0.1u ad=0.0468p as=0.0696p pd=0.68u ps=1.16u
    I_MXI2_I3_I82_MN0 (XI2_I3_I82_n1 I2_SEL_AS I2_I3_q6_2 VSS) gpdk090_nmos1v w=0.24u l=0.1u ad=0.0528p as=0.0468p pd=0.68u ps=0.68u
    I_MXI2_I3_I82_MN1 (VSS I2_S_6 XI2_I3_I82_n1 VSS) gpdk090_nmos1v w=0.24u l=0.1u ad=0.0816p as=0.0528p pd=1.16u ps=0.68u
    I_MXI2_I1_I8_I31_XG_MN2 (I2_I1_I8_G7_4n I2_I1_I8_G7_6 VSS VSS) gpdk090_nmos1v w=0.12u l=0.1u ad=0.0468p as=0.0696p pd=0.68u ps=1.16u
    I_MXI2_I1_I8_I31_XG_MN0 (XI2_I1_I8_I31_XG_n1 I2_I1_I8_P7_6 I2_I1_I8_G7_4n VSS) gpdk090_nmos1v w=0.24u l=0.1u ad=0.0528p as=0.0468p pd=0.68u ps=0.68u
    I_MXI2_I1_I8_I31_XG_MN1 (VSS I2_I1_I8_G5_4 XI2_I1_I8_I31_XG_n1 VSS) gpdk090_nmos1v w=0.24u l=0.1u ad=0.0816p as=0.0528p pd=1.16u ps=0.68u
    I_MXI2_I1_I8_I29_XG_MN2 (I2_I1_I8_G5_2n I2_I1_I8_G5_4 VSS VSS) gpdk090_nmos1v w=0.12u l=0.1u ad=0.0468p as=0.0696p pd=0.68u ps=1.16u
    I_MXI2_I1_I8_I29_XG_MN0 (XI2_I1_I8_I29_XG_n1 I2_I1_I8_P5_4 I2_I1_I8_G5_2n VSS) gpdk090_nmos1v w=0.24u l=0.1u ad=0.0528p as=0.0468p pd=0.68u ps=0.68u
    I_MXI2_I1_I8_I29_XG_MN1 (VSS I2_I1_I8_G3_2 XI2_I1_I8_I29_XG_n1 VSS) gpdk090_nmos1v w=0.24u l=0.1u ad=0.0816p as=0.0528p pd=1.16u ps=0.68u
    I_MXI2_I1_I8_I30_XG_MN2 (I2_I1_I8_G6_3n I2_I1_I8_G6_5 VSS VSS) gpdk090_nmos1v w=0.12u l=0.1u ad=0.0468p as=0.0696p pd=0.68u ps=1.16u
    I_MXI2_I1_I8_I30_XG_MN0 (XI2_I1_I8_I30_XG_n1 I2_I1_I8_P6_5 I2_I1_I8_G6_3n VSS) gpdk090_nmos1v w=0.24u l=0.1u ad=0.0528p as=0.0468p pd=0.68u ps=0.68u
    I_MXI2_I1_I8_I30_XG_MN1 (VSS I2_I1_I8_G4_3 XI2_I1_I8_I30_XG_n1 VSS) gpdk090_nmos1v w=0.24u l=0.1u ad=0.0816p as=0.0528p pd=1.16u ps=0.68u
    I_MXI1_I132_I31_XG_MN2 (I1_I132_G7_4n I1_I132_G7_6 VSS VSS) gpdk090_nmos1v w=0.12u l=0.1u ad=0.0468p as=0.0696p pd=0.68u ps=1.16u
    I_MXI1_I132_I31_XG_MN0 (XI1_I132_I31_XG_n1 I1_I132_P7_6 I1_I132_G7_4n VSS) gpdk090_nmos1v w=0.24u l=0.1u ad=0.0528p as=0.0468p pd=0.68u ps=0.68u
    I_MXI1_I132_I31_XG_MN1 (VSS I1_I132_G5_4 XI1_I132_I31_XG_n1 VSS) gpdk090_nmos1v w=0.24u l=0.1u ad=0.0816p as=0.0528p pd=1.16u ps=0.68u
    I_MXI1_I132_I28_XG_MN2 (I1_I132_G4_1n I1_I132_G4_3 VSS VSS) gpdk090_nmos1v w=0.12u l=0.1u ad=0.0468p as=0.0696p pd=0.68u ps=1.16u
    I_MXI1_I132_I28_XG_MN0 (XI1_I132_I28_XG_n1 I1_I132_P4_3 I1_I132_G4_1n VSS) gpdk090_nmos1v w=0.24u l=0.1u ad=0.0528p as=0.0468p pd=0.68u ps=0.68u
    I_MXI1_I132_I28_XG_MN1 (VSS I1_I132_G2_1 XI1_I132_I28_XG_n1 VSS) gpdk090_nmos1v w=0.24u l=0.1u ad=0.0816p as=0.0528p pd=1.16u ps=0.68u
    I_MXI1_I132_I26_XG_MN2 (I1_I132_G2_0n I1_I132_G2_1 VSS VSS) gpdk090_nmos1v w=0.12u l=0.1u ad=0.0468p as=0.0696p pd=0.68u ps=1.16u
    I_MXI1_I132_I26_XG_MN0 (XI1_I132_I26_XG_n1 I1_I132_P2_1 I1_I132_G2_0n VSS) gpdk090_nmos1v w=0.24u l=0.1u ad=0.0528p as=0.0468p pd=0.68u ps=0.68u
    I_MXI1_I132_I26_XG_MN1 (VSS I1_I132_G0_0 XI1_I132_I26_XG_n1 VSS) gpdk090_nmos1v w=0.24u l=0.1u ad=0.0816p as=0.0528p pd=1.16u ps=0.68u
    I_MXI1_I38_MN2 (I1_nbkn7 I1_nbk6 VSS VSS) gpdk090_nmos1v w=0.12u l=0.1u ad=0.0468p as=0.0696p pd=0.68u ps=1.16u
    I_MXI1_I38_MN0 (XI1_I38_n1 B_7 I1_nbkn7 VSS) gpdk090_nmos1v w=0.24u l=0.1u ad=0.0528p as=0.0468p pd=0.68u ps=0.68u
    I_MXI1_I38_MN1 (VSS B_6 XI1_I38_n1 VSS) gpdk090_nmos1v w=0.24u l=0.1u ad=0.0816p as=0.0528p pd=1.16u ps=0.68u
    I_MXI2_I1_I8_I27_XG_MN2 (I2_I1_I8_G3_0n I2_I1_I8_G3_2 VSS VSS) gpdk090_nmos1v w=0.12u l=0.1u ad=0.0468p as=0.0696p pd=0.68u ps=1.16u
    I_MXI2_I1_I8_I27_XG_MN0 (XI2_I1_I8_I27_XG_n1 I2_I1_I8_P3_2 I2_I1_I8_G3_0n VSS) gpdk090_nmos1v w=0.24u l=0.1u ad=0.0528p as=0.0468p pd=0.68u ps=0.68u
    I_MXI2_I1_I8_I27_XG_MN1 (VSS I2_I1_I8_G1_0 XI2_I1_I8_I27_XG_n1 VSS) gpdk090_nmos1v w=0.24u l=0.1u ad=0.0816p as=0.0528p pd=1.16u ps=0.68u
    I_MXI1_I132_I30_XG_MN2 (I1_I132_G6_3n I1_I132_G6_5 VSS VSS) gpdk090_nmos1v w=0.12u l=0.1u ad=0.0468p as=0.0696p pd=0.68u ps=1.16u
    I_MXI1_I132_I30_XG_MN0 (XI1_I132_I30_XG_n1 I1_I132_P6_5 I1_I132_G6_3n VSS) gpdk090_nmos1v w=0.24u l=0.1u ad=0.0528p as=0.0468p pd=0.68u ps=0.68u
    I_MXI1_I132_I30_XG_MN1 (VSS I1_I132_G4_3 XI1_I132_I30_XG_n1 VSS) gpdk090_nmos1v w=0.24u l=0.1u ad=0.0816p as=0.0528p pd=1.16u ps=0.68u
    I_MXI1_I35_MN2 (I1_nbkn6 I1_nbk5 VSS VSS) gpdk090_nmos1v w=0.12u l=0.1u ad=0.0468p as=0.0696p pd=0.68u ps=1.16u
    I_MXI1_I35_MN0 (XI1_I35_n1 B_7 I1_nbkn6 VSS) gpdk090_nmos1v w=0.24u l=0.1u ad=0.0528p as=0.0468p pd=0.68u ps=0.68u
    I_MXI1_I35_MN1 (VSS B_5 XI1_I35_n1 VSS) gpdk090_nmos1v w=0.24u l=0.1u ad=0.0816p as=0.0528p pd=1.16u ps=0.68u
    I_MXI2_I3_I70_MN2 (I2_I3_q5_2 I2_I3_o5_2 VSS VSS) gpdk090_nmos1v w=0.12u l=0.1u ad=0.0468p as=0.0696p pd=0.68u ps=1.16u
    I_MXI2_I3_I70_MN0 (XI2_I3_I70_n1 I2_SEL_AS I2_I3_q5_2 VSS) gpdk090_nmos1v w=0.24u l=0.1u ad=0.0528p as=0.0468p pd=0.68u ps=0.68u
    I_MXI2_I3_I70_MN1 (VSS I2_S_5 XI2_I3_I70_n1 VSS) gpdk090_nmos1v w=0.24u l=0.1u ad=0.0816p as=0.0528p pd=1.16u ps=0.68u
    I_MXI2_I1_I8_I28_XG_MN2 (I2_I1_I8_G4_1n I2_I1_I8_G4_3 VSS VSS) gpdk090_nmos1v w=0.12u l=0.1u ad=0.0468p as=0.0696p pd=0.68u ps=1.16u
    I_MXI2_I1_I8_I28_XG_MN0 (XI2_I1_I8_I28_XG_n1 I2_I1_I8_P4_3 I2_I1_I8_G4_1n VSS) gpdk090_nmos1v w=0.24u l=0.1u ad=0.0528p as=0.0468p pd=0.68u ps=0.68u
    I_MXI2_I1_I8_I28_XG_MN1 (VSS I2_I1_I8_G2_1 XI2_I1_I8_I28_XG_n1 VSS) gpdk090_nmos1v w=0.24u l=0.1u ad=0.0816p as=0.0528p pd=1.16u ps=0.68u
    I_MXI1_I157_MN2 (I1_nqkn2 I1_nqk1 VSS VSS) gpdk090_nmos1v w=0.12u l=0.1u ad=0.0468p as=0.0696p pd=0.68u ps=1.16u
    I_MXI1_I157_MN0 (XI1_I157_n1 I1_sq I1_nqkn2 VSS) gpdk090_nmos1v w=0.24u l=0.1u ad=0.0528p as=0.0468p pd=0.68u ps=0.68u
    I_MXI1_I157_MN1 (VSS I1_qu1 XI1_I157_n1 VSS) gpdk090_nmos1v w=0.24u l=0.1u ad=0.0816p as=0.0528p pd=1.16u ps=0.68u
    I_MXI2_I3_I58_MN2 (I2_I3_q4_2 I2_I3_o4_2 VSS VSS) gpdk090_nmos1v w=0.12u l=0.1u ad=0.0468p as=0.0696p pd=0.68u ps=1.16u
    I_MXI2_I3_I58_MN0 (XI2_I3_I58_n1 I2_SEL_AS I2_I3_q4_2 VSS) gpdk090_nmos1v w=0.24u l=0.1u ad=0.0528p as=0.0468p pd=0.68u ps=0.68u
    I_MXI2_I3_I58_MN1 (VSS I2_S_4 XI2_I3_I58_n1 VSS) gpdk090_nmos1v w=0.24u l=0.1u ad=0.0816p as=0.0528p pd=1.16u ps=0.68u
    I_MXI2_I1_I8_I26_XG_MN2 (I2_I1_I8_G2_0n I2_I1_I8_G2_1 VSS VSS) gpdk090_nmos1v w=0.12u l=0.1u ad=0.0468p as=0.0696p pd=0.68u ps=1.16u
    I_MXI2_I1_I8_I26_XG_MN0 (XI2_I1_I8_I26_XG_n1 I2_I1_I8_P2_1 I2_I1_I8_G2_0n VSS) gpdk090_nmos1v w=0.24u l=0.1u ad=0.0528p as=0.0468p pd=0.68u ps=0.68u
    I_MXI2_I1_I8_I26_XG_MN1 (VSS I2_I1_I8_G0_0 XI2_I1_I8_I26_XG_n1 VSS) gpdk090_nmos1v w=0.24u l=0.1u ad=0.0816p as=0.0528p pd=1.16u ps=0.68u
    I_MXI1_I120_I26_XG_MN2 (I1_I120_G2_0n I1_I120_G2_1 VSS VSS) gpdk090_nmos1v w=0.12u l=0.1u ad=0.0468p as=0.0696p pd=0.68u ps=1.16u
    I_MXI1_I120_I26_XG_MN0 (XI1_I120_I26_XG_n1 I1_I120_P2_1 I1_I120_G2_0n VSS) gpdk090_nmos1v w=0.24u l=0.1u ad=0.0528p as=0.0468p pd=0.68u ps=0.68u
    I_MXI1_I120_I26_XG_MN1 (VSS I1_I120_G0_0 XI1_I120_I26_XG_n1 VSS) gpdk090_nmos1v w=0.24u l=0.1u ad=0.0816p as=0.0528p pd=1.16u ps=0.68u
    I_MXI1_I32_MN2 (I1_nbkn5 I1_nbk4 VSS VSS) gpdk090_nmos1v w=0.12u l=0.1u ad=0.0468p as=0.0696p pd=0.68u ps=1.16u
    I_MXI1_I32_MN0 (XI1_I32_n1 B_7 I1_nbkn5 VSS) gpdk090_nmos1v w=0.24u l=0.1u ad=0.0528p as=0.0468p pd=0.68u ps=0.68u
    I_MXI1_I32_MN1 (VSS B_4 XI1_I32_n1 VSS) gpdk090_nmos1v w=0.24u l=0.1u ad=0.0816p as=0.0528p pd=1.16u ps=0.68u
    I_MXI2_I3_I22_MN2 (I2_I3_q1_2 I2_I3_o1_2 VSS VSS) gpdk090_nmos1v w=0.12u l=0.1u ad=0.0468p as=0.0696p pd=0.68u ps=1.16u
    I_MXI2_I3_I22_MN0 (XI2_I3_I22_n1 I2_SEL_AS I2_I3_q1_2 VSS) gpdk090_nmos1v w=0.24u l=0.1u ad=0.0528p as=0.0468p pd=0.68u ps=0.68u
    I_MXI2_I3_I22_MN1 (VSS I2_S_1 XI2_I3_I22_n1 VSS) gpdk090_nmos1v w=0.24u l=0.1u ad=0.0816p as=0.0528p pd=1.16u ps=0.68u
    I_MXI2_I3_I46_MN2 (I2_I3_q3_2 I2_I3_o3_2 VSS VSS) gpdk090_nmos1v w=0.12u l=0.1u ad=0.0468p as=0.0696p pd=0.68u ps=1.16u
    I_MXI2_I3_I46_MN0 (XI2_I3_I46_n1 I2_SEL_AS I2_I3_q3_2 VSS) gpdk090_nmos1v w=0.24u l=0.1u ad=0.0528p as=0.0468p pd=0.68u ps=0.68u
    I_MXI2_I3_I46_MN1 (VSS I2_S_3 XI2_I3_I46_n1 VSS) gpdk090_nmos1v w=0.24u l=0.1u ad=0.0816p as=0.0528p pd=1.16u ps=0.68u
    I_MXI2_I3_I34_MN2 (I2_I3_q2_2 I2_I3_o2_2 VSS VSS) gpdk090_nmos1v w=0.12u l=0.1u ad=0.0468p as=0.0696p pd=0.68u ps=1.16u
    I_MXI2_I3_I34_MN0 (XI2_I3_I34_n1 I2_SEL_AS I2_I3_q2_2 VSS) gpdk090_nmos1v w=0.24u l=0.1u ad=0.0528p as=0.0468p pd=0.68u ps=0.68u
    I_MXI2_I3_I34_MN1 (VSS I2_S_2 XI2_I3_I34_n1 VSS) gpdk090_nmos1v w=0.24u l=0.1u ad=0.0816p as=0.0528p pd=1.16u ps=0.68u
    I_MXI1_I120_I31_XG_MN2 (I1_I120_G7_4n I1_I120_G7_6 VSS VSS) gpdk090_nmos1v w=0.12u l=0.1u ad=0.0468p as=0.0696p pd=0.68u ps=1.16u
    I_MXI1_I120_I31_XG_MN0 (XI1_I120_I31_XG_n1 I1_I120_P7_6 I1_I120_G7_4n VSS) gpdk090_nmos1v w=0.24u l=0.1u ad=0.0528p as=0.0468p pd=0.68u ps=0.68u
    I_MXI1_I120_I31_XG_MN1 (VSS I1_I120_G5_4 XI1_I120_I31_XG_n1 VSS) gpdk090_nmos1v w=0.24u l=0.1u ad=0.0816p as=0.0528p pd=1.16u ps=0.68u
    I_MXI1_I120_I29_XG_MN2 (I1_I120_G5_2n I1_I120_G5_4 VSS VSS) gpdk090_nmos1v w=0.12u l=0.1u ad=0.0468p as=0.0696p pd=0.68u ps=1.16u
    I_MXI1_I120_I29_XG_MN0 (XI1_I120_I29_XG_n1 I1_I120_P5_4 I1_I120_G5_2n VSS) gpdk090_nmos1v w=0.24u l=0.1u ad=0.0528p as=0.0468p pd=0.68u ps=0.68u
    I_MXI1_I120_I29_XG_MN1 (VSS I1_I120_G3_2 XI1_I120_I29_XG_n1 VSS) gpdk090_nmos1v w=0.24u l=0.1u ad=0.0816p as=0.0528p pd=1.16u ps=0.68u
    I_MXI1_I120_I27_XG_MN2 (I1_I120_G3_0n I1_I120_G3_2 VSS VSS) gpdk090_nmos1v w=0.12u l=0.1u ad=0.0468p as=0.0696p pd=0.68u ps=1.16u
    I_MXI1_I120_I27_XG_MN0 (XI1_I120_I27_XG_n1 I1_I120_P3_2 I1_I120_G3_0n VSS) gpdk090_nmos1v w=0.24u l=0.1u ad=0.0528p as=0.0468p pd=0.68u ps=0.68u
    I_MXI1_I120_I27_XG_MN1 (VSS I1_I120_G1_0 XI1_I120_I27_XG_n1 VSS) gpdk090_nmos1v w=0.24u l=0.1u ad=0.0816p as=0.0528p pd=1.16u ps=0.68u
    I_MXI1_I120_I30_XG_MN2 (I1_I120_G6_3n I1_I120_G6_5 VSS VSS) gpdk090_nmos1v w=0.12u l=0.1u ad=0.0468p as=0.0696p pd=0.68u ps=1.16u
    I_MXI1_I120_I30_XG_MN0 (XI1_I120_I30_XG_n1 I1_I120_P6_5 I1_I120_G6_3n VSS) gpdk090_nmos1v w=0.24u l=0.1u ad=0.0528p as=0.0468p pd=0.68u ps=0.68u
    I_MXI1_I120_I30_XG_MN1 (VSS I1_I120_G4_3 XI1_I120_I30_XG_n1 VSS) gpdk090_nmos1v w=0.24u l=0.1u ad=0.0816p as=0.0528p pd=1.16u ps=0.68u
    I_MXI1_I120_I28_XG_MN2 (I1_I120_G4_1n I1_I120_G4_3 VSS VSS) gpdk090_nmos1v w=0.12u l=0.1u ad=0.0468p as=0.0696p pd=0.68u ps=1.16u
    I_MXI1_I120_I28_XG_MN0 (XI1_I120_I28_XG_n1 I1_I120_P4_3 I1_I120_G4_1n VSS) gpdk090_nmos1v w=0.24u l=0.1u ad=0.0528p as=0.0468p pd=0.68u ps=0.68u
    I_MXI1_I120_I28_XG_MN1 (VSS I1_I120_G2_1 XI1_I120_I28_XG_n1 VSS) gpdk090_nmos1v w=0.24u l=0.1u ad=0.0816p as=0.0528p pd=1.16u ps=0.68u
    I_MXI1_I160_MN2 (I1_nqkn3 I1_nqk2 VSS VSS) gpdk090_nmos1v w=0.12u l=0.1u ad=0.0468p as=0.0696p pd=0.68u ps=1.16u
    I_MXI1_I160_MN0 (XI1_I160_n1 I1_sq I1_nqkn3 VSS) gpdk090_nmos1v w=0.24u l=0.1u ad=0.0528p as=0.0468p pd=0.68u ps=0.68u
    I_MXI1_I160_MN1 (VSS I1_qu2 XI1_I160_n1 VSS) gpdk090_nmos1v w=0.24u l=0.1u ad=0.0816p as=0.0528p pd=1.16u ps=0.68u
    I_MXI1_I29_MN2 (I1_nbkn4 I1_nbk3 VSS VSS) gpdk090_nmos1v w=0.12u l=0.1u ad=0.0468p as=0.0696p pd=0.68u ps=1.16u
    I_MXI1_I29_MN0 (XI1_I29_n1 B_7 I1_nbkn4 VSS) gpdk090_nmos1v w=0.24u l=0.1u ad=0.0528p as=0.0468p pd=0.68u ps=0.68u
    I_MXI1_I29_MN1 (VSS B_3 XI1_I29_n1 VSS) gpdk090_nmos1v w=0.24u l=0.1u ad=0.0816p as=0.0528p pd=1.16u ps=0.68u
    I_MXI2_I3_I10_MN2 (I2_I3_q0_2 I2_I3_o0_2 VSS VSS) gpdk090_nmos1v w=0.12u l=0.1u ad=0.0468p as=0.0696p pd=0.68u ps=1.16u
    I_MXI2_I3_I10_MN0 (XI2_I3_I10_n1 I2_SEL_AS I2_I3_q0_2 VSS) gpdk090_nmos1v w=0.24u l=0.1u ad=0.0528p as=0.0468p pd=0.68u ps=0.68u
    I_MXI2_I3_I10_MN1 (VSS I2_S_0 XI2_I3_I10_n1 VSS) gpdk090_nmos1v w=0.24u l=0.1u ad=0.0816p as=0.0528p pd=1.16u ps=0.68u
    I_MXI1_I163_MN2 (I1_nqkn4 I1_nqk3 VSS VSS) gpdk090_nmos1v w=0.12u l=0.1u ad=0.0468p as=0.0696p pd=0.68u ps=1.16u
    I_MXI1_I163_MN0 (XI1_I163_n1 I1_sq I1_nqkn4 VSS) gpdk090_nmos1v w=0.24u l=0.1u ad=0.0528p as=0.0468p pd=0.68u ps=0.68u
    I_MXI1_I163_MN1 (VSS I1_qu3 XI1_I163_n1 VSS) gpdk090_nmos1v w=0.24u l=0.1u ad=0.0816p as=0.0528p pd=1.16u ps=0.68u
    I_MXI1_I3_MN2 (I1_nakn2 I1_nak1 VSS VSS) gpdk090_nmos1v w=0.12u l=0.1u ad=0.0468p as=0.0696p pd=0.68u ps=1.16u
    I_MXI1_I3_MN0 (XI1_I3_n1 A_7 I1_nakn2 VSS) gpdk090_nmos1v w=0.24u l=0.1u ad=0.0528p as=0.0468p pd=0.68u ps=0.68u
    I_MXI1_I3_MN1 (VSS A_1 XI1_I3_n1 VSS) gpdk090_nmos1v w=0.24u l=0.1u ad=0.0816p as=0.0528p pd=1.16u ps=0.68u
    I_MXI1_I6_MN2 (I1_nakn3 I1_nak2 VSS VSS) gpdk090_nmos1v w=0.12u l=0.1u ad=0.0468p as=0.0696p pd=0.68u ps=1.16u
    I_MXI1_I6_MN0 (XI1_I6_n1 A_7 I1_nakn3 VSS) gpdk090_nmos1v w=0.24u l=0.1u ad=0.0528p as=0.0468p pd=0.68u ps=0.68u
    I_MXI1_I6_MN1 (VSS A_2 XI1_I6_n1 VSS) gpdk090_nmos1v w=0.24u l=0.1u ad=0.0816p as=0.0528p pd=1.16u ps=0.68u
    I_MXI1_I9_MN2 (I1_nakn4 I1_nak3 VSS VSS) gpdk090_nmos1v w=0.12u l=0.1u ad=0.0468p as=0.0696p pd=0.68u ps=1.16u
    I_MXI1_I9_MN0 (XI1_I9_n1 A_7 I1_nakn4 VSS) gpdk090_nmos1v w=0.24u l=0.1u ad=0.0528p as=0.0468p pd=0.68u ps=0.68u
    I_MXI1_I9_MN1 (VSS A_3 XI1_I9_n1 VSS) gpdk090_nmos1v w=0.24u l=0.1u ad=0.0816p as=0.0528p pd=1.16u ps=0.68u
    I_MXI1_I12_MN2 (I1_nakn5 I1_nak4 VSS VSS) gpdk090_nmos1v w=0.12u l=0.1u ad=0.0468p as=0.0696p pd=0.68u ps=1.16u
    I_MXI1_I12_MN0 (XI1_I12_n1 A_7 I1_nakn5 VSS) gpdk090_nmos1v w=0.24u l=0.1u ad=0.0528p as=0.0468p pd=0.68u ps=0.68u
    I_MXI1_I12_MN1 (VSS A_4 XI1_I12_n1 VSS) gpdk090_nmos1v w=0.24u l=0.1u ad=0.0816p as=0.0528p pd=1.16u ps=0.68u
    I_MXI1_I15_MN2 (I1_nakn6 I1_nak5 VSS VSS) gpdk090_nmos1v w=0.12u l=0.1u ad=0.0468p as=0.0696p pd=0.68u ps=1.16u
    I_MXI1_I15_MN0 (XI1_I15_n1 A_7 I1_nakn6 VSS) gpdk090_nmos1v w=0.24u l=0.1u ad=0.0528p as=0.0468p pd=0.68u ps=0.68u
    I_MXI1_I15_MN1 (VSS A_5 XI1_I15_n1 VSS) gpdk090_nmos1v w=0.24u l=0.1u ad=0.0816p as=0.0528p pd=1.16u ps=0.68u
    I_MXI1_I23_MN2 (I1_nbkn2 I1_nbk1 VSS VSS) gpdk090_nmos1v w=0.12u l=0.1u ad=0.0468p as=0.0696p pd=0.68u ps=1.16u
    I_MXI1_I23_MN0 (XI1_I23_n1 B_7 I1_nbkn2 VSS) gpdk090_nmos1v w=0.24u l=0.1u ad=0.0528p as=0.0468p pd=0.68u ps=0.68u
    I_MXI1_I23_MN1 (VSS B_1 XI1_I23_n1 VSS) gpdk090_nmos1v w=0.24u l=0.1u ad=0.0816p as=0.0528p pd=1.16u ps=0.68u
    I_MXI1_I26_MN2 (I1_nbkn3 I1_nbk2 VSS VSS) gpdk090_nmos1v w=0.12u l=0.1u ad=0.0468p as=0.0696p pd=0.68u ps=1.16u
    I_MXI1_I26_MN0 (XI1_I26_n1 B_7 I1_nbkn3 VSS) gpdk090_nmos1v w=0.24u l=0.1u ad=0.0528p as=0.0468p pd=0.68u ps=0.68u
    I_MXI1_I26_MN1 (VSS B_2 XI1_I26_n1 VSS) gpdk090_nmos1v w=0.24u l=0.1u ad=0.0816p as=0.0528p pd=1.16u ps=0.68u
    I_MXI1_I166_MN2 (I1_nqkn5 I1_nqk4 VSS VSS) gpdk090_nmos1v w=0.12u l=0.1u ad=0.0468p as=0.0696p pd=0.68u ps=1.16u
    I_MXI1_I166_MN0 (XI1_I166_n1 I1_sq I1_nqkn5 VSS) gpdk090_nmos1v w=0.24u l=0.1u ad=0.0528p as=0.0468p pd=0.68u ps=0.68u
    I_MXI1_I166_MN1 (VSS I1_qu4 XI1_I166_n1 VSS) gpdk090_nmos1v w=0.24u l=0.1u ad=0.0816p as=0.0528p pd=1.16u ps=0.68u
    I_MXI1_I169_MN2 (I1_nqkn6 I1_nqk5 VSS VSS) gpdk090_nmos1v w=0.12u l=0.1u ad=0.0468p as=0.0696p pd=0.68u ps=1.16u
    I_MXI1_I169_MN0 (XI1_I169_n1 I1_sq I1_nqkn6 VSS) gpdk090_nmos1v w=0.24u l=0.1u ad=0.0528p as=0.0468p pd=0.68u ps=0.68u
    I_MXI1_I169_MN1 (VSS I1_qu5 XI1_I169_n1 VSS) gpdk090_nmos1v w=0.24u l=0.1u ad=0.0816p as=0.0528p pd=1.16u ps=0.68u
    I_MXI1_I172_MN2 (I1_nqkn7 I1_nqk6 VSS VSS) gpdk090_nmos1v w=0.12u l=0.1u ad=0.0468p as=0.0696p pd=0.68u ps=1.16u
    I_MXI1_I172_MN0 (XI1_I172_n1 I1_sq I1_nqkn7 VSS) gpdk090_nmos1v w=0.24u l=0.1u ad=0.0528p as=0.0468p pd=0.68u ps=0.68u
    I_MXI1_I172_MN1 (VSS I1_qu6 XI1_I172_n1 VSS) gpdk090_nmos1v w=0.24u l=0.1u ad=0.0816p as=0.0528p pd=1.16u ps=0.68u
    I_MXI1_I18_MN2 (I1_nakn7 I1_nak6 VSS VSS) gpdk090_nmos1v w=0.12u l=0.1u ad=0.0468p as=0.0696p pd=0.68u ps=1.16u
    I_MXI1_I18_MN0 (XI1_I18_n1 A_7 I1_nakn7 VSS) gpdk090_nmos1v w=0.24u l=0.1u ad=0.0528p as=0.0468p pd=0.68u ps=0.68u
    I_MXI1_I18_MN1 (VSS A_6 XI1_I18_n1 VSS) gpdk090_nmos1v w=0.24u l=0.1u ad=0.0816p as=0.0528p pd=1.16u ps=0.68u
    I_MXI1_I108_I28_XG_MN2 (I1_I108_G4_1n I1_I108_G4_3 VSS VSS) gpdk090_nmos1v w=0.12u l=0.1u ad=0.0468p as=0.0696p pd=0.68u ps=1.16u
    I_MXI1_I108_I28_XG_MN0 (XI1_I108_I28_XG_n1 I1_I108_P4_3 I1_I108_G4_1n VSS) gpdk090_nmos1v w=0.24u l=0.1u ad=0.0528p as=0.0468p pd=0.68u ps=0.68u
    I_MXI1_I108_I28_XG_MN1 (VSS I1_I108_G2_1 XI1_I108_I28_XG_n1 VSS) gpdk090_nmos1v w=0.24u l=0.1u ad=0.0816p as=0.0528p pd=1.16u ps=0.68u
    I_MXI1_I108_I26_XG_MN2 (I1_I108_G2_0n I1_I108_G2_1 VSS VSS) gpdk090_nmos1v w=0.12u l=0.1u ad=0.0468p as=0.0696p pd=0.68u ps=1.16u
    I_MXI1_I108_I26_XG_MN0 (XI1_I108_I26_XG_n1 I1_I108_P2_1 I1_I108_G2_0n VSS) gpdk090_nmos1v w=0.24u l=0.1u ad=0.0528p as=0.0468p pd=0.68u ps=0.68u
    I_MXI1_I108_I26_XG_MN1 (VSS I1_I108_G0_0 XI1_I108_I26_XG_n1 VSS) gpdk090_nmos1v w=0.24u l=0.1u ad=0.0816p as=0.0528p pd=1.16u ps=0.68u
    I_MXI1_I108_I27_XG_MN2 (I1_I108_G3_0n I1_I108_G3_2 VSS VSS) gpdk090_nmos1v w=0.12u l=0.1u ad=0.0468p as=0.0696p pd=0.68u ps=1.16u
    I_MXI1_I108_I27_XG_MN0 (XI1_I108_I27_XG_n1 I1_I108_P3_2 I1_I108_G3_0n VSS) gpdk090_nmos1v w=0.24u l=0.1u ad=0.0528p as=0.0468p pd=0.68u ps=0.68u
    I_MXI1_I108_I27_XG_MN1 (VSS I1_I108_G1_0 XI1_I108_I27_XG_n1 VSS) gpdk090_nmos1v w=0.24u l=0.1u ad=0.0816p as=0.0528p pd=1.16u ps=0.68u
    I_MXI1_I108_I30_XG_MN2 (I1_I108_G6_3n I1_I108_G6_5 VSS VSS) gpdk090_nmos1v w=0.12u l=0.1u ad=0.0468p as=0.0696p pd=0.68u ps=1.16u
    I_MXI1_I108_I30_XG_MN0 (XI1_I108_I30_XG_n1 I1_I108_P6_5 I1_I108_G6_3n VSS) gpdk090_nmos1v w=0.24u l=0.1u ad=0.0528p as=0.0468p pd=0.68u ps=0.68u
    I_MXI1_I108_I30_XG_MN1 (VSS I1_I108_G4_3 XI1_I108_I30_XG_n1 VSS) gpdk090_nmos1v w=0.24u l=0.1u ad=0.0816p as=0.0528p pd=1.16u ps=0.68u
    I_MXI1_I48_I26_XG_MN2 (I1_I48_G2_0n I1_I48_G2_1 VSS VSS) gpdk090_nmos1v w=0.12u l=0.1u ad=0.0468p as=0.0696p pd=0.68u ps=1.16u
    I_MXI1_I48_I26_XG_MN0 (XI1_I48_I26_XG_n1 I1_I48_P2_1 I1_I48_G2_0n VSS) gpdk090_nmos1v w=0.24u l=0.1u ad=0.0528p as=0.0468p pd=0.68u ps=0.68u
    I_MXI1_I48_I26_XG_MN1 (VSS I1_I48_G0_0 XI1_I48_I26_XG_n1 VSS) gpdk090_nmos1v w=0.24u l=0.1u ad=0.0816p as=0.0528p pd=1.16u ps=0.68u
    I_MXI1_I108_I29_XG_MN2 (I1_I108_G5_2n I1_I108_G5_4 VSS VSS) gpdk090_nmos1v w=0.12u l=0.1u ad=0.0468p as=0.0696p pd=0.68u ps=1.16u
    I_MXI1_I108_I29_XG_MN0 (XI1_I108_I29_XG_n1 I1_I108_P5_4 I1_I108_G5_2n VSS) gpdk090_nmos1v w=0.24u l=0.1u ad=0.0528p as=0.0468p pd=0.68u ps=0.68u
    I_MXI1_I108_I29_XG_MN1 (VSS I1_I108_G3_2 XI1_I108_I29_XG_n1 VSS) gpdk090_nmos1v w=0.24u l=0.1u ad=0.0816p as=0.0528p pd=1.16u ps=0.68u
    I_MXI1_I96_I26_XG_MN2 (I1_I96_G2_0n I1_I96_G2_1 VSS VSS) gpdk090_nmos1v w=0.12u l=0.1u ad=0.0468p as=0.0696p pd=0.68u ps=1.16u
    I_MXI1_I96_I26_XG_MN0 (XI1_I96_I26_XG_n1 I1_I96_P2_1 I1_I96_G2_0n VSS) gpdk090_nmos1v w=0.24u l=0.1u ad=0.0528p as=0.0468p pd=0.68u ps=0.68u
    I_MXI1_I96_I26_XG_MN1 (VSS I1_I96_G0_0 XI1_I96_I26_XG_n1 VSS) gpdk090_nmos1v w=0.24u l=0.1u ad=0.0816p as=0.0528p pd=1.16u ps=0.68u
    I_MXI1_I84_I26_XG_MN2 (I1_I84_G2_0n I1_I84_G2_1 VSS VSS) gpdk090_nmos1v w=0.12u l=0.1u ad=0.0468p as=0.0696p pd=0.68u ps=1.16u
    I_MXI1_I84_I26_XG_MN0 (XI1_I84_I26_XG_n1 I1_I84_P2_1 I1_I84_G2_0n VSS) gpdk090_nmos1v w=0.24u l=0.1u ad=0.0528p as=0.0468p pd=0.68u ps=0.68u
    I_MXI1_I84_I26_XG_MN1 (VSS I1_I84_G0_0 XI1_I84_I26_XG_n1 VSS) gpdk090_nmos1v w=0.24u l=0.1u ad=0.0816p as=0.0528p pd=1.16u ps=0.68u
    I_MXI1_I84_I28_XG_MN2 (I1_I84_G4_1n I1_I84_G4_3 VSS VSS) gpdk090_nmos1v w=0.12u l=0.1u ad=0.0468p as=0.0696p pd=0.68u ps=1.16u
    I_MXI1_I84_I28_XG_MN0 (XI1_I84_I28_XG_n1 I1_I84_P4_3 I1_I84_G4_1n VSS) gpdk090_nmos1v w=0.24u l=0.1u ad=0.0528p as=0.0468p pd=0.68u ps=0.68u
    I_MXI1_I84_I28_XG_MN1 (VSS I1_I84_G2_1 XI1_I84_I28_XG_n1 VSS) gpdk090_nmos1v w=0.24u l=0.1u ad=0.0816p as=0.0528p pd=1.16u ps=0.68u
    I_MXI1_I72_I26_XG_MN2 (I1_I72_G2_0n I1_I72_G2_1 VSS VSS) gpdk090_nmos1v w=0.12u l=0.1u ad=0.0468p as=0.0696p pd=0.68u ps=1.16u
    I_MXI1_I72_I26_XG_MN0 (XI1_I72_I26_XG_n1 I1_I72_P2_1 I1_I72_G2_0n VSS) gpdk090_nmos1v w=0.24u l=0.1u ad=0.0528p as=0.0468p pd=0.68u ps=0.68u
    I_MXI1_I72_I26_XG_MN1 (VSS I1_I72_G0_0 XI1_I72_I26_XG_n1 VSS) gpdk090_nmos1v w=0.24u l=0.1u ad=0.0816p as=0.0528p pd=1.16u ps=0.68u
    I_MXI1_I72_I28_XG_MN2 (I1_I72_G4_1n I1_I72_G4_3 VSS VSS) gpdk090_nmos1v w=0.12u l=0.1u ad=0.0468p as=0.0696p pd=0.68u ps=1.16u
    I_MXI1_I72_I28_XG_MN0 (XI1_I72_I28_XG_n1 I1_I72_P4_3 I1_I72_G4_1n VSS) gpdk090_nmos1v w=0.24u l=0.1u ad=0.0528p as=0.0468p pd=0.68u ps=0.68u
    I_MXI1_I72_I28_XG_MN1 (VSS I1_I72_G2_1 XI1_I72_I28_XG_n1 VSS) gpdk090_nmos1v w=0.24u l=0.1u ad=0.0816p as=0.0528p pd=1.16u ps=0.68u
    I_MXI1_I60_I26_XG_MN2 (I1_I60_G2_0n I1_I60_G2_1 VSS VSS) gpdk090_nmos1v w=0.12u l=0.1u ad=0.0468p as=0.0696p pd=0.68u ps=1.16u
    I_MXI1_I60_I26_XG_MN0 (XI1_I60_I26_XG_n1 I1_I60_P2_1 I1_I60_G2_0n VSS) gpdk090_nmos1v w=0.24u l=0.1u ad=0.0528p as=0.0468p pd=0.68u ps=0.68u
    I_MXI1_I60_I26_XG_MN1 (VSS I1_I60_G0_0 XI1_I60_I26_XG_n1 VSS) gpdk090_nmos1v w=0.24u l=0.1u ad=0.0816p as=0.0528p pd=1.16u ps=0.68u
    I_MXI1_I48_I28_XG_MN2 (I1_I48_G4_1n I1_I48_G4_3 VSS VSS) gpdk090_nmos1v w=0.12u l=0.1u ad=0.0468p as=0.0696p pd=0.68u ps=1.16u
    I_MXI1_I48_I28_XG_MN0 (XI1_I48_I28_XG_n1 I1_I48_P4_3 I1_I48_G4_1n VSS) gpdk090_nmos1v w=0.24u l=0.1u ad=0.0528p as=0.0468p pd=0.68u ps=0.68u
    I_MXI1_I48_I28_XG_MN1 (VSS I1_I48_G2_1 XI1_I48_I28_XG_n1 VSS) gpdk090_nmos1v w=0.24u l=0.1u ad=0.0816p as=0.0528p pd=1.16u ps=0.68u
    I_MXI1_I48_I27_XG_MN2 (I1_I48_G3_0n I1_I48_G3_2 VSS VSS) gpdk090_nmos1v w=0.12u l=0.1u ad=0.0468p as=0.0696p pd=0.68u ps=1.16u
    I_MXI1_I48_I27_XG_MN0 (XI1_I48_I27_XG_n1 I1_I48_P3_2 I1_I48_G3_0n VSS) gpdk090_nmos1v w=0.24u l=0.1u ad=0.0528p as=0.0468p pd=0.68u ps=0.68u
    I_MXI1_I48_I27_XG_MN1 (VSS I1_I48_G1_0 XI1_I48_I27_XG_n1 VSS) gpdk090_nmos1v w=0.24u l=0.1u ad=0.0816p as=0.0528p pd=1.16u ps=0.68u
    I_MXI1_I108_I31_XG_MN2 (I1_I108_G7_4n I1_I108_G7_6 VSS VSS) gpdk090_nmos1v w=0.12u l=0.1u ad=0.0468p as=0.0696p pd=0.68u ps=1.16u
    I_MXI1_I108_I31_XG_MN0 (XI1_I108_I31_XG_n1 I1_I108_P7_6 I1_I108_G7_4n VSS) gpdk090_nmos1v w=0.24u l=0.1u ad=0.0528p as=0.0468p pd=0.68u ps=0.68u
    I_MXI1_I108_I31_XG_MN1 (VSS I1_I108_G5_4 XI1_I108_I31_XG_n1 VSS) gpdk090_nmos1v w=0.24u l=0.1u ad=0.0816p as=0.0528p pd=1.16u ps=0.68u
    I_MXI1_I96_I28_XG_MN2 (I1_I96_G4_1n I1_I96_G4_3 VSS VSS) gpdk090_nmos1v w=0.12u l=0.1u ad=0.0468p as=0.0696p pd=0.68u ps=1.16u
    I_MXI1_I96_I28_XG_MN0 (XI1_I96_I28_XG_n1 I1_I96_P4_3 I1_I96_G4_1n VSS) gpdk090_nmos1v w=0.24u l=0.1u ad=0.0528p as=0.0468p pd=0.68u ps=0.68u
    I_MXI1_I96_I28_XG_MN1 (VSS I1_I96_G2_1 XI1_I96_I28_XG_n1 VSS) gpdk090_nmos1v w=0.24u l=0.1u ad=0.0816p as=0.0528p pd=1.16u ps=0.68u
    I_MXI1_I84_I27_XG_MN2 (I1_I84_G3_0n I1_I84_G3_2 VSS VSS) gpdk090_nmos1v w=0.12u l=0.1u ad=0.0468p as=0.0696p pd=0.68u ps=1.16u
    I_MXI1_I84_I27_XG_MN0 (XI1_I84_I27_XG_n1 I1_I84_P3_2 I1_I84_G3_0n VSS) gpdk090_nmos1v w=0.24u l=0.1u ad=0.0528p as=0.0468p pd=0.68u ps=0.68u
    I_MXI1_I84_I27_XG_MN1 (VSS I1_I84_G1_0 XI1_I84_I27_XG_n1 VSS) gpdk090_nmos1v w=0.24u l=0.1u ad=0.0816p as=0.0528p pd=1.16u ps=0.68u
    I_MXI1_I72_I30_XG_MN2 (I1_I72_G6_3n I1_I72_G6_5 VSS VSS) gpdk090_nmos1v w=0.12u l=0.1u ad=0.0468p as=0.0696p pd=0.68u ps=1.16u
    I_MXI1_I72_I30_XG_MN0 (XI1_I72_I30_XG_n1 I1_I72_P6_5 I1_I72_G6_3n VSS) gpdk090_nmos1v w=0.24u l=0.1u ad=0.0528p as=0.0468p pd=0.68u ps=0.68u
    I_MXI1_I72_I30_XG_MN1 (VSS I1_I72_G4_3 XI1_I72_I30_XG_n1 VSS) gpdk090_nmos1v w=0.24u l=0.1u ad=0.0816p as=0.0528p pd=1.16u ps=0.68u
    I_MXI1_I60_I28_XG_MN2 (I1_I60_G4_1n I1_I60_G4_3 VSS VSS) gpdk090_nmos1v w=0.12u l=0.1u ad=0.0468p as=0.0696p pd=0.68u ps=1.16u
    I_MXI1_I60_I28_XG_MN0 (XI1_I60_I28_XG_n1 I1_I60_P4_3 I1_I60_G4_1n VSS) gpdk090_nmos1v w=0.24u l=0.1u ad=0.0528p as=0.0468p pd=0.68u ps=0.68u
    I_MXI1_I60_I28_XG_MN1 (VSS I1_I60_G2_1 XI1_I60_I28_XG_n1 VSS) gpdk090_nmos1v w=0.24u l=0.1u ad=0.0816p as=0.0528p pd=1.16u ps=0.68u
    I_MXI1_I60_I30_XG_MN2 (I1_I60_G6_3n I1_I60_G6_5 VSS VSS) gpdk090_nmos1v w=0.12u l=0.1u ad=0.0468p as=0.0696p pd=0.68u ps=1.16u
    I_MXI1_I60_I30_XG_MN0 (XI1_I60_I30_XG_n1 I1_I60_P6_5 I1_I60_G6_3n VSS) gpdk090_nmos1v w=0.24u l=0.1u ad=0.0528p as=0.0468p pd=0.68u ps=0.68u
    I_MXI1_I60_I30_XG_MN1 (VSS I1_I60_G4_3 XI1_I60_I30_XG_n1 VSS) gpdk090_nmos1v w=0.24u l=0.1u ad=0.0816p as=0.0528p pd=1.16u ps=0.68u
    I_MXI1_I48_I30_XG_MN2 (I1_I48_G6_3n I1_I48_G6_5 VSS VSS) gpdk090_nmos1v w=0.12u l=0.1u ad=0.0468p as=0.0696p pd=0.68u ps=1.16u
    I_MXI1_I48_I30_XG_MN0 (XI1_I48_I30_XG_n1 I1_I48_P6_5 I1_I48_G6_3n VSS) gpdk090_nmos1v w=0.24u l=0.1u ad=0.0528p as=0.0468p pd=0.68u ps=0.68u
    I_MXI1_I48_I30_XG_MN1 (VSS I1_I48_G4_3 XI1_I48_I30_XG_n1 VSS) gpdk090_nmos1v w=0.24u l=0.1u ad=0.0816p as=0.0528p pd=1.16u ps=0.68u
    I_MXI1_I48_I29_XG_MN2 (I1_I48_G5_2n I1_I48_G5_4 VSS VSS) gpdk090_nmos1v w=0.12u l=0.1u ad=0.0468p as=0.0696p pd=0.68u ps=1.16u
    I_MXI1_I48_I29_XG_MN0 (XI1_I48_I29_XG_n1 I1_I48_P5_4 I1_I48_G5_2n VSS) gpdk090_nmos1v w=0.24u l=0.1u ad=0.0528p as=0.0468p pd=0.68u ps=0.68u
    I_MXI1_I48_I29_XG_MN1 (VSS I1_I48_G3_2 XI1_I48_I29_XG_n1 VSS) gpdk090_nmos1v w=0.24u l=0.1u ad=0.0816p as=0.0528p pd=1.16u ps=0.68u
    I_MXI1_I96_I27_XG_MN2 (I1_I96_G3_0n I1_I96_G3_2 VSS VSS) gpdk090_nmos1v w=0.12u l=0.1u ad=0.0468p as=0.0696p pd=0.68u ps=1.16u
    I_MXI1_I96_I27_XG_MN0 (XI1_I96_I27_XG_n1 I1_I96_P3_2 I1_I96_G3_0n VSS) gpdk090_nmos1v w=0.24u l=0.1u ad=0.0528p as=0.0468p pd=0.68u ps=0.68u
    I_MXI1_I96_I27_XG_MN1 (VSS I1_I96_G1_0 XI1_I96_I27_XG_n1 VSS) gpdk090_nmos1v w=0.24u l=0.1u ad=0.0816p as=0.0528p pd=1.16u ps=0.68u
    I_MXI1_I96_I30_XG_MN2 (I1_I96_G6_3n I1_I96_G6_5 VSS VSS) gpdk090_nmos1v w=0.12u l=0.1u ad=0.0468p as=0.0696p pd=0.68u ps=1.16u
    I_MXI1_I96_I30_XG_MN0 (XI1_I96_I30_XG_n1 I1_I96_P6_5 I1_I96_G6_3n VSS) gpdk090_nmos1v w=0.24u l=0.1u ad=0.0528p as=0.0468p pd=0.68u ps=0.68u
    I_MXI1_I96_I30_XG_MN1 (VSS I1_I96_G4_3 XI1_I96_I30_XG_n1 VSS) gpdk090_nmos1v w=0.24u l=0.1u ad=0.0816p as=0.0528p pd=1.16u ps=0.68u
    I_MXI1_I84_I29_XG_MN2 (I1_I84_G5_2n I1_I84_G5_4 VSS VSS) gpdk090_nmos1v w=0.12u l=0.1u ad=0.0468p as=0.0696p pd=0.68u ps=1.16u
    I_MXI1_I84_I29_XG_MN0 (XI1_I84_I29_XG_n1 I1_I84_P5_4 I1_I84_G5_2n VSS) gpdk090_nmos1v w=0.24u l=0.1u ad=0.0528p as=0.0468p pd=0.68u ps=0.68u
    I_MXI1_I84_I29_XG_MN1 (VSS I1_I84_G3_2 XI1_I84_I29_XG_n1 VSS) gpdk090_nmos1v w=0.24u l=0.1u ad=0.0816p as=0.0528p pd=1.16u ps=0.68u
    I_MXI1_I84_I30_XG_MN2 (I1_I84_G6_3n I1_I84_G6_5 VSS VSS) gpdk090_nmos1v w=0.12u l=0.1u ad=0.0468p as=0.0696p pd=0.68u ps=1.16u
    I_MXI1_I84_I30_XG_MN0 (XI1_I84_I30_XG_n1 I1_I84_P6_5 I1_I84_G6_3n VSS) gpdk090_nmos1v w=0.24u l=0.1u ad=0.0528p as=0.0468p pd=0.68u ps=0.68u
    I_MXI1_I84_I30_XG_MN1 (VSS I1_I84_G4_3 XI1_I84_I30_XG_n1 VSS) gpdk090_nmos1v w=0.24u l=0.1u ad=0.0816p as=0.0528p pd=1.16u ps=0.68u
    I_MXI1_I72_I27_XG_MN2 (I1_I72_G3_0n I1_I72_G3_2 VSS VSS) gpdk090_nmos1v w=0.12u l=0.1u ad=0.0468p as=0.0696p pd=0.68u ps=1.16u
    I_MXI1_I72_I27_XG_MN0 (XI1_I72_I27_XG_n1 I1_I72_P3_2 I1_I72_G3_0n VSS) gpdk090_nmos1v w=0.24u l=0.1u ad=0.0528p as=0.0468p pd=0.68u ps=0.68u
    I_MXI1_I72_I27_XG_MN1 (VSS I1_I72_G1_0 XI1_I72_I27_XG_n1 VSS) gpdk090_nmos1v w=0.24u l=0.1u ad=0.0816p as=0.0528p pd=1.16u ps=0.68u
    I_MXI1_I60_I27_XG_MN2 (I1_I60_G3_0n I1_I60_G3_2 VSS VSS) gpdk090_nmos1v w=0.12u l=0.1u ad=0.0468p as=0.0696p pd=0.68u ps=1.16u
    I_MXI1_I60_I27_XG_MN0 (XI1_I60_I27_XG_n1 I1_I60_P3_2 I1_I60_G3_0n VSS) gpdk090_nmos1v w=0.24u l=0.1u ad=0.0528p as=0.0468p pd=0.68u ps=0.68u
    I_MXI1_I60_I27_XG_MN1 (VSS I1_I60_G1_0 XI1_I60_I27_XG_n1 VSS) gpdk090_nmos1v w=0.24u l=0.1u ad=0.0816p as=0.0528p pd=1.16u ps=0.68u
    I_MXI1_I96_I29_XG_MN2 (I1_I96_G5_2n I1_I96_G5_4 VSS VSS) gpdk090_nmos1v w=0.12u l=0.1u ad=0.0468p as=0.0696p pd=0.68u ps=1.16u
    I_MXI1_I96_I29_XG_MN0 (XI1_I96_I29_XG_n1 I1_I96_P5_4 I1_I96_G5_2n VSS) gpdk090_nmos1v w=0.24u l=0.1u ad=0.0528p as=0.0468p pd=0.68u ps=0.68u
    I_MXI1_I96_I29_XG_MN1 (VSS I1_I96_G3_2 XI1_I96_I29_XG_n1 VSS) gpdk090_nmos1v w=0.24u l=0.1u ad=0.0816p as=0.0528p pd=1.16u ps=0.68u
    I_MXI1_I84_I31_XG_MN2 (I1_I84_G7_4n I1_I84_G7_6 VSS VSS) gpdk090_nmos1v w=0.12u l=0.1u ad=0.0468p as=0.0696p pd=0.68u ps=1.16u
    I_MXI1_I84_I31_XG_MN0 (XI1_I84_I31_XG_n1 I1_I84_P7_6 I1_I84_G7_4n VSS) gpdk090_nmos1v w=0.24u l=0.1u ad=0.0528p as=0.0468p pd=0.68u ps=0.68u
    I_MXI1_I84_I31_XG_MN1 (VSS I1_I84_G5_4 XI1_I84_I31_XG_n1 VSS) gpdk090_nmos1v w=0.24u l=0.1u ad=0.0816p as=0.0528p pd=1.16u ps=0.68u
    I_MXI1_I72_I29_XG_MN2 (I1_I72_G5_2n I1_I72_G5_4 VSS VSS) gpdk090_nmos1v w=0.12u l=0.1u ad=0.0468p as=0.0696p pd=0.68u ps=1.16u
    I_MXI1_I72_I29_XG_MN0 (XI1_I72_I29_XG_n1 I1_I72_P5_4 I1_I72_G5_2n VSS) gpdk090_nmos1v w=0.24u l=0.1u ad=0.0528p as=0.0468p pd=0.68u ps=0.68u
    I_MXI1_I72_I29_XG_MN1 (VSS I1_I72_G3_2 XI1_I72_I29_XG_n1 VSS) gpdk090_nmos1v w=0.24u l=0.1u ad=0.0816p as=0.0528p pd=1.16u ps=0.68u
    I_MXI1_I60_I29_XG_MN2 (I1_I60_G5_2n I1_I60_G5_4 VSS VSS) gpdk090_nmos1v w=0.12u l=0.1u ad=0.0468p as=0.0696p pd=0.68u ps=1.16u
    I_MXI1_I60_I29_XG_MN0 (XI1_I60_I29_XG_n1 I1_I60_P5_4 I1_I60_G5_2n VSS) gpdk090_nmos1v w=0.24u l=0.1u ad=0.0528p as=0.0468p pd=0.68u ps=0.68u
    I_MXI1_I60_I29_XG_MN1 (VSS I1_I60_G3_2 XI1_I60_I29_XG_n1 VSS) gpdk090_nmos1v w=0.24u l=0.1u ad=0.0816p as=0.0528p pd=1.16u ps=0.68u
    I_MXI1_I48_I31_XG_MN2 (I1_I48_G7_4n I1_I48_G7_6 VSS VSS) gpdk090_nmos1v w=0.12u l=0.1u ad=0.0468p as=0.0696p pd=0.68u ps=1.16u
    I_MXI1_I48_I31_XG_MN0 (XI1_I48_I31_XG_n1 I1_I48_P7_6 I1_I48_G7_4n VSS) gpdk090_nmos1v w=0.24u l=0.1u ad=0.0528p as=0.0468p pd=0.68u ps=0.68u
    I_MXI1_I48_I31_XG_MN1 (VSS I1_I48_G5_4 XI1_I48_I31_XG_n1 VSS) gpdk090_nmos1v w=0.24u l=0.1u ad=0.0816p as=0.0528p pd=1.16u ps=0.68u
    I_MXI1_I96_I31_XG_MN2 (I1_I96_G7_4n I1_I96_G7_6 VSS VSS) gpdk090_nmos1v w=0.12u l=0.1u ad=0.0468p as=0.0696p pd=0.68u ps=1.16u
    I_MXI1_I96_I31_XG_MN0 (XI1_I96_I31_XG_n1 I1_I96_P7_6 I1_I96_G7_4n VSS) gpdk090_nmos1v w=0.24u l=0.1u ad=0.0528p as=0.0468p pd=0.68u ps=0.68u
    I_MXI1_I96_I31_XG_MN1 (VSS I1_I96_G5_4 XI1_I96_I31_XG_n1 VSS) gpdk090_nmos1v w=0.24u l=0.1u ad=0.0816p as=0.0528p pd=1.16u ps=0.68u
    I_MXI1_I72_I31_XG_MN2 (I1_I72_G7_4n I1_I72_G7_6 VSS VSS) gpdk090_nmos1v w=0.12u l=0.1u ad=0.0468p as=0.0696p pd=0.68u ps=1.16u
    I_MXI1_I72_I31_XG_MN0 (XI1_I72_I31_XG_n1 I1_I72_P7_6 I1_I72_G7_4n VSS) gpdk090_nmos1v w=0.24u l=0.1u ad=0.0528p as=0.0468p pd=0.68u ps=0.68u
    I_MXI1_I72_I31_XG_MN1 (VSS I1_I72_G5_4 XI1_I72_I31_XG_n1 VSS) gpdk090_nmos1v w=0.24u l=0.1u ad=0.0816p as=0.0528p pd=1.16u ps=0.68u
    I_MXI1_I60_I31_XG_MN2 (I1_I60_G7_4n I1_I60_G7_6 VSS VSS) gpdk090_nmos1v w=0.12u l=0.1u ad=0.0468p as=0.0696p pd=0.68u ps=1.16u
    I_MXI1_I60_I31_XG_MN0 (XI1_I60_I31_XG_n1 I1_I60_P7_6 I1_I60_G7_4n VSS) gpdk090_nmos1v w=0.24u l=0.1u ad=0.0528p as=0.0468p pd=0.68u ps=0.68u
    I_MXI1_I60_I31_XG_MN1 (VSS I1_I60_G5_4 XI1_I60_I31_XG_n1 VSS) gpdk090_nmos1v w=0.24u l=0.1u ad=0.0816p as=0.0528p pd=1.16u ps=0.68u
    I_MXI0_I77_I36_XG_MN2 (XI0_I77_I36_XG_n1 I0_I77_G7_4n VSS VSS) gpdk090_nmos1v w=0.24u l=0.1u ad=0.0528p as=0.0816p pd=0.68u ps=1.16u
    I_MXI0_I77_I36_XG_MN0 (I0_kc8 I0_I77_P7_4n XI0_I77_I36_XG_n1 VSS) gpdk090_nmos1v w=0.24u l=0.1u ad=0.0528p as=0.0528p pd=0.68u ps=0.68u
    I_MXI0_I77_I36_XG_MN1 (XI0_I77_I36_XG_n1 I0_I77_G3_0n I0_kc8 VSS) gpdk090_nmos1v w=0.24u l=0.1u ad=0.0816p as=0.0528p pd=1.16u ps=0.68u
    I_MXI0_I77_I25_XG_MN2 (XI0_I77_I25_XG_n1 I0_I77_gn7 VSS VSS) gpdk090_nmos1v w=0.24u l=0.1u ad=0.0528p as=0.0816p pd=0.68u ps=1.16u
    I_MXI0_I77_I25_XG_MN0 (I0_I77_G7_6 I0_I77_pn7 XI0_I77_I25_XG_n1 VSS) gpdk090_nmos1v w=0.24u l=0.1u ad=0.0528p as=0.0528p pd=0.68u ps=0.68u
    I_MXI0_I77_I25_XG_MN1 (XI0_I77_I25_XG_n1 I0_I77_gn6 I0_I77_G7_6 VSS) gpdk090_nmos1v w=0.24u l=0.1u ad=0.0816p as=0.0528p pd=1.16u ps=0.68u
    I_MXI0_I77_I35_XG_MN2 (XI0_I77_I35_XG_n1 I0_I77_G6_3n VSS VSS) gpdk090_nmos1v w=0.24u l=0.1u ad=0.0528p as=0.0816p pd=0.68u ps=1.16u
    I_MXI0_I77_I35_XG_MN0 (I0_kc7 I0_I77_P6_3n XI0_I77_I35_XG_n1 VSS) gpdk090_nmos1v w=0.24u l=0.1u ad=0.0528p as=0.0528p pd=0.68u ps=0.68u
    I_MXI0_I77_I35_XG_MN1 (XI0_I77_I35_XG_n1 I0_I77_G2_0n I0_kc7 VSS) gpdk090_nmos1v w=0.24u l=0.1u ad=0.0816p as=0.0528p pd=1.16u ps=0.68u
    I_MXI0_I77_I34_XG_MN2 (XI0_I77_I34_XG_n1 I0_I77_G5_2n VSS VSS) gpdk090_nmos1v w=0.24u l=0.1u ad=0.0528p as=0.0816p pd=0.68u ps=1.16u
    I_MXI0_I77_I34_XG_MN0 (I0_I77_G5_0 I0_I77_P5_2n XI0_I77_I34_XG_n1 VSS) gpdk090_nmos1v w=0.24u l=0.1u ad=0.0528p as=0.0528p pd=0.68u ps=0.68u
    I_MXI0_I77_I34_XG_MN1 (XI0_I77_I34_XG_n1 I0_I77_G1_0n I0_I77_G5_0 VSS) gpdk090_nmos1v w=0.24u l=0.1u ad=0.0816p as=0.0528p pd=1.16u ps=0.68u
    I_MXI0_I77_I23_XG_MN2 (XI0_I77_I23_XG_n1 I0_I77_gn5 VSS VSS) gpdk090_nmos1v w=0.24u l=0.1u ad=0.0528p as=0.0816p pd=0.68u ps=1.16u
    I_MXI0_I77_I23_XG_MN0 (I0_I77_G5_4 I0_I77_pn5 XI0_I77_I23_XG_n1 VSS) gpdk090_nmos1v w=0.24u l=0.1u ad=0.0528p as=0.0528p pd=0.68u ps=0.68u
    I_MXI0_I77_I23_XG_MN1 (XI0_I77_I23_XG_n1 I0_I77_gn4 I0_I77_G5_4 VSS) gpdk090_nmos1v w=0.24u l=0.1u ad=0.0816p as=0.0528p pd=1.16u ps=0.68u
    I_MXI0_I77_I24_XG_MN2 (XI0_I77_I24_XG_n1 I0_I77_gn6 VSS VSS) gpdk090_nmos1v w=0.24u l=0.1u ad=0.0528p as=0.0816p pd=0.68u ps=1.16u
    I_MXI0_I77_I24_XG_MN0 (I0_I77_G6_5 I0_I77_pn6 XI0_I77_I24_XG_n1 VSS) gpdk090_nmos1v w=0.24u l=0.1u ad=0.0528p as=0.0528p pd=0.68u ps=0.68u
    I_MXI0_I77_I24_XG_MN1 (XI0_I77_I24_XG_n1 I0_I77_gn5 I0_I77_G6_5 VSS) gpdk090_nmos1v w=0.24u l=0.1u ad=0.0816p as=0.0528p pd=1.16u ps=0.68u
    I_MXI1_I152_I34_XG_MN2 (XI1_I152_I34_XG_n1 I1_I152_G5_2n VSS VSS) gpdk090_nmos1v w=0.24u l=0.1u ad=0.0528p as=0.0816p pd=0.68u ps=1.16u
    I_MXI1_I152_I34_XG_MN0 (I1_I152_G5_0 I1_I152_P5_2n XI1_I152_I34_XG_n1 VSS) gpdk090_nmos1v w=0.24u l=0.1u ad=0.0528p as=0.0528p pd=0.68u ps=0.68u
    I_MXI1_I152_I34_XG_MN1 (XI1_I152_I34_XG_n1 I1_I152_G1_0n I1_I152_G5_0 VSS) gpdk090_nmos1v w=0.24u l=0.1u ad=0.0816p as=0.0528p pd=1.16u ps=0.68u
    I_MXI0_I77_I32_XG_MN2 (XI0_I77_I32_XG_n1 I0_I77_G4_1n VSS VSS) gpdk090_nmos1v w=0.24u l=0.1u ad=0.0528p as=0.0816p pd=0.68u ps=1.16u
    I_MXI0_I77_I32_XG_MN0 (I0_I77_G4_0 I0_I77_P4_1n XI0_I77_I32_XG_n1 VSS) gpdk090_nmos1v w=0.24u l=0.1u ad=0.0528p as=0.0528p pd=0.68u ps=0.68u
    I_MXI0_I77_I32_XG_MN1 (XI0_I77_I32_XG_n1 I0_I77_G0_0n I0_I77_G4_0 VSS) gpdk090_nmos1v w=0.24u l=0.1u ad=0.0816p as=0.0528p pd=1.16u ps=0.68u
    I_MXI0_I77_I22_XG_MN2 (XI0_I77_I22_XG_n1 I0_I77_gn4 VSS VSS) gpdk090_nmos1v w=0.24u l=0.1u ad=0.0528p as=0.0816p pd=0.68u ps=1.16u
    I_MXI0_I77_I22_XG_MN0 (I0_I77_G4_3 I0_I77_pn4 XI0_I77_I22_XG_n1 VSS) gpdk090_nmos1v w=0.24u l=0.1u ad=0.0528p as=0.0528p pd=0.68u ps=0.68u
    I_MXI0_I77_I22_XG_MN1 (XI0_I77_I22_XG_n1 I0_I77_gn3 I0_I77_G4_3 VSS) gpdk090_nmos1v w=0.24u l=0.1u ad=0.0816p as=0.0528p pd=1.16u ps=0.68u
    I_MXI0_I77_I21_XG_MN2 (XI0_I77_I21_XG_n1 I0_I77_gn3 VSS VSS) gpdk090_nmos1v w=0.24u l=0.1u ad=0.0528p as=0.0816p pd=0.68u ps=1.16u
    I_MXI0_I77_I21_XG_MN0 (I0_I77_G3_2 I0_I77_pn3 XI0_I77_I21_XG_n1 VSS) gpdk090_nmos1v w=0.24u l=0.1u ad=0.0528p as=0.0528p pd=0.68u ps=0.68u
    I_MXI0_I77_I21_XG_MN1 (XI0_I77_I21_XG_n1 I0_I77_gn2 I0_I77_G3_2 VSS) gpdk090_nmos1v w=0.24u l=0.1u ad=0.0816p as=0.0528p pd=1.16u ps=0.68u
    I_MXI1_I152_I25_XG_MN2 (XI1_I152_I25_XG_n1 I1_I152_gn7 VSS VSS) gpdk090_nmos1v w=0.24u l=0.1u ad=0.0528p as=0.0816p pd=0.68u ps=1.16u
    I_MXI1_I152_I25_XG_MN0 (I1_I152_G7_6 I1_I152_pn7 XI1_I152_I25_XG_n1 VSS) gpdk090_nmos1v w=0.24u l=0.1u ad=0.0528p as=0.0528p pd=0.68u ps=0.68u
    I_MXI1_I152_I25_XG_MN1 (XI1_I152_I25_XG_n1 I1_I152_gn6 I1_I152_G7_6 VSS) gpdk090_nmos1v w=0.24u l=0.1u ad=0.0816p as=0.0528p pd=1.16u ps=0.68u
    I_MXI1_I152_I36_XG_MN2 (XI1_I152_I36_XG_n1 I1_I152_G7_4n VSS VSS) gpdk090_nmos1v w=0.24u l=0.1u ad=0.0528p as=0.0816p pd=0.68u ps=1.16u
    I_MXI1_I152_I36_XG_MN0 (I1_rc7 I1_I152_P7_4n XI1_I152_I36_XG_n1 VSS) gpdk090_nmos1v w=0.24u l=0.1u ad=0.0528p as=0.0528p pd=0.68u ps=0.68u
    I_MXI1_I152_I36_XG_MN1 (XI1_I152_I36_XG_n1 I1_I152_G3_0n I1_rc7 VSS) gpdk090_nmos1v w=0.24u l=0.1u ad=0.0816p as=0.0528p pd=1.16u ps=0.68u
    I_MXI1_I152_I35_XG_MN2 (XI1_I152_I35_XG_n1 I1_I152_G6_3n VSS VSS) gpdk090_nmos1v w=0.24u l=0.1u ad=0.0528p as=0.0816p pd=0.68u ps=1.16u
    I_MXI1_I152_I35_XG_MN0 (I1_rc6 I1_I152_P6_3n XI1_I152_I35_XG_n1 VSS) gpdk090_nmos1v w=0.24u l=0.1u ad=0.0528p as=0.0528p pd=0.68u ps=0.68u
    I_MXI1_I152_I35_XG_MN1 (XI1_I152_I35_XG_n1 I1_I152_G2_0n I1_rc6 VSS) gpdk090_nmos1v w=0.24u l=0.1u ad=0.0816p as=0.0528p pd=1.16u ps=0.68u
    I_MXI0_I77_I19_XG_MN2 (XI0_I77_I19_XG_n1 I0_I77_gn1 VSS VSS) gpdk090_nmos1v w=0.24u l=0.1u ad=0.0528p as=0.0816p pd=0.68u ps=1.16u
    I_MXI0_I77_I19_XG_MN0 (I0_I77_G1_0 I0_I77_pn1 XI0_I77_I19_XG_n1 VSS) gpdk090_nmos1v w=0.24u l=0.1u ad=0.0528p as=0.0528p pd=0.68u ps=0.68u
    I_MXI0_I77_I19_XG_MN1 (XI0_I77_I19_XG_n1 I0_I77_G0_0n I0_I77_G1_0 VSS) gpdk090_nmos1v w=0.24u l=0.1u ad=0.0816p as=0.0528p pd=1.16u ps=0.68u
    I_MXI0_I77_I20_XG_MN2 (XI0_I77_I20_XG_n1 I0_I77_gn2 VSS VSS) gpdk090_nmos1v w=0.24u l=0.1u ad=0.0528p as=0.0816p pd=0.68u ps=1.16u
    I_MXI0_I77_I20_XG_MN0 (I0_I77_G2_1 I0_I77_pn2 XI0_I77_I20_XG_n1 VSS) gpdk090_nmos1v w=0.24u l=0.1u ad=0.0528p as=0.0528p pd=0.68u ps=0.68u
    I_MXI0_I77_I20_XG_MN1 (XI0_I77_I20_XG_n1 I0_I77_gn1 I0_I77_G2_1 VSS) gpdk090_nmos1v w=0.24u l=0.1u ad=0.0816p as=0.0528p pd=1.16u ps=0.68u
    I_MXI1_I152_I24_XG_MN2 (XI1_I152_I24_XG_n1 I1_I152_gn6 VSS VSS) gpdk090_nmos1v w=0.24u l=0.1u ad=0.0528p as=0.0816p pd=0.68u ps=1.16u
    I_MXI1_I152_I24_XG_MN0 (I1_I152_G6_5 I1_I152_pn6 XI1_I152_I24_XG_n1 VSS) gpdk090_nmos1v w=0.24u l=0.1u ad=0.0528p as=0.0528p pd=0.68u ps=0.68u
    I_MXI1_I152_I24_XG_MN1 (XI1_I152_I24_XG_n1 I1_I152_gn5 I1_I152_G6_5 VSS) gpdk090_nmos1v w=0.24u l=0.1u ad=0.0816p as=0.0528p pd=1.16u ps=0.68u
    I_MXI1_I152_I23_XG_MN2 (XI1_I152_I23_XG_n1 I1_I152_gn5 VSS VSS) gpdk090_nmos1v w=0.24u l=0.1u ad=0.0528p as=0.0816p pd=0.68u ps=1.16u
    I_MXI1_I152_I23_XG_MN0 (I1_I152_G5_4 I1_I152_pn5 XI1_I152_I23_XG_n1 VSS) gpdk090_nmos1v w=0.24u l=0.1u ad=0.0528p as=0.0528p pd=0.68u ps=0.68u
    I_MXI1_I152_I23_XG_MN1 (XI1_I152_I23_XG_n1 I1_I152_gn4 I1_I152_G5_4 VSS) gpdk090_nmos1v w=0.24u l=0.1u ad=0.0816p as=0.0528p pd=1.16u ps=0.68u
    I_MXI1_I152_I32_XG_MN2 (XI1_I152_I32_XG_n1 I1_I152_G4_1n VSS VSS) gpdk090_nmos1v w=0.24u l=0.1u ad=0.0528p as=0.0816p pd=0.68u ps=1.16u
    I_MXI1_I152_I32_XG_MN0 (I1_I152_G4_0 I1_I152_P4_1n XI1_I152_I32_XG_n1 VSS) gpdk090_nmos1v w=0.24u l=0.1u ad=0.0528p as=0.0528p pd=0.68u ps=0.68u
    I_MXI1_I152_I32_XG_MN1 (XI1_I152_I32_XG_n1 I1_I152_G0_0n I1_I152_G4_0 VSS) gpdk090_nmos1v w=0.24u l=0.1u ad=0.0816p as=0.0528p pd=1.16u ps=0.68u
    I_MXI1_I152_I19_XG_MN2 (XI1_I152_I19_XG_n1 I1_I152_gn1 VSS VSS) gpdk090_nmos1v w=0.24u l=0.1u ad=0.0528p as=0.0816p pd=0.68u ps=1.16u
    I_MXI1_I152_I19_XG_MN0 (I1_I152_G1_0 I1_I152_pn1 XI1_I152_I19_XG_n1 VSS) gpdk090_nmos1v w=0.24u l=0.1u ad=0.0528p as=0.0528p pd=0.68u ps=0.68u
    I_MXI1_I152_I19_XG_MN1 (XI1_I152_I19_XG_n1 I1_I152_G0_0n I1_I152_G1_0 VSS) gpdk090_nmos1v w=0.24u l=0.1u ad=0.0816p as=0.0528p pd=1.16u ps=0.68u
    I_MXI0_I77_I17_XG_MN2 (XI0_I77_I17_XG_n1 I0_I77_gn0 VSS VSS) gpdk090_nmos1v w=0.24u l=0.1u ad=0.0528p as=0.0816p pd=0.68u ps=1.16u
    I_MXI0_I77_I17_XG_MN0 (I0_I77_G0_0 I0_I77_pn0 XI0_I77_I17_XG_n1 VSS) gpdk090_nmos1v w=0.24u l=0.1u ad=0.0528p as=0.0528p pd=0.68u ps=0.68u
    I_MXI0_I77_I17_XG_MN1 (XI0_I77_I17_XG_n1 I0_I77_cinn I0_I77_G0_0 VSS) gpdk090_nmos1v w=0.24u l=0.1u ad=0.0816p as=0.0528p pd=1.16u ps=0.68u
    I_MXI1_I152_I22_XG_MN2 (XI1_I152_I22_XG_n1 I1_I152_gn4 VSS VSS) gpdk090_nmos1v w=0.24u l=0.1u ad=0.0528p as=0.0816p pd=0.68u ps=1.16u
    I_MXI1_I152_I22_XG_MN0 (I1_I152_G4_3 I1_I152_pn4 XI1_I152_I22_XG_n1 VSS) gpdk090_nmos1v w=0.24u l=0.1u ad=0.0528p as=0.0528p pd=0.68u ps=0.68u
    I_MXI1_I152_I22_XG_MN1 (XI1_I152_I22_XG_n1 I1_I152_gn3 I1_I152_G4_3 VSS) gpdk090_nmos1v w=0.24u l=0.1u ad=0.0816p as=0.0528p pd=1.16u ps=0.68u
    I_MXI1_I152_I21_XG_MN2 (XI1_I152_I21_XG_n1 I1_I152_gn3 VSS VSS) gpdk090_nmos1v w=0.24u l=0.1u ad=0.0528p as=0.0816p pd=0.68u ps=1.16u
    I_MXI1_I152_I21_XG_MN0 (I1_I152_G3_2 I1_I152_pn3 XI1_I152_I21_XG_n1 VSS) gpdk090_nmos1v w=0.24u l=0.1u ad=0.0528p as=0.0528p pd=0.68u ps=0.68u
    I_MXI1_I152_I21_XG_MN1 (XI1_I152_I21_XG_n1 I1_I152_gn2 I1_I152_G3_2 VSS) gpdk090_nmos1v w=0.24u l=0.1u ad=0.0816p as=0.0528p pd=1.16u ps=0.68u
    I_MXI1_I152_I20_XG_MN2 (XI1_I152_I20_XG_n1 I1_I152_gn2 VSS VSS) gpdk090_nmos1v w=0.24u l=0.1u ad=0.0528p as=0.0816p pd=0.68u ps=1.16u
    I_MXI1_I152_I20_XG_MN0 (I1_I152_G2_1 I1_I152_pn2 XI1_I152_I20_XG_n1 VSS) gpdk090_nmos1v w=0.24u l=0.1u ad=0.0528p as=0.0528p pd=0.68u ps=0.68u
    I_MXI1_I152_I20_XG_MN1 (XI1_I152_I20_XG_n1 I1_I152_gn1 I1_I152_G2_1 VSS) gpdk090_nmos1v w=0.24u l=0.1u ad=0.0816p as=0.0528p pd=1.16u ps=0.68u
    I_MXI2_I1_I8_I25_XG_MN2 (XI2_I1_I8_I25_XG_n1 I2_I1_I8_gn7 VSS VSS) gpdk090_nmos1v w=0.24u l=0.1u ad=0.0528p as=0.0816p pd=0.68u ps=1.16u
    I_MXI2_I1_I8_I25_XG_MN0 (I2_I1_I8_G7_6 I2_I1_I8_pn7 XI2_I1_I8_I25_XG_n1 VSS) gpdk090_nmos1v w=0.24u l=0.1u ad=0.0528p as=0.0528p pd=0.68u ps=0.68u
    I_MXI2_I1_I8_I25_XG_MN1 (XI2_I1_I8_I25_XG_n1 I2_I1_I8_gn6 I2_I1_I8_G7_6 VSS) gpdk090_nmos1v w=0.24u l=0.1u ad=0.0816p as=0.0528p pd=1.16u ps=0.68u
    I_MXI2_I1_I8_I24_XG_MN2 (XI2_I1_I8_I24_XG_n1 I2_I1_I8_gn6 VSS VSS) gpdk090_nmos1v w=0.24u l=0.1u ad=0.0528p as=0.0816p pd=0.68u ps=1.16u
    I_MXI2_I1_I8_I24_XG_MN0 (I2_I1_I8_G6_5 I2_I1_I8_pn6 XI2_I1_I8_I24_XG_n1 VSS) gpdk090_nmos1v w=0.24u l=0.1u ad=0.0528p as=0.0528p pd=0.68u ps=0.68u
    I_MXI2_I1_I8_I24_XG_MN1 (XI2_I1_I8_I24_XG_n1 I2_I1_I8_gn5 I2_I1_I8_G6_5 VSS) gpdk090_nmos1v w=0.24u l=0.1u ad=0.0816p as=0.0528p pd=1.16u ps=0.68u
    I_MXI1_I132_I36_XG_MN2 (XI1_I132_I36_XG_n1 I1_I132_G7_4n VSS VSS) gpdk090_nmos1v w=0.24u l=0.1u ad=0.0528p as=0.0816p pd=0.68u ps=1.16u
    I_MXI1_I132_I36_XG_MN0 (I1_c7_8 I1_I132_P7_4n XI1_I132_I36_XG_n1 VSS) gpdk090_nmos1v w=0.24u l=0.1u ad=0.0528p as=0.0528p pd=0.68u ps=0.68u
    I_MXI1_I132_I36_XG_MN1 (XI1_I132_I36_XG_n1 I1_I132_G3_0n I1_c7_8 VSS) gpdk090_nmos1v w=0.24u l=0.1u ad=0.0816p as=0.0528p pd=1.16u ps=0.68u
    I_MXI1_I132_I34_XG_MN2 (XI1_I132_I34_XG_n1 I1_I132_G5_2n VSS VSS) gpdk090_nmos1v w=0.24u l=0.1u ad=0.0528p as=0.0816p pd=0.68u ps=1.16u
    I_MXI1_I132_I34_XG_MN0 (I1_I132_G5_0 I1_I132_P5_2n XI1_I132_I34_XG_n1 VSS) gpdk090_nmos1v w=0.24u l=0.1u ad=0.0528p as=0.0528p pd=0.68u ps=0.68u
    I_MXI1_I132_I34_XG_MN1 (XI1_I132_I34_XG_n1 I1_I132_G1_0n I1_I132_G5_0 VSS) gpdk090_nmos1v w=0.24u l=0.1u ad=0.0816p as=0.0528p pd=1.16u ps=0.68u
    I_MXI1_I152_I17_XG_MN2 (XI1_I152_I17_XG_n1 I1_I152_gn0 VSS VSS) gpdk090_nmos1v w=0.24u l=0.1u ad=0.0528p as=0.0816p pd=0.68u ps=1.16u
    I_MXI1_I152_I17_XG_MN0 (I1_I152_G0_0 I1_I152_pn0 XI1_I152_I17_XG_n1 VSS) gpdk090_nmos1v w=0.24u l=0.1u ad=0.0528p as=0.0528p pd=0.68u ps=0.68u
    I_MXI1_I152_I17_XG_MN1 (XI1_I152_I17_XG_n1 I1_I152_cinn I1_I152_G0_0 VSS) gpdk090_nmos1v w=0.24u l=0.1u ad=0.0816p as=0.0528p pd=1.16u ps=0.68u
    I_MXI2_I1_I8_I36_XG_MN2 (XI2_I1_I8_I36_XG_n1 I2_I1_I8_G7_4n VSS VSS) gpdk090_nmos1v w=0.24u l=0.1u ad=0.0528p as=0.0816p pd=0.68u ps=1.16u
    I_MXI2_I1_I8_I36_XG_MN0 (I2_C8 I2_I1_I8_P7_4n XI2_I1_I8_I36_XG_n1 VSS) gpdk090_nmos1v w=0.24u l=0.1u ad=0.0528p as=0.0528p pd=0.68u ps=0.68u
    I_MXI2_I1_I8_I36_XG_MN1 (XI2_I1_I8_I36_XG_n1 I2_I1_I8_G3_0n I2_C8 VSS) gpdk090_nmos1v w=0.24u l=0.1u ad=0.0816p as=0.0528p pd=1.16u ps=0.68u
    I_MXI2_I1_I8_I35_XG_MN2 (XI2_I1_I8_I35_XG_n1 I2_I1_I8_G6_3n VSS VSS) gpdk090_nmos1v w=0.24u l=0.1u ad=0.0528p as=0.0816p pd=0.68u ps=1.16u
    I_MXI2_I1_I8_I35_XG_MN0 (I2_C7 I2_I1_I8_P6_3n XI2_I1_I8_I35_XG_n1 VSS) gpdk090_nmos1v w=0.24u l=0.1u ad=0.0528p as=0.0528p pd=0.68u ps=0.68u
    I_MXI2_I1_I8_I35_XG_MN1 (XI2_I1_I8_I35_XG_n1 I2_I1_I8_G2_0n I2_C7 VSS) gpdk090_nmos1v w=0.24u l=0.1u ad=0.0816p as=0.0528p pd=1.16u ps=0.68u
    I_MXI2_I1_I8_I23_XG_MN2 (XI2_I1_I8_I23_XG_n1 I2_I1_I8_gn5 VSS VSS) gpdk090_nmos1v w=0.24u l=0.1u ad=0.0528p as=0.0816p pd=0.68u ps=1.16u
    I_MXI2_I1_I8_I23_XG_MN0 (I2_I1_I8_G5_4 I2_I1_I8_pn5 XI2_I1_I8_I23_XG_n1 VSS) gpdk090_nmos1v w=0.24u l=0.1u ad=0.0528p as=0.0528p pd=0.68u ps=0.68u
    I_MXI2_I1_I8_I23_XG_MN1 (XI2_I1_I8_I23_XG_n1 I2_I1_I8_gn4 I2_I1_I8_G5_4 VSS) gpdk090_nmos1v w=0.24u l=0.1u ad=0.0816p as=0.0528p pd=1.16u ps=0.68u
    I_MXI2_I1_I8_I22_XG_MN2 (XI2_I1_I8_I22_XG_n1 I2_I1_I8_gn4 VSS VSS) gpdk090_nmos1v w=0.24u l=0.1u ad=0.0528p as=0.0816p pd=0.68u ps=1.16u
    I_MXI2_I1_I8_I22_XG_MN0 (I2_I1_I8_G4_3 I2_I1_I8_pn4 XI2_I1_I8_I22_XG_n1 VSS) gpdk090_nmos1v w=0.24u l=0.1u ad=0.0528p as=0.0528p pd=0.68u ps=0.68u
    I_MXI2_I1_I8_I22_XG_MN1 (XI2_I1_I8_I22_XG_n1 I2_I1_I8_gn3 I2_I1_I8_G4_3 VSS) gpdk090_nmos1v w=0.24u l=0.1u ad=0.0816p as=0.0528p pd=1.16u ps=0.68u
    I_MXI1_I132_I35_XG_MN2 (XI1_I132_I35_XG_n1 I1_I132_G6_3n VSS VSS) gpdk090_nmos1v w=0.24u l=0.1u ad=0.0528p as=0.0816p pd=0.68u ps=1.16u
    I_MXI1_I132_I35_XG_MN0 (I1_c7_7 I1_I132_P6_3n XI1_I132_I35_XG_n1 VSS) gpdk090_nmos1v w=0.24u l=0.1u ad=0.0528p as=0.0528p pd=0.68u ps=0.68u
    I_MXI1_I132_I35_XG_MN1 (XI1_I132_I35_XG_n1 I1_I132_G2_0n I1_c7_7 VSS) gpdk090_nmos1v w=0.24u l=0.1u ad=0.0816p as=0.0528p pd=1.16u ps=0.68u
    I_MXI1_I132_I32_XG_MN2 (XI1_I132_I32_XG_n1 I1_I132_G4_1n VSS VSS) gpdk090_nmos1v w=0.24u l=0.1u ad=0.0528p as=0.0816p pd=0.68u ps=1.16u
    I_MXI1_I132_I32_XG_MN0 (I1_I132_G4_0 I1_I132_P4_1n XI1_I132_I32_XG_n1 VSS) gpdk090_nmos1v w=0.24u l=0.1u ad=0.0528p as=0.0528p pd=0.68u ps=0.68u
    I_MXI1_I132_I32_XG_MN1 (XI1_I132_I32_XG_n1 I1_I132_G0_0n I1_I132_G4_0 VSS) gpdk090_nmos1v w=0.24u l=0.1u ad=0.0816p as=0.0528p pd=1.16u ps=0.68u
    I_MXI1_I132_I19_XG_MN2 (XI1_I132_I19_XG_n1 I1_I132_gn1 VSS VSS) gpdk090_nmos1v w=0.24u l=0.1u ad=0.0528p as=0.0816p pd=0.68u ps=1.16u
    I_MXI1_I132_I19_XG_MN0 (I1_I132_G1_0 I1_I132_pn1 XI1_I132_I19_XG_n1 VSS) gpdk090_nmos1v w=0.24u l=0.1u ad=0.0528p as=0.0528p pd=0.68u ps=0.68u
    I_MXI1_I132_I19_XG_MN1 (XI1_I132_I19_XG_n1 I1_I132_G0_0n I1_I132_G1_0 VSS) gpdk090_nmos1v w=0.24u l=0.1u ad=0.0816p as=0.0528p pd=1.16u ps=0.68u
    I_MXI2_I1_I8_I34_XG_MN2 (XI2_I1_I8_I34_XG_n1 I2_I1_I8_G5_2n VSS VSS) gpdk090_nmos1v w=0.24u l=0.1u ad=0.0528p as=0.0816p pd=0.68u ps=1.16u
    I_MXI2_I1_I8_I34_XG_MN0 (I2_I1_I8_G5_0 I2_I1_I8_P5_2n XI2_I1_I8_I34_XG_n1 VSS) gpdk090_nmos1v w=0.24u l=0.1u ad=0.0528p as=0.0528p pd=0.68u ps=0.68u
    I_MXI2_I1_I8_I34_XG_MN1 (XI2_I1_I8_I34_XG_n1 I2_I1_I8_G1_0n I2_I1_I8_G5_0 VSS) gpdk090_nmos1v w=0.24u l=0.1u ad=0.0816p as=0.0528p pd=1.16u ps=0.68u
    I_MXI2_I1_I8_I21_XG_MN2 (XI2_I1_I8_I21_XG_n1 I2_I1_I8_gn3 VSS VSS) gpdk090_nmos1v w=0.24u l=0.1u ad=0.0528p as=0.0816p pd=0.68u ps=1.16u
    I_MXI2_I1_I8_I21_XG_MN0 (I2_I1_I8_G3_2 I2_I1_I8_pn3 XI2_I1_I8_I21_XG_n1 VSS) gpdk090_nmos1v w=0.24u l=0.1u ad=0.0528p as=0.0528p pd=0.68u ps=0.68u
    I_MXI2_I1_I8_I21_XG_MN1 (XI2_I1_I8_I21_XG_n1 I2_I1_I8_gn2 I2_I1_I8_G3_2 VSS) gpdk090_nmos1v w=0.24u l=0.1u ad=0.0816p as=0.0528p pd=1.16u ps=0.68u
    I_MXI1_I132_I25_XG_MN2 (XI1_I132_I25_XG_n1 I1_I132_gn7 VSS VSS) gpdk090_nmos1v w=0.24u l=0.1u ad=0.0528p as=0.0816p pd=0.68u ps=1.16u
    I_MXI1_I132_I25_XG_MN0 (I1_I132_G7_6 I1_I132_pn7 XI1_I132_I25_XG_n1 VSS) gpdk090_nmos1v w=0.24u l=0.1u ad=0.0528p as=0.0528p pd=0.68u ps=0.68u
    I_MXI1_I132_I25_XG_MN1 (XI1_I132_I25_XG_n1 I1_I132_gn6 I1_I132_G7_6 VSS) gpdk090_nmos1v w=0.24u l=0.1u ad=0.0816p as=0.0528p pd=1.16u ps=0.68u
    I_MXI1_I132_I24_XG_MN2 (XI1_I132_I24_XG_n1 I1_I132_gn6 VSS VSS) gpdk090_nmos1v w=0.24u l=0.1u ad=0.0528p as=0.0816p pd=0.68u ps=1.16u
    I_MXI1_I132_I24_XG_MN0 (I1_I132_G6_5 I1_I132_pn6 XI1_I132_I24_XG_n1 VSS) gpdk090_nmos1v w=0.24u l=0.1u ad=0.0528p as=0.0528p pd=0.68u ps=0.68u
    I_MXI1_I132_I24_XG_MN1 (XI1_I132_I24_XG_n1 I1_I132_gn5 I1_I132_G6_5 VSS) gpdk090_nmos1v w=0.24u l=0.1u ad=0.0816p as=0.0528p pd=1.16u ps=0.68u
    I_MXI1_I132_I23_XG_MN2 (XI1_I132_I23_XG_n1 I1_I132_gn5 VSS VSS) gpdk090_nmos1v w=0.24u l=0.1u ad=0.0528p as=0.0816p pd=0.68u ps=1.16u
    I_MXI1_I132_I23_XG_MN0 (I1_I132_G5_4 I1_I132_pn5 XI1_I132_I23_XG_n1 VSS) gpdk090_nmos1v w=0.24u l=0.1u ad=0.0528p as=0.0528p pd=0.68u ps=0.68u
    I_MXI1_I132_I23_XG_MN1 (XI1_I132_I23_XG_n1 I1_I132_gn4 I1_I132_G5_4 VSS) gpdk090_nmos1v w=0.24u l=0.1u ad=0.0816p as=0.0528p pd=1.16u ps=0.68u
    I_MXI1_I132_I22_XG_MN2 (XI1_I132_I22_XG_n1 I1_I132_gn4 VSS VSS) gpdk090_nmos1v w=0.24u l=0.1u ad=0.0528p as=0.0816p pd=0.68u ps=1.16u
    I_MXI1_I132_I22_XG_MN0 (I1_I132_G4_3 I1_I132_pn4 XI1_I132_I22_XG_n1 VSS) gpdk090_nmos1v w=0.24u l=0.1u ad=0.0528p as=0.0528p pd=0.68u ps=0.68u
    I_MXI1_I132_I22_XG_MN1 (XI1_I132_I22_XG_n1 I1_I132_gn3 I1_I132_G4_3 VSS) gpdk090_nmos1v w=0.24u l=0.1u ad=0.0816p as=0.0528p pd=1.16u ps=0.68u
    I_MXI1_I132_I21_XG_MN2 (XI1_I132_I21_XG_n1 I1_I132_gn3 VSS VSS) gpdk090_nmos1v w=0.24u l=0.1u ad=0.0528p as=0.0816p pd=0.68u ps=1.16u
    I_MXI1_I132_I21_XG_MN0 (I1_I132_G3_2 I1_I132_pn3 XI1_I132_I21_XG_n1 VSS) gpdk090_nmos1v w=0.24u l=0.1u ad=0.0528p as=0.0528p pd=0.68u ps=0.68u
    I_MXI1_I132_I21_XG_MN1 (XI1_I132_I21_XG_n1 I1_I132_gn2 I1_I132_G3_2 VSS) gpdk090_nmos1v w=0.24u l=0.1u ad=0.0816p as=0.0528p pd=1.16u ps=0.68u
    I_MXI1_I132_I20_XG_MN2 (XI1_I132_I20_XG_n1 I1_I132_gn2 VSS VSS) gpdk090_nmos1v w=0.24u l=0.1u ad=0.0528p as=0.0816p pd=0.68u ps=1.16u
    I_MXI1_I132_I20_XG_MN0 (I1_I132_G2_1 I1_I132_pn2 XI1_I132_I20_XG_n1 VSS) gpdk090_nmos1v w=0.24u l=0.1u ad=0.0528p as=0.0528p pd=0.68u ps=0.68u
    I_MXI1_I132_I20_XG_MN1 (XI1_I132_I20_XG_n1 I1_I132_gn1 I1_I132_G2_1 VSS) gpdk090_nmos1v w=0.24u l=0.1u ad=0.0816p as=0.0528p pd=1.16u ps=0.68u
    I_MXI1_I132_I17_XG_MN2 (XI1_I132_I17_XG_n1 I1_I132_gn0 VSS VSS) gpdk090_nmos1v w=0.24u l=0.1u ad=0.0528p as=0.0816p pd=0.68u ps=1.16u
    I_MXI1_I132_I17_XG_MN0 (I1_I132_G0_0 I1_I132_pn0 XI1_I132_I17_XG_n1 VSS) gpdk090_nmos1v w=0.24u l=0.1u ad=0.0528p as=0.0528p pd=0.68u ps=0.68u
    I_MXI1_I132_I17_XG_MN1 (XI1_I132_I17_XG_n1 I1_I132_cinn I1_I132_G0_0 VSS) gpdk090_nmos1v w=0.24u l=0.1u ad=0.0816p as=0.0528p pd=1.16u ps=0.68u
    I_MXI2_I1_I8_I32_XG_MN2 (XI2_I1_I8_I32_XG_n1 I2_I1_I8_G4_1n VSS VSS) gpdk090_nmos1v w=0.24u l=0.1u ad=0.0528p as=0.0816p pd=0.68u ps=1.16u
    I_MXI2_I1_I8_I32_XG_MN0 (I2_I1_I8_G4_0 I2_I1_I8_P4_1n XI2_I1_I8_I32_XG_n1 VSS) gpdk090_nmos1v w=0.24u l=0.1u ad=0.0528p as=0.0528p pd=0.68u ps=0.68u
    I_MXI2_I1_I8_I32_XG_MN1 (XI2_I1_I8_I32_XG_n1 I2_I1_I8_G0_0n I2_I1_I8_G4_0 VSS) gpdk090_nmos1v w=0.24u l=0.1u ad=0.0816p as=0.0528p pd=1.16u ps=0.68u
    I_MXI2_I1_I8_I17_XG_MN2 (XI2_I1_I8_I17_XG_n1 I2_I1_I8_gn0 VSS VSS) gpdk090_nmos1v w=0.24u l=0.1u ad=0.0528p as=0.0816p pd=0.68u ps=1.16u
    I_MXI2_I1_I8_I17_XG_MN0 (I2_I1_I8_G0_0 I2_I1_I8_pn0 XI2_I1_I8_I17_XG_n1 VSS) gpdk090_nmos1v w=0.24u l=0.1u ad=0.0528p as=0.0528p pd=0.68u ps=0.68u
    I_MXI2_I1_I8_I17_XG_MN1 (XI2_I1_I8_I17_XG_n1 I2_I1_I8_cinn I2_I1_I8_G0_0 VSS) gpdk090_nmos1v w=0.24u l=0.1u ad=0.0816p as=0.0528p pd=1.16u ps=0.68u
    I_MXI2_I1_I8_I19_XG_MN2 (XI2_I1_I8_I19_XG_n1 I2_I1_I8_gn1 VSS VSS) gpdk090_nmos1v w=0.24u l=0.1u ad=0.0528p as=0.0816p pd=0.68u ps=1.16u
    I_MXI2_I1_I8_I19_XG_MN0 (I2_I1_I8_G1_0 I2_I1_I8_pn1 XI2_I1_I8_I19_XG_n1 VSS) gpdk090_nmos1v w=0.24u l=0.1u ad=0.0528p as=0.0528p pd=0.68u ps=0.68u
    I_MXI2_I1_I8_I19_XG_MN1 (XI2_I1_I8_I19_XG_n1 I2_I1_I8_G0_0n I2_I1_I8_G1_0 VSS) gpdk090_nmos1v w=0.24u l=0.1u ad=0.0816p as=0.0528p pd=1.16u ps=0.68u
    I_MXI2_I1_I8_I20_XG_MN2 (XI2_I1_I8_I20_XG_n1 I2_I1_I8_gn2 VSS VSS) gpdk090_nmos1v w=0.24u l=0.1u ad=0.0528p as=0.0816p pd=0.68u ps=1.16u
    I_MXI2_I1_I8_I20_XG_MN0 (I2_I1_I8_G2_1 I2_I1_I8_pn2 XI2_I1_I8_I20_XG_n1 VSS) gpdk090_nmos1v w=0.24u l=0.1u ad=0.0528p as=0.0528p pd=0.68u ps=0.68u
    I_MXI2_I1_I8_I20_XG_MN1 (XI2_I1_I8_I20_XG_n1 I2_I1_I8_gn1 I2_I1_I8_G2_1 VSS) gpdk090_nmos1v w=0.24u l=0.1u ad=0.0816p as=0.0528p pd=1.16u ps=0.68u
    I_MXI1_I120_I34_XG_MN2 (XI1_I120_I34_XG_n1 I1_I120_G5_2n VSS VSS) gpdk090_nmos1v w=0.24u l=0.1u ad=0.0528p as=0.0816p pd=0.68u ps=1.16u
    I_MXI1_I120_I34_XG_MN0 (I1_I120_G5_0 I1_I120_P5_2n XI1_I120_I34_XG_n1 VSS) gpdk090_nmos1v w=0.24u l=0.1u ad=0.0528p as=0.0528p pd=0.68u ps=0.68u
    I_MXI1_I120_I34_XG_MN1 (XI1_I120_I34_XG_n1 I1_I120_G1_0n I1_I120_G5_0 VSS) gpdk090_nmos1v w=0.24u l=0.1u ad=0.0816p as=0.0528p pd=1.16u ps=0.68u
    I_MXI1_I120_I35_XG_MN2 (XI1_I120_I35_XG_n1 I1_I120_G6_3n VSS VSS) gpdk090_nmos1v w=0.24u l=0.1u ad=0.0528p as=0.0816p pd=0.68u ps=1.16u
    I_MXI1_I120_I35_XG_MN0 (I1_c6_7 I1_I120_P6_3n XI1_I120_I35_XG_n1 VSS) gpdk090_nmos1v w=0.24u l=0.1u ad=0.0528p as=0.0528p pd=0.68u ps=0.68u
    I_MXI1_I120_I35_XG_MN1 (XI1_I120_I35_XG_n1 I1_I120_G2_0n I1_c6_7 VSS) gpdk090_nmos1v w=0.24u l=0.1u ad=0.0816p as=0.0528p pd=1.16u ps=0.68u
    I_MXI1_I120_I32_XG_MN2 (XI1_I120_I32_XG_n1 I1_I120_G4_1n VSS VSS) gpdk090_nmos1v w=0.24u l=0.1u ad=0.0528p as=0.0816p pd=0.68u ps=1.16u
    I_MXI1_I120_I32_XG_MN0 (I1_I120_G4_0 I1_I120_P4_1n XI1_I120_I32_XG_n1 VSS) gpdk090_nmos1v w=0.24u l=0.1u ad=0.0528p as=0.0528p pd=0.68u ps=0.68u
    I_MXI1_I120_I32_XG_MN1 (XI1_I120_I32_XG_n1 I1_I120_G0_0n I1_I120_G4_0 VSS) gpdk090_nmos1v w=0.24u l=0.1u ad=0.0816p as=0.0528p pd=1.16u ps=0.68u
    I_MXI1_I120_I19_XG_MN2 (XI1_I120_I19_XG_n1 I1_I120_gn1 VSS VSS) gpdk090_nmos1v w=0.24u l=0.1u ad=0.0528p as=0.0816p pd=0.68u ps=1.16u
    I_MXI1_I120_I19_XG_MN0 (I1_I120_G1_0 I1_I120_pn1 XI1_I120_I19_XG_n1 VSS) gpdk090_nmos1v w=0.24u l=0.1u ad=0.0528p as=0.0528p pd=0.68u ps=0.68u
    I_MXI1_I120_I19_XG_MN1 (XI1_I120_I19_XG_n1 I1_I120_G0_0n I1_I120_G1_0 VSS) gpdk090_nmos1v w=0.24u l=0.1u ad=0.0816p as=0.0528p pd=1.16u ps=0.68u
    I_MXI1_I120_I17_XG_MN2 (XI1_I120_I17_XG_n1 I1_I120_gn0 VSS VSS) gpdk090_nmos1v w=0.24u l=0.1u ad=0.0528p as=0.0816p pd=0.68u ps=1.16u
    I_MXI1_I120_I17_XG_MN0 (I1_I120_G0_0 I1_I120_pn0 XI1_I120_I17_XG_n1 VSS) gpdk090_nmos1v w=0.24u l=0.1u ad=0.0528p as=0.0528p pd=0.68u ps=0.68u
    I_MXI1_I120_I17_XG_MN1 (XI1_I120_I17_XG_n1 I1_I120_cinn I1_I120_G0_0 VSS) gpdk090_nmos1v w=0.24u l=0.1u ad=0.0816p as=0.0528p pd=1.16u ps=0.68u
    I_MXI1_I120_I36_XG_MN2 (XI1_I120_I36_XG_n1 I1_I120_G7_4n VSS VSS) gpdk090_nmos1v w=0.24u l=0.1u ad=0.0528p as=0.0816p pd=0.68u ps=1.16u
    I_MXI1_I120_I36_XG_MN0 (I1_c6_8 I1_I120_P7_4n XI1_I120_I36_XG_n1 VSS) gpdk090_nmos1v w=0.24u l=0.1u ad=0.0528p as=0.0528p pd=0.68u ps=0.68u
    I_MXI1_I120_I36_XG_MN1 (XI1_I120_I36_XG_n1 I1_I120_G3_0n I1_c6_8 VSS) gpdk090_nmos1v w=0.24u l=0.1u ad=0.0816p as=0.0528p pd=1.16u ps=0.68u
    I_MXI1_I120_I22_XG_MN2 (XI1_I120_I22_XG_n1 I1_I120_gn4 VSS VSS) gpdk090_nmos1v w=0.24u l=0.1u ad=0.0528p as=0.0816p pd=0.68u ps=1.16u
    I_MXI1_I120_I22_XG_MN0 (I1_I120_G4_3 I1_I120_pn4 XI1_I120_I22_XG_n1 VSS) gpdk090_nmos1v w=0.24u l=0.1u ad=0.0528p as=0.0528p pd=0.68u ps=0.68u
    I_MXI1_I120_I22_XG_MN1 (XI1_I120_I22_XG_n1 I1_I120_gn3 I1_I120_G4_3 VSS) gpdk090_nmos1v w=0.24u l=0.1u ad=0.0816p as=0.0528p pd=1.16u ps=0.68u
    I_MXI1_I120_I21_XG_MN2 (XI1_I120_I21_XG_n1 I1_I120_gn3 VSS VSS) gpdk090_nmos1v w=0.24u l=0.1u ad=0.0528p as=0.0816p pd=0.68u ps=1.16u
    I_MXI1_I120_I21_XG_MN0 (I1_I120_G3_2 I1_I120_pn3 XI1_I120_I21_XG_n1 VSS) gpdk090_nmos1v w=0.24u l=0.1u ad=0.0528p as=0.0528p pd=0.68u ps=0.68u
    I_MXI1_I120_I21_XG_MN1 (XI1_I120_I21_XG_n1 I1_I120_gn2 I1_I120_G3_2 VSS) gpdk090_nmos1v w=0.24u l=0.1u ad=0.0816p as=0.0528p pd=1.16u ps=0.68u
    I_MXI1_I120_I20_XG_MN2 (XI1_I120_I20_XG_n1 I1_I120_gn2 VSS VSS) gpdk090_nmos1v w=0.24u l=0.1u ad=0.0528p as=0.0816p pd=0.68u ps=1.16u
    I_MXI1_I120_I20_XG_MN0 (I1_I120_G2_1 I1_I120_pn2 XI1_I120_I20_XG_n1 VSS) gpdk090_nmos1v w=0.24u l=0.1u ad=0.0528p as=0.0528p pd=0.68u ps=0.68u
    I_MXI1_I120_I20_XG_MN1 (XI1_I120_I20_XG_n1 I1_I120_gn1 I1_I120_G2_1 VSS) gpdk090_nmos1v w=0.24u l=0.1u ad=0.0816p as=0.0528p pd=1.16u ps=0.68u
    I_MXI1_I120_I25_XG_MN2 (XI1_I120_I25_XG_n1 I1_I120_gn7 VSS VSS) gpdk090_nmos1v w=0.24u l=0.1u ad=0.0528p as=0.0816p pd=0.68u ps=1.16u
    I_MXI1_I120_I25_XG_MN0 (I1_I120_G7_6 I1_I120_pn7 XI1_I120_I25_XG_n1 VSS) gpdk090_nmos1v w=0.24u l=0.1u ad=0.0528p as=0.0528p pd=0.68u ps=0.68u
    I_MXI1_I120_I25_XG_MN1 (XI1_I120_I25_XG_n1 I1_I120_gn6 I1_I120_G7_6 VSS) gpdk090_nmos1v w=0.24u l=0.1u ad=0.0816p as=0.0528p pd=1.16u ps=0.68u
    I_MXI1_I120_I24_XG_MN2 (XI1_I120_I24_XG_n1 I1_I120_gn6 VSS VSS) gpdk090_nmos1v w=0.24u l=0.1u ad=0.0528p as=0.0816p pd=0.68u ps=1.16u
    I_MXI1_I120_I24_XG_MN0 (I1_I120_G6_5 I1_I120_pn6 XI1_I120_I24_XG_n1 VSS) gpdk090_nmos1v w=0.24u l=0.1u ad=0.0528p as=0.0528p pd=0.68u ps=0.68u
    I_MXI1_I120_I24_XG_MN1 (XI1_I120_I24_XG_n1 I1_I120_gn5 I1_I120_G6_5 VSS) gpdk090_nmos1v w=0.24u l=0.1u ad=0.0816p as=0.0528p pd=1.16u ps=0.68u
    I_MXI1_I120_I23_XG_MN2 (XI1_I120_I23_XG_n1 I1_I120_gn5 VSS VSS) gpdk090_nmos1v w=0.24u l=0.1u ad=0.0528p as=0.0816p pd=0.68u ps=1.16u
    I_MXI1_I120_I23_XG_MN0 (I1_I120_G5_4 I1_I120_pn5 XI1_I120_I23_XG_n1 VSS) gpdk090_nmos1v w=0.24u l=0.1u ad=0.0528p as=0.0528p pd=0.68u ps=0.68u
    I_MXI1_I120_I23_XG_MN1 (XI1_I120_I23_XG_n1 I1_I120_gn4 I1_I120_G5_4 VSS) gpdk090_nmos1v w=0.24u l=0.1u ad=0.0816p as=0.0528p pd=1.16u ps=0.68u
    I_MXI1_I108_I17_XG_MN2 (XI1_I108_I17_XG_n1 I1_I108_gn0 VSS VSS) gpdk090_nmos1v w=0.24u l=0.1u ad=0.0528p as=0.0816p pd=0.68u ps=1.16u
    I_MXI1_I108_I17_XG_MN0 (I1_I108_G0_0 I1_I108_pn0 XI1_I108_I17_XG_n1 VSS) gpdk090_nmos1v w=0.24u l=0.1u ad=0.0528p as=0.0528p pd=0.68u ps=0.68u
    I_MXI1_I108_I17_XG_MN1 (XI1_I108_I17_XG_n1 I1_I108_cinn I1_I108_G0_0 VSS) gpdk090_nmos1v w=0.24u l=0.1u ad=0.0816p as=0.0528p pd=1.16u ps=0.68u
    I_MXI1_I108_I19_XG_MN2 (XI1_I108_I19_XG_n1 I1_I108_gn1 VSS VSS) gpdk090_nmos1v w=0.24u l=0.1u ad=0.0528p as=0.0816p pd=0.68u ps=1.16u
    I_MXI1_I108_I19_XG_MN0 (I1_I108_G1_0 I1_I108_pn1 XI1_I108_I19_XG_n1 VSS) gpdk090_nmos1v w=0.24u l=0.1u ad=0.0528p as=0.0528p pd=0.68u ps=0.68u
    I_MXI1_I108_I19_XG_MN1 (XI1_I108_I19_XG_n1 I1_I108_G0_0n I1_I108_G1_0 VSS) gpdk090_nmos1v w=0.24u l=0.1u ad=0.0816p as=0.0528p pd=1.16u ps=0.68u
    I_MXI1_I96_I17_XG_MN2 (XI1_I96_I17_XG_n1 I1_I96_gn0 VSS VSS) gpdk090_nmos1v w=0.24u l=0.1u ad=0.0528p as=0.0816p pd=0.68u ps=1.16u
    I_MXI1_I96_I17_XG_MN0 (I1_I96_G0_0 I1_I96_pn0 XI1_I96_I17_XG_n1 VSS) gpdk090_nmos1v w=0.24u l=0.1u ad=0.0528p as=0.0528p pd=0.68u ps=0.68u
    I_MXI1_I96_I17_XG_MN1 (XI1_I96_I17_XG_n1 I1_I96_cinn I1_I96_G0_0 VSS) gpdk090_nmos1v w=0.24u l=0.1u ad=0.0816p as=0.0528p pd=1.16u ps=0.68u
    I_MXI1_I84_I17_XG_MN2 (XI1_I84_I17_XG_n1 I1_I84_gn0 VSS VSS) gpdk090_nmos1v w=0.24u l=0.1u ad=0.0528p as=0.0816p pd=0.68u ps=1.16u
    I_MXI1_I84_I17_XG_MN0 (I1_I84_G0_0 I1_I84_pn0 XI1_I84_I17_XG_n1 VSS) gpdk090_nmos1v w=0.24u l=0.1u ad=0.0528p as=0.0528p pd=0.68u ps=0.68u
    I_MXI1_I84_I17_XG_MN1 (XI1_I84_I17_XG_n1 I1_I84_cinn I1_I84_G0_0 VSS) gpdk090_nmos1v w=0.24u l=0.1u ad=0.0816p as=0.0528p pd=1.16u ps=0.68u
    I_MXI1_I108_I32_XG_MN2 (XI1_I108_I32_XG_n1 I1_I108_G4_1n VSS VSS) gpdk090_nmos1v w=0.24u l=0.1u ad=0.0528p as=0.0816p pd=0.68u ps=1.16u
    I_MXI1_I108_I32_XG_MN0 (I1_I108_G4_0 I1_I108_P4_1n XI1_I108_I32_XG_n1 VSS) gpdk090_nmos1v w=0.24u l=0.1u ad=0.0528p as=0.0528p pd=0.68u ps=0.68u
    I_MXI1_I108_I32_XG_MN1 (XI1_I108_I32_XG_n1 I1_I108_G0_0n I1_I108_G4_0 VSS) gpdk090_nmos1v w=0.24u l=0.1u ad=0.0816p as=0.0528p pd=1.16u ps=0.68u
    I_MXI1_I108_I20_XG_MN2 (XI1_I108_I20_XG_n1 I1_I108_gn2 VSS VSS) gpdk090_nmos1v w=0.24u l=0.1u ad=0.0528p as=0.0816p pd=0.68u ps=1.16u
    I_MXI1_I108_I20_XG_MN0 (I1_I108_G2_1 I1_I108_pn2 XI1_I108_I20_XG_n1 VSS) gpdk090_nmos1v w=0.24u l=0.1u ad=0.0528p as=0.0528p pd=0.68u ps=0.68u
    I_MXI1_I108_I20_XG_MN1 (XI1_I108_I20_XG_n1 I1_I108_gn1 I1_I108_G2_1 VSS) gpdk090_nmos1v w=0.24u l=0.1u ad=0.0816p as=0.0528p pd=1.16u ps=0.68u
    I_MXI1_I72_I17_XG_MN2 (XI1_I72_I17_XG_n1 I1_I72_gn0 VSS VSS) gpdk090_nmos1v w=0.24u l=0.1u ad=0.0528p as=0.0816p pd=0.68u ps=1.16u
    I_MXI1_I72_I17_XG_MN0 (I1_I72_G0_0 I1_I72_pn0 XI1_I72_I17_XG_n1 VSS) gpdk090_nmos1v w=0.24u l=0.1u ad=0.0528p as=0.0528p pd=0.68u ps=0.68u
    I_MXI1_I72_I17_XG_MN1 (XI1_I72_I17_XG_n1 I1_I72_cinn I1_I72_G0_0 VSS) gpdk090_nmos1v w=0.24u l=0.1u ad=0.0816p as=0.0528p pd=1.16u ps=0.68u
    I_MXI1_I60_I17_XG_MN2 (XI1_I60_I17_XG_n1 I1_I60_gn0 VSS VSS) gpdk090_nmos1v w=0.24u l=0.1u ad=0.0528p as=0.0816p pd=0.68u ps=1.16u
    I_MXI1_I60_I17_XG_MN0 (I1_I60_G0_0 I1_I60_pn0 XI1_I60_I17_XG_n1 VSS) gpdk090_nmos1v w=0.24u l=0.1u ad=0.0528p as=0.0528p pd=0.68u ps=0.68u
    I_MXI1_I60_I17_XG_MN1 (XI1_I60_I17_XG_n1 I1_I60_cinn I1_I60_G0_0 VSS) gpdk090_nmos1v w=0.24u l=0.1u ad=0.0816p as=0.0528p pd=1.16u ps=0.68u
    I_MXI1_I48_I17_XG_MN2 (XI1_I48_I17_XG_n1 I1_I48_gn0 VSS VSS) gpdk090_nmos1v w=0.24u l=0.1u ad=0.0528p as=0.0816p pd=0.68u ps=1.16u
    I_MXI1_I48_I17_XG_MN0 (I1_I48_G0_0 I1_I48_pn0 XI1_I48_I17_XG_n1 VSS) gpdk090_nmos1v w=0.24u l=0.1u ad=0.0528p as=0.0528p pd=0.68u ps=0.68u
    I_MXI1_I48_I17_XG_MN1 (XI1_I48_I17_XG_n1 I1_I48_cinn I1_I48_G0_0 VSS) gpdk090_nmos1v w=0.24u l=0.1u ad=0.0816p as=0.0528p pd=1.16u ps=0.68u
    I_MXI1_I108_I35_XG_MN2 (XI1_I108_I35_XG_n1 I1_I108_G6_3n VSS VSS) gpdk090_nmos1v w=0.24u l=0.1u ad=0.0528p as=0.0816p pd=0.68u ps=1.16u
    I_MXI1_I108_I35_XG_MN0 (I1_c5_7 I1_I108_P6_3n XI1_I108_I35_XG_n1 VSS) gpdk090_nmos1v w=0.24u l=0.1u ad=0.0528p as=0.0528p pd=0.68u ps=0.68u
    I_MXI1_I108_I35_XG_MN1 (XI1_I108_I35_XG_n1 I1_I108_G2_0n I1_c5_7 VSS) gpdk090_nmos1v w=0.24u l=0.1u ad=0.0816p as=0.0528p pd=1.16u ps=0.68u
    I_MXI1_I108_I22_XG_MN2 (XI1_I108_I22_XG_n1 I1_I108_gn4 VSS VSS) gpdk090_nmos1v w=0.24u l=0.1u ad=0.0528p as=0.0816p pd=0.68u ps=1.16u
    I_MXI1_I108_I22_XG_MN0 (I1_I108_G4_3 I1_I108_pn4 XI1_I108_I22_XG_n1 VSS) gpdk090_nmos1v w=0.24u l=0.1u ad=0.0528p as=0.0528p pd=0.68u ps=0.68u
    I_MXI1_I108_I22_XG_MN1 (XI1_I108_I22_XG_n1 I1_I108_gn3 I1_I108_G4_3 VSS) gpdk090_nmos1v w=0.24u l=0.1u ad=0.0816p as=0.0528p pd=1.16u ps=0.68u
    I_MXI1_I108_I21_XG_MN2 (XI1_I108_I21_XG_n1 I1_I108_gn3 VSS VSS) gpdk090_nmos1v w=0.24u l=0.1u ad=0.0528p as=0.0816p pd=0.68u ps=1.16u
    I_MXI1_I108_I21_XG_MN0 (I1_I108_G3_2 I1_I108_pn3 XI1_I108_I21_XG_n1 VSS) gpdk090_nmos1v w=0.24u l=0.1u ad=0.0528p as=0.0528p pd=0.68u ps=0.68u
    I_MXI1_I108_I21_XG_MN1 (XI1_I108_I21_XG_n1 I1_I108_gn2 I1_I108_G3_2 VSS) gpdk090_nmos1v w=0.24u l=0.1u ad=0.0816p as=0.0528p pd=1.16u ps=0.68u
    I_MXI1_I84_I19_XG_MN2 (XI1_I84_I19_XG_n1 I1_I84_gn1 VSS VSS) gpdk090_nmos1v w=0.24u l=0.1u ad=0.0528p as=0.0816p pd=0.68u ps=1.16u
    I_MXI1_I84_I19_XG_MN0 (I1_I84_G1_0 I1_I84_pn1 XI1_I84_I19_XG_n1 VSS) gpdk090_nmos1v w=0.24u l=0.1u ad=0.0528p as=0.0528p pd=0.68u ps=0.68u
    I_MXI1_I84_I19_XG_MN1 (XI1_I84_I19_XG_n1 I1_I84_G0_0n I1_I84_G1_0 VSS) gpdk090_nmos1v w=0.24u l=0.1u ad=0.0816p as=0.0528p pd=1.16u ps=0.68u
    I_MXI1_I84_I20_XG_MN2 (XI1_I84_I20_XG_n1 I1_I84_gn2 VSS VSS) gpdk090_nmos1v w=0.24u l=0.1u ad=0.0528p as=0.0816p pd=0.68u ps=1.16u
    I_MXI1_I84_I20_XG_MN0 (I1_I84_G2_1 I1_I84_pn2 XI1_I84_I20_XG_n1 VSS) gpdk090_nmos1v w=0.24u l=0.1u ad=0.0528p as=0.0528p pd=0.68u ps=0.68u
    I_MXI1_I84_I20_XG_MN1 (XI1_I84_I20_XG_n1 I1_I84_gn1 I1_I84_G2_1 VSS) gpdk090_nmos1v w=0.24u l=0.1u ad=0.0816p as=0.0528p pd=1.16u ps=0.68u
    I_MXI1_I72_I19_XG_MN2 (XI1_I72_I19_XG_n1 I1_I72_gn1 VSS VSS) gpdk090_nmos1v w=0.24u l=0.1u ad=0.0528p as=0.0816p pd=0.68u ps=1.16u
    I_MXI1_I72_I19_XG_MN0 (I1_I72_G1_0 I1_I72_pn1 XI1_I72_I19_XG_n1 VSS) gpdk090_nmos1v w=0.24u l=0.1u ad=0.0528p as=0.0528p pd=0.68u ps=0.68u
    I_MXI1_I72_I19_XG_MN1 (XI1_I72_I19_XG_n1 I1_I72_G0_0n I1_I72_G1_0 VSS) gpdk090_nmos1v w=0.24u l=0.1u ad=0.0816p as=0.0528p pd=1.16u ps=0.68u
    I_MXI1_I48_I19_XG_MN2 (XI1_I48_I19_XG_n1 I1_I48_gn1 VSS VSS) gpdk090_nmos1v w=0.24u l=0.1u ad=0.0528p as=0.0816p pd=0.68u ps=1.16u
    I_MXI1_I48_I19_XG_MN0 (I1_I48_G1_0 I1_I48_pn1 XI1_I48_I19_XG_n1 VSS) gpdk090_nmos1v w=0.24u l=0.1u ad=0.0528p as=0.0528p pd=0.68u ps=0.68u
    I_MXI1_I48_I19_XG_MN1 (XI1_I48_I19_XG_n1 I1_I48_G0_0n I1_I48_G1_0 VSS) gpdk090_nmos1v w=0.24u l=0.1u ad=0.0816p as=0.0528p pd=1.16u ps=0.68u
    I_MXI1_I48_I20_XG_MN2 (XI1_I48_I20_XG_n1 I1_I48_gn2 VSS VSS) gpdk090_nmos1v w=0.24u l=0.1u ad=0.0528p as=0.0816p pd=0.68u ps=1.16u
    I_MXI1_I48_I20_XG_MN0 (I1_I48_G2_1 I1_I48_pn2 XI1_I48_I20_XG_n1 VSS) gpdk090_nmos1v w=0.24u l=0.1u ad=0.0528p as=0.0528p pd=0.68u ps=0.68u
    I_MXI1_I48_I20_XG_MN1 (XI1_I48_I20_XG_n1 I1_I48_gn1 I1_I48_G2_1 VSS) gpdk090_nmos1v w=0.24u l=0.1u ad=0.0816p as=0.0528p pd=1.16u ps=0.68u
    I_MXI1_I48_I21_XG_MN2 (XI1_I48_I21_XG_n1 I1_I48_gn3 VSS VSS) gpdk090_nmos1v w=0.24u l=0.1u ad=0.0528p as=0.0816p pd=0.68u ps=1.16u
    I_MXI1_I48_I21_XG_MN0 (I1_I48_G3_2 I1_I48_pn3 XI1_I48_I21_XG_n1 VSS) gpdk090_nmos1v w=0.24u l=0.1u ad=0.0528p as=0.0528p pd=0.68u ps=0.68u
    I_MXI1_I48_I21_XG_MN1 (XI1_I48_I21_XG_n1 I1_I48_gn2 I1_I48_G3_2 VSS) gpdk090_nmos1v w=0.24u l=0.1u ad=0.0816p as=0.0528p pd=1.16u ps=0.68u
    I_MXI1_I108_I34_XG_MN2 (XI1_I108_I34_XG_n1 I1_I108_G5_2n VSS VSS) gpdk090_nmos1v w=0.24u l=0.1u ad=0.0528p as=0.0816p pd=0.68u ps=1.16u
    I_MXI1_I108_I34_XG_MN0 (I1_I108_G5_0 I1_I108_P5_2n XI1_I108_I34_XG_n1 VSS) gpdk090_nmos1v w=0.24u l=0.1u ad=0.0528p as=0.0528p pd=0.68u ps=0.68u
    I_MXI1_I108_I34_XG_MN1 (XI1_I108_I34_XG_n1 I1_I108_G1_0n I1_I108_G5_0 VSS) gpdk090_nmos1v w=0.24u l=0.1u ad=0.0816p as=0.0528p pd=1.16u ps=0.68u
    I_MXI1_I108_I36_XG_MN2 (XI1_I108_I36_XG_n1 I1_I108_G7_4n VSS VSS) gpdk090_nmos1v w=0.24u l=0.1u ad=0.0528p as=0.0816p pd=0.68u ps=1.16u
    I_MXI1_I108_I36_XG_MN0 (I1_c5_8 I1_I108_P7_4n XI1_I108_I36_XG_n1 VSS) gpdk090_nmos1v w=0.24u l=0.1u ad=0.0528p as=0.0528p pd=0.68u ps=0.68u
    I_MXI1_I108_I36_XG_MN1 (XI1_I108_I36_XG_n1 I1_I108_G3_0n I1_c5_8 VSS) gpdk090_nmos1v w=0.24u l=0.1u ad=0.0816p as=0.0528p pd=1.16u ps=0.68u
    I_MXI1_I96_I19_XG_MN2 (XI1_I96_I19_XG_n1 I1_I96_gn1 VSS VSS) gpdk090_nmos1v w=0.24u l=0.1u ad=0.0528p as=0.0816p pd=0.68u ps=1.16u
    I_MXI1_I96_I19_XG_MN0 (I1_I96_G1_0 I1_I96_pn1 XI1_I96_I19_XG_n1 VSS) gpdk090_nmos1v w=0.24u l=0.1u ad=0.0528p as=0.0528p pd=0.68u ps=0.68u
    I_MXI1_I96_I19_XG_MN1 (XI1_I96_I19_XG_n1 I1_I96_G0_0n I1_I96_G1_0 VSS) gpdk090_nmos1v w=0.24u l=0.1u ad=0.0816p as=0.0528p pd=1.16u ps=0.68u
    I_MXI1_I96_I20_XG_MN2 (XI1_I96_I20_XG_n1 I1_I96_gn2 VSS VSS) gpdk090_nmos1v w=0.24u l=0.1u ad=0.0528p as=0.0816p pd=0.68u ps=1.16u
    I_MXI1_I96_I20_XG_MN0 (I1_I96_G2_1 I1_I96_pn2 XI1_I96_I20_XG_n1 VSS) gpdk090_nmos1v w=0.24u l=0.1u ad=0.0528p as=0.0528p pd=0.68u ps=0.68u
    I_MXI1_I96_I20_XG_MN1 (XI1_I96_I20_XG_n1 I1_I96_gn1 I1_I96_G2_1 VSS) gpdk090_nmos1v w=0.24u l=0.1u ad=0.0816p as=0.0528p pd=1.16u ps=0.68u
    I_MXI1_I84_I32_XG_MN2 (XI1_I84_I32_XG_n1 I1_I84_G4_1n VSS VSS) gpdk090_nmos1v w=0.24u l=0.1u ad=0.0528p as=0.0816p pd=0.68u ps=1.16u
    I_MXI1_I84_I32_XG_MN0 (I1_I84_G4_0 I1_I84_P4_1n XI1_I84_I32_XG_n1 VSS) gpdk090_nmos1v w=0.24u l=0.1u ad=0.0528p as=0.0528p pd=0.68u ps=0.68u
    I_MXI1_I84_I32_XG_MN1 (XI1_I84_I32_XG_n1 I1_I84_G0_0n I1_I84_G4_0 VSS) gpdk090_nmos1v w=0.24u l=0.1u ad=0.0816p as=0.0528p pd=1.16u ps=0.68u
    I_MXI1_I84_I21_XG_MN2 (XI1_I84_I21_XG_n1 I1_I84_gn3 VSS VSS) gpdk090_nmos1v w=0.24u l=0.1u ad=0.0528p as=0.0816p pd=0.68u ps=1.16u
    I_MXI1_I84_I21_XG_MN0 (I1_I84_G3_2 I1_I84_pn3 XI1_I84_I21_XG_n1 VSS) gpdk090_nmos1v w=0.24u l=0.1u ad=0.0528p as=0.0528p pd=0.68u ps=0.68u
    I_MXI1_I84_I21_XG_MN1 (XI1_I84_I21_XG_n1 I1_I84_gn2 I1_I84_G3_2 VSS) gpdk090_nmos1v w=0.24u l=0.1u ad=0.0816p as=0.0528p pd=1.16u ps=0.68u
    I_MXI1_I72_I32_XG_MN2 (XI1_I72_I32_XG_n1 I1_I72_G4_1n VSS VSS) gpdk090_nmos1v w=0.24u l=0.1u ad=0.0528p as=0.0816p pd=0.68u ps=1.16u
    I_MXI1_I72_I32_XG_MN0 (I1_I72_G4_0 I1_I72_P4_1n XI1_I72_I32_XG_n1 VSS) gpdk090_nmos1v w=0.24u l=0.1u ad=0.0528p as=0.0528p pd=0.68u ps=0.68u
    I_MXI1_I72_I32_XG_MN1 (XI1_I72_I32_XG_n1 I1_I72_G0_0n I1_I72_G4_0 VSS) gpdk090_nmos1v w=0.24u l=0.1u ad=0.0816p as=0.0528p pd=1.16u ps=0.68u
    I_MXI1_I72_I20_XG_MN2 (XI1_I72_I20_XG_n1 I1_I72_gn2 VSS VSS) gpdk090_nmos1v w=0.24u l=0.1u ad=0.0528p as=0.0816p pd=0.68u ps=1.16u
    I_MXI1_I72_I20_XG_MN0 (I1_I72_G2_1 I1_I72_pn2 XI1_I72_I20_XG_n1 VSS) gpdk090_nmos1v w=0.24u l=0.1u ad=0.0528p as=0.0528p pd=0.68u ps=0.68u
    I_MXI1_I72_I20_XG_MN1 (XI1_I72_I20_XG_n1 I1_I72_gn1 I1_I72_G2_1 VSS) gpdk090_nmos1v w=0.24u l=0.1u ad=0.0816p as=0.0528p pd=1.16u ps=0.68u
    I_MXI1_I60_I19_XG_MN2 (XI1_I60_I19_XG_n1 I1_I60_gn1 VSS VSS) gpdk090_nmos1v w=0.24u l=0.1u ad=0.0528p as=0.0816p pd=0.68u ps=1.16u
    I_MXI1_I60_I19_XG_MN0 (I1_I60_G1_0 I1_I60_pn1 XI1_I60_I19_XG_n1 VSS) gpdk090_nmos1v w=0.24u l=0.1u ad=0.0528p as=0.0528p pd=0.68u ps=0.68u
    I_MXI1_I60_I19_XG_MN1 (XI1_I60_I19_XG_n1 I1_I60_G0_0n I1_I60_G1_0 VSS) gpdk090_nmos1v w=0.24u l=0.1u ad=0.0816p as=0.0528p pd=1.16u ps=0.68u
    I_MXI1_I60_I20_XG_MN2 (XI1_I60_I20_XG_n1 I1_I60_gn2 VSS VSS) gpdk090_nmos1v w=0.24u l=0.1u ad=0.0528p as=0.0816p pd=0.68u ps=1.16u
    I_MXI1_I60_I20_XG_MN0 (I1_I60_G2_1 I1_I60_pn2 XI1_I60_I20_XG_n1 VSS) gpdk090_nmos1v w=0.24u l=0.1u ad=0.0528p as=0.0528p pd=0.68u ps=0.68u
    I_MXI1_I60_I20_XG_MN1 (XI1_I60_I20_XG_n1 I1_I60_gn1 I1_I60_G2_1 VSS) gpdk090_nmos1v w=0.24u l=0.1u ad=0.0816p as=0.0528p pd=1.16u ps=0.68u
    I_MXI1_I48_I32_XG_MN2 (XI1_I48_I32_XG_n1 I1_I48_G4_1n VSS VSS) gpdk090_nmos1v w=0.24u l=0.1u ad=0.0528p as=0.0816p pd=0.68u ps=1.16u
    I_MXI1_I48_I32_XG_MN0 (I1_I48_G4_0 I1_I48_P4_1n XI1_I48_I32_XG_n1 VSS) gpdk090_nmos1v w=0.24u l=0.1u ad=0.0528p as=0.0528p pd=0.68u ps=0.68u
    I_MXI1_I48_I32_XG_MN1 (XI1_I48_I32_XG_n1 I1_I48_G0_0n I1_I48_G4_0 VSS) gpdk090_nmos1v w=0.24u l=0.1u ad=0.0816p as=0.0528p pd=1.16u ps=0.68u
    I_MXI1_I48_I22_XG_MN2 (XI1_I48_I22_XG_n1 I1_I48_gn4 VSS VSS) gpdk090_nmos1v w=0.24u l=0.1u ad=0.0528p as=0.0816p pd=0.68u ps=1.16u
    I_MXI1_I48_I22_XG_MN0 (I1_I48_G4_3 I1_I48_pn4 XI1_I48_I22_XG_n1 VSS) gpdk090_nmos1v w=0.24u l=0.1u ad=0.0528p as=0.0528p pd=0.68u ps=0.68u
    I_MXI1_I48_I22_XG_MN1 (XI1_I48_I22_XG_n1 I1_I48_gn3 I1_I48_G4_3 VSS) gpdk090_nmos1v w=0.24u l=0.1u ad=0.0816p as=0.0528p pd=1.16u ps=0.68u
    I_MXI1_I108_I24_XG_MN2 (XI1_I108_I24_XG_n1 I1_I108_gn6 VSS VSS) gpdk090_nmos1v w=0.24u l=0.1u ad=0.0528p as=0.0816p pd=0.68u ps=1.16u
    I_MXI1_I108_I24_XG_MN0 (I1_I108_G6_5 I1_I108_pn6 XI1_I108_I24_XG_n1 VSS) gpdk090_nmos1v w=0.24u l=0.1u ad=0.0528p as=0.0528p pd=0.68u ps=0.68u
    I_MXI1_I108_I24_XG_MN1 (XI1_I108_I24_XG_n1 I1_I108_gn5 I1_I108_G6_5 VSS) gpdk090_nmos1v w=0.24u l=0.1u ad=0.0816p as=0.0528p pd=1.16u ps=0.68u
    I_MXI1_I108_I23_XG_MN2 (XI1_I108_I23_XG_n1 I1_I108_gn5 VSS VSS) gpdk090_nmos1v w=0.24u l=0.1u ad=0.0528p as=0.0816p pd=0.68u ps=1.16u
    I_MXI1_I108_I23_XG_MN0 (I1_I108_G5_4 I1_I108_pn5 XI1_I108_I23_XG_n1 VSS) gpdk090_nmos1v w=0.24u l=0.1u ad=0.0528p as=0.0528p pd=0.68u ps=0.68u
    I_MXI1_I108_I23_XG_MN1 (XI1_I108_I23_XG_n1 I1_I108_gn4 I1_I108_G5_4 VSS) gpdk090_nmos1v w=0.24u l=0.1u ad=0.0816p as=0.0528p pd=1.16u ps=0.68u
    I_MXI1_I96_I32_XG_MN2 (XI1_I96_I32_XG_n1 I1_I96_G4_1n VSS VSS) gpdk090_nmos1v w=0.24u l=0.1u ad=0.0528p as=0.0816p pd=0.68u ps=1.16u
    I_MXI1_I96_I32_XG_MN0 (I1_I96_G4_0 I1_I96_P4_1n XI1_I96_I32_XG_n1 VSS) gpdk090_nmos1v w=0.24u l=0.1u ad=0.0528p as=0.0528p pd=0.68u ps=0.68u
    I_MXI1_I96_I32_XG_MN1 (XI1_I96_I32_XG_n1 I1_I96_G0_0n I1_I96_G4_0 VSS) gpdk090_nmos1v w=0.24u l=0.1u ad=0.0816p as=0.0528p pd=1.16u ps=0.68u
    I_MXI1_I96_I22_XG_MN2 (XI1_I96_I22_XG_n1 I1_I96_gn4 VSS VSS) gpdk090_nmos1v w=0.24u l=0.1u ad=0.0528p as=0.0816p pd=0.68u ps=1.16u
    I_MXI1_I96_I22_XG_MN0 (I1_I96_G4_3 I1_I96_pn4 XI1_I96_I22_XG_n1 VSS) gpdk090_nmos1v w=0.24u l=0.1u ad=0.0528p as=0.0528p pd=0.68u ps=0.68u
    I_MXI1_I96_I22_XG_MN1 (XI1_I96_I22_XG_n1 I1_I96_gn3 I1_I96_G4_3 VSS) gpdk090_nmos1v w=0.24u l=0.1u ad=0.0816p as=0.0528p pd=1.16u ps=0.68u
    I_MXI1_I96_I21_XG_MN2 (XI1_I96_I21_XG_n1 I1_I96_gn3 VSS VSS) gpdk090_nmos1v w=0.24u l=0.1u ad=0.0528p as=0.0816p pd=0.68u ps=1.16u
    I_MXI1_I96_I21_XG_MN0 (I1_I96_G3_2 I1_I96_pn3 XI1_I96_I21_XG_n1 VSS) gpdk090_nmos1v w=0.24u l=0.1u ad=0.0528p as=0.0528p pd=0.68u ps=0.68u
    I_MXI1_I96_I21_XG_MN1 (XI1_I96_I21_XG_n1 I1_I96_gn2 I1_I96_G3_2 VSS) gpdk090_nmos1v w=0.24u l=0.1u ad=0.0816p as=0.0528p pd=1.16u ps=0.68u
    I_MXI1_I84_I22_XG_MN2 (XI1_I84_I22_XG_n1 I1_I84_gn4 VSS VSS) gpdk090_nmos1v w=0.24u l=0.1u ad=0.0528p as=0.0816p pd=0.68u ps=1.16u
    I_MXI1_I84_I22_XG_MN0 (I1_I84_G4_3 I1_I84_pn4 XI1_I84_I22_XG_n1 VSS) gpdk090_nmos1v w=0.24u l=0.1u ad=0.0528p as=0.0528p pd=0.68u ps=0.68u
    I_MXI1_I84_I22_XG_MN1 (XI1_I84_I22_XG_n1 I1_I84_gn3 I1_I84_G4_3 VSS) gpdk090_nmos1v w=0.24u l=0.1u ad=0.0816p as=0.0528p pd=1.16u ps=0.68u
    I_MXI1_I72_I35_XG_MN2 (XI1_I72_I35_XG_n1 I1_I72_G6_3n VSS VSS) gpdk090_nmos1v w=0.24u l=0.1u ad=0.0528p as=0.0816p pd=0.68u ps=1.16u
    I_MXI1_I72_I35_XG_MN0 (I1_c2_7 I1_I72_P6_3n XI1_I72_I35_XG_n1 VSS) gpdk090_nmos1v w=0.24u l=0.1u ad=0.0528p as=0.0528p pd=0.68u ps=0.68u
    I_MXI1_I72_I35_XG_MN1 (XI1_I72_I35_XG_n1 I1_I72_G2_0n I1_c2_7 VSS) gpdk090_nmos1v w=0.24u l=0.1u ad=0.0816p as=0.0528p pd=1.16u ps=0.68u
    I_MXI1_I72_I21_XG_MN2 (XI1_I72_I21_XG_n1 I1_I72_gn3 VSS VSS) gpdk090_nmos1v w=0.24u l=0.1u ad=0.0528p as=0.0816p pd=0.68u ps=1.16u
    I_MXI1_I72_I21_XG_MN0 (I1_I72_G3_2 I1_I72_pn3 XI1_I72_I21_XG_n1 VSS) gpdk090_nmos1v w=0.24u l=0.1u ad=0.0528p as=0.0528p pd=0.68u ps=0.68u
    I_MXI1_I72_I21_XG_MN1 (XI1_I72_I21_XG_n1 I1_I72_gn2 I1_I72_G3_2 VSS) gpdk090_nmos1v w=0.24u l=0.1u ad=0.0816p as=0.0528p pd=1.16u ps=0.68u
    I_MXI1_I72_I22_XG_MN2 (XI1_I72_I22_XG_n1 I1_I72_gn4 VSS VSS) gpdk090_nmos1v w=0.24u l=0.1u ad=0.0528p as=0.0816p pd=0.68u ps=1.16u
    I_MXI1_I72_I22_XG_MN0 (I1_I72_G4_3 I1_I72_pn4 XI1_I72_I22_XG_n1 VSS) gpdk090_nmos1v w=0.24u l=0.1u ad=0.0528p as=0.0528p pd=0.68u ps=0.68u
    I_MXI1_I72_I22_XG_MN1 (XI1_I72_I22_XG_n1 I1_I72_gn3 I1_I72_G4_3 VSS) gpdk090_nmos1v w=0.24u l=0.1u ad=0.0816p as=0.0528p pd=1.16u ps=0.68u
    I_MXI1_I60_I32_XG_MN2 (XI1_I60_I32_XG_n1 I1_I60_G4_1n VSS VSS) gpdk090_nmos1v w=0.24u l=0.1u ad=0.0528p as=0.0816p pd=0.68u ps=1.16u
    I_MXI1_I60_I32_XG_MN0 (I1_I60_G4_0 I1_I60_P4_1n XI1_I60_I32_XG_n1 VSS) gpdk090_nmos1v w=0.24u l=0.1u ad=0.0528p as=0.0528p pd=0.68u ps=0.68u
    I_MXI1_I60_I32_XG_MN1 (XI1_I60_I32_XG_n1 I1_I60_G0_0n I1_I60_G4_0 VSS) gpdk090_nmos1v w=0.24u l=0.1u ad=0.0816p as=0.0528p pd=1.16u ps=0.68u
    I_MXI1_I60_I35_XG_MN2 (XI1_I60_I35_XG_n1 I1_I60_G6_3n VSS VSS) gpdk090_nmos1v w=0.24u l=0.1u ad=0.0528p as=0.0816p pd=0.68u ps=1.16u
    I_MXI1_I60_I35_XG_MN0 (I1_c1_7 I1_I60_P6_3n XI1_I60_I35_XG_n1 VSS) gpdk090_nmos1v w=0.24u l=0.1u ad=0.0528p as=0.0528p pd=0.68u ps=0.68u
    I_MXI1_I60_I35_XG_MN1 (XI1_I60_I35_XG_n1 I1_I60_G2_0n I1_c1_7 VSS) gpdk090_nmos1v w=0.24u l=0.1u ad=0.0816p as=0.0528p pd=1.16u ps=0.68u
    I_MXI1_I60_I21_XG_MN2 (XI1_I60_I21_XG_n1 I1_I60_gn3 VSS VSS) gpdk090_nmos1v w=0.24u l=0.1u ad=0.0528p as=0.0816p pd=0.68u ps=1.16u
    I_MXI1_I60_I21_XG_MN0 (I1_I60_G3_2 I1_I60_pn3 XI1_I60_I21_XG_n1 VSS) gpdk090_nmos1v w=0.24u l=0.1u ad=0.0528p as=0.0528p pd=0.68u ps=0.68u
    I_MXI1_I60_I21_XG_MN1 (XI1_I60_I21_XG_n1 I1_I60_gn2 I1_I60_G3_2 VSS) gpdk090_nmos1v w=0.24u l=0.1u ad=0.0816p as=0.0528p pd=1.16u ps=0.68u
    I_MXI1_I60_I22_XG_MN2 (XI1_I60_I22_XG_n1 I1_I60_gn4 VSS VSS) gpdk090_nmos1v w=0.24u l=0.1u ad=0.0528p as=0.0816p pd=0.68u ps=1.16u
    I_MXI1_I60_I22_XG_MN0 (I1_I60_G4_3 I1_I60_pn4 XI1_I60_I22_XG_n1 VSS) gpdk090_nmos1v w=0.24u l=0.1u ad=0.0528p as=0.0528p pd=0.68u ps=0.68u
    I_MXI1_I60_I22_XG_MN1 (XI1_I60_I22_XG_n1 I1_I60_gn3 I1_I60_G4_3 VSS) gpdk090_nmos1v w=0.24u l=0.1u ad=0.0816p as=0.0528p pd=1.16u ps=0.68u
    I_MXI1_I48_I35_XG_MN2 (XI1_I48_I35_XG_n1 I1_I48_G6_3n VSS VSS) gpdk090_nmos1v w=0.24u l=0.1u ad=0.0528p as=0.0816p pd=0.68u ps=1.16u
    I_MXI1_I48_I35_XG_MN0 (I1_c0_7 I1_I48_P6_3n XI1_I48_I35_XG_n1 VSS) gpdk090_nmos1v w=0.24u l=0.1u ad=0.0528p as=0.0528p pd=0.68u ps=0.68u
    I_MXI1_I48_I35_XG_MN1 (XI1_I48_I35_XG_n1 I1_I48_G2_0n I1_c0_7 VSS) gpdk090_nmos1v w=0.24u l=0.1u ad=0.0816p as=0.0528p pd=1.16u ps=0.68u
    I_MXI1_I48_I34_XG_MN2 (XI1_I48_I34_XG_n1 I1_I48_G5_2n VSS VSS) gpdk090_nmos1v w=0.24u l=0.1u ad=0.0528p as=0.0816p pd=0.68u ps=1.16u
    I_MXI1_I48_I34_XG_MN0 (I1_I48_G5_0 I1_I48_P5_2n XI1_I48_I34_XG_n1 VSS) gpdk090_nmos1v w=0.24u l=0.1u ad=0.0528p as=0.0528p pd=0.68u ps=0.68u
    I_MXI1_I48_I34_XG_MN1 (XI1_I48_I34_XG_n1 I1_I48_G1_0n I1_I48_G5_0 VSS) gpdk090_nmos1v w=0.24u l=0.1u ad=0.0816p as=0.0528p pd=1.16u ps=0.68u
    I_MXI1_I108_I25_XG_MN2 (XI1_I108_I25_XG_n1 I1_I108_gn7 VSS VSS) gpdk090_nmos1v w=0.24u l=0.1u ad=0.0528p as=0.0816p pd=0.68u ps=1.16u
    I_MXI1_I108_I25_XG_MN0 (I1_I108_G7_6 I1_I108_pn7 XI1_I108_I25_XG_n1 VSS) gpdk090_nmos1v w=0.24u l=0.1u ad=0.0528p as=0.0528p pd=0.68u ps=0.68u
    I_MXI1_I108_I25_XG_MN1 (XI1_I108_I25_XG_n1 I1_I108_gn6 I1_I108_G7_6 VSS) gpdk090_nmos1v w=0.24u l=0.1u ad=0.0816p as=0.0528p pd=1.16u ps=0.68u
    I_MXI1_I96_I35_XG_MN2 (XI1_I96_I35_XG_n1 I1_I96_G6_3n VSS VSS) gpdk090_nmos1v w=0.24u l=0.1u ad=0.0528p as=0.0816p pd=0.68u ps=1.16u
    I_MXI1_I96_I35_XG_MN0 (I1_c4_7 I1_I96_P6_3n XI1_I96_I35_XG_n1 VSS) gpdk090_nmos1v w=0.24u l=0.1u ad=0.0528p as=0.0528p pd=0.68u ps=0.68u
    I_MXI1_I96_I35_XG_MN1 (XI1_I96_I35_XG_n1 I1_I96_G2_0n I1_c4_7 VSS) gpdk090_nmos1v w=0.24u l=0.1u ad=0.0816p as=0.0528p pd=1.16u ps=0.68u
    I_MXI1_I96_I24_XG_MN2 (XI1_I96_I24_XG_n1 I1_I96_gn6 VSS VSS) gpdk090_nmos1v w=0.24u l=0.1u ad=0.0528p as=0.0816p pd=0.68u ps=1.16u
    I_MXI1_I96_I24_XG_MN0 (I1_I96_G6_5 I1_I96_pn6 XI1_I96_I24_XG_n1 VSS) gpdk090_nmos1v w=0.24u l=0.1u ad=0.0528p as=0.0528p pd=0.68u ps=0.68u
    I_MXI1_I96_I24_XG_MN1 (XI1_I96_I24_XG_n1 I1_I96_gn5 I1_I96_G6_5 VSS) gpdk090_nmos1v w=0.24u l=0.1u ad=0.0816p as=0.0528p pd=1.16u ps=0.68u
    I_MXI1_I96_I23_XG_MN2 (XI1_I96_I23_XG_n1 I1_I96_gn5 VSS VSS) gpdk090_nmos1v w=0.24u l=0.1u ad=0.0528p as=0.0816p pd=0.68u ps=1.16u
    I_MXI1_I96_I23_XG_MN0 (I1_I96_G5_4 I1_I96_pn5 XI1_I96_I23_XG_n1 VSS) gpdk090_nmos1v w=0.24u l=0.1u ad=0.0528p as=0.0528p pd=0.68u ps=0.68u
    I_MXI1_I96_I23_XG_MN1 (XI1_I96_I23_XG_n1 I1_I96_gn4 I1_I96_G5_4 VSS) gpdk090_nmos1v w=0.24u l=0.1u ad=0.0816p as=0.0528p pd=1.16u ps=0.68u
    I_MXI1_I84_I34_XG_MN2 (XI1_I84_I34_XG_n1 I1_I84_G5_2n VSS VSS) gpdk090_nmos1v w=0.24u l=0.1u ad=0.0528p as=0.0816p pd=0.68u ps=1.16u
    I_MXI1_I84_I34_XG_MN0 (I1_I84_G5_0 I1_I84_P5_2n XI1_I84_I34_XG_n1 VSS) gpdk090_nmos1v w=0.24u l=0.1u ad=0.0528p as=0.0528p pd=0.68u ps=0.68u
    I_MXI1_I84_I34_XG_MN1 (XI1_I84_I34_XG_n1 I1_I84_G1_0n I1_I84_G5_0 VSS) gpdk090_nmos1v w=0.24u l=0.1u ad=0.0816p as=0.0528p pd=1.16u ps=0.68u
    I_MXI1_I84_I35_XG_MN2 (XI1_I84_I35_XG_n1 I1_I84_G6_3n VSS VSS) gpdk090_nmos1v w=0.24u l=0.1u ad=0.0528p as=0.0816p pd=0.68u ps=1.16u
    I_MXI1_I84_I35_XG_MN0 (I1_c3_7 I1_I84_P6_3n XI1_I84_I35_XG_n1 VSS) gpdk090_nmos1v w=0.24u l=0.1u ad=0.0528p as=0.0528p pd=0.68u ps=0.68u
    I_MXI1_I84_I35_XG_MN1 (XI1_I84_I35_XG_n1 I1_I84_G2_0n I1_c3_7 VSS) gpdk090_nmos1v w=0.24u l=0.1u ad=0.0816p as=0.0528p pd=1.16u ps=0.68u
    I_MXI1_I84_I23_XG_MN2 (XI1_I84_I23_XG_n1 I1_I84_gn5 VSS VSS) gpdk090_nmos1v w=0.24u l=0.1u ad=0.0528p as=0.0816p pd=0.68u ps=1.16u
    I_MXI1_I84_I23_XG_MN0 (I1_I84_G5_4 I1_I84_pn5 XI1_I84_I23_XG_n1 VSS) gpdk090_nmos1v w=0.24u l=0.1u ad=0.0528p as=0.0528p pd=0.68u ps=0.68u
    I_MXI1_I84_I23_XG_MN1 (XI1_I84_I23_XG_n1 I1_I84_gn4 I1_I84_G5_4 VSS) gpdk090_nmos1v w=0.24u l=0.1u ad=0.0816p as=0.0528p pd=1.16u ps=0.68u
    I_MXI1_I72_I23_XG_MN2 (XI1_I72_I23_XG_n1 I1_I72_gn5 VSS VSS) gpdk090_nmos1v w=0.24u l=0.1u ad=0.0528p as=0.0816p pd=0.68u ps=1.16u
    I_MXI1_I72_I23_XG_MN0 (I1_I72_G5_4 I1_I72_pn5 XI1_I72_I23_XG_n1 VSS) gpdk090_nmos1v w=0.24u l=0.1u ad=0.0528p as=0.0528p pd=0.68u ps=0.68u
    I_MXI1_I72_I23_XG_MN1 (XI1_I72_I23_XG_n1 I1_I72_gn4 I1_I72_G5_4 VSS) gpdk090_nmos1v w=0.24u l=0.1u ad=0.0816p as=0.0528p pd=1.16u ps=0.68u
    I_MXI1_I72_I24_XG_MN2 (XI1_I72_I24_XG_n1 I1_I72_gn6 VSS VSS) gpdk090_nmos1v w=0.24u l=0.1u ad=0.0528p as=0.0816p pd=0.68u ps=1.16u
    I_MXI1_I72_I24_XG_MN0 (I1_I72_G6_5 I1_I72_pn6 XI1_I72_I24_XG_n1 VSS) gpdk090_nmos1v w=0.24u l=0.1u ad=0.0528p as=0.0528p pd=0.68u ps=0.68u
    I_MXI1_I72_I24_XG_MN1 (XI1_I72_I24_XG_n1 I1_I72_gn5 I1_I72_G6_5 VSS) gpdk090_nmos1v w=0.24u l=0.1u ad=0.0816p as=0.0528p pd=1.16u ps=0.68u
    I_MXI1_I60_I23_XG_MN2 (XI1_I60_I23_XG_n1 I1_I60_gn5 VSS VSS) gpdk090_nmos1v w=0.24u l=0.1u ad=0.0528p as=0.0816p pd=0.68u ps=1.16u
    I_MXI1_I60_I23_XG_MN0 (I1_I60_G5_4 I1_I60_pn5 XI1_I60_I23_XG_n1 VSS) gpdk090_nmos1v w=0.24u l=0.1u ad=0.0528p as=0.0528p pd=0.68u ps=0.68u
    I_MXI1_I60_I23_XG_MN1 (XI1_I60_I23_XG_n1 I1_I60_gn4 I1_I60_G5_4 VSS) gpdk090_nmos1v w=0.24u l=0.1u ad=0.0816p as=0.0528p pd=1.16u ps=0.68u
    I_MXI1_I60_I24_XG_MN2 (XI1_I60_I24_XG_n1 I1_I60_gn6 VSS VSS) gpdk090_nmos1v w=0.24u l=0.1u ad=0.0528p as=0.0816p pd=0.68u ps=1.16u
    I_MXI1_I60_I24_XG_MN0 (I1_I60_G6_5 I1_I60_pn6 XI1_I60_I24_XG_n1 VSS) gpdk090_nmos1v w=0.24u l=0.1u ad=0.0528p as=0.0528p pd=0.68u ps=0.68u
    I_MXI1_I60_I24_XG_MN1 (XI1_I60_I24_XG_n1 I1_I60_gn5 I1_I60_G6_5 VSS) gpdk090_nmos1v w=0.24u l=0.1u ad=0.0816p as=0.0528p pd=1.16u ps=0.68u
    I_MXI1_I48_I24_XG_MN2 (XI1_I48_I24_XG_n1 I1_I48_gn6 VSS VSS) gpdk090_nmos1v w=0.24u l=0.1u ad=0.0528p as=0.0816p pd=0.68u ps=1.16u
    I_MXI1_I48_I24_XG_MN0 (I1_I48_G6_5 I1_I48_pn6 XI1_I48_I24_XG_n1 VSS) gpdk090_nmos1v w=0.24u l=0.1u ad=0.0528p as=0.0528p pd=0.68u ps=0.68u
    I_MXI1_I48_I24_XG_MN1 (XI1_I48_I24_XG_n1 I1_I48_gn5 I1_I48_G6_5 VSS) gpdk090_nmos1v w=0.24u l=0.1u ad=0.0816p as=0.0528p pd=1.16u ps=0.68u
    I_MXI1_I48_I23_XG_MN2 (XI1_I48_I23_XG_n1 I1_I48_gn5 VSS VSS) gpdk090_nmos1v w=0.24u l=0.1u ad=0.0528p as=0.0816p pd=0.68u ps=1.16u
    I_MXI1_I48_I23_XG_MN0 (I1_I48_G5_4 I1_I48_pn5 XI1_I48_I23_XG_n1 VSS) gpdk090_nmos1v w=0.24u l=0.1u ad=0.0528p as=0.0528p pd=0.68u ps=0.68u
    I_MXI1_I48_I23_XG_MN1 (XI1_I48_I23_XG_n1 I1_I48_gn4 I1_I48_G5_4 VSS) gpdk090_nmos1v w=0.24u l=0.1u ad=0.0816p as=0.0528p pd=1.16u ps=0.68u
    I_MXI1_I96_I34_XG_MN2 (XI1_I96_I34_XG_n1 I1_I96_G5_2n VSS VSS) gpdk090_nmos1v w=0.24u l=0.1u ad=0.0528p as=0.0816p pd=0.68u ps=1.16u
    I_MXI1_I96_I34_XG_MN0 (I1_I96_G5_0 I1_I96_P5_2n XI1_I96_I34_XG_n1 VSS) gpdk090_nmos1v w=0.24u l=0.1u ad=0.0528p as=0.0528p pd=0.68u ps=0.68u
    I_MXI1_I96_I34_XG_MN1 (XI1_I96_I34_XG_n1 I1_I96_G1_0n I1_I96_G5_0 VSS) gpdk090_nmos1v w=0.24u l=0.1u ad=0.0816p as=0.0528p pd=1.16u ps=0.68u
    I_MXI1_I84_I24_XG_MN2 (XI1_I84_I24_XG_n1 I1_I84_gn6 VSS VSS) gpdk090_nmos1v w=0.24u l=0.1u ad=0.0528p as=0.0816p pd=0.68u ps=1.16u
    I_MXI1_I84_I24_XG_MN0 (I1_I84_G6_5 I1_I84_pn6 XI1_I84_I24_XG_n1 VSS) gpdk090_nmos1v w=0.24u l=0.1u ad=0.0528p as=0.0528p pd=0.68u ps=0.68u
    I_MXI1_I84_I24_XG_MN1 (XI1_I84_I24_XG_n1 I1_I84_gn5 I1_I84_G6_5 VSS) gpdk090_nmos1v w=0.24u l=0.1u ad=0.0816p as=0.0528p pd=1.16u ps=0.68u
    I_MXI1_I84_I25_XG_MN2 (XI1_I84_I25_XG_n1 I1_I84_gn7 VSS VSS) gpdk090_nmos1v w=0.24u l=0.1u ad=0.0528p as=0.0816p pd=0.68u ps=1.16u
    I_MXI1_I84_I25_XG_MN0 (I1_I84_G7_6 I1_I84_pn7 XI1_I84_I25_XG_n1 VSS) gpdk090_nmos1v w=0.24u l=0.1u ad=0.0528p as=0.0528p pd=0.68u ps=0.68u
    I_MXI1_I84_I25_XG_MN1 (XI1_I84_I25_XG_n1 I1_I84_gn6 I1_I84_G7_6 VSS) gpdk090_nmos1v w=0.24u l=0.1u ad=0.0816p as=0.0528p pd=1.16u ps=0.68u
    I_MXI1_I72_I34_XG_MN2 (XI1_I72_I34_XG_n1 I1_I72_G5_2n VSS VSS) gpdk090_nmos1v w=0.24u l=0.1u ad=0.0528p as=0.0816p pd=0.68u ps=1.16u
    I_MXI1_I72_I34_XG_MN0 (I1_I72_G5_0 I1_I72_P5_2n XI1_I72_I34_XG_n1 VSS) gpdk090_nmos1v w=0.24u l=0.1u ad=0.0528p as=0.0528p pd=0.68u ps=0.68u
    I_MXI1_I72_I34_XG_MN1 (XI1_I72_I34_XG_n1 I1_I72_G1_0n I1_I72_G5_0 VSS) gpdk090_nmos1v w=0.24u l=0.1u ad=0.0816p as=0.0528p pd=1.16u ps=0.68u
    I_MXI1_I60_I34_XG_MN2 (XI1_I60_I34_XG_n1 I1_I60_G5_2n VSS VSS) gpdk090_nmos1v w=0.24u l=0.1u ad=0.0528p as=0.0816p pd=0.68u ps=1.16u
    I_MXI1_I60_I34_XG_MN0 (I1_I60_G5_0 I1_I60_P5_2n XI1_I60_I34_XG_n1 VSS) gpdk090_nmos1v w=0.24u l=0.1u ad=0.0528p as=0.0528p pd=0.68u ps=0.68u
    I_MXI1_I60_I34_XG_MN1 (XI1_I60_I34_XG_n1 I1_I60_G1_0n I1_I60_G5_0 VSS) gpdk090_nmos1v w=0.24u l=0.1u ad=0.0816p as=0.0528p pd=1.16u ps=0.68u
    I_MXI1_I48_I25_XG_MN2 (XI1_I48_I25_XG_n1 I1_I48_gn7 VSS VSS) gpdk090_nmos1v w=0.24u l=0.1u ad=0.0528p as=0.0816p pd=0.68u ps=1.16u
    I_MXI1_I48_I25_XG_MN0 (I1_I48_G7_6 I1_I48_pn7 XI1_I48_I25_XG_n1 VSS) gpdk090_nmos1v w=0.24u l=0.1u ad=0.0528p as=0.0528p pd=0.68u ps=0.68u
    I_MXI1_I48_I25_XG_MN1 (XI1_I48_I25_XG_n1 I1_I48_gn6 I1_I48_G7_6 VSS) gpdk090_nmos1v w=0.24u l=0.1u ad=0.0816p as=0.0528p pd=1.16u ps=0.68u
    I_MXI1_I48_I36_XG_MN2 (XI1_I48_I36_XG_n1 I1_I48_G7_4n VSS VSS) gpdk090_nmos1v w=0.24u l=0.1u ad=0.0528p as=0.0816p pd=0.68u ps=1.16u
    I_MXI1_I48_I36_XG_MN0 (I1_c0_8 I1_I48_P7_4n XI1_I48_I36_XG_n1 VSS) gpdk090_nmos1v w=0.24u l=0.1u ad=0.0528p as=0.0528p pd=0.68u ps=0.68u
    I_MXI1_I48_I36_XG_MN1 (XI1_I48_I36_XG_n1 I1_I48_G3_0n I1_c0_8 VSS) gpdk090_nmos1v w=0.24u l=0.1u ad=0.0816p as=0.0528p pd=1.16u ps=0.68u
    I_MXI1_I96_I36_XG_MN2 (XI1_I96_I36_XG_n1 I1_I96_G7_4n VSS VSS) gpdk090_nmos1v w=0.24u l=0.1u ad=0.0528p as=0.0816p pd=0.68u ps=1.16u
    I_MXI1_I96_I36_XG_MN0 (I1_c4_8 I1_I96_P7_4n XI1_I96_I36_XG_n1 VSS) gpdk090_nmos1v w=0.24u l=0.1u ad=0.0528p as=0.0528p pd=0.68u ps=0.68u
    I_MXI1_I96_I36_XG_MN1 (XI1_I96_I36_XG_n1 I1_I96_G3_0n I1_c4_8 VSS) gpdk090_nmos1v w=0.24u l=0.1u ad=0.0816p as=0.0528p pd=1.16u ps=0.68u
    I_MXI1_I96_I25_XG_MN2 (XI1_I96_I25_XG_n1 I1_I96_gn7 VSS VSS) gpdk090_nmos1v w=0.24u l=0.1u ad=0.0528p as=0.0816p pd=0.68u ps=1.16u
    I_MXI1_I96_I25_XG_MN0 (I1_I96_G7_6 I1_I96_pn7 XI1_I96_I25_XG_n1 VSS) gpdk090_nmos1v w=0.24u l=0.1u ad=0.0528p as=0.0528p pd=0.68u ps=0.68u
    I_MXI1_I96_I25_XG_MN1 (XI1_I96_I25_XG_n1 I1_I96_gn6 I1_I96_G7_6 VSS) gpdk090_nmos1v w=0.24u l=0.1u ad=0.0816p as=0.0528p pd=1.16u ps=0.68u
    I_MXI1_I84_I36_XG_MN2 (XI1_I84_I36_XG_n1 I1_I84_G7_4n VSS VSS) gpdk090_nmos1v w=0.24u l=0.1u ad=0.0528p as=0.0816p pd=0.68u ps=1.16u
    I_MXI1_I84_I36_XG_MN0 (I1_c3_8 I1_I84_P7_4n XI1_I84_I36_XG_n1 VSS) gpdk090_nmos1v w=0.24u l=0.1u ad=0.0528p as=0.0528p pd=0.68u ps=0.68u
    I_MXI1_I84_I36_XG_MN1 (XI1_I84_I36_XG_n1 I1_I84_G3_0n I1_c3_8 VSS) gpdk090_nmos1v w=0.24u l=0.1u ad=0.0816p as=0.0528p pd=1.16u ps=0.68u
    I_MXI1_I72_I36_XG_MN2 (XI1_I72_I36_XG_n1 I1_I72_G7_4n VSS VSS) gpdk090_nmos1v w=0.24u l=0.1u ad=0.0528p as=0.0816p pd=0.68u ps=1.16u
    I_MXI1_I72_I36_XG_MN0 (I1_c2_8 I1_I72_P7_4n XI1_I72_I36_XG_n1 VSS) gpdk090_nmos1v w=0.24u l=0.1u ad=0.0528p as=0.0528p pd=0.68u ps=0.68u
    I_MXI1_I72_I36_XG_MN1 (XI1_I72_I36_XG_n1 I1_I72_G3_0n I1_c2_8 VSS) gpdk090_nmos1v w=0.24u l=0.1u ad=0.0816p as=0.0528p pd=1.16u ps=0.68u
    I_MXI1_I72_I25_XG_MN2 (XI1_I72_I25_XG_n1 I1_I72_gn7 VSS VSS) gpdk090_nmos1v w=0.24u l=0.1u ad=0.0528p as=0.0816p pd=0.68u ps=1.16u
    I_MXI1_I72_I25_XG_MN0 (I1_I72_G7_6 I1_I72_pn7 XI1_I72_I25_XG_n1 VSS) gpdk090_nmos1v w=0.24u l=0.1u ad=0.0528p as=0.0528p pd=0.68u ps=0.68u
    I_MXI1_I72_I25_XG_MN1 (XI1_I72_I25_XG_n1 I1_I72_gn6 I1_I72_G7_6 VSS) gpdk090_nmos1v w=0.24u l=0.1u ad=0.0816p as=0.0528p pd=1.16u ps=0.68u
    I_MXI1_I60_I36_XG_MN2 (XI1_I60_I36_XG_n1 I1_I60_G7_4n VSS VSS) gpdk090_nmos1v w=0.24u l=0.1u ad=0.0528p as=0.0816p pd=0.68u ps=1.16u
    I_MXI1_I60_I36_XG_MN0 (I1_c1_8 I1_I60_P7_4n XI1_I60_I36_XG_n1 VSS) gpdk090_nmos1v w=0.24u l=0.1u ad=0.0528p as=0.0528p pd=0.68u ps=0.68u
    I_MXI1_I60_I36_XG_MN1 (XI1_I60_I36_XG_n1 I1_I60_G3_0n I1_c1_8 VSS) gpdk090_nmos1v w=0.24u l=0.1u ad=0.0816p as=0.0528p pd=1.16u ps=0.68u
    I_MXI1_I60_I25_XG_MN2 (XI1_I60_I25_XG_n1 I1_I60_gn7 VSS VSS) gpdk090_nmos1v w=0.24u l=0.1u ad=0.0528p as=0.0816p pd=0.68u ps=1.16u
    I_MXI1_I60_I25_XG_MN0 (I1_I60_G7_6 I1_I60_pn7 XI1_I60_I25_XG_n1 VSS) gpdk090_nmos1v w=0.24u l=0.1u ad=0.0528p as=0.0528p pd=0.68u ps=0.68u
    I_MXI1_I60_I25_XG_MN1 (XI1_I60_I25_XG_n1 I1_I60_gn6 I1_I60_G7_6 VSS) gpdk090_nmos1v w=0.24u l=0.1u ad=0.0816p as=0.0528p pd=1.16u ps=0.68u
    I_MXI0_I42_MN11 (VSS B_7 XI0_I42_xbn VSS) gpdk090_nmos1v w=0.12u l=0.1u ad=0.0696p as=0.0696p pd=1.16u ps=1.16u
    I_MXI0_I42_MN14 (VSS XI0_I42_xbn XI0_I42_xn1 VSS) gpdk090_nmos1v w=0.24u l=0.1u ad=0.0528p as=0.0816p pd=0.68u ps=1.16u
    I_MXI0_I42_MN16 (XI0_I42_xn2 B_7 VSS VSS) gpdk090_nmos1v w=0.24u l=0.1u ad=0.0528p as=0.0528p pd=0.68u ps=0.68u
    I_MXI0_I42_MN15 (I0_pp3_8 XI0_I42_xan XI0_I42_xn2 VSS) gpdk090_nmos1v w=0.24u l=0.1u ad=0.0528p as=0.0528p pd=0.68u ps=0.68u
    I_MXI0_I42_MN13 (XI0_I42_xn1 XI0_I42_xn I0_pp3_8 VSS) gpdk090_nmos1v w=0.24u l=0.1u ad=0.0816p as=0.0528p pd=1.16u ps=0.68u
    I_MXI0_I42_MN2 (VSS A_7 XI0_I42_n1 VSS) gpdk090_nmos1v w=0.24u l=0.1u ad=0.0528p as=0.0816p pd=0.68u ps=1.16u
    I_MXI0_I42_MN4 (XI0_I42_n2 A_7 VSS VSS) gpdk090_nmos1v w=0.24u l=0.1u ad=0.0528p as=0.0528p pd=0.68u ps=0.68u
    I_MXI0_I42_MN3 (XI0_I42_xn I0_two3 XI0_I42_n2 VSS) gpdk090_nmos1v w=0.24u l=0.1u ad=0.0528p as=0.0528p pd=0.68u ps=0.68u
    I_MXI0_I42_MN1 (XI0_I42_n1 I0_one3 XI0_I42_xn VSS) gpdk090_nmos1v w=0.24u l=0.1u ad=0.0816p as=0.0528p pd=1.16u ps=0.68u
    I_MXI0_I42_MN9 (VSS XI0_I42_xn XI0_I42_xan VSS) gpdk090_nmos1v w=0.12u l=0.1u ad=0.0696p as=0.0696p pd=1.16u ps=1.16u
    I_MXI0_I30_MN11 (VSS B_5 XI0_I30_xbn VSS) gpdk090_nmos1v w=0.12u l=0.1u ad=0.0696p as=0.0696p pd=1.16u ps=1.16u
    I_MXI0_I30_MN14 (VSS XI0_I30_xbn XI0_I30_xn1 VSS) gpdk090_nmos1v w=0.24u l=0.1u ad=0.0528p as=0.0816p pd=0.68u ps=1.16u
    I_MXI0_I30_MN16 (XI0_I30_xn2 B_5 VSS VSS) gpdk090_nmos1v w=0.24u l=0.1u ad=0.0528p as=0.0528p pd=0.68u ps=0.68u
    I_MXI0_I30_MN15 (I0_pp2_7 XI0_I30_xan XI0_I30_xn2 VSS) gpdk090_nmos1v w=0.24u l=0.1u ad=0.0528p as=0.0528p pd=0.68u ps=0.68u
    I_MXI0_I30_MN13 (XI0_I30_xn1 XI0_I30_xn I0_pp2_7 VSS) gpdk090_nmos1v w=0.24u l=0.1u ad=0.0816p as=0.0528p pd=1.16u ps=0.68u
    I_MXI0_I30_MN2 (VSS A_7 XI0_I30_n1 VSS) gpdk090_nmos1v w=0.24u l=0.1u ad=0.0528p as=0.0816p pd=0.68u ps=1.16u
    I_MXI0_I30_MN4 (XI0_I30_n2 A_6 VSS VSS) gpdk090_nmos1v w=0.24u l=0.1u ad=0.0528p as=0.0528p pd=0.68u ps=0.68u
    I_MXI0_I30_MN3 (XI0_I30_xn I0_two2 XI0_I30_n2 VSS) gpdk090_nmos1v w=0.24u l=0.1u ad=0.0528p as=0.0528p pd=0.68u ps=0.68u
    I_MXI0_I30_MN1 (XI0_I30_n1 I0_one2 XI0_I30_xn VSS) gpdk090_nmos1v w=0.24u l=0.1u ad=0.0816p as=0.0528p pd=1.16u ps=0.68u
    I_MXI0_I30_MN9 (VSS XI0_I30_xn XI0_I30_xan VSS) gpdk090_nmos1v w=0.12u l=0.1u ad=0.0696p as=0.0696p pd=1.16u ps=1.16u
    I_MXI0_I31_MN11 (VSS B_5 XI0_I31_xbn VSS) gpdk090_nmos1v w=0.12u l=0.1u ad=0.0696p as=0.0696p pd=1.16u ps=1.16u
    I_MXI0_I31_MN14 (VSS XI0_I31_xbn XI0_I31_xn1 VSS) gpdk090_nmos1v w=0.24u l=0.1u ad=0.0528p as=0.0816p pd=0.68u ps=1.16u
    I_MXI0_I31_MN16 (XI0_I31_xn2 B_5 VSS VSS) gpdk090_nmos1v w=0.24u l=0.1u ad=0.0528p as=0.0528p pd=0.68u ps=0.68u
    I_MXI0_I31_MN15 (I0_pp2_8 XI0_I31_xan XI0_I31_xn2 VSS) gpdk090_nmos1v w=0.24u l=0.1u ad=0.0528p as=0.0528p pd=0.68u ps=0.68u
    I_MXI0_I31_MN13 (XI0_I31_xn1 XI0_I31_xn I0_pp2_8 VSS) gpdk090_nmos1v w=0.24u l=0.1u ad=0.0816p as=0.0528p pd=1.16u ps=0.68u
    I_MXI0_I31_MN2 (VSS A_7 XI0_I31_n1 VSS) gpdk090_nmos1v w=0.24u l=0.1u ad=0.0528p as=0.0816p pd=0.68u ps=1.16u
    I_MXI0_I31_MN4 (XI0_I31_n2 A_7 VSS VSS) gpdk090_nmos1v w=0.24u l=0.1u ad=0.0528p as=0.0528p pd=0.68u ps=0.68u
    I_MXI0_I31_MN3 (XI0_I31_xn I0_two2 XI0_I31_n2 VSS) gpdk090_nmos1v w=0.24u l=0.1u ad=0.0528p as=0.0528p pd=0.68u ps=0.68u
    I_MXI0_I31_MN1 (XI0_I31_n1 I0_one2 XI0_I31_xn VSS) gpdk090_nmos1v w=0.24u l=0.1u ad=0.0816p as=0.0528p pd=1.16u ps=0.68u
    I_MXI0_I31_MN9 (VSS XI0_I31_xn XI0_I31_xan VSS) gpdk090_nmos1v w=0.12u l=0.1u ad=0.0696p as=0.0696p pd=1.16u ps=1.16u
    I_MXI0_I40_MN11 (VSS B_7 XI0_I40_xbn VSS) gpdk090_nmos1v w=0.12u l=0.1u ad=0.0696p as=0.0696p pd=1.16u ps=1.16u
    I_MXI0_I40_MN14 (VSS XI0_I40_xbn XI0_I40_xn1 VSS) gpdk090_nmos1v w=0.24u l=0.1u ad=0.0528p as=0.0816p pd=0.68u ps=1.16u
    I_MXI0_I40_MN16 (XI0_I40_xn2 B_7 VSS VSS) gpdk090_nmos1v w=0.24u l=0.1u ad=0.0528p as=0.0528p pd=0.68u ps=0.68u
    I_MXI0_I40_MN15 (I0_pp3_6 XI0_I40_xan XI0_I40_xn2 VSS) gpdk090_nmos1v w=0.24u l=0.1u ad=0.0528p as=0.0528p pd=0.68u ps=0.68u
    I_MXI0_I40_MN13 (XI0_I40_xn1 XI0_I40_xn I0_pp3_6 VSS) gpdk090_nmos1v w=0.24u l=0.1u ad=0.0816p as=0.0528p pd=1.16u ps=0.68u
    I_MXI0_I40_MN2 (VSS A_6 XI0_I40_n1 VSS) gpdk090_nmos1v w=0.24u l=0.1u ad=0.0528p as=0.0816p pd=0.68u ps=1.16u
    I_MXI0_I40_MN4 (XI0_I40_n2 A_5 VSS VSS) gpdk090_nmos1v w=0.24u l=0.1u ad=0.0528p as=0.0528p pd=0.68u ps=0.68u
    I_MXI0_I40_MN3 (XI0_I40_xn I0_two3 XI0_I40_n2 VSS) gpdk090_nmos1v w=0.24u l=0.1u ad=0.0528p as=0.0528p pd=0.68u ps=0.68u
    I_MXI0_I40_MN1 (XI0_I40_n1 I0_one3 XI0_I40_xn VSS) gpdk090_nmos1v w=0.24u l=0.1u ad=0.0816p as=0.0528p pd=1.16u ps=0.68u
    I_MXI0_I40_MN9 (VSS XI0_I40_xn XI0_I40_xan VSS) gpdk090_nmos1v w=0.12u l=0.1u ad=0.0696p as=0.0696p pd=1.16u ps=1.16u
    I_MXI0_I41_MN11 (VSS B_7 XI0_I41_xbn VSS) gpdk090_nmos1v w=0.12u l=0.1u ad=0.0696p as=0.0696p pd=1.16u ps=1.16u
    I_MXI0_I41_MN14 (VSS XI0_I41_xbn XI0_I41_xn1 VSS) gpdk090_nmos1v w=0.24u l=0.1u ad=0.0528p as=0.0816p pd=0.68u ps=1.16u
    I_MXI0_I41_MN16 (XI0_I41_xn2 B_7 VSS VSS) gpdk090_nmos1v w=0.24u l=0.1u ad=0.0528p as=0.0528p pd=0.68u ps=0.68u
    I_MXI0_I41_MN15 (I0_pp3_7 XI0_I41_xan XI0_I41_xn2 VSS) gpdk090_nmos1v w=0.24u l=0.1u ad=0.0528p as=0.0528p pd=0.68u ps=0.68u
    I_MXI0_I41_MN13 (XI0_I41_xn1 XI0_I41_xn I0_pp3_7 VSS) gpdk090_nmos1v w=0.24u l=0.1u ad=0.0816p as=0.0528p pd=1.16u ps=0.68u
    I_MXI0_I41_MN2 (VSS A_7 XI0_I41_n1 VSS) gpdk090_nmos1v w=0.24u l=0.1u ad=0.0528p as=0.0816p pd=0.68u ps=1.16u
    I_MXI0_I41_MN4 (XI0_I41_n2 A_6 VSS VSS) gpdk090_nmos1v w=0.24u l=0.1u ad=0.0528p as=0.0528p pd=0.68u ps=0.68u
    I_MXI0_I41_MN3 (XI0_I41_xn I0_two3 XI0_I41_n2 VSS) gpdk090_nmos1v w=0.24u l=0.1u ad=0.0528p as=0.0528p pd=0.68u ps=0.68u
    I_MXI0_I41_MN1 (XI0_I41_n1 I0_one3 XI0_I41_xn VSS) gpdk090_nmos1v w=0.24u l=0.1u ad=0.0816p as=0.0528p pd=1.16u ps=0.68u
    I_MXI0_I41_MN9 (VSS XI0_I41_xn XI0_I41_xan VSS) gpdk090_nmos1v w=0.12u l=0.1u ad=0.0696p as=0.0696p pd=1.16u ps=1.16u
    I_MXI0_I29_MN11 (VSS B_5 XI0_I29_xbn VSS) gpdk090_nmos1v w=0.12u l=0.1u ad=0.0696p as=0.0696p pd=1.16u ps=1.16u
    I_MXI0_I29_MN14 (VSS XI0_I29_xbn XI0_I29_xn1 VSS) gpdk090_nmos1v w=0.24u l=0.1u ad=0.0528p as=0.0816p pd=0.68u ps=1.16u
    I_MXI0_I29_MN16 (XI0_I29_xn2 B_5 VSS VSS) gpdk090_nmos1v w=0.24u l=0.1u ad=0.0528p as=0.0528p pd=0.68u ps=0.68u
    I_MXI0_I29_MN15 (I0_pp2_6 XI0_I29_xan XI0_I29_xn2 VSS) gpdk090_nmos1v w=0.24u l=0.1u ad=0.0528p as=0.0528p pd=0.68u ps=0.68u
    I_MXI0_I29_MN13 (XI0_I29_xn1 XI0_I29_xn I0_pp2_6 VSS) gpdk090_nmos1v w=0.24u l=0.1u ad=0.0816p as=0.0528p pd=1.16u ps=0.68u
    I_MXI0_I29_MN2 (VSS A_6 XI0_I29_n1 VSS) gpdk090_nmos1v w=0.24u l=0.1u ad=0.0528p as=0.0816p pd=0.68u ps=1.16u
    I_MXI0_I29_MN4 (XI0_I29_n2 A_5 VSS VSS) gpdk090_nmos1v w=0.24u l=0.1u ad=0.0528p as=0.0528p pd=0.68u ps=0.68u
    I_MXI0_I29_MN3 (XI0_I29_xn I0_two2 XI0_I29_n2 VSS) gpdk090_nmos1v w=0.24u l=0.1u ad=0.0528p as=0.0528p pd=0.68u ps=0.68u
    I_MXI0_I29_MN1 (XI0_I29_n1 I0_one2 XI0_I29_xn VSS) gpdk090_nmos1v w=0.24u l=0.1u ad=0.0816p as=0.0528p pd=1.16u ps=0.68u
    I_MXI0_I29_MN9 (VSS XI0_I29_xn XI0_I29_xan VSS) gpdk090_nmos1v w=0.12u l=0.1u ad=0.0696p as=0.0696p pd=1.16u ps=1.16u
    I_MXI0_I20_MN11 (VSS B_3 XI0_I20_xbn VSS) gpdk090_nmos1v w=0.12u l=0.1u ad=0.0696p as=0.0696p pd=1.16u ps=1.16u
    I_MXI0_I20_MN14 (VSS XI0_I20_xbn XI0_I20_xn1 VSS) gpdk090_nmos1v w=0.24u l=0.1u ad=0.0528p as=0.0816p pd=0.68u ps=1.16u
    I_MXI0_I20_MN16 (XI0_I20_xn2 B_3 VSS VSS) gpdk090_nmos1v w=0.24u l=0.1u ad=0.0528p as=0.0528p pd=0.68u ps=0.68u
    I_MXI0_I20_MN15 (I0_pp1_8 XI0_I20_xan XI0_I20_xn2 VSS) gpdk090_nmos1v w=0.24u l=0.1u ad=0.0528p as=0.0528p pd=0.68u ps=0.68u
    I_MXI0_I20_MN13 (XI0_I20_xn1 XI0_I20_xn I0_pp1_8 VSS) gpdk090_nmos1v w=0.24u l=0.1u ad=0.0816p as=0.0528p pd=1.16u ps=0.68u
    I_MXI0_I20_MN2 (VSS A_7 XI0_I20_n1 VSS) gpdk090_nmos1v w=0.24u l=0.1u ad=0.0528p as=0.0816p pd=0.68u ps=1.16u
    I_MXI0_I20_MN4 (XI0_I20_n2 A_7 VSS VSS) gpdk090_nmos1v w=0.24u l=0.1u ad=0.0528p as=0.0528p pd=0.68u ps=0.68u
    I_MXI0_I20_MN3 (XI0_I20_xn I0_two1 XI0_I20_n2 VSS) gpdk090_nmos1v w=0.24u l=0.1u ad=0.0528p as=0.0528p pd=0.68u ps=0.68u
    I_MXI0_I20_MN1 (XI0_I20_n1 I0_one1 XI0_I20_xn VSS) gpdk090_nmos1v w=0.24u l=0.1u ad=0.0816p as=0.0528p pd=1.16u ps=0.68u
    I_MXI0_I20_MN9 (VSS XI0_I20_xn XI0_I20_xan VSS) gpdk090_nmos1v w=0.12u l=0.1u ad=0.0696p as=0.0696p pd=1.16u ps=1.16u
    I_MXI0_I28_MN11 (VSS B_5 XI0_I28_xbn VSS) gpdk090_nmos1v w=0.12u l=0.1u ad=0.0696p as=0.0696p pd=1.16u ps=1.16u
    I_MXI0_I28_MN14 (VSS XI0_I28_xbn XI0_I28_xn1 VSS) gpdk090_nmos1v w=0.24u l=0.1u ad=0.0528p as=0.0816p pd=0.68u ps=1.16u
    I_MXI0_I28_MN16 (XI0_I28_xn2 B_5 VSS VSS) gpdk090_nmos1v w=0.24u l=0.1u ad=0.0528p as=0.0528p pd=0.68u ps=0.68u
    I_MXI0_I28_MN15 (I0_pp2_5 XI0_I28_xan XI0_I28_xn2 VSS) gpdk090_nmos1v w=0.24u l=0.1u ad=0.0528p as=0.0528p pd=0.68u ps=0.68u
    I_MXI0_I28_MN13 (XI0_I28_xn1 XI0_I28_xn I0_pp2_5 VSS) gpdk090_nmos1v w=0.24u l=0.1u ad=0.0816p as=0.0528p pd=1.16u ps=0.68u
    I_MXI0_I28_MN2 (VSS A_5 XI0_I28_n1 VSS) gpdk090_nmos1v w=0.24u l=0.1u ad=0.0528p as=0.0816p pd=0.68u ps=1.16u
    I_MXI0_I28_MN4 (XI0_I28_n2 A_4 VSS VSS) gpdk090_nmos1v w=0.24u l=0.1u ad=0.0528p as=0.0528p pd=0.68u ps=0.68u
    I_MXI0_I28_MN3 (XI0_I28_xn I0_two2 XI0_I28_n2 VSS) gpdk090_nmos1v w=0.24u l=0.1u ad=0.0528p as=0.0528p pd=0.68u ps=0.68u
    I_MXI0_I28_MN1 (XI0_I28_n1 I0_one2 XI0_I28_xn VSS) gpdk090_nmos1v w=0.24u l=0.1u ad=0.0816p as=0.0528p pd=1.16u ps=0.68u
    I_MXI0_I28_MN9 (VSS XI0_I28_xn XI0_I28_xan VSS) gpdk090_nmos1v w=0.12u l=0.1u ad=0.0696p as=0.0696p pd=1.16u ps=1.16u
    I_MXI0_I19_MN11 (VSS B_3 XI0_I19_xbn VSS) gpdk090_nmos1v w=0.12u l=0.1u ad=0.0696p as=0.0696p pd=1.16u ps=1.16u
    I_MXI0_I19_MN14 (VSS XI0_I19_xbn XI0_I19_xn1 VSS) gpdk090_nmos1v w=0.24u l=0.1u ad=0.0528p as=0.0816p pd=0.68u ps=1.16u
    I_MXI0_I19_MN16 (XI0_I19_xn2 B_3 VSS VSS) gpdk090_nmos1v w=0.24u l=0.1u ad=0.0528p as=0.0528p pd=0.68u ps=0.68u
    I_MXI0_I19_MN15 (I0_pp1_7 XI0_I19_xan XI0_I19_xn2 VSS) gpdk090_nmos1v w=0.24u l=0.1u ad=0.0528p as=0.0528p pd=0.68u ps=0.68u
    I_MXI0_I19_MN13 (XI0_I19_xn1 XI0_I19_xn I0_pp1_7 VSS) gpdk090_nmos1v w=0.24u l=0.1u ad=0.0816p as=0.0528p pd=1.16u ps=0.68u
    I_MXI0_I19_MN2 (VSS A_7 XI0_I19_n1 VSS) gpdk090_nmos1v w=0.24u l=0.1u ad=0.0528p as=0.0816p pd=0.68u ps=1.16u
    I_MXI0_I19_MN4 (XI0_I19_n2 A_6 VSS VSS) gpdk090_nmos1v w=0.24u l=0.1u ad=0.0528p as=0.0528p pd=0.68u ps=0.68u
    I_MXI0_I19_MN3 (XI0_I19_xn I0_two1 XI0_I19_n2 VSS) gpdk090_nmos1v w=0.24u l=0.1u ad=0.0528p as=0.0528p pd=0.68u ps=0.68u
    I_MXI0_I19_MN1 (XI0_I19_n1 I0_one1 XI0_I19_xn VSS) gpdk090_nmos1v w=0.24u l=0.1u ad=0.0816p as=0.0528p pd=1.16u ps=0.68u
    I_MXI0_I19_MN9 (VSS XI0_I19_xn XI0_I19_xan VSS) gpdk090_nmos1v w=0.12u l=0.1u ad=0.0696p as=0.0696p pd=1.16u ps=1.16u
    I_MXI0_I38_MN11 (VSS B_7 XI0_I38_xbn VSS) gpdk090_nmos1v w=0.12u l=0.1u ad=0.0696p as=0.0696p pd=1.16u ps=1.16u
    I_MXI0_I38_MN14 (VSS XI0_I38_xbn XI0_I38_xn1 VSS) gpdk090_nmos1v w=0.24u l=0.1u ad=0.0528p as=0.0816p pd=0.68u ps=1.16u
    I_MXI0_I38_MN16 (XI0_I38_xn2 B_7 VSS VSS) gpdk090_nmos1v w=0.24u l=0.1u ad=0.0528p as=0.0528p pd=0.68u ps=0.68u
    I_MXI0_I38_MN15 (I0_pp3_4 XI0_I38_xan XI0_I38_xn2 VSS) gpdk090_nmos1v w=0.24u l=0.1u ad=0.0528p as=0.0528p pd=0.68u ps=0.68u
    I_MXI0_I38_MN13 (XI0_I38_xn1 XI0_I38_xn I0_pp3_4 VSS) gpdk090_nmos1v w=0.24u l=0.1u ad=0.0816p as=0.0528p pd=1.16u ps=0.68u
    I_MXI0_I38_MN2 (VSS A_4 XI0_I38_n1 VSS) gpdk090_nmos1v w=0.24u l=0.1u ad=0.0528p as=0.0816p pd=0.68u ps=1.16u
    I_MXI0_I38_MN4 (XI0_I38_n2 A_3 VSS VSS) gpdk090_nmos1v w=0.24u l=0.1u ad=0.0528p as=0.0528p pd=0.68u ps=0.68u
    I_MXI0_I38_MN3 (XI0_I38_xn I0_two3 XI0_I38_n2 VSS) gpdk090_nmos1v w=0.24u l=0.1u ad=0.0528p as=0.0528p pd=0.68u ps=0.68u
    I_MXI0_I38_MN1 (XI0_I38_n1 I0_one3 XI0_I38_xn VSS) gpdk090_nmos1v w=0.24u l=0.1u ad=0.0816p as=0.0528p pd=1.16u ps=0.68u
    I_MXI0_I38_MN9 (VSS XI0_I38_xn XI0_I38_xan VSS) gpdk090_nmos1v w=0.12u l=0.1u ad=0.0696p as=0.0696p pd=1.16u ps=1.16u
    I_MXI0_I39_MN11 (VSS B_7 XI0_I39_xbn VSS) gpdk090_nmos1v w=0.12u l=0.1u ad=0.0696p as=0.0696p pd=1.16u ps=1.16u
    I_MXI0_I39_MN14 (VSS XI0_I39_xbn XI0_I39_xn1 VSS) gpdk090_nmos1v w=0.24u l=0.1u ad=0.0528p as=0.0816p pd=0.68u ps=1.16u
    I_MXI0_I39_MN16 (XI0_I39_xn2 B_7 VSS VSS) gpdk090_nmos1v w=0.24u l=0.1u ad=0.0528p as=0.0528p pd=0.68u ps=0.68u
    I_MXI0_I39_MN15 (I0_pp3_5 XI0_I39_xan XI0_I39_xn2 VSS) gpdk090_nmos1v w=0.24u l=0.1u ad=0.0528p as=0.0528p pd=0.68u ps=0.68u
    I_MXI0_I39_MN13 (XI0_I39_xn1 XI0_I39_xn I0_pp3_5 VSS) gpdk090_nmos1v w=0.24u l=0.1u ad=0.0816p as=0.0528p pd=1.16u ps=0.68u
    I_MXI0_I39_MN2 (VSS A_5 XI0_I39_n1 VSS) gpdk090_nmos1v w=0.24u l=0.1u ad=0.0528p as=0.0816p pd=0.68u ps=1.16u
    I_MXI0_I39_MN4 (XI0_I39_n2 A_4 VSS VSS) gpdk090_nmos1v w=0.24u l=0.1u ad=0.0528p as=0.0528p pd=0.68u ps=0.68u
    I_MXI0_I39_MN3 (XI0_I39_xn I0_two3 XI0_I39_n2 VSS) gpdk090_nmos1v w=0.24u l=0.1u ad=0.0528p as=0.0528p pd=0.68u ps=0.68u
    I_MXI0_I39_MN1 (XI0_I39_n1 I0_one3 XI0_I39_xn VSS) gpdk090_nmos1v w=0.24u l=0.1u ad=0.0816p as=0.0528p pd=1.16u ps=0.68u
    I_MXI0_I39_MN9 (VSS XI0_I39_xn XI0_I39_xan VSS) gpdk090_nmos1v w=0.12u l=0.1u ad=0.0696p as=0.0696p pd=1.16u ps=1.16u
    I_MXI0_I18_MN11 (VSS B_3 XI0_I18_xbn VSS) gpdk090_nmos1v w=0.12u l=0.1u ad=0.0696p as=0.0696p pd=1.16u ps=1.16u
    I_MXI0_I18_MN14 (VSS XI0_I18_xbn XI0_I18_xn1 VSS) gpdk090_nmos1v w=0.24u l=0.1u ad=0.0528p as=0.0816p pd=0.68u ps=1.16u
    I_MXI0_I18_MN16 (XI0_I18_xn2 B_3 VSS VSS) gpdk090_nmos1v w=0.24u l=0.1u ad=0.0528p as=0.0528p pd=0.68u ps=0.68u
    I_MXI0_I18_MN15 (I0_pp1_6 XI0_I18_xan XI0_I18_xn2 VSS) gpdk090_nmos1v w=0.24u l=0.1u ad=0.0528p as=0.0528p pd=0.68u ps=0.68u
    I_MXI0_I18_MN13 (XI0_I18_xn1 XI0_I18_xn I0_pp1_6 VSS) gpdk090_nmos1v w=0.24u l=0.1u ad=0.0816p as=0.0528p pd=1.16u ps=0.68u
    I_MXI0_I18_MN2 (VSS A_6 XI0_I18_n1 VSS) gpdk090_nmos1v w=0.24u l=0.1u ad=0.0528p as=0.0816p pd=0.68u ps=1.16u
    I_MXI0_I18_MN4 (XI0_I18_n2 A_5 VSS VSS) gpdk090_nmos1v w=0.24u l=0.1u ad=0.0528p as=0.0528p pd=0.68u ps=0.68u
    I_MXI0_I18_MN3 (XI0_I18_xn I0_two1 XI0_I18_n2 VSS) gpdk090_nmos1v w=0.24u l=0.1u ad=0.0528p as=0.0528p pd=0.68u ps=0.68u
    I_MXI0_I18_MN1 (XI0_I18_n1 I0_one1 XI0_I18_xn VSS) gpdk090_nmos1v w=0.24u l=0.1u ad=0.0816p as=0.0528p pd=1.16u ps=0.68u
    I_MXI0_I18_MN9 (VSS XI0_I18_xn XI0_I18_xan VSS) gpdk090_nmos1v w=0.12u l=0.1u ad=0.0696p as=0.0696p pd=1.16u ps=1.16u
    I_MXI0_I27_MN11 (VSS B_5 XI0_I27_xbn VSS) gpdk090_nmos1v w=0.12u l=0.1u ad=0.0696p as=0.0696p pd=1.16u ps=1.16u
    I_MXI0_I27_MN14 (VSS XI0_I27_xbn XI0_I27_xn1 VSS) gpdk090_nmos1v w=0.24u l=0.1u ad=0.0528p as=0.0816p pd=0.68u ps=1.16u
    I_MXI0_I27_MN16 (XI0_I27_xn2 B_5 VSS VSS) gpdk090_nmos1v w=0.24u l=0.1u ad=0.0528p as=0.0528p pd=0.68u ps=0.68u
    I_MXI0_I27_MN15 (I0_pp2_4 XI0_I27_xan XI0_I27_xn2 VSS) gpdk090_nmos1v w=0.24u l=0.1u ad=0.0528p as=0.0528p pd=0.68u ps=0.68u
    I_MXI0_I27_MN13 (XI0_I27_xn1 XI0_I27_xn I0_pp2_4 VSS) gpdk090_nmos1v w=0.24u l=0.1u ad=0.0816p as=0.0528p pd=1.16u ps=0.68u
    I_MXI0_I27_MN2 (VSS A_4 XI0_I27_n1 VSS) gpdk090_nmos1v w=0.24u l=0.1u ad=0.0528p as=0.0816p pd=0.68u ps=1.16u
    I_MXI0_I27_MN4 (XI0_I27_n2 A_3 VSS VSS) gpdk090_nmos1v w=0.24u l=0.1u ad=0.0528p as=0.0528p pd=0.68u ps=0.68u
    I_MXI0_I27_MN3 (XI0_I27_xn I0_two2 XI0_I27_n2 VSS) gpdk090_nmos1v w=0.24u l=0.1u ad=0.0528p as=0.0528p pd=0.68u ps=0.68u
    I_MXI0_I27_MN1 (XI0_I27_n1 I0_one2 XI0_I27_xn VSS) gpdk090_nmos1v w=0.24u l=0.1u ad=0.0816p as=0.0528p pd=1.16u ps=0.68u
    I_MXI0_I27_MN9 (VSS XI0_I27_xn XI0_I27_xan VSS) gpdk090_nmos1v w=0.12u l=0.1u ad=0.0696p as=0.0696p pd=1.16u ps=1.16u
    I_MXI0_I37_MN11 (VSS B_7 XI0_I37_xbn VSS) gpdk090_nmos1v w=0.12u l=0.1u ad=0.0696p as=0.0696p pd=1.16u ps=1.16u
    I_MXI0_I37_MN14 (VSS XI0_I37_xbn XI0_I37_xn1 VSS) gpdk090_nmos1v w=0.24u l=0.1u ad=0.0528p as=0.0816p pd=0.68u ps=1.16u
    I_MXI0_I37_MN16 (XI0_I37_xn2 B_7 VSS VSS) gpdk090_nmos1v w=0.24u l=0.1u ad=0.0528p as=0.0528p pd=0.68u ps=0.68u
    I_MXI0_I37_MN15 (I0_pp3_3 XI0_I37_xan XI0_I37_xn2 VSS) gpdk090_nmos1v w=0.24u l=0.1u ad=0.0528p as=0.0528p pd=0.68u ps=0.68u
    I_MXI0_I37_MN13 (XI0_I37_xn1 XI0_I37_xn I0_pp3_3 VSS) gpdk090_nmos1v w=0.24u l=0.1u ad=0.0816p as=0.0528p pd=1.16u ps=0.68u
    I_MXI0_I37_MN2 (VSS A_3 XI0_I37_n1 VSS) gpdk090_nmos1v w=0.24u l=0.1u ad=0.0528p as=0.0816p pd=0.68u ps=1.16u
    I_MXI0_I37_MN4 (XI0_I37_n2 A_2 VSS VSS) gpdk090_nmos1v w=0.24u l=0.1u ad=0.0528p as=0.0528p pd=0.68u ps=0.68u
    I_MXI0_I37_MN3 (XI0_I37_xn I0_two3 XI0_I37_n2 VSS) gpdk090_nmos1v w=0.24u l=0.1u ad=0.0528p as=0.0528p pd=0.68u ps=0.68u
    I_MXI0_I37_MN1 (XI0_I37_n1 I0_one3 XI0_I37_xn VSS) gpdk090_nmos1v w=0.24u l=0.1u ad=0.0816p as=0.0528p pd=1.16u ps=0.68u
    I_MXI0_I37_MN9 (VSS XI0_I37_xn XI0_I37_xan VSS) gpdk090_nmos1v w=0.12u l=0.1u ad=0.0696p as=0.0696p pd=1.16u ps=1.16u
    I_MXI0_I26_MN11 (VSS B_5 XI0_I26_xbn VSS) gpdk090_nmos1v w=0.12u l=0.1u ad=0.0696p as=0.0696p pd=1.16u ps=1.16u
    I_MXI0_I26_MN14 (VSS XI0_I26_xbn XI0_I26_xn1 VSS) gpdk090_nmos1v w=0.24u l=0.1u ad=0.0528p as=0.0816p pd=0.68u ps=1.16u
    I_MXI0_I26_MN16 (XI0_I26_xn2 B_5 VSS VSS) gpdk090_nmos1v w=0.24u l=0.1u ad=0.0528p as=0.0528p pd=0.68u ps=0.68u
    I_MXI0_I26_MN15 (I0_pp2_3 XI0_I26_xan XI0_I26_xn2 VSS) gpdk090_nmos1v w=0.24u l=0.1u ad=0.0528p as=0.0528p pd=0.68u ps=0.68u
    I_MXI0_I26_MN13 (XI0_I26_xn1 XI0_I26_xn I0_pp2_3 VSS) gpdk090_nmos1v w=0.24u l=0.1u ad=0.0816p as=0.0528p pd=1.16u ps=0.68u
    I_MXI0_I26_MN2 (VSS A_3 XI0_I26_n1 VSS) gpdk090_nmos1v w=0.24u l=0.1u ad=0.0528p as=0.0816p pd=0.68u ps=1.16u
    I_MXI0_I26_MN4 (XI0_I26_n2 A_2 VSS VSS) gpdk090_nmos1v w=0.24u l=0.1u ad=0.0528p as=0.0528p pd=0.68u ps=0.68u
    I_MXI0_I26_MN3 (XI0_I26_xn I0_two2 XI0_I26_n2 VSS) gpdk090_nmos1v w=0.24u l=0.1u ad=0.0528p as=0.0528p pd=0.68u ps=0.68u
    I_MXI0_I26_MN1 (XI0_I26_n1 I0_one2 XI0_I26_xn VSS) gpdk090_nmos1v w=0.24u l=0.1u ad=0.0816p as=0.0528p pd=1.16u ps=0.68u
    I_MXI0_I26_MN9 (VSS XI0_I26_xn XI0_I26_xan VSS) gpdk090_nmos1v w=0.12u l=0.1u ad=0.0696p as=0.0696p pd=1.16u ps=1.16u
    I_MXI0_I36_MN11 (VSS B_7 XI0_I36_xbn VSS) gpdk090_nmos1v w=0.12u l=0.1u ad=0.0696p as=0.0696p pd=1.16u ps=1.16u
    I_MXI0_I36_MN14 (VSS XI0_I36_xbn XI0_I36_xn1 VSS) gpdk090_nmos1v w=0.24u l=0.1u ad=0.0528p as=0.0816p pd=0.68u ps=1.16u
    I_MXI0_I36_MN16 (XI0_I36_xn2 B_7 VSS VSS) gpdk090_nmos1v w=0.24u l=0.1u ad=0.0528p as=0.0528p pd=0.68u ps=0.68u
    I_MXI0_I36_MN15 (I0_pp3_2 XI0_I36_xan XI0_I36_xn2 VSS) gpdk090_nmos1v w=0.24u l=0.1u ad=0.0528p as=0.0528p pd=0.68u ps=0.68u
    I_MXI0_I36_MN13 (XI0_I36_xn1 XI0_I36_xn I0_pp3_2 VSS) gpdk090_nmos1v w=0.24u l=0.1u ad=0.0816p as=0.0528p pd=1.16u ps=0.68u
    I_MXI0_I36_MN2 (VSS A_2 XI0_I36_n1 VSS) gpdk090_nmos1v w=0.24u l=0.1u ad=0.0528p as=0.0816p pd=0.68u ps=1.16u
    I_MXI0_I36_MN4 (XI0_I36_n2 A_1 VSS VSS) gpdk090_nmos1v w=0.24u l=0.1u ad=0.0528p as=0.0528p pd=0.68u ps=0.68u
    I_MXI0_I36_MN3 (XI0_I36_xn I0_two3 XI0_I36_n2 VSS) gpdk090_nmos1v w=0.24u l=0.1u ad=0.0528p as=0.0528p pd=0.68u ps=0.68u
    I_MXI0_I36_MN1 (XI0_I36_n1 I0_one3 XI0_I36_xn VSS) gpdk090_nmos1v w=0.24u l=0.1u ad=0.0816p as=0.0528p pd=1.16u ps=0.68u
    I_MXI0_I36_MN9 (VSS XI0_I36_xn XI0_I36_xan VSS) gpdk090_nmos1v w=0.12u l=0.1u ad=0.0696p as=0.0696p pd=1.16u ps=1.16u
    I_MXI0_I15_MN11 (VSS B_3 XI0_I15_xbn VSS) gpdk090_nmos1v w=0.12u l=0.1u ad=0.0696p as=0.0696p pd=1.16u ps=1.16u
    I_MXI0_I15_MN14 (VSS XI0_I15_xbn XI0_I15_xn1 VSS) gpdk090_nmos1v w=0.24u l=0.1u ad=0.0528p as=0.0816p pd=0.68u ps=1.16u
    I_MXI0_I15_MN16 (XI0_I15_xn2 B_3 VSS VSS) gpdk090_nmos1v w=0.24u l=0.1u ad=0.0528p as=0.0528p pd=0.68u ps=0.68u
    I_MXI0_I15_MN15 (I0_pp1_3 XI0_I15_xan XI0_I15_xn2 VSS) gpdk090_nmos1v w=0.24u l=0.1u ad=0.0528p as=0.0528p pd=0.68u ps=0.68u
    I_MXI0_I15_MN13 (XI0_I15_xn1 XI0_I15_xn I0_pp1_3 VSS) gpdk090_nmos1v w=0.24u l=0.1u ad=0.0816p as=0.0528p pd=1.16u ps=0.68u
    I_MXI0_I15_MN2 (VSS A_3 XI0_I15_n1 VSS) gpdk090_nmos1v w=0.24u l=0.1u ad=0.0528p as=0.0816p pd=0.68u ps=1.16u
    I_MXI0_I15_MN4 (XI0_I15_n2 A_2 VSS VSS) gpdk090_nmos1v w=0.24u l=0.1u ad=0.0528p as=0.0528p pd=0.68u ps=0.68u
    I_MXI0_I15_MN3 (XI0_I15_xn I0_two1 XI0_I15_n2 VSS) gpdk090_nmos1v w=0.24u l=0.1u ad=0.0528p as=0.0528p pd=0.68u ps=0.68u
    I_MXI0_I15_MN1 (XI0_I15_n1 I0_one1 XI0_I15_xn VSS) gpdk090_nmos1v w=0.24u l=0.1u ad=0.0816p as=0.0528p pd=1.16u ps=0.68u
    I_MXI0_I15_MN9 (VSS XI0_I15_xn XI0_I15_xan VSS) gpdk090_nmos1v w=0.12u l=0.1u ad=0.0696p as=0.0696p pd=1.16u ps=1.16u
    I_MXI0_I17_MN11 (VSS B_3 XI0_I17_xbn VSS) gpdk090_nmos1v w=0.12u l=0.1u ad=0.0696p as=0.0696p pd=1.16u ps=1.16u
    I_MXI0_I17_MN14 (VSS XI0_I17_xbn XI0_I17_xn1 VSS) gpdk090_nmos1v w=0.24u l=0.1u ad=0.0528p as=0.0816p pd=0.68u ps=1.16u
    I_MXI0_I17_MN16 (XI0_I17_xn2 B_3 VSS VSS) gpdk090_nmos1v w=0.24u l=0.1u ad=0.0528p as=0.0528p pd=0.68u ps=0.68u
    I_MXI0_I17_MN15 (I0_pp1_5 XI0_I17_xan XI0_I17_xn2 VSS) gpdk090_nmos1v w=0.24u l=0.1u ad=0.0528p as=0.0528p pd=0.68u ps=0.68u
    I_MXI0_I17_MN13 (XI0_I17_xn1 XI0_I17_xn I0_pp1_5 VSS) gpdk090_nmos1v w=0.24u l=0.1u ad=0.0816p as=0.0528p pd=1.16u ps=0.68u
    I_MXI0_I17_MN2 (VSS A_5 XI0_I17_n1 VSS) gpdk090_nmos1v w=0.24u l=0.1u ad=0.0528p as=0.0816p pd=0.68u ps=1.16u
    I_MXI0_I17_MN4 (XI0_I17_n2 A_4 VSS VSS) gpdk090_nmos1v w=0.24u l=0.1u ad=0.0528p as=0.0528p pd=0.68u ps=0.68u
    I_MXI0_I17_MN3 (XI0_I17_xn I0_two1 XI0_I17_n2 VSS) gpdk090_nmos1v w=0.24u l=0.1u ad=0.0528p as=0.0528p pd=0.68u ps=0.68u
    I_MXI0_I17_MN1 (XI0_I17_n1 I0_one1 XI0_I17_xn VSS) gpdk090_nmos1v w=0.24u l=0.1u ad=0.0816p as=0.0528p pd=1.16u ps=0.68u
    I_MXI0_I17_MN9 (VSS XI0_I17_xn XI0_I17_xan VSS) gpdk090_nmos1v w=0.12u l=0.1u ad=0.0696p as=0.0696p pd=1.16u ps=1.16u
    I_MXI0_I25_MN11 (VSS B_5 XI0_I25_xbn VSS) gpdk090_nmos1v w=0.12u l=0.1u ad=0.0696p as=0.0696p pd=1.16u ps=1.16u
    I_MXI0_I25_MN14 (VSS XI0_I25_xbn XI0_I25_xn1 VSS) gpdk090_nmos1v w=0.24u l=0.1u ad=0.0528p as=0.0816p pd=0.68u ps=1.16u
    I_MXI0_I25_MN16 (XI0_I25_xn2 B_5 VSS VSS) gpdk090_nmos1v w=0.24u l=0.1u ad=0.0528p as=0.0528p pd=0.68u ps=0.68u
    I_MXI0_I25_MN15 (I0_pp2_2 XI0_I25_xan XI0_I25_xn2 VSS) gpdk090_nmos1v w=0.24u l=0.1u ad=0.0528p as=0.0528p pd=0.68u ps=0.68u
    I_MXI0_I25_MN13 (XI0_I25_xn1 XI0_I25_xn I0_pp2_2 VSS) gpdk090_nmos1v w=0.24u l=0.1u ad=0.0816p as=0.0528p pd=1.16u ps=0.68u
    I_MXI0_I25_MN2 (VSS A_2 XI0_I25_n1 VSS) gpdk090_nmos1v w=0.24u l=0.1u ad=0.0528p as=0.0816p pd=0.68u ps=1.16u
    I_MXI0_I25_MN4 (XI0_I25_n2 A_1 VSS VSS) gpdk090_nmos1v w=0.24u l=0.1u ad=0.0528p as=0.0528p pd=0.68u ps=0.68u
    I_MXI0_I25_MN3 (XI0_I25_xn I0_two2 XI0_I25_n2 VSS) gpdk090_nmos1v w=0.24u l=0.1u ad=0.0528p as=0.0528p pd=0.68u ps=0.68u
    I_MXI0_I25_MN1 (XI0_I25_n1 I0_one2 XI0_I25_xn VSS) gpdk090_nmos1v w=0.24u l=0.1u ad=0.0816p as=0.0528p pd=1.16u ps=0.68u
    I_MXI0_I25_MN9 (VSS XI0_I25_xn XI0_I25_xan VSS) gpdk090_nmos1v w=0.12u l=0.1u ad=0.0696p as=0.0696p pd=1.16u ps=1.16u
    I_MXI0_I34_MN11 (VSS B_7 XI0_I34_xbn VSS) gpdk090_nmos1v w=0.12u l=0.1u ad=0.0696p as=0.0696p pd=1.16u ps=1.16u
    I_MXI0_I34_MN14 (VSS XI0_I34_xbn XI0_I34_xn1 VSS) gpdk090_nmos1v w=0.24u l=0.1u ad=0.0528p as=0.0816p pd=0.68u ps=1.16u
    I_MXI0_I34_MN16 (XI0_I34_xn2 B_7 VSS VSS) gpdk090_nmos1v w=0.24u l=0.1u ad=0.0528p as=0.0528p pd=0.68u ps=0.68u
    I_MXI0_I34_MN15 (I0_pp3_0 XI0_I34_xan XI0_I34_xn2 VSS) gpdk090_nmos1v w=0.24u l=0.1u ad=0.0528p as=0.0528p pd=0.68u ps=0.68u
    I_MXI0_I34_MN13 (XI0_I34_xn1 XI0_I34_xn I0_pp3_0 VSS) gpdk090_nmos1v w=0.24u l=0.1u ad=0.0816p as=0.0528p pd=1.16u ps=0.68u
    I_MXI0_I34_MN2 (VSS A_0 XI0_I34_n1 VSS) gpdk090_nmos1v w=0.24u l=0.1u ad=0.0528p as=0.0816p pd=0.68u ps=1.16u
    I_MXI0_I34_MN4 (XI0_I34_n2 VSS VSS VSS) gpdk090_nmos1v w=0.24u l=0.1u ad=0.0528p as=0.0528p pd=0.68u ps=0.68u
    I_MXI0_I34_MN3 (XI0_I34_xn I0_two3 XI0_I34_n2 VSS) gpdk090_nmos1v w=0.24u l=0.1u ad=0.0528p as=0.0528p pd=0.68u ps=0.68u
    I_MXI0_I34_MN1 (XI0_I34_n1 I0_one3 XI0_I34_xn VSS) gpdk090_nmos1v w=0.24u l=0.1u ad=0.0816p as=0.0528p pd=1.16u ps=0.68u
    I_MXI0_I34_MN9 (VSS XI0_I34_xn XI0_I34_xan VSS) gpdk090_nmos1v w=0.12u l=0.1u ad=0.0696p as=0.0696p pd=1.16u ps=1.16u
    I_MXI0_I35_MN11 (VSS B_7 XI0_I35_xbn VSS) gpdk090_nmos1v w=0.12u l=0.1u ad=0.0696p as=0.0696p pd=1.16u ps=1.16u
    I_MXI0_I35_MN14 (VSS XI0_I35_xbn XI0_I35_xn1 VSS) gpdk090_nmos1v w=0.24u l=0.1u ad=0.0528p as=0.0816p pd=0.68u ps=1.16u
    I_MXI0_I35_MN16 (XI0_I35_xn2 B_7 VSS VSS) gpdk090_nmos1v w=0.24u l=0.1u ad=0.0528p as=0.0528p pd=0.68u ps=0.68u
    I_MXI0_I35_MN15 (I0_pp3_1 XI0_I35_xan XI0_I35_xn2 VSS) gpdk090_nmos1v w=0.24u l=0.1u ad=0.0528p as=0.0528p pd=0.68u ps=0.68u
    I_MXI0_I35_MN13 (XI0_I35_xn1 XI0_I35_xn I0_pp3_1 VSS) gpdk090_nmos1v w=0.24u l=0.1u ad=0.0816p as=0.0528p pd=1.16u ps=0.68u
    I_MXI0_I35_MN2 (VSS A_1 XI0_I35_n1 VSS) gpdk090_nmos1v w=0.24u l=0.1u ad=0.0528p as=0.0816p pd=0.68u ps=1.16u
    I_MXI0_I35_MN4 (XI0_I35_n2 A_0 VSS VSS) gpdk090_nmos1v w=0.24u l=0.1u ad=0.0528p as=0.0528p pd=0.68u ps=0.68u
    I_MXI0_I35_MN3 (XI0_I35_xn I0_two3 XI0_I35_n2 VSS) gpdk090_nmos1v w=0.24u l=0.1u ad=0.0528p as=0.0528p pd=0.68u ps=0.68u
    I_MXI0_I35_MN1 (XI0_I35_n1 I0_one3 XI0_I35_xn VSS) gpdk090_nmos1v w=0.24u l=0.1u ad=0.0816p as=0.0528p pd=1.16u ps=0.68u
    I_MXI0_I35_MN9 (VSS XI0_I35_xn XI0_I35_xan VSS) gpdk090_nmos1v w=0.12u l=0.1u ad=0.0696p as=0.0696p pd=1.16u ps=1.16u
    I_MXI0_I14_MN11 (VSS B_3 XI0_I14_xbn VSS) gpdk090_nmos1v w=0.12u l=0.1u ad=0.0696p as=0.0696p pd=1.16u ps=1.16u
    I_MXI0_I14_MN14 (VSS XI0_I14_xbn XI0_I14_xn1 VSS) gpdk090_nmos1v w=0.24u l=0.1u ad=0.0528p as=0.0816p pd=0.68u ps=1.16u
    I_MXI0_I14_MN16 (XI0_I14_xn2 B_3 VSS VSS) gpdk090_nmos1v w=0.24u l=0.1u ad=0.0528p as=0.0528p pd=0.68u ps=0.68u
    I_MXI0_I14_MN15 (I0_pp1_2 XI0_I14_xan XI0_I14_xn2 VSS) gpdk090_nmos1v w=0.24u l=0.1u ad=0.0528p as=0.0528p pd=0.68u ps=0.68u
    I_MXI0_I14_MN13 (XI0_I14_xn1 XI0_I14_xn I0_pp1_2 VSS) gpdk090_nmos1v w=0.24u l=0.1u ad=0.0816p as=0.0528p pd=1.16u ps=0.68u
    I_MXI0_I14_MN2 (VSS A_2 XI0_I14_n1 VSS) gpdk090_nmos1v w=0.24u l=0.1u ad=0.0528p as=0.0816p pd=0.68u ps=1.16u
    I_MXI0_I14_MN4 (XI0_I14_n2 A_1 VSS VSS) gpdk090_nmos1v w=0.24u l=0.1u ad=0.0528p as=0.0528p pd=0.68u ps=0.68u
    I_MXI0_I14_MN3 (XI0_I14_xn I0_two1 XI0_I14_n2 VSS) gpdk090_nmos1v w=0.24u l=0.1u ad=0.0528p as=0.0528p pd=0.68u ps=0.68u
    I_MXI0_I14_MN1 (XI0_I14_n1 I0_one1 XI0_I14_xn VSS) gpdk090_nmos1v w=0.24u l=0.1u ad=0.0816p as=0.0528p pd=1.16u ps=0.68u
    I_MXI0_I14_MN9 (VSS XI0_I14_xn XI0_I14_xan VSS) gpdk090_nmos1v w=0.12u l=0.1u ad=0.0696p as=0.0696p pd=1.16u ps=1.16u
    I_MXI0_I24_MN11 (VSS B_5 XI0_I24_xbn VSS) gpdk090_nmos1v w=0.12u l=0.1u ad=0.0696p as=0.0696p pd=1.16u ps=1.16u
    I_MXI0_I24_MN14 (VSS XI0_I24_xbn XI0_I24_xn1 VSS) gpdk090_nmos1v w=0.24u l=0.1u ad=0.0528p as=0.0816p pd=0.68u ps=1.16u
    I_MXI0_I24_MN16 (XI0_I24_xn2 B_5 VSS VSS) gpdk090_nmos1v w=0.24u l=0.1u ad=0.0528p as=0.0528p pd=0.68u ps=0.68u
    I_MXI0_I24_MN15 (I0_pp2_1 XI0_I24_xan XI0_I24_xn2 VSS) gpdk090_nmos1v w=0.24u l=0.1u ad=0.0528p as=0.0528p pd=0.68u ps=0.68u
    I_MXI0_I24_MN13 (XI0_I24_xn1 XI0_I24_xn I0_pp2_1 VSS) gpdk090_nmos1v w=0.24u l=0.1u ad=0.0816p as=0.0528p pd=1.16u ps=0.68u
    I_MXI0_I24_MN2 (VSS A_1 XI0_I24_n1 VSS) gpdk090_nmos1v w=0.24u l=0.1u ad=0.0528p as=0.0816p pd=0.68u ps=1.16u
    I_MXI0_I24_MN4 (XI0_I24_n2 A_0 VSS VSS) gpdk090_nmos1v w=0.24u l=0.1u ad=0.0528p as=0.0528p pd=0.68u ps=0.68u
    I_MXI0_I24_MN3 (XI0_I24_xn I0_two2 XI0_I24_n2 VSS) gpdk090_nmos1v w=0.24u l=0.1u ad=0.0528p as=0.0528p pd=0.68u ps=0.68u
    I_MXI0_I24_MN1 (XI0_I24_n1 I0_one2 XI0_I24_xn VSS) gpdk090_nmos1v w=0.24u l=0.1u ad=0.0816p as=0.0528p pd=1.16u ps=0.68u
    I_MXI0_I24_MN9 (VSS XI0_I24_xn XI0_I24_xan VSS) gpdk090_nmos1v w=0.12u l=0.1u ad=0.0696p as=0.0696p pd=1.16u ps=1.16u
    I_MXI0_I16_MN11 (VSS B_3 XI0_I16_xbn VSS) gpdk090_nmos1v w=0.12u l=0.1u ad=0.0696p as=0.0696p pd=1.16u ps=1.16u
    I_MXI0_I16_MN14 (VSS XI0_I16_xbn XI0_I16_xn1 VSS) gpdk090_nmos1v w=0.24u l=0.1u ad=0.0528p as=0.0816p pd=0.68u ps=1.16u
    I_MXI0_I16_MN16 (XI0_I16_xn2 B_3 VSS VSS) gpdk090_nmos1v w=0.24u l=0.1u ad=0.0528p as=0.0528p pd=0.68u ps=0.68u
    I_MXI0_I16_MN15 (I0_pp1_4 XI0_I16_xan XI0_I16_xn2 VSS) gpdk090_nmos1v w=0.24u l=0.1u ad=0.0528p as=0.0528p pd=0.68u ps=0.68u
    I_MXI0_I16_MN13 (XI0_I16_xn1 XI0_I16_xn I0_pp1_4 VSS) gpdk090_nmos1v w=0.24u l=0.1u ad=0.0816p as=0.0528p pd=1.16u ps=0.68u
    I_MXI0_I16_MN2 (VSS A_4 XI0_I16_n1 VSS) gpdk090_nmos1v w=0.24u l=0.1u ad=0.0528p as=0.0816p pd=0.68u ps=1.16u
    I_MXI0_I16_MN4 (XI0_I16_n2 A_3 VSS VSS) gpdk090_nmos1v w=0.24u l=0.1u ad=0.0528p as=0.0528p pd=0.68u ps=0.68u
    I_MXI0_I16_MN3 (XI0_I16_xn I0_two1 XI0_I16_n2 VSS) gpdk090_nmos1v w=0.24u l=0.1u ad=0.0528p as=0.0528p pd=0.68u ps=0.68u
    I_MXI0_I16_MN1 (XI0_I16_n1 I0_one1 XI0_I16_xn VSS) gpdk090_nmos1v w=0.24u l=0.1u ad=0.0816p as=0.0528p pd=1.16u ps=0.68u
    I_MXI0_I16_MN9 (VSS XI0_I16_xn XI0_I16_xan VSS) gpdk090_nmos1v w=0.12u l=0.1u ad=0.0696p as=0.0696p pd=1.16u ps=1.16u
    I_MXI0_I23_MN11 (VSS B_5 XI0_I23_xbn VSS) gpdk090_nmos1v w=0.12u l=0.1u ad=0.0696p as=0.0696p pd=1.16u ps=1.16u
    I_MXI0_I23_MN14 (VSS XI0_I23_xbn XI0_I23_xn1 VSS) gpdk090_nmos1v w=0.24u l=0.1u ad=0.0528p as=0.0816p pd=0.68u ps=1.16u
    I_MXI0_I23_MN16 (XI0_I23_xn2 B_5 VSS VSS) gpdk090_nmos1v w=0.24u l=0.1u ad=0.0528p as=0.0528p pd=0.68u ps=0.68u
    I_MXI0_I23_MN15 (I0_pp2_0 XI0_I23_xan XI0_I23_xn2 VSS) gpdk090_nmos1v w=0.24u l=0.1u ad=0.0528p as=0.0528p pd=0.68u ps=0.68u
    I_MXI0_I23_MN13 (XI0_I23_xn1 XI0_I23_xn I0_pp2_0 VSS) gpdk090_nmos1v w=0.24u l=0.1u ad=0.0816p as=0.0528p pd=1.16u ps=0.68u
    I_MXI0_I23_MN2 (VSS A_0 XI0_I23_n1 VSS) gpdk090_nmos1v w=0.24u l=0.1u ad=0.0528p as=0.0816p pd=0.68u ps=1.16u
    I_MXI0_I23_MN4 (XI0_I23_n2 VSS VSS VSS) gpdk090_nmos1v w=0.24u l=0.1u ad=0.0528p as=0.0528p pd=0.68u ps=0.68u
    I_MXI0_I23_MN3 (XI0_I23_xn I0_two2 XI0_I23_n2 VSS) gpdk090_nmos1v w=0.24u l=0.1u ad=0.0528p as=0.0528p pd=0.68u ps=0.68u
    I_MXI0_I23_MN1 (XI0_I23_n1 I0_one2 XI0_I23_xn VSS) gpdk090_nmos1v w=0.24u l=0.1u ad=0.0816p as=0.0528p pd=1.16u ps=0.68u
    I_MXI0_I23_MN9 (VSS XI0_I23_xn XI0_I23_xan VSS) gpdk090_nmos1v w=0.12u l=0.1u ad=0.0696p as=0.0696p pd=1.16u ps=1.16u
    I_MXI0_I6_MN11 (VSS B_1 XI0_I6_xbn VSS) gpdk090_nmos1v w=0.12u l=0.1u ad=0.0696p as=0.0696p pd=1.16u ps=1.16u
    I_MXI0_I6_MN14 (VSS XI0_I6_xbn XI0_I6_xn1 VSS) gpdk090_nmos1v w=0.24u l=0.1u ad=0.0528p as=0.0816p pd=0.68u ps=1.16u
    I_MXI0_I6_MN16 (XI0_I6_xn2 B_1 VSS VSS) gpdk090_nmos1v w=0.24u l=0.1u ad=0.0528p as=0.0528p pd=0.68u ps=0.68u
    I_MXI0_I6_MN15 (I0_pp0_5 XI0_I6_xan XI0_I6_xn2 VSS) gpdk090_nmos1v w=0.24u l=0.1u ad=0.0528p as=0.0528p pd=0.68u ps=0.68u
    I_MXI0_I6_MN13 (XI0_I6_xn1 XI0_I6_xn I0_pp0_5 VSS) gpdk090_nmos1v w=0.24u l=0.1u ad=0.0816p as=0.0528p pd=1.16u ps=0.68u
    I_MXI0_I6_MN2 (VSS A_5 XI0_I6_n1 VSS) gpdk090_nmos1v w=0.24u l=0.1u ad=0.0528p as=0.0816p pd=0.68u ps=1.16u
    I_MXI0_I6_MN4 (XI0_I6_n2 A_4 VSS VSS) gpdk090_nmos1v w=0.24u l=0.1u ad=0.0528p as=0.0528p pd=0.68u ps=0.68u
    I_MXI0_I6_MN3 (XI0_I6_xn I0_two0 XI0_I6_n2 VSS) gpdk090_nmos1v w=0.24u l=0.1u ad=0.0528p as=0.0528p pd=0.68u ps=0.68u
    I_MXI0_I6_MN1 (XI0_I6_n1 I0_one0 XI0_I6_xn VSS) gpdk090_nmos1v w=0.24u l=0.1u ad=0.0816p as=0.0528p pd=1.16u ps=0.68u
    I_MXI0_I6_MN9 (VSS XI0_I6_xn XI0_I6_xan VSS) gpdk090_nmos1v w=0.12u l=0.1u ad=0.0696p as=0.0696p pd=1.16u ps=1.16u
    I_MXI0_I8_MN11 (VSS B_1 XI0_I8_xbn VSS) gpdk090_nmos1v w=0.12u l=0.1u ad=0.0696p as=0.0696p pd=1.16u ps=1.16u
    I_MXI0_I8_MN14 (VSS XI0_I8_xbn XI0_I8_xn1 VSS) gpdk090_nmos1v w=0.24u l=0.1u ad=0.0528p as=0.0816p pd=0.68u ps=1.16u
    I_MXI0_I8_MN16 (XI0_I8_xn2 B_1 VSS VSS) gpdk090_nmos1v w=0.24u l=0.1u ad=0.0528p as=0.0528p pd=0.68u ps=0.68u
    I_MXI0_I8_MN15 (I0_pp0_7 XI0_I8_xan XI0_I8_xn2 VSS) gpdk090_nmos1v w=0.24u l=0.1u ad=0.0528p as=0.0528p pd=0.68u ps=0.68u
    I_MXI0_I8_MN13 (XI0_I8_xn1 XI0_I8_xn I0_pp0_7 VSS) gpdk090_nmos1v w=0.24u l=0.1u ad=0.0816p as=0.0528p pd=1.16u ps=0.68u
    I_MXI0_I8_MN2 (VSS A_7 XI0_I8_n1 VSS) gpdk090_nmos1v w=0.24u l=0.1u ad=0.0528p as=0.0816p pd=0.68u ps=1.16u
    I_MXI0_I8_MN4 (XI0_I8_n2 A_6 VSS VSS) gpdk090_nmos1v w=0.24u l=0.1u ad=0.0528p as=0.0528p pd=0.68u ps=0.68u
    I_MXI0_I8_MN3 (XI0_I8_xn I0_two0 XI0_I8_n2 VSS) gpdk090_nmos1v w=0.24u l=0.1u ad=0.0528p as=0.0528p pd=0.68u ps=0.68u
    I_MXI0_I8_MN1 (XI0_I8_n1 I0_one0 XI0_I8_xn VSS) gpdk090_nmos1v w=0.24u l=0.1u ad=0.0816p as=0.0528p pd=1.16u ps=0.68u
    I_MXI0_I8_MN9 (VSS XI0_I8_xn XI0_I8_xan VSS) gpdk090_nmos1v w=0.12u l=0.1u ad=0.0696p as=0.0696p pd=1.16u ps=1.16u
    I_MXI0_I12_MN11 (VSS B_3 XI0_I12_xbn VSS) gpdk090_nmos1v w=0.12u l=0.1u ad=0.0696p as=0.0696p pd=1.16u ps=1.16u
    I_MXI0_I12_MN14 (VSS XI0_I12_xbn XI0_I12_xn1 VSS) gpdk090_nmos1v w=0.24u l=0.1u ad=0.0528p as=0.0816p pd=0.68u ps=1.16u
    I_MXI0_I12_MN16 (XI0_I12_xn2 B_3 VSS VSS) gpdk090_nmos1v w=0.24u l=0.1u ad=0.0528p as=0.0528p pd=0.68u ps=0.68u
    I_MXI0_I12_MN15 (I0_pp1_0 XI0_I12_xan XI0_I12_xn2 VSS) gpdk090_nmos1v w=0.24u l=0.1u ad=0.0528p as=0.0528p pd=0.68u ps=0.68u
    I_MXI0_I12_MN13 (XI0_I12_xn1 XI0_I12_xn I0_pp1_0 VSS) gpdk090_nmos1v w=0.24u l=0.1u ad=0.0816p as=0.0528p pd=1.16u ps=0.68u
    I_MXI0_I12_MN2 (VSS A_0 XI0_I12_n1 VSS) gpdk090_nmos1v w=0.24u l=0.1u ad=0.0528p as=0.0816p pd=0.68u ps=1.16u
    I_MXI0_I12_MN4 (XI0_I12_n2 VSS VSS VSS) gpdk090_nmos1v w=0.24u l=0.1u ad=0.0528p as=0.0528p pd=0.68u ps=0.68u
    I_MXI0_I12_MN3 (XI0_I12_xn I0_two1 XI0_I12_n2 VSS) gpdk090_nmos1v w=0.24u l=0.1u ad=0.0528p as=0.0528p pd=0.68u ps=0.68u
    I_MXI0_I12_MN1 (XI0_I12_n1 I0_one1 XI0_I12_xn VSS) gpdk090_nmos1v w=0.24u l=0.1u ad=0.0816p as=0.0528p pd=1.16u ps=0.68u
    I_MXI0_I12_MN9 (VSS XI0_I12_xn XI0_I12_xan VSS) gpdk090_nmos1v w=0.12u l=0.1u ad=0.0696p as=0.0696p pd=1.16u ps=1.16u
    I_MXI0_I13_MN11 (VSS B_3 XI0_I13_xbn VSS) gpdk090_nmos1v w=0.12u l=0.1u ad=0.0696p as=0.0696p pd=1.16u ps=1.16u
    I_MXI0_I13_MN14 (VSS XI0_I13_xbn XI0_I13_xn1 VSS) gpdk090_nmos1v w=0.24u l=0.1u ad=0.0528p as=0.0816p pd=0.68u ps=1.16u
    I_MXI0_I13_MN16 (XI0_I13_xn2 B_3 VSS VSS) gpdk090_nmos1v w=0.24u l=0.1u ad=0.0528p as=0.0528p pd=0.68u ps=0.68u
    I_MXI0_I13_MN15 (I0_pp1_1 XI0_I13_xan XI0_I13_xn2 VSS) gpdk090_nmos1v w=0.24u l=0.1u ad=0.0528p as=0.0528p pd=0.68u ps=0.68u
    I_MXI0_I13_MN13 (XI0_I13_xn1 XI0_I13_xn I0_pp1_1 VSS) gpdk090_nmos1v w=0.24u l=0.1u ad=0.0816p as=0.0528p pd=1.16u ps=0.68u
    I_MXI0_I13_MN2 (VSS A_1 XI0_I13_n1 VSS) gpdk090_nmos1v w=0.24u l=0.1u ad=0.0528p as=0.0816p pd=0.68u ps=1.16u
    I_MXI0_I13_MN4 (XI0_I13_n2 A_0 VSS VSS) gpdk090_nmos1v w=0.24u l=0.1u ad=0.0528p as=0.0528p pd=0.68u ps=0.68u
    I_MXI0_I13_MN3 (XI0_I13_xn I0_two1 XI0_I13_n2 VSS) gpdk090_nmos1v w=0.24u l=0.1u ad=0.0528p as=0.0528p pd=0.68u ps=0.68u
    I_MXI0_I13_MN1 (XI0_I13_n1 I0_one1 XI0_I13_xn VSS) gpdk090_nmos1v w=0.24u l=0.1u ad=0.0816p as=0.0528p pd=1.16u ps=0.68u
    I_MXI0_I13_MN9 (VSS XI0_I13_xn XI0_I13_xan VSS) gpdk090_nmos1v w=0.12u l=0.1u ad=0.0696p as=0.0696p pd=1.16u ps=1.16u
    I_MXI0_I5_MN11 (VSS B_1 XI0_I5_xbn VSS) gpdk090_nmos1v w=0.12u l=0.1u ad=0.0696p as=0.0696p pd=1.16u ps=1.16u
    I_MXI0_I5_MN14 (VSS XI0_I5_xbn XI0_I5_xn1 VSS) gpdk090_nmos1v w=0.24u l=0.1u ad=0.0528p as=0.0816p pd=0.68u ps=1.16u
    I_MXI0_I5_MN16 (XI0_I5_xn2 B_1 VSS VSS) gpdk090_nmos1v w=0.24u l=0.1u ad=0.0528p as=0.0528p pd=0.68u ps=0.68u
    I_MXI0_I5_MN15 (I0_pp0_4 XI0_I5_xan XI0_I5_xn2 VSS) gpdk090_nmos1v w=0.24u l=0.1u ad=0.0528p as=0.0528p pd=0.68u ps=0.68u
    I_MXI0_I5_MN13 (XI0_I5_xn1 XI0_I5_xn I0_pp0_4 VSS) gpdk090_nmos1v w=0.24u l=0.1u ad=0.0816p as=0.0528p pd=1.16u ps=0.68u
    I_MXI0_I5_MN2 (VSS A_4 XI0_I5_n1 VSS) gpdk090_nmos1v w=0.24u l=0.1u ad=0.0528p as=0.0816p pd=0.68u ps=1.16u
    I_MXI0_I5_MN4 (XI0_I5_n2 A_3 VSS VSS) gpdk090_nmos1v w=0.24u l=0.1u ad=0.0528p as=0.0528p pd=0.68u ps=0.68u
    I_MXI0_I5_MN3 (XI0_I5_xn I0_two0 XI0_I5_n2 VSS) gpdk090_nmos1v w=0.24u l=0.1u ad=0.0528p as=0.0528p pd=0.68u ps=0.68u
    I_MXI0_I5_MN1 (XI0_I5_n1 I0_one0 XI0_I5_xn VSS) gpdk090_nmos1v w=0.24u l=0.1u ad=0.0816p as=0.0528p pd=1.16u ps=0.68u
    I_MXI0_I5_MN9 (VSS XI0_I5_xn XI0_I5_xan VSS) gpdk090_nmos1v w=0.12u l=0.1u ad=0.0696p as=0.0696p pd=1.16u ps=1.16u
    I_MXI0_I9_MN11 (VSS B_1 XI0_I9_xbn VSS) gpdk090_nmos1v w=0.12u l=0.1u ad=0.0696p as=0.0696p pd=1.16u ps=1.16u
    I_MXI0_I9_MN14 (VSS XI0_I9_xbn XI0_I9_xn1 VSS) gpdk090_nmos1v w=0.24u l=0.1u ad=0.0528p as=0.0816p pd=0.68u ps=1.16u
    I_MXI0_I9_MN16 (XI0_I9_xn2 B_1 VSS VSS) gpdk090_nmos1v w=0.24u l=0.1u ad=0.0528p as=0.0528p pd=0.68u ps=0.68u
    I_MXI0_I9_MN15 (I0_pp0_8 XI0_I9_xan XI0_I9_xn2 VSS) gpdk090_nmos1v w=0.24u l=0.1u ad=0.0528p as=0.0528p pd=0.68u ps=0.68u
    I_MXI0_I9_MN13 (XI0_I9_xn1 XI0_I9_xn I0_pp0_8 VSS) gpdk090_nmos1v w=0.24u l=0.1u ad=0.0816p as=0.0528p pd=1.16u ps=0.68u
    I_MXI0_I9_MN2 (VSS A_7 XI0_I9_n1 VSS) gpdk090_nmos1v w=0.24u l=0.1u ad=0.0528p as=0.0816p pd=0.68u ps=1.16u
    I_MXI0_I9_MN4 (XI0_I9_n2 A_7 VSS VSS) gpdk090_nmos1v w=0.24u l=0.1u ad=0.0528p as=0.0528p pd=0.68u ps=0.68u
    I_MXI0_I9_MN3 (XI0_I9_xn I0_two0 XI0_I9_n2 VSS) gpdk090_nmos1v w=0.24u l=0.1u ad=0.0528p as=0.0528p pd=0.68u ps=0.68u
    I_MXI0_I9_MN1 (XI0_I9_n1 I0_one0 XI0_I9_xn VSS) gpdk090_nmos1v w=0.24u l=0.1u ad=0.0816p as=0.0528p pd=1.16u ps=0.68u
    I_MXI0_I9_MN9 (VSS XI0_I9_xn XI0_I9_xan VSS) gpdk090_nmos1v w=0.12u l=0.1u ad=0.0696p as=0.0696p pd=1.16u ps=1.16u
    I_MXI0_I7_MN11 (VSS B_1 XI0_I7_xbn VSS) gpdk090_nmos1v w=0.12u l=0.1u ad=0.0696p as=0.0696p pd=1.16u ps=1.16u
    I_MXI0_I7_MN14 (VSS XI0_I7_xbn XI0_I7_xn1 VSS) gpdk090_nmos1v w=0.24u l=0.1u ad=0.0528p as=0.0816p pd=0.68u ps=1.16u
    I_MXI0_I7_MN16 (XI0_I7_xn2 B_1 VSS VSS) gpdk090_nmos1v w=0.24u l=0.1u ad=0.0528p as=0.0528p pd=0.68u ps=0.68u
    I_MXI0_I7_MN15 (I0_pp0_6 XI0_I7_xan XI0_I7_xn2 VSS) gpdk090_nmos1v w=0.24u l=0.1u ad=0.0528p as=0.0528p pd=0.68u ps=0.68u
    I_MXI0_I7_MN13 (XI0_I7_xn1 XI0_I7_xn I0_pp0_6 VSS) gpdk090_nmos1v w=0.24u l=0.1u ad=0.0816p as=0.0528p pd=1.16u ps=0.68u
    I_MXI0_I7_MN2 (VSS A_6 XI0_I7_n1 VSS) gpdk090_nmos1v w=0.24u l=0.1u ad=0.0528p as=0.0816p pd=0.68u ps=1.16u
    I_MXI0_I7_MN4 (XI0_I7_n2 A_5 VSS VSS) gpdk090_nmos1v w=0.24u l=0.1u ad=0.0528p as=0.0528p pd=0.68u ps=0.68u
    I_MXI0_I7_MN3 (XI0_I7_xn I0_two0 XI0_I7_n2 VSS) gpdk090_nmos1v w=0.24u l=0.1u ad=0.0528p as=0.0528p pd=0.68u ps=0.68u
    I_MXI0_I7_MN1 (XI0_I7_n1 I0_one0 XI0_I7_xn VSS) gpdk090_nmos1v w=0.24u l=0.1u ad=0.0816p as=0.0528p pd=1.16u ps=0.68u
    I_MXI0_I7_MN9 (VSS XI0_I7_xn XI0_I7_xan VSS) gpdk090_nmos1v w=0.12u l=0.1u ad=0.0696p as=0.0696p pd=1.16u ps=1.16u
    I_MXI0_I4_MN11 (VSS B_1 XI0_I4_xbn VSS) gpdk090_nmos1v w=0.12u l=0.1u ad=0.0696p as=0.0696p pd=1.16u ps=1.16u
    I_MXI0_I4_MN14 (VSS XI0_I4_xbn XI0_I4_xn1 VSS) gpdk090_nmos1v w=0.24u l=0.1u ad=0.0528p as=0.0816p pd=0.68u ps=1.16u
    I_MXI0_I4_MN16 (XI0_I4_xn2 B_1 VSS VSS) gpdk090_nmos1v w=0.24u l=0.1u ad=0.0528p as=0.0528p pd=0.68u ps=0.68u
    I_MXI0_I4_MN15 (I0_pp0_3 XI0_I4_xan XI0_I4_xn2 VSS) gpdk090_nmos1v w=0.24u l=0.1u ad=0.0528p as=0.0528p pd=0.68u ps=0.68u
    I_MXI0_I4_MN13 (XI0_I4_xn1 XI0_I4_xn I0_pp0_3 VSS) gpdk090_nmos1v w=0.24u l=0.1u ad=0.0816p as=0.0528p pd=1.16u ps=0.68u
    I_MXI0_I4_MN2 (VSS A_3 XI0_I4_n1 VSS) gpdk090_nmos1v w=0.24u l=0.1u ad=0.0528p as=0.0816p pd=0.68u ps=1.16u
    I_MXI0_I4_MN4 (XI0_I4_n2 A_2 VSS VSS) gpdk090_nmos1v w=0.24u l=0.1u ad=0.0528p as=0.0528p pd=0.68u ps=0.68u
    I_MXI0_I4_MN3 (XI0_I4_xn I0_two0 XI0_I4_n2 VSS) gpdk090_nmos1v w=0.24u l=0.1u ad=0.0528p as=0.0528p pd=0.68u ps=0.68u
    I_MXI0_I4_MN1 (XI0_I4_n1 I0_one0 XI0_I4_xn VSS) gpdk090_nmos1v w=0.24u l=0.1u ad=0.0816p as=0.0528p pd=1.16u ps=0.68u
    I_MXI0_I4_MN9 (VSS XI0_I4_xn XI0_I4_xan VSS) gpdk090_nmos1v w=0.12u l=0.1u ad=0.0696p as=0.0696p pd=1.16u ps=1.16u
    I_MXI0_I2_MN11 (VSS B_1 XI0_I2_xbn VSS) gpdk090_nmos1v w=0.12u l=0.1u ad=0.0696p as=0.0696p pd=1.16u ps=1.16u
    I_MXI0_I2_MN14 (VSS XI0_I2_xbn XI0_I2_xn1 VSS) gpdk090_nmos1v w=0.24u l=0.1u ad=0.0528p as=0.0816p pd=0.68u ps=1.16u
    I_MXI0_I2_MN16 (XI0_I2_xn2 B_1 VSS VSS) gpdk090_nmos1v w=0.24u l=0.1u ad=0.0528p as=0.0528p pd=0.68u ps=0.68u
    I_MXI0_I2_MN15 (I0_pp0_1 XI0_I2_xan XI0_I2_xn2 VSS) gpdk090_nmos1v w=0.24u l=0.1u ad=0.0528p as=0.0528p pd=0.68u ps=0.68u
    I_MXI0_I2_MN13 (XI0_I2_xn1 XI0_I2_xn I0_pp0_1 VSS) gpdk090_nmos1v w=0.24u l=0.1u ad=0.0816p as=0.0528p pd=1.16u ps=0.68u
    I_MXI0_I2_MN2 (VSS A_1 XI0_I2_n1 VSS) gpdk090_nmos1v w=0.24u l=0.1u ad=0.0528p as=0.0816p pd=0.68u ps=1.16u
    I_MXI0_I2_MN4 (XI0_I2_n2 A_0 VSS VSS) gpdk090_nmos1v w=0.24u l=0.1u ad=0.0528p as=0.0528p pd=0.68u ps=0.68u
    I_MXI0_I2_MN3 (XI0_I2_xn I0_two0 XI0_I2_n2 VSS) gpdk090_nmos1v w=0.24u l=0.1u ad=0.0528p as=0.0528p pd=0.68u ps=0.68u
    I_MXI0_I2_MN1 (XI0_I2_n1 I0_one0 XI0_I2_xn VSS) gpdk090_nmos1v w=0.24u l=0.1u ad=0.0816p as=0.0528p pd=1.16u ps=0.68u
    I_MXI0_I2_MN9 (VSS XI0_I2_xn XI0_I2_xan VSS) gpdk090_nmos1v w=0.12u l=0.1u ad=0.0696p as=0.0696p pd=1.16u ps=1.16u
    I_MXI0_I1_MN11 (VSS B_1 XI0_I1_xbn VSS) gpdk090_nmos1v w=0.12u l=0.1u ad=0.0696p as=0.0696p pd=1.16u ps=1.16u
    I_MXI0_I1_MN14 (VSS XI0_I1_xbn XI0_I1_xn1 VSS) gpdk090_nmos1v w=0.24u l=0.1u ad=0.0528p as=0.0816p pd=0.68u ps=1.16u
    I_MXI0_I1_MN16 (XI0_I1_xn2 B_1 VSS VSS) gpdk090_nmos1v w=0.24u l=0.1u ad=0.0528p as=0.0528p pd=0.68u ps=0.68u
    I_MXI0_I1_MN15 (I0_pp0_0 XI0_I1_xan XI0_I1_xn2 VSS) gpdk090_nmos1v w=0.24u l=0.1u ad=0.0528p as=0.0528p pd=0.68u ps=0.68u
    I_MXI0_I1_MN13 (XI0_I1_xn1 XI0_I1_xn I0_pp0_0 VSS) gpdk090_nmos1v w=0.24u l=0.1u ad=0.0816p as=0.0528p pd=1.16u ps=0.68u
    I_MXI0_I1_MN2 (VSS A_0 XI0_I1_n1 VSS) gpdk090_nmos1v w=0.24u l=0.1u ad=0.0528p as=0.0816p pd=0.68u ps=1.16u
    I_MXI0_I1_MN4 (XI0_I1_n2 VSS VSS VSS) gpdk090_nmos1v w=0.24u l=0.1u ad=0.0528p as=0.0528p pd=0.68u ps=0.68u
    I_MXI0_I1_MN3 (XI0_I1_xn I0_two0 XI0_I1_n2 VSS) gpdk090_nmos1v w=0.24u l=0.1u ad=0.0528p as=0.0528p pd=0.68u ps=0.68u
    I_MXI0_I1_MN1 (XI0_I1_n1 I0_one0 XI0_I1_xn VSS) gpdk090_nmos1v w=0.24u l=0.1u ad=0.0816p as=0.0528p pd=1.16u ps=0.68u
    I_MXI0_I1_MN9 (VSS XI0_I1_xn XI0_I1_xan VSS) gpdk090_nmos1v w=0.12u l=0.1u ad=0.0696p as=0.0696p pd=1.16u ps=1.16u
    I_MXI0_I3_MN11 (VSS B_1 XI0_I3_xbn VSS) gpdk090_nmos1v w=0.12u l=0.1u ad=0.0696p as=0.0696p pd=1.16u ps=1.16u
    I_MXI0_I3_MN14 (VSS XI0_I3_xbn XI0_I3_xn1 VSS) gpdk090_nmos1v w=0.24u l=0.1u ad=0.0528p as=0.0816p pd=0.68u ps=1.16u
    I_MXI0_I3_MN16 (XI0_I3_xn2 B_1 VSS VSS) gpdk090_nmos1v w=0.24u l=0.1u ad=0.0528p as=0.0528p pd=0.68u ps=0.68u
    I_MXI0_I3_MN15 (I0_pp0_2 XI0_I3_xan XI0_I3_xn2 VSS) gpdk090_nmos1v w=0.24u l=0.1u ad=0.0528p as=0.0528p pd=0.68u ps=0.68u
    I_MXI0_I3_MN13 (XI0_I3_xn1 XI0_I3_xn I0_pp0_2 VSS) gpdk090_nmos1v w=0.24u l=0.1u ad=0.0816p as=0.0528p pd=1.16u ps=0.68u
    I_MXI0_I3_MN2 (VSS A_2 XI0_I3_n1 VSS) gpdk090_nmos1v w=0.24u l=0.1u ad=0.0528p as=0.0816p pd=0.68u ps=1.16u
    I_MXI0_I3_MN4 (XI0_I3_n2 A_1 VSS VSS) gpdk090_nmos1v w=0.24u l=0.1u ad=0.0528p as=0.0528p pd=0.68u ps=0.68u
    I_MXI0_I3_MN3 (XI0_I3_xn I0_two0 XI0_I3_n2 VSS) gpdk090_nmos1v w=0.24u l=0.1u ad=0.0528p as=0.0528p pd=0.68u ps=0.68u
    I_MXI0_I3_MN1 (XI0_I3_n1 I0_one0 XI0_I3_xn VSS) gpdk090_nmos1v w=0.24u l=0.1u ad=0.0816p as=0.0528p pd=1.16u ps=0.68u
    I_MXI0_I3_MN9 (VSS XI0_I3_xn XI0_I3_xan VSS) gpdk090_nmos1v w=0.12u l=0.1u ad=0.0696p as=0.0696p pd=1.16u ps=1.16u
    I_MXI2_I3_I115_MN1 (XI2_I3_I115_n1 DIVR_6 VSS VSS) gpdk090_nmos1v w=0.24u l=0.1u ad=0.0528p as=0.0816p pd=0.68u ps=1.16u
    I_MXI2_I3_I115_MN0 (I2_I3_hd14 I2_SEL_DIV XI2_I3_I115_n1 VSS) gpdk090_nmos1v w=0.24u l=0.1u ad=0.0816p as=0.0528p pd=1.16u ps=0.68u
    I_MXI2_I3_I116_MN1 (XI2_I3_I116_n1 I2_I3_hd14 VSS VSS) gpdk090_nmos1v w=0.24u l=0.1u ad=0.0528p as=0.0816p pd=0.68u ps=1.16u
    I_MXI2_I3_I116_MN0 (Y_14 I2_I3_hm14 XI2_I3_I116_n1 VSS) gpdk090_nmos1v w=0.24u l=0.1u ad=0.0816p as=0.0528p pd=1.16u ps=0.68u
    I_MXI2_I3_I119_MN1 (XI2_I3_I119_n1 I2_I3_hd15 VSS VSS) gpdk090_nmos1v w=0.24u l=0.1u ad=0.0528p as=0.0816p pd=0.68u ps=1.16u
    I_MXI2_I3_I119_MN0 (Y_15 I2_I3_hm15 XI2_I3_I119_n1 VSS) gpdk090_nmos1v w=0.24u l=0.1u ad=0.0816p as=0.0528p pd=1.16u ps=0.68u
    I_MXI2_I3_I117_MN1 (XI2_I3_I117_n1 MULP_15 VSS VSS) gpdk090_nmos1v w=0.24u l=0.1u ad=0.0528p as=0.0816p pd=0.68u ps=1.16u
    I_MXI2_I3_I117_MN0 (I2_I3_hm15 I2_SEL_MUL XI2_I3_I117_n1 VSS) gpdk090_nmos1v w=0.24u l=0.1u ad=0.0816p as=0.0528p pd=1.16u ps=0.68u
    I_MXI2_I3_I114_MN1 (XI2_I3_I114_n1 MULP_14 VSS VSS) gpdk090_nmos1v w=0.24u l=0.1u ad=0.0528p as=0.0816p pd=0.68u ps=1.16u
    I_MXI2_I3_I114_MN0 (I2_I3_hm14 I2_SEL_MUL XI2_I3_I114_n1 VSS) gpdk090_nmos1v w=0.24u l=0.1u ad=0.0816p as=0.0528p pd=1.16u ps=0.68u
    I_MXI0_I77_I29_XP_MN1 (XI0_I77_I29_XP_n1 I0_I77_P3_2 VSS VSS) gpdk090_nmos1v w=0.24u l=0.1u ad=0.0528p as=0.0816p pd=0.68u ps=1.16u
    I_MXI0_I77_I29_XP_MN0 (I0_I77_P5_2n I0_I77_P5_4 XI0_I77_I29_XP_n1 VSS) gpdk090_nmos1v w=0.24u l=0.1u ad=0.0816p as=0.0528p pd=1.16u ps=0.68u
    I_MXI0_I77_I31_XP_MN1 (XI0_I77_I31_XP_n1 I0_I77_P5_4 VSS VSS) gpdk090_nmos1v w=0.24u l=0.1u ad=0.0528p as=0.0816p pd=0.68u ps=1.16u
    I_MXI0_I77_I31_XP_MN0 (I0_I77_P7_4n I0_I77_P7_6 XI0_I77_I31_XP_n1 VSS) gpdk090_nmos1v w=0.24u l=0.1u ad=0.0816p as=0.0528p pd=1.16u ps=0.68u
    I_MXI0_I77_I7_MN1 (XI0_I77_I7_n1 I0_ha25_0 VSS VSS) gpdk090_nmos1v w=0.24u l=0.1u ad=0.0528p as=0.0816p pd=0.68u ps=1.16u
    I_MXI0_I77_I7_MN0 (I0_I77_gn7 I0_ha24_1 XI0_I77_I7_n1 VSS) gpdk090_nmos1v w=0.24u l=0.1u ad=0.0816p as=0.0528p pd=1.16u ps=0.68u
    I_MXI2_I0_I6_MN1 (XI2_I0_I6_n1 I2_I0_opn2 VSS VSS) gpdk090_nmos1v w=0.24u l=0.1u ad=0.0528p as=0.0816p pd=0.68u ps=1.16u
    I_MXI2_I0_I6_MN0 (I2_I0_h10 OP_3 XI2_I0_I6_n1 VSS) gpdk090_nmos1v w=0.24u l=0.1u ad=0.0816p as=0.0528p pd=1.16u ps=0.68u
    I_MXI2_I0_I5_MN1 (XI2_I0_I5_n1 OP_2 VSS VSS) gpdk090_nmos1v w=0.24u l=0.1u ad=0.0528p as=0.0816p pd=0.68u ps=1.16u
    I_MXI2_I0_I5_MN0 (I2_I0_h01 I2_I0_opn3 XI2_I0_I5_n1 VSS) gpdk090_nmos1v w=0.24u l=0.1u ad=0.0816p as=0.0528p pd=1.16u ps=0.68u
    I_MXI2_I3_I118_MN1 (XI2_I3_I118_n1 DIVR_7 VSS VSS) gpdk090_nmos1v w=0.24u l=0.1u ad=0.0528p as=0.0816p pd=0.68u ps=1.16u
    I_MXI2_I3_I118_MN0 (I2_I3_hd15 I2_SEL_DIV XI2_I3_I118_n1 VSS) gpdk090_nmos1v w=0.24u l=0.1u ad=0.0816p as=0.0528p pd=1.16u ps=0.68u
    I_MXI2_I3_I112_MN1 (XI2_I3_I112_n1 DIVR_5 VSS VSS) gpdk090_nmos1v w=0.24u l=0.1u ad=0.0528p as=0.0816p pd=0.68u ps=1.16u
    I_MXI2_I3_I112_MN0 (I2_I3_hd13 I2_SEL_DIV XI2_I3_I112_n1 VSS) gpdk090_nmos1v w=0.24u l=0.1u ad=0.0816p as=0.0528p pd=1.16u ps=0.68u
    I_MXI2_I3_I113_MN1 (XI2_I3_I113_n1 I2_I3_hd13 VSS VSS) gpdk090_nmos1v w=0.24u l=0.1u ad=0.0528p as=0.0816p pd=0.68u ps=1.16u
    I_MXI2_I3_I113_MN0 (Y_13 I2_I3_hm13 XI2_I3_I113_n1 VSS) gpdk090_nmos1v w=0.24u l=0.1u ad=0.0816p as=0.0528p pd=1.16u ps=0.68u
    I_MXI2_I3_I109_MN1 (XI2_I3_I109_n1 DIVR_4 VSS VSS) gpdk090_nmos1v w=0.24u l=0.1u ad=0.0528p as=0.0816p pd=0.68u ps=1.16u
    I_MXI2_I3_I109_MN0 (I2_I3_hd12 I2_SEL_DIV XI2_I3_I109_n1 VSS) gpdk090_nmos1v w=0.24u l=0.1u ad=0.0816p as=0.0528p pd=1.16u ps=0.68u
    I_MXI2_I3_I110_MN1 (XI2_I3_I110_n1 I2_I3_hd12 VSS VSS) gpdk090_nmos1v w=0.24u l=0.1u ad=0.0528p as=0.0816p pd=0.68u ps=1.16u
    I_MXI2_I3_I110_MN0 (Y_12 I2_I3_hm12 XI2_I3_I110_n1 VSS) gpdk090_nmos1v w=0.24u l=0.1u ad=0.0816p as=0.0528p pd=1.16u ps=0.68u
    I_MXI2_I4_I11_MN1 (XI2_I4_I11_n1 I2_I4_za7 VSS VSS) gpdk090_nmos1v w=0.24u l=0.1u ad=0.0528p as=0.0816p pd=0.68u ps=1.16u
    I_MXI2_I4_I11_MN0 (I2_I4_zb3 I2_I4_za6 XI2_I4_I11_n1 VSS) gpdk090_nmos1v w=0.24u l=0.1u ad=0.0816p as=0.0528p pd=1.16u ps=0.68u
    I_MXI2_I4_I10_MN1 (XI2_I4_I10_n1 I2_I4_za5 VSS VSS) gpdk090_nmos1v w=0.24u l=0.1u ad=0.0528p as=0.0816p pd=0.68u ps=1.16u
    I_MXI2_I4_I10_MN0 (I2_I4_zb2 I2_I4_za4 XI2_I4_I10_n1 VSS) gpdk090_nmos1v w=0.24u l=0.1u ad=0.0816p as=0.0528p pd=1.16u ps=0.68u
    I_MXI2_I4_I14_MN1 (XI2_I4_I14_n1 I2_I4_zc1 VSS VSS) gpdk090_nmos1v w=0.24u l=0.1u ad=0.0528p as=0.0816p pd=0.68u ps=1.16u
    I_MXI2_I4_I14_MN0 (I2_I4_zd I2_I4_zc0 XI2_I4_I14_n1 VSS) gpdk090_nmos1v w=0.24u l=0.1u ad=0.0816p as=0.0528p pd=1.16u ps=0.68u
    I_MXI2_I3_I111_MN1 (XI2_I3_I111_n1 MULP_13 VSS VSS) gpdk090_nmos1v w=0.24u l=0.1u ad=0.0528p as=0.0816p pd=0.68u ps=1.16u
    I_MXI2_I3_I111_MN0 (I2_I3_hm13 I2_SEL_MUL XI2_I3_I111_n1 VSS) gpdk090_nmos1v w=0.24u l=0.1u ad=0.0816p as=0.0528p pd=1.16u ps=0.68u
    I_MXI2_I3_I108_MN1 (XI2_I3_I108_n1 MULP_12 VSS VSS) gpdk090_nmos1v w=0.24u l=0.1u ad=0.0528p as=0.0816p pd=0.68u ps=1.16u
    I_MXI2_I3_I108_MN0 (I2_I3_hm12 I2_SEL_MUL XI2_I3_I108_n1 VSS) gpdk090_nmos1v w=0.24u l=0.1u ad=0.0816p as=0.0528p pd=1.16u ps=0.68u
    I_MXI0_I77_I30_XP_MN1 (XI0_I77_I30_XP_n1 I0_I77_P4_3 VSS VSS) gpdk090_nmos1v w=0.24u l=0.1u ad=0.0528p as=0.0816p pd=0.68u ps=1.16u
    I_MXI0_I77_I30_XP_MN0 (I0_I77_P6_3n I0_I77_P6_5 XI0_I77_I30_XP_n1 VSS) gpdk090_nmos1v w=0.24u l=0.1u ad=0.0816p as=0.0528p pd=1.16u ps=0.68u
    I_MXI0_I77_I4_MN1 (XI0_I77_I4_n1 I0_ha22_0 VSS VSS) gpdk090_nmos1v w=0.24u l=0.1u ad=0.0528p as=0.0816p pd=0.68u ps=1.16u
    I_MXI0_I77_I4_MN0 (I0_I77_gn4 I0_ha21_1 XI0_I77_I4_n1 VSS) gpdk090_nmos1v w=0.24u l=0.1u ad=0.0816p as=0.0528p pd=1.16u ps=0.68u
    I_MXI0_I77_I5_MN1 (XI0_I77_I5_n1 I0_ha23_0 VSS VSS) gpdk090_nmos1v w=0.24u l=0.1u ad=0.0528p as=0.0816p pd=0.68u ps=1.16u
    I_MXI0_I77_I5_MN0 (I0_I77_gn5 I0_ha22_1 XI0_I77_I5_n1 VSS) gpdk090_nmos1v w=0.24u l=0.1u ad=0.0816p as=0.0528p pd=1.16u ps=0.68u
    I_MXI0_I77_I6_MN1 (XI0_I77_I6_n1 I0_ha24_0 VSS VSS) gpdk090_nmos1v w=0.24u l=0.1u ad=0.0528p as=0.0816p pd=0.68u ps=1.16u
    I_MXI0_I77_I6_MN0 (I0_I77_gn6 I0_ha23_1 XI0_I77_I6_n1 VSS) gpdk090_nmos1v w=0.24u l=0.1u ad=0.0816p as=0.0528p pd=1.16u ps=0.68u
    I_MXI2_I3_I91_MN1 (XI2_I3_I91_n1 I2_I3_n7_3 VSS VSS) gpdk090_nmos1v w=0.24u l=0.1u ad=0.0528p as=0.0816p pd=0.68u ps=1.16u
    I_MXI2_I3_I91_MN0 (I2_I3_o7_1 I2_I3_n7_2 XI2_I3_I91_n1 VSS) gpdk090_nmos1v w=0.24u l=0.1u ad=0.0816p as=0.0528p pd=1.16u ps=0.68u
    I_MXI2_I3_I87_MN1 (XI2_I3_I87_n1 I2_NOT_7 VSS VSS) gpdk090_nmos1v w=0.24u l=0.1u ad=0.0528p as=0.0816p pd=0.68u ps=1.16u
    I_MXI2_I3_I87_MN0 (I2_I3_n7_3 I2_SEL_NOT XI2_I3_I87_n1 VSS) gpdk090_nmos1v w=0.24u l=0.1u ad=0.0816p as=0.0528p pd=1.16u ps=0.68u
    I_MXI2_I3_I86_MN1 (XI2_I3_I86_n1 I2_XOR_7 VSS VSS) gpdk090_nmos1v w=0.24u l=0.1u ad=0.0528p as=0.0816p pd=0.68u ps=1.16u
    I_MXI2_I3_I86_MN0 (I2_I3_n7_2 I2_SEL_XOR XI2_I3_I86_n1 VSS) gpdk090_nmos1v w=0.24u l=0.1u ad=0.0816p as=0.0528p pd=1.16u ps=0.68u
    I_MXI2_I0_I8_MN1 (XI2_I0_I8_n1 OP_0 VSS VSS) gpdk090_nmos1v w=0.24u l=0.1u ad=0.0528p as=0.0816p pd=0.68u ps=1.16u
    I_MXI2_I0_I8_MN0 (I2_I0_l01 I2_I0_opn1 XI2_I0_I8_n1 VSS) gpdk090_nmos1v w=0.24u l=0.1u ad=0.0816p as=0.0528p pd=1.16u ps=0.68u
    I_MXI2_I0_I4_MN1 (XI2_I0_I4_n1 I2_I0_opn2 VSS VSS) gpdk090_nmos1v w=0.24u l=0.1u ad=0.0528p as=0.0816p pd=0.68u ps=1.16u
    I_MXI2_I0_I4_MN0 (I2_I0_h00 I2_I0_opn3 XI2_I0_I4_n1 VSS) gpdk090_nmos1v w=0.24u l=0.1u ad=0.0816p as=0.0528p pd=1.16u ps=0.68u
    I_MXI2_I0_I7_MN1 (XI2_I0_I7_n1 I2_I0_opn0 VSS VSS) gpdk090_nmos1v w=0.24u l=0.1u ad=0.0528p as=0.0816p pd=0.68u ps=1.16u
    I_MXI2_I0_I7_MN0 (I2_I0_l00 I2_I0_opn1 XI2_I0_I7_n1 VSS) gpdk090_nmos1v w=0.24u l=0.1u ad=0.0816p as=0.0528p pd=1.16u ps=0.68u
    I_MXI1_I152_I29_XP_MN1 (XI1_I152_I29_XP_n1 I1_I152_P3_2 VSS VSS) gpdk090_nmos1v w=0.24u l=0.1u ad=0.0528p as=0.0816p pd=0.68u ps=1.16u
    I_MXI1_I152_I29_XP_MN0 (I1_I152_P5_2n I1_I152_P5_4 XI1_I152_I29_XP_n1 VSS) gpdk090_nmos1v w=0.24u l=0.1u ad=0.0816p as=0.0528p pd=1.16u ps=0.68u
    I_MXI2_I3_I106_MN1 (XI2_I3_I106_n1 DIVR_3 VSS VSS) gpdk090_nmos1v w=0.24u l=0.1u ad=0.0528p as=0.0816p pd=0.68u ps=1.16u
    I_MXI2_I3_I106_MN0 (I2_I3_hd11 I2_SEL_DIV XI2_I3_I106_n1 VSS) gpdk090_nmos1v w=0.24u l=0.1u ad=0.0816p as=0.0528p pd=1.16u ps=0.68u
    I_MXI2_I3_I107_MN1 (XI2_I3_I107_n1 I2_I3_hd11 VSS VSS) gpdk090_nmos1v w=0.24u l=0.1u ad=0.0528p as=0.0816p pd=0.68u ps=1.16u
    I_MXI2_I3_I107_MN0 (Y_11 I2_I3_hm11 XI2_I3_I107_n1 VSS) gpdk090_nmos1v w=0.24u l=0.1u ad=0.0816p as=0.0528p pd=1.16u ps=0.68u
    I_MXI2_I3_I103_MN1 (XI2_I3_I103_n1 DIVR_2 VSS VSS) gpdk090_nmos1v w=0.24u l=0.1u ad=0.0528p as=0.0816p pd=0.68u ps=1.16u
    I_MXI2_I3_I103_MN0 (I2_I3_hd10 I2_SEL_DIV XI2_I3_I103_n1 VSS) gpdk090_nmos1v w=0.24u l=0.1u ad=0.0816p as=0.0528p pd=1.16u ps=0.68u
    I_MXI2_I3_I104_MN1 (XI2_I3_I104_n1 I2_I3_hd10 VSS VSS) gpdk090_nmos1v w=0.24u l=0.1u ad=0.0528p as=0.0816p pd=0.68u ps=1.16u
    I_MXI2_I3_I104_MN0 (Y_10 I2_I3_hm10 XI2_I3_I104_n1 VSS) gpdk090_nmos1v w=0.24u l=0.1u ad=0.0816p as=0.0528p pd=1.16u ps=0.68u
    I_MXI2_I3_I105_MN1 (XI2_I3_I105_n1 MULP_11 VSS VSS) gpdk090_nmos1v w=0.24u l=0.1u ad=0.0528p as=0.0816p pd=0.68u ps=1.16u
    I_MXI2_I3_I105_MN0 (I2_I3_hm11 I2_SEL_MUL XI2_I3_I105_n1 VSS) gpdk090_nmos1v w=0.24u l=0.1u ad=0.0816p as=0.0528p pd=1.16u ps=0.68u
    I_MXI2_I3_I102_MN1 (XI2_I3_I102_n1 MULP_10 VSS VSS) gpdk090_nmos1v w=0.24u l=0.1u ad=0.0528p as=0.0816p pd=0.68u ps=1.16u
    I_MXI2_I3_I102_MN0 (I2_I3_hm10 I2_SEL_MUL XI2_I3_I102_n1 VSS) gpdk090_nmos1v w=0.24u l=0.1u ad=0.0816p as=0.0528p pd=1.16u ps=0.68u
    I_MXI0_I77_I28_XP_MN1 (XI0_I77_I28_XP_n1 I0_I77_P2_1 VSS VSS) gpdk090_nmos1v w=0.24u l=0.1u ad=0.0528p as=0.0816p pd=0.68u ps=1.16u
    I_MXI0_I77_I28_XP_MN0 (I0_I77_P4_1n I0_I77_P4_3 XI0_I77_I28_XP_n1 VSS) gpdk090_nmos1v w=0.24u l=0.1u ad=0.0816p as=0.0528p pd=1.16u ps=0.68u
    I_MXI0_I77_I3_MN1 (XI0_I77_I3_n1 I0_ha21_0 VSS VSS) gpdk090_nmos1v w=0.24u l=0.1u ad=0.0528p as=0.0816p pd=0.68u ps=1.16u
    I_MXI0_I77_I3_MN0 (I0_I77_gn3 I0_ha20_1 XI0_I77_I3_n1 VSS) gpdk090_nmos1v w=0.24u l=0.1u ad=0.0816p as=0.0528p pd=1.16u ps=0.68u
    I_MXI2_I3_I85_MN1 (XI2_I3_I85_n1 I2_OR_7 VSS VSS) gpdk090_nmos1v w=0.24u l=0.1u ad=0.0528p as=0.0816p pd=0.68u ps=1.16u
    I_MXI2_I3_I85_MN0 (I2_I3_n7_1 I2_SEL_OR XI2_I3_I85_n1 VSS) gpdk090_nmos1v w=0.24u l=0.1u ad=0.0816p as=0.0528p pd=1.16u ps=0.68u
    I_MXI2_I3_I90_MN1 (XI2_I3_I90_n1 I2_I3_n7_1 VSS VSS) gpdk090_nmos1v w=0.24u l=0.1u ad=0.0528p as=0.0816p pd=0.68u ps=1.16u
    I_MXI2_I3_I90_MN0 (I2_I3_o7_0 I2_I3_n7_0 XI2_I3_I90_n1 VSS) gpdk090_nmos1v w=0.24u l=0.1u ad=0.0816p as=0.0528p pd=1.16u ps=0.68u
    I_MXI2_I3_I84_MN1 (XI2_I3_I84_n1 I2_AND_7 VSS VSS) gpdk090_nmos1v w=0.24u l=0.1u ad=0.0528p as=0.0816p pd=0.68u ps=1.16u
    I_MXI2_I3_I84_MN0 (I2_I3_n7_0 I2_SEL_AND XI2_I3_I84_n1 VSS) gpdk090_nmos1v w=0.24u l=0.1u ad=0.0816p as=0.0528p pd=1.16u ps=0.68u
    I_MXI2_I2_I42_MN1 (XI2_I2_I42_n1 B_7 VSS VSS) gpdk090_nmos1v w=0.24u l=0.1u ad=0.0528p as=0.0816p pd=0.68u ps=1.16u
    I_MXI2_I2_I42_MN0 (I2_I2_nand7 A_7 XI2_I2_I42_n1 VSS) gpdk090_nmos1v w=0.24u l=0.1u ad=0.0816p as=0.0528p pd=1.16u ps=0.68u
    I_MXI2_I0_I10_MN1 (XI2_I0_I10_n1 OP_0 VSS VSS) gpdk090_nmos1v w=0.24u l=0.1u ad=0.0528p as=0.0816p pd=0.68u ps=1.16u
    I_MXI2_I0_I10_MN0 (I2_I0_l11 OP_1 XI2_I0_I10_n1 VSS) gpdk090_nmos1v w=0.24u l=0.1u ad=0.0816p as=0.0528p pd=1.16u ps=0.68u
    I_MXI2_I0_I9_MN1 (XI2_I0_I9_n1 I2_I0_opn0 VSS VSS) gpdk090_nmos1v w=0.24u l=0.1u ad=0.0528p as=0.0816p pd=0.68u ps=1.16u
    I_MXI2_I0_I9_MN0 (I2_I0_l10 OP_1 XI2_I0_I9_n1 VSS) gpdk090_nmos1v w=0.24u l=0.1u ad=0.0816p as=0.0528p pd=1.16u ps=0.68u
    I_MXI2_I3_I66_MN1 (XI2_I3_I66_n1 I2_I3_n5_1 VSS VSS) gpdk090_nmos1v w=0.24u l=0.1u ad=0.0528p as=0.0816p pd=0.68u ps=1.16u
    I_MXI2_I3_I66_MN0 (I2_I3_o5_0 I2_I3_n5_0 XI2_I3_I66_n1 VSS) gpdk090_nmos1v w=0.24u l=0.1u ad=0.0816p as=0.0528p pd=1.16u ps=0.68u
    I_MXI2_I3_I60_MN1 (XI2_I3_I60_n1 I2_AND_5 VSS VSS) gpdk090_nmos1v w=0.24u l=0.1u ad=0.0528p as=0.0816p pd=0.68u ps=1.16u
    I_MXI2_I3_I60_MN0 (I2_I3_n5_0 I2_SEL_AND XI2_I3_I60_n1 VSS) gpdk090_nmos1v w=0.24u l=0.1u ad=0.0816p as=0.0528p pd=1.16u ps=0.68u
    I_MXI2_I2_I30_MN1 (XI2_I2_I30_n1 B_5 VSS VSS) gpdk090_nmos1v w=0.24u l=0.1u ad=0.0528p as=0.0816p pd=0.68u ps=1.16u
    I_MXI2_I2_I30_MN0 (I2_I2_nand5 A_5 XI2_I2_I30_n1 VSS) gpdk090_nmos1v w=0.24u l=0.1u ad=0.0816p as=0.0528p pd=1.16u ps=0.68u
    I_MXI1_I152_I31_XP_MN1 (XI1_I152_I31_XP_n1 I1_I152_P5_4 VSS VSS) gpdk090_nmos1v w=0.24u l=0.1u ad=0.0528p as=0.0816p pd=0.68u ps=1.16u
    I_MXI1_I152_I31_XP_MN0 (I1_I152_P7_4n I1_I152_P7_6 XI1_I152_I31_XP_n1 VSS) gpdk090_nmos1v w=0.24u l=0.1u ad=0.0816p as=0.0528p pd=1.16u ps=0.68u
    I_MXI2_I3_I100_MN1 (XI2_I3_I100_n1 DIVR_1 VSS VSS) gpdk090_nmos1v w=0.24u l=0.1u ad=0.0528p as=0.0816p pd=0.68u ps=1.16u
    I_MXI2_I3_I100_MN0 (I2_I3_hd9 I2_SEL_DIV XI2_I3_I100_n1 VSS) gpdk090_nmos1v w=0.24u l=0.1u ad=0.0816p as=0.0528p pd=1.16u ps=0.68u
    I_MXI2_I3_I101_MN1 (XI2_I3_I101_n1 I2_I3_hd9 VSS VSS) gpdk090_nmos1v w=0.24u l=0.1u ad=0.0528p as=0.0816p pd=0.68u ps=1.16u
    I_MXI2_I3_I101_MN0 (Y_9 I2_I3_hm9 XI2_I3_I101_n1 VSS) gpdk090_nmos1v w=0.24u l=0.1u ad=0.0816p as=0.0528p pd=1.16u ps=0.68u
    I_MXI0_I77_I1_MN1 (XI0_I77_I1_n1 I0_ha19_0 VSS VSS) gpdk090_nmos1v w=0.24u l=0.1u ad=0.0528p as=0.0816p pd=0.68u ps=1.16u
    I_MXI0_I77_I1_MN0 (I0_I77_gn1 I0_ha18_1 XI0_I77_I1_n1 VSS) gpdk090_nmos1v w=0.24u l=0.1u ad=0.0816p as=0.0528p pd=1.16u ps=0.68u
    I_MXI0_I77_I2_MN1 (XI0_I77_I2_n1 I0_ha20_0 VSS VSS) gpdk090_nmos1v w=0.24u l=0.1u ad=0.0528p as=0.0816p pd=0.68u ps=1.16u
    I_MXI0_I77_I2_MN0 (I0_I77_gn2 I0_ha19_1 XI0_I77_I2_n1 VSS) gpdk090_nmos1v w=0.24u l=0.1u ad=0.0816p as=0.0528p pd=1.16u ps=0.68u
    I_MXI2_I3_I73_MN1 (XI2_I3_I73_n1 I2_OR_6 VSS VSS) gpdk090_nmos1v w=0.24u l=0.1u ad=0.0528p as=0.0816p pd=0.68u ps=1.16u
    I_MXI2_I3_I73_MN0 (I2_I3_n6_1 I2_SEL_OR XI2_I3_I73_n1 VSS) gpdk090_nmos1v w=0.24u l=0.1u ad=0.0816p as=0.0528p pd=1.16u ps=0.68u
    I_MXI2_I3_I78_MN1 (XI2_I3_I78_n1 I2_I3_n6_1 VSS VSS) gpdk090_nmos1v w=0.24u l=0.1u ad=0.0528p as=0.0816p pd=0.68u ps=1.16u
    I_MXI2_I3_I78_MN0 (I2_I3_o6_0 I2_I3_n6_0 XI2_I3_I78_n1 VSS) gpdk090_nmos1v w=0.24u l=0.1u ad=0.0816p as=0.0528p pd=1.16u ps=0.68u
    I_MXI2_I3_I72_MN1 (XI2_I3_I72_n1 I2_AND_6 VSS VSS) gpdk090_nmos1v w=0.24u l=0.1u ad=0.0528p as=0.0816p pd=0.68u ps=1.16u
    I_MXI2_I3_I72_MN0 (I2_I3_n6_0 I2_SEL_AND XI2_I3_I72_n1 VSS) gpdk090_nmos1v w=0.24u l=0.1u ad=0.0816p as=0.0528p pd=1.16u ps=0.68u
    I_MXI2_I3_I79_MN1 (XI2_I3_I79_n1 I2_I3_n6_3 VSS VSS) gpdk090_nmos1v w=0.24u l=0.1u ad=0.0528p as=0.0816p pd=0.68u ps=1.16u
    I_MXI2_I3_I79_MN0 (I2_I3_o6_1 I2_I3_n6_2 XI2_I3_I79_n1 VSS) gpdk090_nmos1v w=0.24u l=0.1u ad=0.0816p as=0.0528p pd=1.16u ps=0.68u
    I_MXI2_I3_I75_MN1 (XI2_I3_I75_n1 I2_NOT_6 VSS VSS) gpdk090_nmos1v w=0.24u l=0.1u ad=0.0528p as=0.0816p pd=0.68u ps=1.16u
    I_MXI2_I3_I75_MN0 (I2_I3_n6_3 I2_SEL_NOT XI2_I3_I75_n1 VSS) gpdk090_nmos1v w=0.24u l=0.1u ad=0.0816p as=0.0528p pd=1.16u ps=0.68u
    I_MXI2_I3_I63_MN1 (XI2_I3_I63_n1 I2_NOT_5 VSS VSS) gpdk090_nmos1v w=0.24u l=0.1u ad=0.0528p as=0.0816p pd=0.68u ps=1.16u
    I_MXI2_I3_I63_MN0 (I2_I3_n5_3 I2_SEL_NOT XI2_I3_I63_n1 VSS) gpdk090_nmos1v w=0.24u l=0.1u ad=0.0816p as=0.0528p pd=1.16u ps=0.68u
    I_MXI2_I3_I37_MN1 (XI2_I3_I37_n1 I2_OR_3 VSS VSS) gpdk090_nmos1v w=0.24u l=0.1u ad=0.0528p as=0.0816p pd=0.68u ps=1.16u
    I_MXI2_I3_I37_MN0 (I2_I3_n3_1 I2_SEL_OR XI2_I3_I37_n1 VSS) gpdk090_nmos1v w=0.24u l=0.1u ad=0.0816p as=0.0528p pd=1.16u ps=0.68u
    I_MXI2_I3_I67_MN1 (XI2_I3_I67_n1 I2_I3_n5_3 VSS VSS) gpdk090_nmos1v w=0.24u l=0.1u ad=0.0528p as=0.0816p pd=0.68u ps=1.16u
    I_MXI2_I3_I67_MN0 (I2_I3_o5_1 I2_I3_n5_2 XI2_I3_I67_n1 VSS) gpdk090_nmos1v w=0.24u l=0.1u ad=0.0816p as=0.0528p pd=1.16u ps=0.68u
    I_MXI2_I3_I42_MN1 (XI2_I3_I42_n1 I2_I3_n3_1 VSS VSS) gpdk090_nmos1v w=0.24u l=0.1u ad=0.0528p as=0.0816p pd=0.68u ps=1.16u
    I_MXI2_I3_I42_MN0 (I2_I3_o3_0 I2_I3_n3_0 XI2_I3_I42_n1 VSS) gpdk090_nmos1v w=0.24u l=0.1u ad=0.0816p as=0.0528p pd=1.16u ps=0.68u
    I_MXI2_I3_I36_MN1 (XI2_I3_I36_n1 I2_AND_3 VSS VSS) gpdk090_nmos1v w=0.24u l=0.1u ad=0.0528p as=0.0816p pd=0.68u ps=1.16u
    I_MXI2_I3_I36_MN0 (I2_I3_n3_0 I2_SEL_AND XI2_I3_I36_n1 VSS) gpdk090_nmos1v w=0.24u l=0.1u ad=0.0816p as=0.0528p pd=1.16u ps=0.68u
    I_MXI2_I3_I61_MN1 (XI2_I3_I61_n1 I2_OR_5 VSS VSS) gpdk090_nmos1v w=0.24u l=0.1u ad=0.0528p as=0.0816p pd=0.68u ps=1.16u
    I_MXI2_I3_I61_MN0 (I2_I3_n5_1 I2_SEL_OR XI2_I3_I61_n1 VSS) gpdk090_nmos1v w=0.24u l=0.1u ad=0.0816p as=0.0528p pd=1.16u ps=0.68u
    I_MXI2_I3_I39_MN1 (XI2_I3_I39_n1 I2_NOT_3 VSS VSS) gpdk090_nmos1v w=0.24u l=0.1u ad=0.0528p as=0.0816p pd=0.68u ps=1.16u
    I_MXI2_I3_I39_MN0 (I2_I3_n3_3 I2_SEL_NOT XI2_I3_I39_n1 VSS) gpdk090_nmos1v w=0.24u l=0.1u ad=0.0816p as=0.0528p pd=1.16u ps=0.68u
    I_MXI2_I3_I62_MN1 (XI2_I3_I62_n1 I2_XOR_5 VSS VSS) gpdk090_nmos1v w=0.24u l=0.1u ad=0.0528p as=0.0816p pd=0.68u ps=1.16u
    I_MXI2_I3_I62_MN0 (I2_I3_n5_2 I2_SEL_XOR XI2_I3_I62_n1 VSS) gpdk090_nmos1v w=0.24u l=0.1u ad=0.0816p as=0.0528p pd=1.16u ps=0.68u
    I_MXI2_I3_I43_MN1 (XI2_I3_I43_n1 I2_I3_n3_3 VSS VSS) gpdk090_nmos1v w=0.24u l=0.1u ad=0.0528p as=0.0816p pd=0.68u ps=1.16u
    I_MXI2_I3_I43_MN0 (I2_I3_o3_1 I2_I3_n3_2 XI2_I3_I43_n1 VSS) gpdk090_nmos1v w=0.24u l=0.1u ad=0.0816p as=0.0528p pd=1.16u ps=0.68u
    I_MXI1_I152_I7_MN1 (XI1_I152_I7_n1 I1_dm7 VSS VSS) gpdk090_nmos1v w=0.24u l=0.1u ad=0.0528p as=0.0816p pd=0.68u ps=1.16u
    I_MXI1_I152_I7_MN0 (I1_I152_gn7 I1_p7_7 XI1_I152_I7_n1 VSS) gpdk090_nmos1v w=0.24u l=0.1u ad=0.0816p as=0.0528p pd=1.16u ps=0.68u
    I_MXI1_I152_I6_MN1 (XI1_I152_I6_n1 I1_dm6 VSS VSS) gpdk090_nmos1v w=0.24u l=0.1u ad=0.0528p as=0.0816p pd=0.68u ps=1.16u
    I_MXI1_I152_I6_MN0 (I1_I152_gn6 I1_p7_6 XI1_I152_I6_n1 VSS) gpdk090_nmos1v w=0.24u l=0.1u ad=0.0816p as=0.0528p pd=1.16u ps=0.68u
    I_MXI1_I152_I30_XP_MN1 (XI1_I152_I30_XP_n1 I1_I152_P4_3 VSS VSS) gpdk090_nmos1v w=0.24u l=0.1u ad=0.0528p as=0.0816p pd=0.68u ps=1.16u
    I_MXI1_I152_I30_XP_MN0 (I1_I152_P6_3n I1_I152_P6_5 XI1_I152_I30_XP_n1 VSS) gpdk090_nmos1v w=0.24u l=0.1u ad=0.0816p as=0.0528p pd=1.16u ps=0.68u
    I_MXI1_I152_I28_XP_MN1 (XI1_I152_I28_XP_n1 I1_I152_P2_1 VSS VSS) gpdk090_nmos1v w=0.24u l=0.1u ad=0.0528p as=0.0816p pd=0.68u ps=1.16u
    I_MXI1_I152_I28_XP_MN0 (I1_I152_P4_1n I1_I152_P4_3 XI1_I152_I28_XP_n1 VSS) gpdk090_nmos1v w=0.24u l=0.1u ad=0.0816p as=0.0528p pd=1.16u ps=0.68u
    I_MXI2_I3_I99_MN1 (XI2_I3_I99_n1 MULP_9 VSS VSS) gpdk090_nmos1v w=0.24u l=0.1u ad=0.0528p as=0.0816p pd=0.68u ps=1.16u
    I_MXI2_I3_I99_MN0 (I2_I3_hm9 I2_SEL_MUL XI2_I3_I99_n1 VSS) gpdk090_nmos1v w=0.24u l=0.1u ad=0.0816p as=0.0528p pd=1.16u ps=0.68u
    I_MXI2_I3_I98_MN1 (XI2_I3_I98_n1 I2_I3_hd8 VSS VSS) gpdk090_nmos1v w=0.24u l=0.1u ad=0.0528p as=0.0816p pd=0.68u ps=1.16u
    I_MXI2_I3_I98_MN0 (Y_8 I2_I3_hm8 XI2_I3_I98_n1 VSS) gpdk090_nmos1v w=0.24u l=0.1u ad=0.0816p as=0.0528p pd=1.16u ps=0.68u
    I_MXI2_I3_I96_MN1 (XI2_I3_I96_n1 MULP_8 VSS VSS) gpdk090_nmos1v w=0.24u l=0.1u ad=0.0528p as=0.0816p pd=0.68u ps=1.16u
    I_MXI2_I3_I96_MN0 (I2_I3_hm8 I2_SEL_MUL XI2_I3_I96_n1 VSS) gpdk090_nmos1v w=0.24u l=0.1u ad=0.0816p as=0.0528p pd=1.16u ps=0.68u
    I_MXI0_I77_I0_MN1 (XI0_I77_I0_n1 I0_ha18_0 VSS VSS) gpdk090_nmos1v w=0.24u l=0.1u ad=0.0528p as=0.0816p pd=0.68u ps=1.16u
    I_MXI0_I77_I0_MN0 (I0_I77_gn0 I0_ha17_1 XI0_I77_I0_n1 VSS) gpdk090_nmos1v w=0.24u l=0.1u ad=0.0816p as=0.0528p pd=1.16u ps=0.68u
    I_MXI2_I2_I36_MN1 (XI2_I2_I36_n1 B_6 VSS VSS) gpdk090_nmos1v w=0.24u l=0.1u ad=0.0528p as=0.0816p pd=0.68u ps=1.16u
    I_MXI2_I2_I36_MN0 (I2_I2_nand6 A_6 XI2_I2_I36_n1 VSS) gpdk090_nmos1v w=0.24u l=0.1u ad=0.0816p as=0.0528p pd=1.16u ps=0.68u
    I_MXI2_I3_I74_MN1 (XI2_I3_I74_n1 I2_XOR_6 VSS VSS) gpdk090_nmos1v w=0.24u l=0.1u ad=0.0528p as=0.0816p pd=0.68u ps=1.16u
    I_MXI2_I3_I74_MN0 (I2_I3_n6_2 I2_SEL_XOR XI2_I3_I74_n1 VSS) gpdk090_nmos1v w=0.24u l=0.1u ad=0.0816p as=0.0528p pd=1.16u ps=0.68u
    I_MXI2_I1_I8_I6_MN1 (XI2_I1_I8_I6_n1 I2_I1_bx6 VSS VSS) gpdk090_nmos1v w=0.24u l=0.1u ad=0.0528p as=0.0816p pd=0.68u ps=1.16u
    I_MXI2_I1_I8_I6_MN0 (I2_I1_I8_gn6 A_6 XI2_I1_I8_I6_n1 VSS) gpdk090_nmos1v w=0.24u l=0.1u ad=0.0816p as=0.0528p pd=1.16u ps=0.68u
    I_MXI2_I2_I18_MN1 (XI2_I2_I18_n1 B_3 VSS VSS) gpdk090_nmos1v w=0.24u l=0.1u ad=0.0528p as=0.0816p pd=0.68u ps=1.16u
    I_MXI2_I2_I18_MN0 (I2_I2_nand3 A_3 XI2_I2_I18_n1 VSS) gpdk090_nmos1v w=0.24u l=0.1u ad=0.0816p as=0.0528p pd=1.16u ps=0.68u
    I_MXI2_I3_I38_MN1 (XI2_I3_I38_n1 I2_XOR_3 VSS VSS) gpdk090_nmos1v w=0.24u l=0.1u ad=0.0528p as=0.0816p pd=0.68u ps=1.16u
    I_MXI2_I3_I38_MN0 (I2_I3_n3_2 I2_SEL_XOR XI2_I3_I38_n1 VSS) gpdk090_nmos1v w=0.24u l=0.1u ad=0.0816p as=0.0528p pd=1.16u ps=0.68u
    I_MXI1_I152_I5_MN1 (XI1_I152_I5_n1 I1_dm5 VSS VSS) gpdk090_nmos1v w=0.24u l=0.1u ad=0.0528p as=0.0816p pd=0.68u ps=1.16u
    I_MXI1_I152_I5_MN0 (I1_I152_gn5 I1_p7_5 XI1_I152_I5_n1 VSS) gpdk090_nmos1v w=0.24u l=0.1u ad=0.0816p as=0.0528p pd=1.16u ps=0.68u
    I_MXI1_I152_I4_MN1 (XI1_I152_I4_n1 I1_dm4 VSS VSS) gpdk090_nmos1v w=0.24u l=0.1u ad=0.0528p as=0.0816p pd=0.68u ps=1.16u
    I_MXI1_I152_I4_MN0 (I1_I152_gn4 I1_p7_4 XI1_I152_I4_n1 VSS) gpdk090_nmos1v w=0.24u l=0.1u ad=0.0816p as=0.0528p pd=1.16u ps=0.68u
    I_MXI1_I152_I2_MN1 (XI1_I152_I2_n1 I1_dm2 VSS VSS) gpdk090_nmos1v w=0.24u l=0.1u ad=0.0528p as=0.0816p pd=0.68u ps=1.16u
    I_MXI1_I152_I2_MN0 (I1_I152_gn2 I1_p7_2 XI1_I152_I2_n1 VSS) gpdk090_nmos1v w=0.24u l=0.1u ad=0.0816p as=0.0528p pd=1.16u ps=0.68u
    I_MXI1_I152_I1_MN1 (XI1_I152_I1_n1 I1_dm1 VSS VSS) gpdk090_nmos1v w=0.24u l=0.1u ad=0.0528p as=0.0816p pd=0.68u ps=1.16u
    I_MXI1_I152_I1_MN0 (I1_I152_gn1 I1_p7_1 XI1_I152_I1_n1 VSS) gpdk090_nmos1v w=0.24u l=0.1u ad=0.0816p as=0.0528p pd=1.16u ps=0.68u
    I_MXI1_I174_MN1 (XI1_I174_n1 DIVR_0 VSS VSS) gpdk090_nmos1v w=0.24u l=0.1u ad=0.0528p as=0.0816p pd=0.68u ps=1.16u
    I_MXI1_I174_MN0 (I1_nrkn1 A_7 XI1_I174_n1 VSS) gpdk090_nmos1v w=0.24u l=0.1u ad=0.0816p as=0.0528p pd=1.16u ps=0.68u
    I_MXI2_I3_I97_MN1 (XI2_I3_I97_n1 DIVR_0 VSS VSS) gpdk090_nmos1v w=0.24u l=0.1u ad=0.0528p as=0.0816p pd=0.68u ps=1.16u
    I_MXI2_I3_I97_MN0 (I2_I3_hd8 I2_SEL_DIV XI2_I3_I97_n1 VSS) gpdk090_nmos1v w=0.24u l=0.1u ad=0.0816p as=0.0528p pd=1.16u ps=0.68u
    I_MXI2_I3_I88_MN1 (XI2_I3_I88_n1 MULP_7 VSS VSS) gpdk090_nmos1v w=0.24u l=0.1u ad=0.0528p as=0.0816p pd=0.68u ps=1.16u
    I_MXI2_I3_I88_MN0 (I2_I3_n7_4 I2_SEL_MUL XI2_I3_I88_n1 VSS) gpdk090_nmos1v w=0.24u l=0.1u ad=0.0816p as=0.0528p pd=1.16u ps=0.68u
    I_MXI2_I3_I92_MN1 (XI2_I3_I92_n1 I2_I3_n7_5 VSS VSS) gpdk090_nmos1v w=0.24u l=0.1u ad=0.0528p as=0.0816p pd=0.68u ps=1.16u
    I_MXI2_I3_I92_MN0 (I2_I3_o7_2 I2_I3_n7_4 XI2_I3_I92_n1 VSS) gpdk090_nmos1v w=0.24u l=0.1u ad=0.0816p as=0.0528p pd=1.16u ps=0.68u
    I_MXI2_I3_I95_MN1 (XI2_I3_I95_n1 I2_I3_q7_2 VSS VSS) gpdk090_nmos1v w=0.24u l=0.1u ad=0.0528p as=0.0816p pd=0.68u ps=1.16u
    I_MXI2_I3_I95_MN0 (Y_7 I2_I3_q7_1 XI2_I3_I95_n1 VSS) gpdk090_nmos1v w=0.24u l=0.1u ad=0.0816p as=0.0528p pd=1.16u ps=0.68u
    I_MXI2_I1_I8_I7_MN1 (XI2_I1_I8_I7_n1 I2_I1_bx7 VSS VSS) gpdk090_nmos1v w=0.24u l=0.1u ad=0.0528p as=0.0816p pd=0.68u ps=1.16u
    I_MXI2_I1_I8_I7_MN0 (I2_I1_I8_gn7 A_7 XI2_I1_I8_I7_n1 VSS) gpdk090_nmos1v w=0.24u l=0.1u ad=0.0816p as=0.0528p pd=1.16u ps=0.68u
    I_MXI2_I1_I8_I5_MN1 (XI2_I1_I8_I5_n1 I2_I1_bx5 VSS VSS) gpdk090_nmos1v w=0.24u l=0.1u ad=0.0528p as=0.0816p pd=0.68u ps=1.16u
    I_MXI2_I1_I8_I5_MN0 (I2_I1_I8_gn5 A_5 XI2_I1_I8_I5_n1 VSS) gpdk090_nmos1v w=0.24u l=0.1u ad=0.0816p as=0.0528p pd=1.16u ps=0.68u
    I_MXI1_I132_I31_XP_MN1 (XI1_I132_I31_XP_n1 I1_I132_P5_4 VSS VSS) gpdk090_nmos1v w=0.24u l=0.1u ad=0.0528p as=0.0816p pd=0.68u ps=1.16u
    I_MXI1_I132_I31_XP_MN0 (I1_I132_P7_4n I1_I132_P7_6 XI1_I132_I31_XP_n1 VSS) gpdk090_nmos1v w=0.24u l=0.1u ad=0.0816p as=0.0528p pd=1.16u ps=0.68u
    I_MXI1_I132_I29_XP_MN1 (XI1_I132_I29_XP_n1 I1_I132_P3_2 VSS VSS) gpdk090_nmos1v w=0.24u l=0.1u ad=0.0528p as=0.0816p pd=0.68u ps=1.16u
    I_MXI1_I132_I29_XP_MN0 (I1_I132_P5_2n I1_I132_P5_4 XI1_I132_I29_XP_n1 VSS) gpdk090_nmos1v w=0.24u l=0.1u ad=0.0816p as=0.0528p pd=1.16u ps=0.68u
    I_MXI1_I152_I3_MN1 (XI1_I152_I3_n1 I1_dm3 VSS VSS) gpdk090_nmos1v w=0.24u l=0.1u ad=0.0528p as=0.0816p pd=0.68u ps=1.16u
    I_MXI1_I152_I3_MN0 (I1_I152_gn3 I1_p7_3 XI1_I152_I3_n1 VSS) gpdk090_nmos1v w=0.24u l=0.1u ad=0.0816p as=0.0528p pd=1.16u ps=0.68u
    I_MXI1_I152_I0_MN1 (XI1_I152_I0_n1 I1_dm0 VSS VSS) gpdk090_nmos1v w=0.24u l=0.1u ad=0.0528p as=0.0816p pd=0.68u ps=1.16u
    I_MXI1_I152_I0_MN0 (I1_I152_gn0 I1_p7_0 XI1_I152_I0_n1 VSS) gpdk090_nmos1v w=0.24u l=0.1u ad=0.0816p as=0.0528p pd=1.16u ps=0.68u
    I_MXI2_I3_I76_MN1 (XI2_I3_I76_n1 MULP_6 VSS VSS) gpdk090_nmos1v w=0.24u l=0.1u ad=0.0528p as=0.0816p pd=0.68u ps=1.16u
    I_MXI2_I3_I76_MN0 (I2_I3_n6_4 I2_SEL_MUL XI2_I3_I76_n1 VSS) gpdk090_nmos1v w=0.24u l=0.1u ad=0.0816p as=0.0528p pd=1.16u ps=0.68u
    I_MXI2_I3_I80_MN1 (XI2_I3_I80_n1 I2_I3_n6_5 VSS VSS) gpdk090_nmos1v w=0.24u l=0.1u ad=0.0528p as=0.0816p pd=0.68u ps=1.16u
    I_MXI2_I3_I80_MN0 (I2_I3_o6_2 I2_I3_n6_4 XI2_I3_I80_n1 VSS) gpdk090_nmos1v w=0.24u l=0.1u ad=0.0816p as=0.0528p pd=1.16u ps=0.68u
    I_MXI2_I3_I83_MN1 (XI2_I3_I83_n1 I2_I3_q6_2 VSS VSS) gpdk090_nmos1v w=0.24u l=0.1u ad=0.0528p as=0.0816p pd=0.68u ps=1.16u
    I_MXI2_I3_I83_MN0 (Y_6 I2_I3_q6_1 XI2_I3_I83_n1 VSS) gpdk090_nmos1v w=0.24u l=0.1u ad=0.0816p as=0.0528p pd=1.16u ps=0.68u
    I_MXI2_I1_I8_I31_XP_MN1 (XI2_I1_I8_I31_XP_n1 I2_I1_I8_P5_4 VSS VSS) gpdk090_nmos1v w=0.24u l=0.1u ad=0.0528p as=0.0816p pd=0.68u ps=1.16u
    I_MXI2_I1_I8_I31_XP_MN0 (I2_I1_I8_P7_4n I2_I1_I8_P7_6 XI2_I1_I8_I31_XP_n1 VSS) gpdk090_nmos1v w=0.24u l=0.1u ad=0.0816p as=0.0528p pd=1.16u ps=0.68u
    I_MXI2_I1_I8_I3_MN1 (XI2_I1_I8_I3_n1 I2_I1_bx3 VSS VSS) gpdk090_nmos1v w=0.24u l=0.1u ad=0.0528p as=0.0816p pd=0.68u ps=1.16u
    I_MXI2_I1_I8_I3_MN0 (I2_I1_I8_gn3 A_3 XI2_I1_I8_I3_n1 VSS) gpdk090_nmos1v w=0.24u l=0.1u ad=0.0816p as=0.0528p pd=1.16u ps=0.68u
    I_MXI1_I150_MN1 (XI1_I150_n1 I1_p7_8 VSS VSS) gpdk090_nmos1v w=0.24u l=0.1u ad=0.0528p as=0.0816p pd=0.68u ps=1.16u
    I_MXI1_I150_MN0 (I1_dmn7 I1_dd7 XI1_I150_n1 VSS) gpdk090_nmos1v w=0.24u l=0.1u ad=0.0816p as=0.0528p pd=1.16u ps=0.68u
    I_MXI1_I132_I30_XP_MN1 (XI1_I132_I30_XP_n1 I1_I132_P4_3 VSS VSS) gpdk090_nmos1v w=0.24u l=0.1u ad=0.0528p as=0.0816p pd=0.68u ps=1.16u
    I_MXI1_I132_I30_XP_MN0 (I1_I132_P6_3n I1_I132_P6_5 XI1_I132_I30_XP_n1 VSS) gpdk090_nmos1v w=0.24u l=0.1u ad=0.0816p as=0.0528p pd=1.16u ps=0.68u
    I_MXI1_I132_I28_XP_MN1 (XI1_I132_I28_XP_n1 I1_I132_P2_1 VSS VSS) gpdk090_nmos1v w=0.24u l=0.1u ad=0.0528p as=0.0816p pd=0.68u ps=1.16u
    I_MXI1_I132_I28_XP_MN0 (I1_I132_P4_1n I1_I132_P4_3 XI1_I132_I28_XP_n1 VSS) gpdk090_nmos1v w=0.24u l=0.1u ad=0.0816p as=0.0528p pd=1.16u ps=0.68u
    I_MXI2_I4_I19_MN1 (XI2_I4_I19_n1 I2_I4_ovf VSS VSS) gpdk090_nmos1v w=0.24u l=0.1u ad=0.0528p as=0.0816p pd=0.68u ps=1.16u
    I_MXI2_I4_I19_MN0 (I2_I4_v1 I2_SEL_AS XI2_I4_I19_n1 VSS) gpdk090_nmos1v w=0.24u l=0.1u ad=0.0816p as=0.0528p pd=1.16u ps=0.68u
    I_MXI2_I4_I9_MN1 (XI2_I4_I9_n1 I2_I4_za3 VSS VSS) gpdk090_nmos1v w=0.24u l=0.1u ad=0.0528p as=0.0816p pd=0.68u ps=1.16u
    I_MXI2_I4_I9_MN0 (I2_I4_zb1 I2_I4_za2 XI2_I4_I9_n1 VSS) gpdk090_nmos1v w=0.24u l=0.1u ad=0.0816p as=0.0528p pd=1.16u ps=0.68u
    I_MXI2_I3_I71_MN1 (XI2_I3_I71_n1 I2_I3_q5_2 VSS VSS) gpdk090_nmos1v w=0.24u l=0.1u ad=0.0528p as=0.0816p pd=0.68u ps=1.16u
    I_MXI2_I3_I71_MN0 (Y_5 I2_I3_q5_1 XI2_I3_I71_n1 VSS) gpdk090_nmos1v w=0.24u l=0.1u ad=0.0816p as=0.0528p pd=1.16u ps=0.68u
    I_MXI2_I4_I16_MN1 (XI2_I4_I16_n1 I2_SEL_AS VSS VSS) gpdk090_nmos1v w=0.24u l=0.1u ad=0.0528p as=0.0816p pd=0.68u ps=1.16u
    I_MXI2_I4_I16_MN0 (I2_I4_cn I2_C8 XI2_I4_I16_n1 VSS) gpdk090_nmos1v w=0.24u l=0.1u ad=0.0816p as=0.0528p pd=1.16u ps=0.68u
    I_MXI2_I1_I8_I29_XP_MN1 (XI2_I1_I8_I29_XP_n1 I2_I1_I8_P3_2 VSS VSS) gpdk090_nmos1v w=0.24u l=0.1u ad=0.0528p as=0.0816p pd=0.68u ps=1.16u
    I_MXI2_I1_I8_I29_XP_MN0 (I2_I1_I8_P5_2n I2_I1_I8_P5_4 XI2_I1_I8_I29_XP_n1 VSS) gpdk090_nmos1v w=0.24u l=0.1u ad=0.0816p as=0.0528p pd=1.16u ps=0.68u
    I_MXI2_I1_I8_I30_XP_MN1 (XI2_I1_I8_I30_XP_n1 I2_I1_I8_P4_3 VSS VSS) gpdk090_nmos1v w=0.24u l=0.1u ad=0.0528p as=0.0816p pd=0.68u ps=1.16u
    I_MXI2_I1_I8_I30_XP_MN0 (I2_I1_I8_P6_3n I2_I1_I8_P6_5 XI2_I1_I8_I30_XP_n1 VSS) gpdk090_nmos1v w=0.24u l=0.1u ad=0.0816p as=0.0528p pd=1.16u ps=0.68u
    I_MXI2_I1_I8_I4_MN1 (XI2_I1_I8_I4_n1 I2_I1_bx4 VSS VSS) gpdk090_nmos1v w=0.24u l=0.1u ad=0.0528p as=0.0816p pd=0.68u ps=1.16u
    I_MXI2_I1_I8_I4_MN0 (I2_I1_I8_gn4 A_4 XI2_I1_I8_I4_n1 VSS) gpdk090_nmos1v w=0.24u l=0.1u ad=0.0816p as=0.0528p pd=1.16u ps=0.68u
    I_MXI1_I132_I7_MN1 (XI1_I132_I7_n1 I1_b7_7 VSS VSS) gpdk090_nmos1v w=0.24u l=0.1u ad=0.0528p as=0.0816p pd=0.68u ps=1.16u
    I_MXI1_I132_I7_MN0 (I1_I132_gn7 I1_p6_6 XI1_I132_I7_n1 VSS) gpdk090_nmos1v w=0.24u l=0.1u ad=0.0816p as=0.0528p pd=1.16u ps=0.68u
    I_MXI1_I132_I6_MN1 (XI1_I132_I6_n1 I1_b7_6 VSS VSS) gpdk090_nmos1v w=0.24u l=0.1u ad=0.0528p as=0.0816p pd=0.68u ps=1.16u
    I_MXI1_I132_I6_MN0 (I1_I132_gn6 I1_p6_5 XI1_I132_I6_n1 VSS) gpdk090_nmos1v w=0.24u l=0.1u ad=0.0816p as=0.0528p pd=1.16u ps=0.68u
    I_MXI1_I148_MN1 (XI1_I148_n1 I1_p7_8 VSS VSS) gpdk090_nmos1v w=0.24u l=0.1u ad=0.0528p as=0.0816p pd=0.68u ps=1.16u
    I_MXI1_I148_MN0 (I1_dmn6 I1_dd6 XI1_I148_n1 VSS) gpdk090_nmos1v w=0.24u l=0.1u ad=0.0816p as=0.0528p pd=1.16u ps=0.68u
    I_MXI1_I132_I5_MN1 (XI1_I132_I5_n1 I1_b7_5 VSS VSS) gpdk090_nmos1v w=0.24u l=0.1u ad=0.0528p as=0.0816p pd=0.68u ps=1.16u
    I_MXI1_I132_I5_MN0 (I1_I132_gn5 I1_p6_4 XI1_I132_I5_n1 VSS) gpdk090_nmos1v w=0.24u l=0.1u ad=0.0816p as=0.0528p pd=1.16u ps=0.68u
    I_MXI1_I132_I4_MN1 (XI1_I132_I4_n1 I1_b7_4 VSS VSS) gpdk090_nmos1v w=0.24u l=0.1u ad=0.0528p as=0.0816p pd=0.68u ps=1.16u
    I_MXI1_I132_I4_MN0 (I1_I132_gn4 I1_p6_3 XI1_I132_I4_n1 VSS) gpdk090_nmos1v w=0.24u l=0.1u ad=0.0816p as=0.0528p pd=1.16u ps=0.68u
    I_MXI1_I132_I3_MN1 (XI1_I132_I3_n1 I1_b7_3 VSS VSS) gpdk090_nmos1v w=0.24u l=0.1u ad=0.0528p as=0.0816p pd=0.68u ps=1.16u
    I_MXI1_I132_I3_MN0 (I1_I132_gn3 I1_p6_2 XI1_I132_I3_n1 VSS) gpdk090_nmos1v w=0.24u l=0.1u ad=0.0816p as=0.0528p pd=1.16u ps=0.68u
    I_MXI1_I142_MN1 (XI1_I142_n1 I1_p7_8 VSS VSS) gpdk090_nmos1v w=0.24u l=0.1u ad=0.0528p as=0.0816p pd=0.68u ps=1.16u
    I_MXI1_I142_MN0 (I1_dmn3 I1_dd3 XI1_I142_n1 VSS) gpdk090_nmos1v w=0.24u l=0.1u ad=0.0816p as=0.0528p pd=1.16u ps=0.68u
    I_MXI1_I132_I1_MN1 (XI1_I132_I1_n1 I1_b7_1 VSS VSS) gpdk090_nmos1v w=0.24u l=0.1u ad=0.0528p as=0.0816p pd=0.68u ps=1.16u
    I_MXI1_I132_I1_MN0 (I1_I132_gn1 I1_p6_0 XI1_I132_I1_n1 VSS) gpdk090_nmos1v w=0.24u l=0.1u ad=0.0816p as=0.0528p pd=1.16u ps=0.68u
    I_MXI1_I138_MN1 (XI1_I138_n1 I1_p7_8 VSS VSS) gpdk090_nmos1v w=0.24u l=0.1u ad=0.0528p as=0.0816p pd=0.68u ps=1.16u
    I_MXI1_I138_MN0 (I1_dmn1 I1_dd1 XI1_I138_n1 VSS) gpdk090_nmos1v w=0.24u l=0.1u ad=0.0816p as=0.0528p pd=1.16u ps=0.68u
    I_MXI1_I136_MN1 (XI1_I136_n1 I1_p7_8 VSS VSS) gpdk090_nmos1v w=0.24u l=0.1u ad=0.0528p as=0.0816p pd=0.68u ps=1.16u
    I_MXI1_I136_MN0 (I1_dmn0 B_0 XI1_I136_n1 VSS) gpdk090_nmos1v w=0.24u l=0.1u ad=0.0816p as=0.0528p pd=1.16u ps=0.68u
    I_MXI1_I132_I0_MN1 (XI1_I132_I0_n1 I1_b7_0 VSS VSS) gpdk090_nmos1v w=0.24u l=0.1u ad=0.0528p as=0.0816p pd=0.68u ps=1.16u
    I_MXI1_I132_I0_MN0 (I1_I132_gn0 A_0 XI1_I132_I0_n1 VSS) gpdk090_nmos1v w=0.24u l=0.1u ad=0.0816p as=0.0528p pd=1.16u ps=0.68u
    I_MXI2_I3_I64_MN1 (XI2_I3_I64_n1 MULP_5 VSS VSS) gpdk090_nmos1v w=0.24u l=0.1u ad=0.0528p as=0.0816p pd=0.68u ps=1.16u
    I_MXI2_I3_I64_MN0 (I2_I3_n5_4 I2_SEL_MUL XI2_I3_I64_n1 VSS) gpdk090_nmos1v w=0.24u l=0.1u ad=0.0816p as=0.0528p pd=1.16u ps=0.68u
    I_MXI2_I3_I68_MN1 (XI2_I3_I68_n1 I2_I3_n5_5 VSS VSS) gpdk090_nmos1v w=0.24u l=0.1u ad=0.0528p as=0.0816p pd=0.68u ps=1.16u
    I_MXI2_I3_I68_MN0 (I2_I3_o5_2 I2_I3_n5_4 XI2_I3_I68_n1 VSS) gpdk090_nmos1v w=0.24u l=0.1u ad=0.0816p as=0.0528p pd=1.16u ps=0.68u
    I_MXI2_I3_I89_MN1 (XI2_I3_I89_n1 DIVQ_7 VSS VSS) gpdk090_nmos1v w=0.24u l=0.1u ad=0.0528p as=0.0816p pd=0.68u ps=1.16u
    I_MXI2_I3_I89_MN0 (I2_I3_n7_5 I2_SEL_DIV XI2_I3_I89_n1 VSS) gpdk090_nmos1v w=0.24u l=0.1u ad=0.0816p as=0.0528p pd=1.16u ps=0.68u
    I_MXI2_I4_I20_MN1 (XI2_I4_I20_n1 DIVV VSS VSS) gpdk090_nmos1v w=0.24u l=0.1u ad=0.0528p as=0.0816p pd=0.68u ps=1.16u
    I_MXI2_I4_I20_MN0 (I2_I4_v2 I2_SEL_DIV XI2_I4_I20_n1 VSS) gpdk090_nmos1v w=0.24u l=0.1u ad=0.0816p as=0.0528p pd=1.16u ps=0.68u
    I_MXI2_I4_I21_MN1 (XI2_I4_I21_n1 I2_I4_v2 VSS VSS) gpdk090_nmos1v w=0.24u l=0.1u ad=0.0528p as=0.0816p pd=0.68u ps=1.16u
    I_MXI2_I4_I21_MN0 (V I2_I4_v1 XI2_I4_I21_n1 VSS) gpdk090_nmos1v w=0.24u l=0.1u ad=0.0816p as=0.0528p pd=1.16u ps=0.68u
    I_MXI2_I1_I8_I28_XP_MN1 (XI2_I1_I8_I28_XP_n1 I2_I1_I8_P2_1 VSS VSS) gpdk090_nmos1v w=0.24u l=0.1u ad=0.0528p as=0.0816p pd=0.68u ps=1.16u
    I_MXI2_I1_I8_I28_XP_MN0 (I2_I1_I8_P4_1n I2_I1_I8_P4_3 XI2_I1_I8_I28_XP_n1 VSS) gpdk090_nmos1v w=0.24u l=0.1u ad=0.0816p as=0.0528p pd=1.16u ps=0.68u
    I_MXI1_I146_MN1 (XI1_I146_n1 I1_p7_8 VSS VSS) gpdk090_nmos1v w=0.24u l=0.1u ad=0.0528p as=0.0816p pd=0.68u ps=1.16u
    I_MXI1_I146_MN0 (I1_dmn5 I1_dd5 XI1_I146_n1 VSS) gpdk090_nmos1v w=0.24u l=0.1u ad=0.0816p as=0.0528p pd=1.16u ps=0.68u
    I_MXI1_I144_MN1 (XI1_I144_n1 I1_p7_8 VSS VSS) gpdk090_nmos1v w=0.24u l=0.1u ad=0.0528p as=0.0816p pd=0.68u ps=1.16u
    I_MXI1_I144_MN0 (I1_dmn4 I1_dd4 XI1_I144_n1 VSS) gpdk090_nmos1v w=0.24u l=0.1u ad=0.0816p as=0.0528p pd=1.16u ps=0.68u
    I_MXI1_I140_MN1 (XI1_I140_n1 I1_p7_8 VSS VSS) gpdk090_nmos1v w=0.24u l=0.1u ad=0.0528p as=0.0816p pd=0.68u ps=1.16u
    I_MXI1_I140_MN0 (I1_dmn2 I1_dd2 XI1_I140_n1 VSS) gpdk090_nmos1v w=0.24u l=0.1u ad=0.0816p as=0.0528p pd=1.16u ps=0.68u
    I_MXI1_I132_I2_MN1 (XI1_I132_I2_n1 I1_b7_2 VSS VSS) gpdk090_nmos1v w=0.24u l=0.1u ad=0.0528p as=0.0816p pd=0.68u ps=1.16u
    I_MXI1_I132_I2_MN0 (I1_I132_gn2 I1_p6_1 XI1_I132_I2_n1 VSS) gpdk090_nmos1v w=0.24u l=0.1u ad=0.0816p as=0.0528p pd=1.16u ps=0.68u
    I_MXI1_I154_MN1 (XI1_I154_n1 DIVQ_0 VSS VSS) gpdk090_nmos1v w=0.24u l=0.1u ad=0.0528p as=0.0816p pd=0.68u ps=1.16u
    I_MXI1_I154_MN0 (I1_nqkn1 I1_sq XI1_I154_n1 VSS) gpdk090_nmos1v w=0.24u l=0.1u ad=0.0816p as=0.0528p pd=1.16u ps=0.68u
    I_MXI2_I3_I65_MN1 (XI2_I3_I65_n1 DIVQ_5 VSS VSS) gpdk090_nmos1v w=0.24u l=0.1u ad=0.0528p as=0.0816p pd=0.68u ps=1.16u
    I_MXI2_I3_I65_MN0 (I2_I3_n5_5 I2_SEL_DIV XI2_I3_I65_n1 VSS) gpdk090_nmos1v w=0.24u l=0.1u ad=0.0816p as=0.0528p pd=1.16u ps=0.68u
    I_MXI2_I3_I56_MN1 (XI2_I3_I56_n1 I2_I3_n4_5 VSS VSS) gpdk090_nmos1v w=0.24u l=0.1u ad=0.0528p as=0.0816p pd=0.68u ps=1.16u
    I_MXI2_I3_I56_MN0 (I2_I3_o4_2 I2_I3_n4_4 XI2_I3_I56_n1 VSS) gpdk090_nmos1v w=0.24u l=0.1u ad=0.0816p as=0.0528p pd=1.16u ps=0.68u
    I_MXI2_I3_I52_MN1 (XI2_I3_I52_n1 MULP_4 VSS VSS) gpdk090_nmos1v w=0.24u l=0.1u ad=0.0528p as=0.0816p pd=0.68u ps=1.16u
    I_MXI2_I3_I52_MN0 (I2_I3_n4_4 I2_SEL_MUL XI2_I3_I52_n1 VSS) gpdk090_nmos1v w=0.24u l=0.1u ad=0.0816p as=0.0528p pd=1.16u ps=0.68u
    I_MXI1_I199_MN1 (XI1_I199_n1 I1_z1_3 VSS VSS) gpdk090_nmos1v w=0.24u l=0.1u ad=0.0528p as=0.0816p pd=0.68u ps=1.16u
    I_MXI1_I199_MN0 (I1_z2_1 I1_z1_2 XI1_I199_n1 VSS) gpdk090_nmos1v w=0.24u l=0.1u ad=0.0816p as=0.0528p pd=1.16u ps=0.68u
    I_MXI2_I4_I22_MN1 (XI2_I4_I22_n1 DIVDZ VSS VSS) gpdk090_nmos1v w=0.24u l=0.1u ad=0.0528p as=0.0816p pd=0.68u ps=1.16u
    I_MXI2_I4_I22_MN0 (I2_I4_dzn I2_SEL_DIV XI2_I4_I22_n1 VSS) gpdk090_nmos1v w=0.24u l=0.1u ad=0.0816p as=0.0528p pd=1.16u ps=0.68u
    I_MXI2_I1_I8_I0_MN1 (XI2_I1_I8_I0_n1 I2_I1_bx0 VSS VSS) gpdk090_nmos1v w=0.24u l=0.1u ad=0.0528p as=0.0816p pd=0.68u ps=1.16u
    I_MXI2_I1_I8_I0_MN0 (I2_I1_I8_gn0 A_0 XI2_I1_I8_I0_n1 VSS) gpdk090_nmos1v w=0.24u l=0.1u ad=0.0816p as=0.0528p pd=1.16u ps=0.68u
    I_MXI2_I3_I59_MN1 (XI2_I3_I59_n1 I2_I3_q4_2 VSS VSS) gpdk090_nmos1v w=0.24u l=0.1u ad=0.0528p as=0.0816p pd=0.68u ps=1.16u
    I_MXI2_I3_I59_MN0 (Y_4 I2_I3_q4_1 XI2_I3_I59_n1 VSS) gpdk090_nmos1v w=0.24u l=0.1u ad=0.0816p as=0.0528p pd=1.16u ps=0.68u
    I_MXI2_I1_I8_I1_MN1 (XI2_I1_I8_I1_n1 I2_I1_bx1 VSS VSS) gpdk090_nmos1v w=0.24u l=0.1u ad=0.0528p as=0.0816p pd=0.68u ps=1.16u
    I_MXI2_I1_I8_I1_MN0 (I2_I1_I8_gn1 A_1 XI2_I1_I8_I1_n1 VSS) gpdk090_nmos1v w=0.24u l=0.1u ad=0.0816p as=0.0528p pd=1.16u ps=0.68u
    I_MXI2_I1_I8_I2_MN1 (XI2_I1_I8_I2_n1 I2_I1_bx2 VSS VSS) gpdk090_nmos1v w=0.24u l=0.1u ad=0.0528p as=0.0816p pd=0.68u ps=1.16u
    I_MXI2_I1_I8_I2_MN0 (I2_I1_I8_gn2 A_2 XI2_I1_I8_I2_n1 VSS) gpdk090_nmos1v w=0.24u l=0.1u ad=0.0816p as=0.0528p pd=1.16u ps=0.68u
    I_MXI1_I120_I30_XP_MN1 (XI1_I120_I30_XP_n1 I1_I120_P4_3 VSS VSS) gpdk090_nmos1v w=0.24u l=0.1u ad=0.0528p as=0.0816p pd=0.68u ps=1.16u
    I_MXI1_I120_I30_XP_MN0 (I1_I120_P6_3n I1_I120_P6_5 XI1_I120_I30_XP_n1 VSS) gpdk090_nmos1v w=0.24u l=0.1u ad=0.0816p as=0.0528p pd=1.16u ps=0.68u
    I_MXI1_I120_I28_XP_MN1 (XI1_I120_I28_XP_n1 I1_I120_P2_1 VSS VSS) gpdk090_nmos1v w=0.24u l=0.1u ad=0.0528p as=0.0816p pd=0.68u ps=1.16u
    I_MXI1_I120_I28_XP_MN0 (I1_I120_P4_1n I1_I120_P4_3 XI1_I120_I28_XP_n1 VSS) gpdk090_nmos1v w=0.24u l=0.1u ad=0.0816p as=0.0528p pd=1.16u ps=0.68u
    I_MXI1_I120_I0_MN1 (XI1_I120_I0_n1 I1_b6_0 VSS VSS) gpdk090_nmos1v w=0.24u l=0.1u ad=0.0528p as=0.0816p pd=0.68u ps=1.16u
    I_MXI1_I120_I0_MN0 (I1_I120_gn0 I1_aa1 XI1_I120_I0_n1 VSS) gpdk090_nmos1v w=0.24u l=0.1u ad=0.0816p as=0.0528p pd=1.16u ps=0.68u
    I_MXI2_I3_I17_MN1 (XI2_I3_I17_n1 DIVQ_1 VSS VSS) gpdk090_nmos1v w=0.24u l=0.1u ad=0.0528p as=0.0816p pd=0.68u ps=1.16u
    I_MXI2_I3_I17_MN0 (I2_I3_n1_5 I2_SEL_DIV XI2_I3_I17_n1 VSS) gpdk090_nmos1v w=0.24u l=0.1u ad=0.0816p as=0.0528p pd=1.16u ps=0.68u
    I_MXI2_I3_I53_MN1 (XI2_I3_I53_n1 DIVQ_4 VSS VSS) gpdk090_nmos1v w=0.24u l=0.1u ad=0.0528p as=0.0816p pd=0.68u ps=1.16u
    I_MXI2_I3_I53_MN0 (I2_I3_n4_5 I2_SEL_DIV XI2_I3_I53_n1 VSS) gpdk090_nmos1v w=0.24u l=0.1u ad=0.0816p as=0.0528p pd=1.16u ps=0.68u
    I_MXI2_I3_I29_MN1 (XI2_I3_I29_n1 DIVQ_2 VSS VSS) gpdk090_nmos1v w=0.24u l=0.1u ad=0.0528p as=0.0816p pd=0.68u ps=1.16u
    I_MXI2_I3_I29_MN0 (I2_I3_n2_5 I2_SEL_DIV XI2_I3_I29_n1 VSS) gpdk090_nmos1v w=0.24u l=0.1u ad=0.0816p as=0.0528p pd=1.16u ps=0.68u
    I_MXI2_I3_I5_MN1 (XI2_I3_I5_n1 DIVQ_0 VSS VSS) gpdk090_nmos1v w=0.24u l=0.1u ad=0.0528p as=0.0816p pd=0.68u ps=1.16u
    I_MXI2_I3_I5_MN0 (I2_I3_n0_5 I2_SEL_DIV XI2_I3_I5_n1 VSS) gpdk090_nmos1v w=0.24u l=0.1u ad=0.0816p as=0.0528p pd=1.16u ps=0.68u
    I_MXI2_I3_I40_MN1 (XI2_I3_I40_n1 MULP_3 VSS VSS) gpdk090_nmos1v w=0.24u l=0.1u ad=0.0528p as=0.0816p pd=0.68u ps=1.16u
    I_MXI2_I3_I40_MN0 (I2_I3_n3_4 I2_SEL_MUL XI2_I3_I40_n1 VSS) gpdk090_nmos1v w=0.24u l=0.1u ad=0.0816p as=0.0528p pd=1.16u ps=0.68u
    I_MXI2_I3_I77_MN1 (XI2_I3_I77_n1 DIVQ_6 VSS VSS) gpdk090_nmos1v w=0.24u l=0.1u ad=0.0528p as=0.0816p pd=0.68u ps=1.16u
    I_MXI2_I3_I77_MN0 (I2_I3_n6_5 I2_SEL_DIV XI2_I3_I77_n1 VSS) gpdk090_nmos1v w=0.24u l=0.1u ad=0.0816p as=0.0528p pd=1.16u ps=0.68u
    I_MXI2_I3_I41_MN1 (XI2_I3_I41_n1 DIVQ_3 VSS VSS) gpdk090_nmos1v w=0.24u l=0.1u ad=0.0528p as=0.0816p pd=0.68u ps=1.16u
    I_MXI2_I3_I41_MN0 (I2_I3_n3_5 I2_SEL_DIV XI2_I3_I41_n1 VSS) gpdk090_nmos1v w=0.24u l=0.1u ad=0.0816p as=0.0528p pd=1.16u ps=0.68u
    I_MXI2_I3_I44_MN1 (XI2_I3_I44_n1 I2_I3_n3_5 VSS VSS) gpdk090_nmos1v w=0.24u l=0.1u ad=0.0528p as=0.0816p pd=0.68u ps=1.16u
    I_MXI2_I3_I44_MN0 (I2_I3_o3_2 I2_I3_n3_4 XI2_I3_I44_n1 VSS) gpdk090_nmos1v w=0.24u l=0.1u ad=0.0816p as=0.0528p pd=1.16u ps=0.68u
    I_MXI2_I3_I28_MN1 (XI2_I3_I28_n1 MULP_2 VSS VSS) gpdk090_nmos1v w=0.24u l=0.1u ad=0.0528p as=0.0816p pd=0.68u ps=1.16u
    I_MXI2_I3_I28_MN0 (I2_I3_n2_4 I2_SEL_MUL XI2_I3_I28_n1 VSS) gpdk090_nmos1v w=0.24u l=0.1u ad=0.0816p as=0.0528p pd=1.16u ps=0.68u
    I_MXI2_I3_I32_MN1 (XI2_I3_I32_n1 I2_I3_n2_5 VSS VSS) gpdk090_nmos1v w=0.24u l=0.1u ad=0.0528p as=0.0816p pd=0.68u ps=1.16u
    I_MXI2_I3_I32_MN0 (I2_I3_o2_2 I2_I3_n2_4 XI2_I3_I32_n1 VSS) gpdk090_nmos1v w=0.24u l=0.1u ad=0.0816p as=0.0528p pd=1.16u ps=0.68u
    I_MXI2_I3_I20_MN1 (XI2_I3_I20_n1 I2_I3_n1_5 VSS VSS) gpdk090_nmos1v w=0.24u l=0.1u ad=0.0528p as=0.0816p pd=0.68u ps=1.16u
    I_MXI2_I3_I20_MN0 (I2_I3_o1_2 I2_I3_n1_4 XI2_I3_I20_n1 VSS) gpdk090_nmos1v w=0.24u l=0.1u ad=0.0816p as=0.0528p pd=1.16u ps=0.68u
    I_MXI2_I3_I16_MN1 (XI2_I3_I16_n1 MULP_1 VSS VSS) gpdk090_nmos1v w=0.24u l=0.1u ad=0.0528p as=0.0816p pd=0.68u ps=1.16u
    I_MXI2_I3_I16_MN0 (I2_I3_n1_4 I2_SEL_MUL XI2_I3_I16_n1 VSS) gpdk090_nmos1v w=0.24u l=0.1u ad=0.0816p as=0.0528p pd=1.16u ps=0.68u
    I_MXI1_I202_MN1 (XI1_I202_n1 I1_sqn VSS VSS) gpdk090_nmos1v w=0.24u l=0.1u ad=0.0528p as=0.0816p pd=0.68u ps=1.16u
    I_MXI1_I202_MN0 (I1_vn DIVQ_7 XI1_I202_n1 VSS) gpdk090_nmos1v w=0.24u l=0.1u ad=0.0816p as=0.0528p pd=1.16u ps=0.68u
    I_MXI2_I3_I4_MN1 (XI2_I3_I4_n1 MULP_0 VSS VSS) gpdk090_nmos1v w=0.24u l=0.1u ad=0.0528p as=0.0816p pd=0.68u ps=1.16u
    I_MXI2_I3_I4_MN0 (I2_I3_n0_4 I2_SEL_MUL XI2_I3_I4_n1 VSS) gpdk090_nmos1v w=0.24u l=0.1u ad=0.0816p as=0.0528p pd=1.16u ps=0.68u
    I_MXI2_I3_I8_MN1 (XI2_I3_I8_n1 I2_I3_n0_5 VSS VSS) gpdk090_nmos1v w=0.24u l=0.1u ad=0.0528p as=0.0816p pd=0.68u ps=1.16u
    I_MXI2_I3_I8_MN0 (I2_I3_o0_2 I2_I3_n0_4 XI2_I3_I8_n1 VSS) gpdk090_nmos1v w=0.24u l=0.1u ad=0.0816p as=0.0528p pd=1.16u ps=0.68u
    I_MXI1_I198_MN1 (XI1_I198_n1 I1_z1_1 VSS VSS) gpdk090_nmos1v w=0.24u l=0.1u ad=0.0528p as=0.0816p pd=0.68u ps=1.16u
    I_MXI1_I198_MN0 (I1_z2_0 I1_z1_0 XI1_I198_n1 VSS) gpdk090_nmos1v w=0.24u l=0.1u ad=0.0816p as=0.0528p pd=1.16u ps=0.68u
    I_MXI2_I4_I8_MN1 (XI2_I4_I8_n1 I2_I4_za1 VSS VSS) gpdk090_nmos1v w=0.24u l=0.1u ad=0.0528p as=0.0816p pd=0.68u ps=1.16u
    I_MXI2_I4_I8_MN0 (I2_I4_zb0 I2_I4_za0 XI2_I4_I8_n1 VSS) gpdk090_nmos1v w=0.24u l=0.1u ad=0.0816p as=0.0528p pd=1.16u ps=0.68u
    I_MXI2_I3_I47_MN1 (XI2_I3_I47_n1 I2_I3_q3_2 VSS VSS) gpdk090_nmos1v w=0.24u l=0.1u ad=0.0528p as=0.0816p pd=0.68u ps=1.16u
    I_MXI2_I3_I47_MN0 (Y_3 I2_I3_q3_1 XI2_I3_I47_n1 VSS) gpdk090_nmos1v w=0.24u l=0.1u ad=0.0816p as=0.0528p pd=1.16u ps=0.68u
    I_MXI1_I120_I29_XP_MN1 (XI1_I120_I29_XP_n1 I1_I120_P3_2 VSS VSS) gpdk090_nmos1v w=0.24u l=0.1u ad=0.0528p as=0.0816p pd=0.68u ps=1.16u
    I_MXI1_I120_I29_XP_MN0 (I1_I120_P5_2n I1_I120_P5_4 XI1_I120_I29_XP_n1 VSS) gpdk090_nmos1v w=0.24u l=0.1u ad=0.0816p as=0.0528p pd=1.16u ps=0.68u
    I_MXI1_I120_I31_XP_MN1 (XI1_I120_I31_XP_n1 I1_I120_P5_4 VSS VSS) gpdk090_nmos1v w=0.24u l=0.1u ad=0.0528p as=0.0816p pd=0.68u ps=1.16u
    I_MXI1_I120_I31_XP_MN0 (I1_I120_P7_4n I1_I120_P7_6 XI1_I120_I31_XP_n1 VSS) gpdk090_nmos1v w=0.24u l=0.1u ad=0.0816p as=0.0528p pd=1.16u ps=0.68u
    I_MXI1_I120_I3_MN1 (XI1_I120_I3_n1 I1_b6_3 VSS VSS) gpdk090_nmos1v w=0.24u l=0.1u ad=0.0528p as=0.0816p pd=0.68u ps=1.16u
    I_MXI1_I120_I3_MN0 (I1_I120_gn3 I1_p5_2 XI1_I120_I3_n1 VSS) gpdk090_nmos1v w=0.24u l=0.1u ad=0.0816p as=0.0528p pd=1.16u ps=0.68u
    I_MXI1_I120_I2_MN1 (XI1_I120_I2_n1 I1_b6_2 VSS VSS) gpdk090_nmos1v w=0.24u l=0.1u ad=0.0528p as=0.0816p pd=0.68u ps=1.16u
    I_MXI1_I120_I2_MN0 (I1_I120_gn2 I1_p5_1 XI1_I120_I2_n1 VSS) gpdk090_nmos1v w=0.24u l=0.1u ad=0.0816p as=0.0528p pd=1.16u ps=0.68u
    I_MXI1_I120_I1_MN1 (XI1_I120_I1_n1 I1_b6_1 VSS VSS) gpdk090_nmos1v w=0.24u l=0.1u ad=0.0528p as=0.0816p pd=0.68u ps=1.16u
    I_MXI1_I120_I1_MN0 (I1_I120_gn1 I1_p5_0 XI1_I120_I1_n1 VSS) gpdk090_nmos1v w=0.24u l=0.1u ad=0.0816p as=0.0528p pd=1.16u ps=0.68u
    I_MXI1_I0_MN1 (XI1_I0_n1 A_0 VSS VSS) gpdk090_nmos1v w=0.24u l=0.1u ad=0.0528p as=0.0816p pd=0.68u ps=1.16u
    I_MXI1_I0_MN0 (I1_nakn1 A_7 XI1_I0_n1 VSS) gpdk090_nmos1v w=0.24u l=0.1u ad=0.0816p as=0.0528p pd=1.16u ps=0.68u
    I_MXI2_I3_I11_MN1 (XI2_I3_I11_n1 I2_I3_q0_2 VSS VSS) gpdk090_nmos1v w=0.24u l=0.1u ad=0.0528p as=0.0816p pd=0.68u ps=1.16u
    I_MXI2_I3_I11_MN0 (Y_0 I2_I3_q0_1 XI2_I3_I11_n1 VSS) gpdk090_nmos1v w=0.24u l=0.1u ad=0.0816p as=0.0528p pd=1.16u ps=0.68u
    I_MXI2_I3_I3_MN1 (XI2_I3_I3_n1 I2_NOT_0 VSS VSS) gpdk090_nmos1v w=0.24u l=0.1u ad=0.0528p as=0.0816p pd=0.68u ps=1.16u
    I_MXI2_I3_I3_MN0 (I2_I3_n0_3 I2_SEL_NOT XI2_I3_I3_n1 VSS) gpdk090_nmos1v w=0.24u l=0.1u ad=0.0816p as=0.0528p pd=1.16u ps=0.68u
    I_MXI2_I3_I23_MN1 (XI2_I3_I23_n1 I2_I3_q1_2 VSS VSS) gpdk090_nmos1v w=0.24u l=0.1u ad=0.0528p as=0.0816p pd=0.68u ps=1.16u
    I_MXI2_I3_I23_MN0 (Y_1 I2_I3_q1_1 XI2_I3_I23_n1 VSS) gpdk090_nmos1v w=0.24u l=0.1u ad=0.0816p as=0.0528p pd=1.16u ps=0.68u
    I_MXI2_I3_I7_MN1 (XI2_I3_I7_n1 I2_I3_n0_3 VSS VSS) gpdk090_nmos1v w=0.24u l=0.1u ad=0.0528p as=0.0816p pd=0.68u ps=1.16u
    I_MXI2_I3_I7_MN0 (I2_I3_o0_1 I2_I3_n0_2 XI2_I3_I7_n1 VSS) gpdk090_nmos1v w=0.24u l=0.1u ad=0.0816p as=0.0528p pd=1.16u ps=0.68u
    I_MXI2_I3_I35_MN1 (XI2_I3_I35_n1 I2_I3_q2_2 VSS VSS) gpdk090_nmos1v w=0.24u l=0.1u ad=0.0528p as=0.0816p pd=0.68u ps=1.16u
    I_MXI2_I3_I35_MN0 (Y_2 I2_I3_q2_1 XI2_I3_I35_n1 VSS) gpdk090_nmos1v w=0.24u l=0.1u ad=0.0816p as=0.0528p pd=1.16u ps=0.68u
    I_MXI2_I3_I55_MN1 (XI2_I3_I55_n1 I2_I3_n4_3 VSS VSS) gpdk090_nmos1v w=0.24u l=0.1u ad=0.0528p as=0.0816p pd=0.68u ps=1.16u
    I_MXI2_I3_I55_MN0 (I2_I3_o4_1 I2_I3_n4_2 XI2_I3_I55_n1 VSS) gpdk090_nmos1v w=0.24u l=0.1u ad=0.0816p as=0.0528p pd=1.16u ps=0.68u
    I_MXI2_I3_I51_MN1 (XI2_I3_I51_n1 I2_NOT_4 VSS VSS) gpdk090_nmos1v w=0.24u l=0.1u ad=0.0528p as=0.0816p pd=0.68u ps=1.16u
    I_MXI2_I3_I51_MN0 (I2_I3_n4_3 I2_SEL_NOT XI2_I3_I51_n1 VSS) gpdk090_nmos1v w=0.24u l=0.1u ad=0.0816p as=0.0528p pd=1.16u ps=0.68u
    I_MXI2_I3_I50_MN1 (XI2_I3_I50_n1 I2_XOR_4 VSS VSS) gpdk090_nmos1v w=0.24u l=0.1u ad=0.0528p as=0.0816p pd=0.68u ps=1.16u
    I_MXI2_I3_I50_MN0 (I2_I3_n4_2 I2_SEL_XOR XI2_I3_I50_n1 VSS) gpdk090_nmos1v w=0.24u l=0.1u ad=0.0816p as=0.0528p pd=1.16u ps=0.68u
    I_MXI1_I120_I6_MN1 (XI1_I120_I6_n1 I1_b6_6 VSS VSS) gpdk090_nmos1v w=0.24u l=0.1u ad=0.0528p as=0.0816p pd=0.68u ps=1.16u
    I_MXI1_I120_I6_MN0 (I1_I120_gn6 I1_p5_5 XI1_I120_I6_n1 VSS) gpdk090_nmos1v w=0.24u l=0.1u ad=0.0816p as=0.0528p pd=1.16u ps=0.68u
    I_MXI1_I120_I4_MN1 (XI1_I120_I4_n1 I1_b6_4 VSS VSS) gpdk090_nmos1v w=0.24u l=0.1u ad=0.0528p as=0.0816p pd=0.68u ps=1.16u
    I_MXI1_I120_I4_MN0 (I1_I120_gn4 I1_p5_3 XI1_I120_I4_n1 VSS) gpdk090_nmos1v w=0.24u l=0.1u ad=0.0816p as=0.0528p pd=1.16u ps=0.68u
    I_MXI1_I20_MN1 (XI1_I20_n1 B_0 VSS VSS) gpdk090_nmos1v w=0.24u l=0.1u ad=0.0528p as=0.0816p pd=0.68u ps=1.16u
    I_MXI1_I20_MN0 (I1_nbkn1 B_7 XI1_I20_n1 VSS) gpdk090_nmos1v w=0.24u l=0.1u ad=0.0816p as=0.0528p pd=1.16u ps=0.68u
    I_MXI2_I2_I0_MN1 (XI2_I2_I0_n1 B_0 VSS VSS) gpdk090_nmos1v w=0.24u l=0.1u ad=0.0528p as=0.0816p pd=0.68u ps=1.16u
    I_MXI2_I2_I0_MN0 (I2_I2_nand0 A_0 XI2_I2_I0_n1 VSS) gpdk090_nmos1v w=0.24u l=0.1u ad=0.0816p as=0.0528p pd=1.16u ps=0.68u
    I_MXI2_I3_I2_MN1 (XI2_I3_I2_n1 I2_XOR_0 VSS VSS) gpdk090_nmos1v w=0.24u l=0.1u ad=0.0528p as=0.0816p pd=0.68u ps=1.16u
    I_MXI2_I3_I2_MN0 (I2_I3_n0_2 I2_SEL_XOR XI2_I3_I2_n1 VSS) gpdk090_nmos1v w=0.24u l=0.1u ad=0.0816p as=0.0528p pd=1.16u ps=0.68u
    I_MXI2_I3_I19_MN1 (XI2_I3_I19_n1 I2_I3_n1_3 VSS VSS) gpdk090_nmos1v w=0.24u l=0.1u ad=0.0528p as=0.0816p pd=0.68u ps=1.16u
    I_MXI2_I3_I19_MN0 (I2_I3_o1_1 I2_I3_n1_2 XI2_I3_I19_n1 VSS) gpdk090_nmos1v w=0.24u l=0.1u ad=0.0816p as=0.0528p pd=1.16u ps=0.68u
    I_MXI2_I3_I15_MN1 (XI2_I3_I15_n1 I2_NOT_1 VSS VSS) gpdk090_nmos1v w=0.24u l=0.1u ad=0.0528p as=0.0816p pd=0.68u ps=1.16u
    I_MXI2_I3_I15_MN0 (I2_I3_n1_3 I2_SEL_NOT XI2_I3_I15_n1 VSS) gpdk090_nmos1v w=0.24u l=0.1u ad=0.0816p as=0.0528p pd=1.16u ps=0.68u
    I_MXI2_I2_I6_MN1 (XI2_I2_I6_n1 B_1 VSS VSS) gpdk090_nmos1v w=0.24u l=0.1u ad=0.0528p as=0.0816p pd=0.68u ps=1.16u
    I_MXI2_I2_I6_MN0 (I2_I2_nand1 A_1 XI2_I2_I6_n1 VSS) gpdk090_nmos1v w=0.24u l=0.1u ad=0.0816p as=0.0528p pd=1.16u ps=0.68u
    I_MXI2_I3_I14_MN1 (XI2_I3_I14_n1 I2_XOR_1 VSS VSS) gpdk090_nmos1v w=0.24u l=0.1u ad=0.0528p as=0.0816p pd=0.68u ps=1.16u
    I_MXI2_I3_I14_MN0 (I2_I3_n1_2 I2_SEL_XOR XI2_I3_I14_n1 VSS) gpdk090_nmos1v w=0.24u l=0.1u ad=0.0816p as=0.0528p pd=1.16u ps=0.68u
    I_MXI2_I3_I54_MN1 (XI2_I3_I54_n1 I2_I3_n4_1 VSS VSS) gpdk090_nmos1v w=0.24u l=0.1u ad=0.0528p as=0.0816p pd=0.68u ps=1.16u
    I_MXI2_I3_I54_MN0 (I2_I3_o4_0 I2_I3_n4_0 XI2_I3_I54_n1 VSS) gpdk090_nmos1v w=0.24u l=0.1u ad=0.0816p as=0.0528p pd=1.16u ps=0.68u
    I_MXI2_I3_I49_MN1 (XI2_I3_I49_n1 I2_OR_4 VSS VSS) gpdk090_nmos1v w=0.24u l=0.1u ad=0.0528p as=0.0816p pd=0.68u ps=1.16u
    I_MXI2_I3_I49_MN0 (I2_I3_n4_1 I2_SEL_OR XI2_I3_I49_n1 VSS) gpdk090_nmos1v w=0.24u l=0.1u ad=0.0816p as=0.0528p pd=1.16u ps=0.68u
    I_MXI2_I3_I48_MN1 (XI2_I3_I48_n1 I2_AND_4 VSS VSS) gpdk090_nmos1v w=0.24u l=0.1u ad=0.0528p as=0.0816p pd=0.68u ps=1.16u
    I_MXI2_I3_I48_MN0 (I2_I3_n4_0 I2_SEL_AND XI2_I3_I48_n1 VSS) gpdk090_nmos1v w=0.24u l=0.1u ad=0.0816p as=0.0528p pd=1.16u ps=0.68u
    I_MXI2_I2_I12_MN1 (XI2_I2_I12_n1 B_2 VSS VSS) gpdk090_nmos1v w=0.24u l=0.1u ad=0.0528p as=0.0816p pd=0.68u ps=1.16u
    I_MXI2_I2_I12_MN0 (I2_I2_nand2 A_2 XI2_I2_I12_n1 VSS) gpdk090_nmos1v w=0.24u l=0.1u ad=0.0816p as=0.0528p pd=1.16u ps=0.68u
    I_MXI2_I2_I24_MN1 (XI2_I2_I24_n1 B_4 VSS VSS) gpdk090_nmos1v w=0.24u l=0.1u ad=0.0528p as=0.0816p pd=0.68u ps=1.16u
    I_MXI2_I2_I24_MN0 (I2_I2_nand4 A_4 XI2_I2_I24_n1 VSS) gpdk090_nmos1v w=0.24u l=0.1u ad=0.0816p as=0.0528p pd=1.16u ps=0.68u
    I_MXI1_I120_I7_MN1 (XI1_I120_I7_n1 I1_b6_7 VSS VSS) gpdk090_nmos1v w=0.24u l=0.1u ad=0.0528p as=0.0816p pd=0.68u ps=1.16u
    I_MXI1_I120_I7_MN0 (I1_I120_gn7 I1_p5_6 XI1_I120_I7_n1 VSS) gpdk090_nmos1v w=0.24u l=0.1u ad=0.0816p as=0.0528p pd=1.16u ps=0.68u
    I_MXI1_I120_I5_MN1 (XI1_I120_I5_n1 I1_b6_5 VSS VSS) gpdk090_nmos1v w=0.24u l=0.1u ad=0.0528p as=0.0816p pd=0.68u ps=1.16u
    I_MXI1_I120_I5_MN0 (I1_I120_gn5 I1_p5_4 XI1_I120_I5_n1 VSS) gpdk090_nmos1v w=0.24u l=0.1u ad=0.0816p as=0.0528p pd=1.16u ps=0.68u
    I_MXI1_I108_I1_MN1 (XI1_I108_I1_n1 I1_b5_1 VSS VSS) gpdk090_nmos1v w=0.24u l=0.1u ad=0.0528p as=0.0816p pd=0.68u ps=1.16u
    I_MXI1_I108_I1_MN0 (I1_I108_gn1 I1_p4_0 XI1_I108_I1_n1 VSS) gpdk090_nmos1v w=0.24u l=0.1u ad=0.0816p as=0.0528p pd=1.16u ps=0.68u
    I_MXI1_I108_I0_MN1 (XI1_I108_I0_n1 I1_b5_0 VSS VSS) gpdk090_nmos1v w=0.24u l=0.1u ad=0.0528p as=0.0816p pd=0.68u ps=1.16u
    I_MXI1_I108_I0_MN0 (I1_I108_gn0 I1_aa2 XI1_I108_I0_n1 VSS) gpdk090_nmos1v w=0.24u l=0.1u ad=0.0816p as=0.0528p pd=1.16u ps=0.68u
    I_MXI1_I96_I0_MN1 (XI1_I96_I0_n1 I1_b4_0 VSS VSS) gpdk090_nmos1v w=0.24u l=0.1u ad=0.0528p as=0.0816p pd=0.68u ps=1.16u
    I_MXI1_I96_I0_MN0 (I1_I96_gn0 I1_aa3 XI1_I96_I0_n1 VSS) gpdk090_nmos1v w=0.24u l=0.1u ad=0.0816p as=0.0528p pd=1.16u ps=0.68u
    I_MXI1_I84_I0_MN1 (XI1_I84_I0_n1 I1_b3_0 VSS VSS) gpdk090_nmos1v w=0.24u l=0.1u ad=0.0528p as=0.0816p pd=0.68u ps=1.16u
    I_MXI1_I84_I0_MN0 (I1_I84_gn0 I1_aa4 XI1_I84_I0_n1 VSS) gpdk090_nmos1v w=0.24u l=0.1u ad=0.0816p as=0.0528p pd=1.16u ps=0.68u
    I_MXI1_I60_I0_MN1 (XI1_I60_I0_n1 I1_b1_0 VSS VSS) gpdk090_nmos1v w=0.24u l=0.1u ad=0.0528p as=0.0816p pd=0.68u ps=1.16u
    I_MXI1_I60_I0_MN0 (I1_I60_gn0 I1_aa6 XI1_I60_I0_n1 VSS) gpdk090_nmos1v w=0.24u l=0.1u ad=0.0816p as=0.0528p pd=1.16u ps=0.68u
    I_MXI2_I3_I1_MN1 (XI2_I3_I1_n1 I2_OR_0 VSS VSS) gpdk090_nmos1v w=0.24u l=0.1u ad=0.0528p as=0.0816p pd=0.68u ps=1.16u
    I_MXI2_I3_I1_MN0 (I2_I3_n0_1 I2_SEL_OR XI2_I3_I1_n1 VSS) gpdk090_nmos1v w=0.24u l=0.1u ad=0.0816p as=0.0528p pd=1.16u ps=0.68u
    I_MXI2_I3_I6_MN1 (XI2_I3_I6_n1 I2_I3_n0_1 VSS VSS) gpdk090_nmos1v w=0.24u l=0.1u ad=0.0528p as=0.0816p pd=0.68u ps=1.16u
    I_MXI2_I3_I6_MN0 (I2_I3_o0_0 I2_I3_n0_0 XI2_I3_I6_n1 VSS) gpdk090_nmos1v w=0.24u l=0.1u ad=0.0816p as=0.0528p pd=1.16u ps=0.68u
    I_MXI2_I3_I0_MN1 (XI2_I3_I0_n1 I2_AND_0 VSS VSS) gpdk090_nmos1v w=0.24u l=0.1u ad=0.0528p as=0.0816p pd=0.68u ps=1.16u
    I_MXI2_I3_I0_MN0 (I2_I3_n0_0 I2_SEL_AND XI2_I3_I0_n1 VSS) gpdk090_nmos1v w=0.24u l=0.1u ad=0.0816p as=0.0528p pd=1.16u ps=0.68u
    I_MXI2_I3_I13_MN1 (XI2_I3_I13_n1 I2_OR_1 VSS VSS) gpdk090_nmos1v w=0.24u l=0.1u ad=0.0528p as=0.0816p pd=0.68u ps=1.16u
    I_MXI2_I3_I13_MN0 (I2_I3_n1_1 I2_SEL_OR XI2_I3_I13_n1 VSS) gpdk090_nmos1v w=0.24u l=0.1u ad=0.0816p as=0.0528p pd=1.16u ps=0.68u
    I_MXI2_I3_I18_MN1 (XI2_I3_I18_n1 I2_I3_n1_1 VSS VSS) gpdk090_nmos1v w=0.24u l=0.1u ad=0.0528p as=0.0816p pd=0.68u ps=1.16u
    I_MXI2_I3_I18_MN0 (I2_I3_o1_0 I2_I3_n1_0 XI2_I3_I18_n1 VSS) gpdk090_nmos1v w=0.24u l=0.1u ad=0.0816p as=0.0528p pd=1.16u ps=0.68u
    I_MXI2_I3_I12_MN1 (XI2_I3_I12_n1 I2_AND_1 VSS VSS) gpdk090_nmos1v w=0.24u l=0.1u ad=0.0528p as=0.0816p pd=0.68u ps=1.16u
    I_MXI2_I3_I12_MN0 (I2_I3_n1_0 I2_SEL_AND XI2_I3_I12_n1 VSS) gpdk090_nmos1v w=0.24u l=0.1u ad=0.0816p as=0.0528p pd=1.16u ps=0.68u
    I_MXI2_I3_I27_MN1 (XI2_I3_I27_n1 I2_NOT_2 VSS VSS) gpdk090_nmos1v w=0.24u l=0.1u ad=0.0528p as=0.0816p pd=0.68u ps=1.16u
    I_MXI2_I3_I27_MN0 (I2_I3_n2_3 I2_SEL_NOT XI2_I3_I27_n1 VSS) gpdk090_nmos1v w=0.24u l=0.1u ad=0.0816p as=0.0528p pd=1.16u ps=0.68u
    I_MXI2_I3_I30_MN1 (XI2_I3_I30_n1 I2_I3_n2_1 VSS VSS) gpdk090_nmos1v w=0.24u l=0.1u ad=0.0528p as=0.0816p pd=0.68u ps=1.16u
    I_MXI2_I3_I30_MN0 (I2_I3_o2_0 I2_I3_n2_0 XI2_I3_I30_n1 VSS) gpdk090_nmos1v w=0.24u l=0.1u ad=0.0816p as=0.0528p pd=1.16u ps=0.68u
    I_MXI2_I3_I24_MN1 (XI2_I3_I24_n1 I2_AND_2 VSS VSS) gpdk090_nmos1v w=0.24u l=0.1u ad=0.0528p as=0.0816p pd=0.68u ps=1.16u
    I_MXI2_I3_I24_MN0 (I2_I3_n2_0 I2_SEL_AND XI2_I3_I24_n1 VSS) gpdk090_nmos1v w=0.24u l=0.1u ad=0.0816p as=0.0528p pd=1.16u ps=0.68u
    I_MXI2_I3_I31_MN1 (XI2_I3_I31_n1 I2_I3_n2_3 VSS VSS) gpdk090_nmos1v w=0.24u l=0.1u ad=0.0528p as=0.0816p pd=0.68u ps=1.16u
    I_MXI2_I3_I31_MN0 (I2_I3_o2_1 I2_I3_n2_2 XI2_I3_I31_n1 VSS) gpdk090_nmos1v w=0.24u l=0.1u ad=0.0816p as=0.0528p pd=1.16u ps=0.68u
    I_MXI2_I3_I26_MN1 (XI2_I3_I26_n1 I2_XOR_2 VSS VSS) gpdk090_nmos1v w=0.24u l=0.1u ad=0.0528p as=0.0816p pd=0.68u ps=1.16u
    I_MXI2_I3_I26_MN0 (I2_I3_n2_2 I2_SEL_XOR XI2_I3_I26_n1 VSS) gpdk090_nmos1v w=0.24u l=0.1u ad=0.0816p as=0.0528p pd=1.16u ps=0.68u
    I_MXI1_I108_I28_XP_MN1 (XI1_I108_I28_XP_n1 I1_I108_P2_1 VSS VSS) gpdk090_nmos1v w=0.24u l=0.1u ad=0.0528p as=0.0816p pd=0.68u ps=1.16u
    I_MXI1_I108_I28_XP_MN0 (I1_I108_P4_1n I1_I108_P4_3 XI1_I108_I28_XP_n1 VSS) gpdk090_nmos1v w=0.24u l=0.1u ad=0.0816p as=0.0528p pd=1.16u ps=0.68u
    I_MXI1_I108_I2_MN1 (XI1_I108_I2_n1 I1_b5_2 VSS VSS) gpdk090_nmos1v w=0.24u l=0.1u ad=0.0528p as=0.0816p pd=0.68u ps=1.16u
    I_MXI1_I108_I2_MN0 (I1_I108_gn2 I1_p4_1 XI1_I108_I2_n1 VSS) gpdk090_nmos1v w=0.24u l=0.1u ad=0.0816p as=0.0528p pd=1.16u ps=0.68u
    I_MXI1_I72_I0_MN1 (XI1_I72_I0_n1 I1_b2_0 VSS VSS) gpdk090_nmos1v w=0.24u l=0.1u ad=0.0528p as=0.0816p pd=0.68u ps=1.16u
    I_MXI1_I72_I0_MN0 (I1_I72_gn0 I1_aa5 XI1_I72_I0_n1 VSS) gpdk090_nmos1v w=0.24u l=0.1u ad=0.0816p as=0.0528p pd=1.16u ps=0.68u
    I_MXI1_I48_I0_MN1 (XI1_I48_I0_n1 I1_b0_0 VSS VSS) gpdk090_nmos1v w=0.24u l=0.1u ad=0.0528p as=0.0816p pd=0.68u ps=1.16u
    I_MXI1_I48_I0_MN0 (I1_I48_gn0 I1_aa7 XI1_I48_I0_n1 VSS) gpdk090_nmos1v w=0.24u l=0.1u ad=0.0816p as=0.0528p pd=1.16u ps=0.68u
    I_MXI1_I48_I2_MN1 (XI1_I48_I2_n1 I1_b0_2 VSS VSS) gpdk090_nmos1v w=0.24u l=0.1u ad=0.0528p as=0.0816p pd=0.68u ps=1.16u
    I_MXI1_I48_I2_MN0 (I1_I48_gn2 VSS XI1_I48_I2_n1 VSS) gpdk090_nmos1v w=0.24u l=0.1u ad=0.0816p as=0.0528p pd=1.16u ps=0.68u
    I_MXI2_I3_I25_MN1 (XI2_I3_I25_n1 I2_OR_2 VSS VSS) gpdk090_nmos1v w=0.24u l=0.1u ad=0.0528p as=0.0816p pd=0.68u ps=1.16u
    I_MXI2_I3_I25_MN0 (I2_I3_n2_1 I2_SEL_OR XI2_I3_I25_n1 VSS) gpdk090_nmos1v w=0.24u l=0.1u ad=0.0816p as=0.0528p pd=1.16u ps=0.68u
    I_MXI1_I48_I3_MN1 (XI1_I48_I3_n1 I1_b0_3 VSS VSS) gpdk090_nmos1v w=0.24u l=0.1u ad=0.0528p as=0.0816p pd=0.68u ps=1.16u
    I_MXI1_I48_I3_MN0 (I1_I48_gn3 VSS XI1_I48_I3_n1 VSS) gpdk090_nmos1v w=0.24u l=0.1u ad=0.0816p as=0.0528p pd=1.16u ps=0.68u
    I_MXI1_I108_I29_XP_MN1 (XI1_I108_I29_XP_n1 I1_I108_P3_2 VSS VSS) gpdk090_nmos1v w=0.24u l=0.1u ad=0.0528p as=0.0816p pd=0.68u ps=1.16u
    I_MXI1_I108_I29_XP_MN0 (I1_I108_P5_2n I1_I108_P5_4 XI1_I108_I29_XP_n1 VSS) gpdk090_nmos1v w=0.24u l=0.1u ad=0.0816p as=0.0528p pd=1.16u ps=0.68u
    I_MXI1_I108_I30_XP_MN1 (XI1_I108_I30_XP_n1 I1_I108_P4_3 VSS VSS) gpdk090_nmos1v w=0.24u l=0.1u ad=0.0528p as=0.0816p pd=0.68u ps=1.16u
    I_MXI1_I108_I30_XP_MN0 (I1_I108_P6_3n I1_I108_P6_5 XI1_I108_I30_XP_n1 VSS) gpdk090_nmos1v w=0.24u l=0.1u ad=0.0816p as=0.0528p pd=1.16u ps=0.68u
    I_MXI1_I108_I3_MN1 (XI1_I108_I3_n1 I1_b5_3 VSS VSS) gpdk090_nmos1v w=0.24u l=0.1u ad=0.0528p as=0.0816p pd=0.68u ps=1.16u
    I_MXI1_I108_I3_MN0 (I1_I108_gn3 I1_p4_2 XI1_I108_I3_n1 VSS) gpdk090_nmos1v w=0.24u l=0.1u ad=0.0816p as=0.0528p pd=1.16u ps=0.68u
    I_MXI1_I96_I2_MN1 (XI1_I96_I2_n1 I1_b4_2 VSS VSS) gpdk090_nmos1v w=0.24u l=0.1u ad=0.0528p as=0.0816p pd=0.68u ps=1.16u
    I_MXI1_I96_I2_MN0 (I1_I96_gn2 I1_p3_1 XI1_I96_I2_n1 VSS) gpdk090_nmos1v w=0.24u l=0.1u ad=0.0816p as=0.0528p pd=1.16u ps=0.68u
    I_MXI1_I96_I1_MN1 (XI1_I96_I1_n1 I1_b4_1 VSS VSS) gpdk090_nmos1v w=0.24u l=0.1u ad=0.0528p as=0.0816p pd=0.68u ps=1.16u
    I_MXI1_I96_I1_MN0 (I1_I96_gn1 I1_p3_0 XI1_I96_I1_n1 VSS) gpdk090_nmos1v w=0.24u l=0.1u ad=0.0816p as=0.0528p pd=1.16u ps=0.68u
    I_MXI1_I84_I1_MN1 (XI1_I84_I1_n1 I1_b3_1 VSS VSS) gpdk090_nmos1v w=0.24u l=0.1u ad=0.0528p as=0.0816p pd=0.68u ps=1.16u
    I_MXI1_I84_I1_MN0 (I1_I84_gn1 I1_p2_0 XI1_I84_I1_n1 VSS) gpdk090_nmos1v w=0.24u l=0.1u ad=0.0816p as=0.0528p pd=1.16u ps=0.68u
    I_MXI1_I84_I2_MN1 (XI1_I84_I2_n1 I1_b3_2 VSS VSS) gpdk090_nmos1v w=0.24u l=0.1u ad=0.0528p as=0.0816p pd=0.68u ps=1.16u
    I_MXI1_I84_I2_MN0 (I1_I84_gn2 I1_p2_1 XI1_I84_I2_n1 VSS) gpdk090_nmos1v w=0.24u l=0.1u ad=0.0816p as=0.0528p pd=1.16u ps=0.68u
    I_MXI1_I72_I1_MN1 (XI1_I72_I1_n1 I1_b2_1 VSS VSS) gpdk090_nmos1v w=0.24u l=0.1u ad=0.0528p as=0.0816p pd=0.68u ps=1.16u
    I_MXI1_I72_I1_MN0 (I1_I72_gn1 I1_p1_0 XI1_I72_I1_n1 VSS) gpdk090_nmos1v w=0.24u l=0.1u ad=0.0816p as=0.0528p pd=1.16u ps=0.68u
    I_MXI1_I72_I2_MN1 (XI1_I72_I2_n1 I1_b2_2 VSS VSS) gpdk090_nmos1v w=0.24u l=0.1u ad=0.0528p as=0.0816p pd=0.68u ps=1.16u
    I_MXI1_I72_I2_MN0 (I1_I72_gn2 I1_p1_1 XI1_I72_I2_n1 VSS) gpdk090_nmos1v w=0.24u l=0.1u ad=0.0816p as=0.0528p pd=1.16u ps=0.68u
    I_MXI1_I60_I1_MN1 (XI1_I60_I1_n1 I1_b1_1 VSS VSS) gpdk090_nmos1v w=0.24u l=0.1u ad=0.0528p as=0.0816p pd=0.68u ps=1.16u
    I_MXI1_I60_I1_MN0 (I1_I60_gn1 I1_p0_0 XI1_I60_I1_n1 VSS) gpdk090_nmos1v w=0.24u l=0.1u ad=0.0816p as=0.0528p pd=1.16u ps=0.68u
    I_MXI1_I60_I2_MN1 (XI1_I60_I2_n1 I1_b1_2 VSS VSS) gpdk090_nmos1v w=0.24u l=0.1u ad=0.0528p as=0.0816p pd=0.68u ps=1.16u
    I_MXI1_I60_I2_MN0 (I1_I60_gn2 I1_p0_1 XI1_I60_I2_n1 VSS) gpdk090_nmos1v w=0.24u l=0.1u ad=0.0816p as=0.0528p pd=1.16u ps=0.68u
    I_MXI1_I48_I1_MN1 (XI1_I48_I1_n1 I1_b0_1 VSS VSS) gpdk090_nmos1v w=0.24u l=0.1u ad=0.0528p as=0.0816p pd=0.68u ps=1.16u
    I_MXI1_I48_I1_MN0 (I1_I48_gn1 VSS XI1_I48_I1_n1 VSS) gpdk090_nmos1v w=0.24u l=0.1u ad=0.0816p as=0.0528p pd=1.16u ps=0.68u
    I_MXI1_I108_I31_XP_MN1 (XI1_I108_I31_XP_n1 I1_I108_P5_4 VSS VSS) gpdk090_nmos1v w=0.24u l=0.1u ad=0.0528p as=0.0816p pd=0.68u ps=1.16u
    I_MXI1_I108_I31_XP_MN0 (I1_I108_P7_4n I1_I108_P7_6 XI1_I108_I31_XP_n1 VSS) gpdk090_nmos1v w=0.24u l=0.1u ad=0.0816p as=0.0528p pd=1.16u ps=0.68u
    I_MXI1_I108_I4_MN1 (XI1_I108_I4_n1 I1_b5_4 VSS VSS) gpdk090_nmos1v w=0.24u l=0.1u ad=0.0528p as=0.0816p pd=0.68u ps=1.16u
    I_MXI1_I108_I4_MN0 (I1_I108_gn4 I1_p4_3 XI1_I108_I4_n1 VSS) gpdk090_nmos1v w=0.24u l=0.1u ad=0.0816p as=0.0528p pd=1.16u ps=0.68u
    I_MXI1_I96_I3_MN1 (XI1_I96_I3_n1 I1_b4_3 VSS VSS) gpdk090_nmos1v w=0.24u l=0.1u ad=0.0528p as=0.0816p pd=0.68u ps=1.16u
    I_MXI1_I96_I3_MN0 (I1_I96_gn3 I1_p3_2 XI1_I96_I3_n1 VSS) gpdk090_nmos1v w=0.24u l=0.1u ad=0.0816p as=0.0528p pd=1.16u ps=0.68u
    I_MXI1_I84_I28_XP_MN1 (XI1_I84_I28_XP_n1 I1_I84_P2_1 VSS VSS) gpdk090_nmos1v w=0.24u l=0.1u ad=0.0528p as=0.0816p pd=0.68u ps=1.16u
    I_MXI1_I84_I28_XP_MN0 (I1_I84_P4_1n I1_I84_P4_3 XI1_I84_I28_XP_n1 VSS) gpdk090_nmos1v w=0.24u l=0.1u ad=0.0816p as=0.0528p pd=1.16u ps=0.68u
    I_MXI1_I84_I3_MN1 (XI1_I84_I3_n1 I1_b3_3 VSS VSS) gpdk090_nmos1v w=0.24u l=0.1u ad=0.0528p as=0.0816p pd=0.68u ps=1.16u
    I_MXI1_I84_I3_MN0 (I1_I84_gn3 I1_p2_2 XI1_I84_I3_n1 VSS) gpdk090_nmos1v w=0.24u l=0.1u ad=0.0816p as=0.0528p pd=1.16u ps=0.68u
    I_MXI1_I72_I28_XP_MN1 (XI1_I72_I28_XP_n1 I1_I72_P2_1 VSS VSS) gpdk090_nmos1v w=0.24u l=0.1u ad=0.0528p as=0.0816p pd=0.68u ps=1.16u
    I_MXI1_I72_I28_XP_MN0 (I1_I72_P4_1n I1_I72_P4_3 XI1_I72_I28_XP_n1 VSS) gpdk090_nmos1v w=0.24u l=0.1u ad=0.0816p as=0.0528p pd=1.16u ps=0.68u
    I_MXI1_I72_I3_MN1 (XI1_I72_I3_n1 I1_b2_3 VSS VSS) gpdk090_nmos1v w=0.24u l=0.1u ad=0.0528p as=0.0816p pd=0.68u ps=1.16u
    I_MXI1_I72_I3_MN0 (I1_I72_gn3 I1_p1_2 XI1_I72_I3_n1 VSS) gpdk090_nmos1v w=0.24u l=0.1u ad=0.0816p as=0.0528p pd=1.16u ps=0.68u
    I_MXI1_I60_I28_XP_MN1 (XI1_I60_I28_XP_n1 I1_I60_P2_1 VSS VSS) gpdk090_nmos1v w=0.24u l=0.1u ad=0.0528p as=0.0816p pd=0.68u ps=1.16u
    I_MXI1_I60_I28_XP_MN0 (I1_I60_P4_1n I1_I60_P4_3 XI1_I60_I28_XP_n1 VSS) gpdk090_nmos1v w=0.24u l=0.1u ad=0.0816p as=0.0528p pd=1.16u ps=0.68u
    I_MXI1_I60_I3_MN1 (XI1_I60_I3_n1 I1_b1_3 VSS VSS) gpdk090_nmos1v w=0.24u l=0.1u ad=0.0528p as=0.0816p pd=0.68u ps=1.16u
    I_MXI1_I60_I3_MN0 (I1_I60_gn3 I1_p0_2 XI1_I60_I3_n1 VSS) gpdk090_nmos1v w=0.24u l=0.1u ad=0.0816p as=0.0528p pd=1.16u ps=0.68u
    I_MXI1_I48_I28_XP_MN1 (XI1_I48_I28_XP_n1 I1_I48_P2_1 VSS VSS) gpdk090_nmos1v w=0.24u l=0.1u ad=0.0528p as=0.0816p pd=0.68u ps=1.16u
    I_MXI1_I48_I28_XP_MN0 (I1_I48_P4_1n I1_I48_P4_3 XI1_I48_I28_XP_n1 VSS) gpdk090_nmos1v w=0.24u l=0.1u ad=0.0816p as=0.0528p pd=1.16u ps=0.68u
    I_MXI1_I48_I4_MN1 (XI1_I48_I4_n1 I1_b0_4 VSS VSS) gpdk090_nmos1v w=0.24u l=0.1u ad=0.0528p as=0.0816p pd=0.68u ps=1.16u
    I_MXI1_I48_I4_MN0 (I1_I48_gn4 VSS XI1_I48_I4_n1 VSS) gpdk090_nmos1v w=0.24u l=0.1u ad=0.0816p as=0.0528p pd=1.16u ps=0.68u
    I_MXI1_I108_I5_MN1 (XI1_I108_I5_n1 I1_b5_5 VSS VSS) gpdk090_nmos1v w=0.24u l=0.1u ad=0.0528p as=0.0816p pd=0.68u ps=1.16u
    I_MXI1_I108_I5_MN0 (I1_I108_gn5 I1_p4_4 XI1_I108_I5_n1 VSS) gpdk090_nmos1v w=0.24u l=0.1u ad=0.0816p as=0.0528p pd=1.16u ps=0.68u
    I_MXI1_I96_I28_XP_MN1 (XI1_I96_I28_XP_n1 I1_I96_P2_1 VSS VSS) gpdk090_nmos1v w=0.24u l=0.1u ad=0.0528p as=0.0816p pd=0.68u ps=1.16u
    I_MXI1_I96_I28_XP_MN0 (I1_I96_P4_1n I1_I96_P4_3 XI1_I96_I28_XP_n1 VSS) gpdk090_nmos1v w=0.24u l=0.1u ad=0.0816p as=0.0528p pd=1.16u ps=0.68u
    I_MXI1_I84_I4_MN1 (XI1_I84_I4_n1 I1_b3_4 VSS VSS) gpdk090_nmos1v w=0.24u l=0.1u ad=0.0528p as=0.0816p pd=0.68u ps=1.16u
    I_MXI1_I84_I4_MN0 (I1_I84_gn4 I1_p2_3 XI1_I84_I4_n1 VSS) gpdk090_nmos1v w=0.24u l=0.1u ad=0.0816p as=0.0528p pd=1.16u ps=0.68u
    I_MXI1_I72_I30_XP_MN1 (XI1_I72_I30_XP_n1 I1_I72_P4_3 VSS VSS) gpdk090_nmos1v w=0.24u l=0.1u ad=0.0528p as=0.0816p pd=0.68u ps=1.16u
    I_MXI1_I72_I30_XP_MN0 (I1_I72_P6_3n I1_I72_P6_5 XI1_I72_I30_XP_n1 VSS) gpdk090_nmos1v w=0.24u l=0.1u ad=0.0816p as=0.0528p pd=1.16u ps=0.68u
    I_MXI1_I72_I4_MN1 (XI1_I72_I4_n1 I1_b2_4 VSS VSS) gpdk090_nmos1v w=0.24u l=0.1u ad=0.0528p as=0.0816p pd=0.68u ps=1.16u
    I_MXI1_I72_I4_MN0 (I1_I72_gn4 I1_p1_3 XI1_I72_I4_n1 VSS) gpdk090_nmos1v w=0.24u l=0.1u ad=0.0816p as=0.0528p pd=1.16u ps=0.68u
    I_MXI1_I60_I30_XP_MN1 (XI1_I60_I30_XP_n1 I1_I60_P4_3 VSS VSS) gpdk090_nmos1v w=0.24u l=0.1u ad=0.0528p as=0.0816p pd=0.68u ps=1.16u
    I_MXI1_I60_I30_XP_MN0 (I1_I60_P6_3n I1_I60_P6_5 XI1_I60_I30_XP_n1 VSS) gpdk090_nmos1v w=0.24u l=0.1u ad=0.0816p as=0.0528p pd=1.16u ps=0.68u
    I_MXI1_I60_I4_MN1 (XI1_I60_I4_n1 I1_b1_4 VSS VSS) gpdk090_nmos1v w=0.24u l=0.1u ad=0.0528p as=0.0816p pd=0.68u ps=1.16u
    I_MXI1_I60_I4_MN0 (I1_I60_gn4 I1_p0_3 XI1_I60_I4_n1 VSS) gpdk090_nmos1v w=0.24u l=0.1u ad=0.0816p as=0.0528p pd=1.16u ps=0.68u
    I_MXI1_I48_I30_XP_MN1 (XI1_I48_I30_XP_n1 I1_I48_P4_3 VSS VSS) gpdk090_nmos1v w=0.24u l=0.1u ad=0.0528p as=0.0816p pd=0.68u ps=1.16u
    I_MXI1_I48_I30_XP_MN0 (I1_I48_P6_3n I1_I48_P6_5 XI1_I48_I30_XP_n1 VSS) gpdk090_nmos1v w=0.24u l=0.1u ad=0.0816p as=0.0528p pd=1.16u ps=0.68u
    I_MXI1_I48_I29_XP_MN1 (XI1_I48_I29_XP_n1 I1_I48_P3_2 VSS VSS) gpdk090_nmos1v w=0.24u l=0.1u ad=0.0528p as=0.0816p pd=0.68u ps=1.16u
    I_MXI1_I48_I29_XP_MN0 (I1_I48_P5_2n I1_I48_P5_4 XI1_I48_I29_XP_n1 VSS) gpdk090_nmos1v w=0.24u l=0.1u ad=0.0816p as=0.0528p pd=1.16u ps=0.68u
    I_MXI1_I108_I6_MN1 (XI1_I108_I6_n1 I1_b5_6 VSS VSS) gpdk090_nmos1v w=0.24u l=0.1u ad=0.0528p as=0.0816p pd=0.68u ps=1.16u
    I_MXI1_I108_I6_MN0 (I1_I108_gn6 I1_p4_5 XI1_I108_I6_n1 VSS) gpdk090_nmos1v w=0.24u l=0.1u ad=0.0816p as=0.0528p pd=1.16u ps=0.68u
    I_MXI1_I96_I29_XP_MN1 (XI1_I96_I29_XP_n1 I1_I96_P3_2 VSS VSS) gpdk090_nmos1v w=0.24u l=0.1u ad=0.0528p as=0.0816p pd=0.68u ps=1.16u
    I_MXI1_I96_I29_XP_MN0 (I1_I96_P5_2n I1_I96_P5_4 XI1_I96_I29_XP_n1 VSS) gpdk090_nmos1v w=0.24u l=0.1u ad=0.0816p as=0.0528p pd=1.16u ps=0.68u
    I_MXI1_I96_I30_XP_MN1 (XI1_I96_I30_XP_n1 I1_I96_P4_3 VSS VSS) gpdk090_nmos1v w=0.24u l=0.1u ad=0.0528p as=0.0816p pd=0.68u ps=1.16u
    I_MXI1_I96_I30_XP_MN0 (I1_I96_P6_3n I1_I96_P6_5 XI1_I96_I30_XP_n1 VSS) gpdk090_nmos1v w=0.24u l=0.1u ad=0.0816p as=0.0528p pd=1.16u ps=0.68u
    I_MXI1_I96_I4_MN1 (XI1_I96_I4_n1 I1_b4_4 VSS VSS) gpdk090_nmos1v w=0.24u l=0.1u ad=0.0528p as=0.0816p pd=0.68u ps=1.16u
    I_MXI1_I96_I4_MN0 (I1_I96_gn4 I1_p3_3 XI1_I96_I4_n1 VSS) gpdk090_nmos1v w=0.24u l=0.1u ad=0.0816p as=0.0528p pd=1.16u ps=0.68u
    I_MXI1_I84_I29_XP_MN1 (XI1_I84_I29_XP_n1 I1_I84_P3_2 VSS VSS) gpdk090_nmos1v w=0.24u l=0.1u ad=0.0528p as=0.0816p pd=0.68u ps=1.16u
    I_MXI1_I84_I29_XP_MN0 (I1_I84_P5_2n I1_I84_P5_4 XI1_I84_I29_XP_n1 VSS) gpdk090_nmos1v w=0.24u l=0.1u ad=0.0816p as=0.0528p pd=1.16u ps=0.68u
    I_MXI1_I84_I30_XP_MN1 (XI1_I84_I30_XP_n1 I1_I84_P4_3 VSS VSS) gpdk090_nmos1v w=0.24u l=0.1u ad=0.0528p as=0.0816p pd=0.68u ps=1.16u
    I_MXI1_I84_I30_XP_MN0 (I1_I84_P6_3n I1_I84_P6_5 XI1_I84_I30_XP_n1 VSS) gpdk090_nmos1v w=0.24u l=0.1u ad=0.0816p as=0.0528p pd=1.16u ps=0.68u
    I_MXI1_I84_I5_MN1 (XI1_I84_I5_n1 I1_b3_5 VSS VSS) gpdk090_nmos1v w=0.24u l=0.1u ad=0.0528p as=0.0816p pd=0.68u ps=1.16u
    I_MXI1_I84_I5_MN0 (I1_I84_gn5 I1_p2_4 XI1_I84_I5_n1 VSS) gpdk090_nmos1v w=0.24u l=0.1u ad=0.0816p as=0.0528p pd=1.16u ps=0.68u
    I_MXI1_I72_I6_MN1 (XI1_I72_I6_n1 I1_b2_6 VSS VSS) gpdk090_nmos1v w=0.24u l=0.1u ad=0.0528p as=0.0816p pd=0.68u ps=1.16u
    I_MXI1_I72_I6_MN0 (I1_I72_gn6 I1_p1_5 XI1_I72_I6_n1 VSS) gpdk090_nmos1v w=0.24u l=0.1u ad=0.0816p as=0.0528p pd=1.16u ps=0.68u
    I_MXI1_I72_I5_MN1 (XI1_I72_I5_n1 I1_b2_5 VSS VSS) gpdk090_nmos1v w=0.24u l=0.1u ad=0.0528p as=0.0816p pd=0.68u ps=1.16u
    I_MXI1_I72_I5_MN0 (I1_I72_gn5 I1_p1_4 XI1_I72_I5_n1 VSS) gpdk090_nmos1v w=0.24u l=0.1u ad=0.0816p as=0.0528p pd=1.16u ps=0.68u
    I_MXI1_I60_I5_MN1 (XI1_I60_I5_n1 I1_b1_5 VSS VSS) gpdk090_nmos1v w=0.24u l=0.1u ad=0.0528p as=0.0816p pd=0.68u ps=1.16u
    I_MXI1_I60_I5_MN0 (I1_I60_gn5 I1_p0_4 XI1_I60_I5_n1 VSS) gpdk090_nmos1v w=0.24u l=0.1u ad=0.0816p as=0.0528p pd=1.16u ps=0.68u
    I_MXI1_I48_I5_MN1 (XI1_I48_I5_n1 I1_b0_5 VSS VSS) gpdk090_nmos1v w=0.24u l=0.1u ad=0.0528p as=0.0816p pd=0.68u ps=1.16u
    I_MXI1_I48_I5_MN0 (I1_I48_gn5 VSS XI1_I48_I5_n1 VSS) gpdk090_nmos1v w=0.24u l=0.1u ad=0.0816p as=0.0528p pd=1.16u ps=0.68u
    I_MXI1_I108_I7_MN1 (XI1_I108_I7_n1 I1_b5_7 VSS VSS) gpdk090_nmos1v w=0.24u l=0.1u ad=0.0528p as=0.0816p pd=0.68u ps=1.16u
    I_MXI1_I108_I7_MN0 (I1_I108_gn7 I1_p4_6 XI1_I108_I7_n1 VSS) gpdk090_nmos1v w=0.24u l=0.1u ad=0.0816p as=0.0528p pd=1.16u ps=0.68u
    I_MXI1_I96_I31_XP_MN1 (XI1_I96_I31_XP_n1 I1_I96_P5_4 VSS VSS) gpdk090_nmos1v w=0.24u l=0.1u ad=0.0528p as=0.0816p pd=0.68u ps=1.16u
    I_MXI1_I96_I31_XP_MN0 (I1_I96_P7_4n I1_I96_P7_6 XI1_I96_I31_XP_n1 VSS) gpdk090_nmos1v w=0.24u l=0.1u ad=0.0816p as=0.0528p pd=1.16u ps=0.68u
    I_MXI1_I96_I6_MN1 (XI1_I96_I6_n1 I1_b4_6 VSS VSS) gpdk090_nmos1v w=0.24u l=0.1u ad=0.0528p as=0.0816p pd=0.68u ps=1.16u
    I_MXI1_I96_I6_MN0 (I1_I96_gn6 I1_p3_5 XI1_I96_I6_n1 VSS) gpdk090_nmos1v w=0.24u l=0.1u ad=0.0816p as=0.0528p pd=1.16u ps=0.68u
    I_MXI1_I96_I5_MN1 (XI1_I96_I5_n1 I1_b4_5 VSS VSS) gpdk090_nmos1v w=0.24u l=0.1u ad=0.0528p as=0.0816p pd=0.68u ps=1.16u
    I_MXI1_I96_I5_MN0 (I1_I96_gn5 I1_p3_4 XI1_I96_I5_n1 VSS) gpdk090_nmos1v w=0.24u l=0.1u ad=0.0816p as=0.0528p pd=1.16u ps=0.68u
    I_MXI1_I84_I31_XP_MN1 (XI1_I84_I31_XP_n1 I1_I84_P5_4 VSS VSS) gpdk090_nmos1v w=0.24u l=0.1u ad=0.0528p as=0.0816p pd=0.68u ps=1.16u
    I_MXI1_I84_I31_XP_MN0 (I1_I84_P7_4n I1_I84_P7_6 XI1_I84_I31_XP_n1 VSS) gpdk090_nmos1v w=0.24u l=0.1u ad=0.0816p as=0.0528p pd=1.16u ps=0.68u
    I_MXI1_I84_I7_MN1 (XI1_I84_I7_n1 I1_b3_7 VSS VSS) gpdk090_nmos1v w=0.24u l=0.1u ad=0.0528p as=0.0816p pd=0.68u ps=1.16u
    I_MXI1_I84_I7_MN0 (I1_I84_gn7 I1_p2_6 XI1_I84_I7_n1 VSS) gpdk090_nmos1v w=0.24u l=0.1u ad=0.0816p as=0.0528p pd=1.16u ps=0.68u
    I_MXI1_I84_I6_MN1 (XI1_I84_I6_n1 I1_b3_6 VSS VSS) gpdk090_nmos1v w=0.24u l=0.1u ad=0.0528p as=0.0816p pd=0.68u ps=1.16u
    I_MXI1_I84_I6_MN0 (I1_I84_gn6 I1_p2_5 XI1_I84_I6_n1 VSS) gpdk090_nmos1v w=0.24u l=0.1u ad=0.0816p as=0.0528p pd=1.16u ps=0.68u
    I_MXI1_I72_I29_XP_MN1 (XI1_I72_I29_XP_n1 I1_I72_P3_2 VSS VSS) gpdk090_nmos1v w=0.24u l=0.1u ad=0.0528p as=0.0816p pd=0.68u ps=1.16u
    I_MXI1_I72_I29_XP_MN0 (I1_I72_P5_2n I1_I72_P5_4 XI1_I72_I29_XP_n1 VSS) gpdk090_nmos1v w=0.24u l=0.1u ad=0.0816p as=0.0528p pd=1.16u ps=0.68u
    I_MXI1_I72_I31_XP_MN1 (XI1_I72_I31_XP_n1 I1_I72_P5_4 VSS VSS) gpdk090_nmos1v w=0.24u l=0.1u ad=0.0528p as=0.0816p pd=0.68u ps=1.16u
    I_MXI1_I72_I31_XP_MN0 (I1_I72_P7_4n I1_I72_P7_6 XI1_I72_I31_XP_n1 VSS) gpdk090_nmos1v w=0.24u l=0.1u ad=0.0816p as=0.0528p pd=1.16u ps=0.68u
    I_MXI1_I60_I29_XP_MN1 (XI1_I60_I29_XP_n1 I1_I60_P3_2 VSS VSS) gpdk090_nmos1v w=0.24u l=0.1u ad=0.0528p as=0.0816p pd=0.68u ps=1.16u
    I_MXI1_I60_I29_XP_MN0 (I1_I60_P5_2n I1_I60_P5_4 XI1_I60_I29_XP_n1 VSS) gpdk090_nmos1v w=0.24u l=0.1u ad=0.0816p as=0.0528p pd=1.16u ps=0.68u
    I_MXI1_I60_I31_XP_MN1 (XI1_I60_I31_XP_n1 I1_I60_P5_4 VSS VSS) gpdk090_nmos1v w=0.24u l=0.1u ad=0.0528p as=0.0816p pd=0.68u ps=1.16u
    I_MXI1_I60_I31_XP_MN0 (I1_I60_P7_4n I1_I60_P7_6 XI1_I60_I31_XP_n1 VSS) gpdk090_nmos1v w=0.24u l=0.1u ad=0.0816p as=0.0528p pd=1.16u ps=0.68u
    I_MXI1_I60_I6_MN1 (XI1_I60_I6_n1 I1_b1_6 VSS VSS) gpdk090_nmos1v w=0.24u l=0.1u ad=0.0528p as=0.0816p pd=0.68u ps=1.16u
    I_MXI1_I60_I6_MN0 (I1_I60_gn6 I1_p0_5 XI1_I60_I6_n1 VSS) gpdk090_nmos1v w=0.24u l=0.1u ad=0.0816p as=0.0528p pd=1.16u ps=0.68u
    I_MXI1_I48_I6_MN1 (XI1_I48_I6_n1 I1_b0_6 VSS VSS) gpdk090_nmos1v w=0.24u l=0.1u ad=0.0528p as=0.0816p pd=0.68u ps=1.16u
    I_MXI1_I48_I6_MN0 (I1_I48_gn6 VSS XI1_I48_I6_n1 VSS) gpdk090_nmos1v w=0.24u l=0.1u ad=0.0816p as=0.0528p pd=1.16u ps=0.68u
    I_MXI1_I48_I31_XP_MN1 (XI1_I48_I31_XP_n1 I1_I48_P5_4 VSS VSS) gpdk090_nmos1v w=0.24u l=0.1u ad=0.0528p as=0.0816p pd=0.68u ps=1.16u
    I_MXI1_I48_I31_XP_MN0 (I1_I48_P7_4n I1_I48_P7_6 XI1_I48_I31_XP_n1 VSS) gpdk090_nmos1v w=0.24u l=0.1u ad=0.0816p as=0.0528p pd=1.16u ps=0.68u
    I_MXI1_I96_I7_MN1 (XI1_I96_I7_n1 I1_b4_7 VSS VSS) gpdk090_nmos1v w=0.24u l=0.1u ad=0.0528p as=0.0816p pd=0.68u ps=1.16u
    I_MXI1_I96_I7_MN0 (I1_I96_gn7 I1_p3_6 XI1_I96_I7_n1 VSS) gpdk090_nmos1v w=0.24u l=0.1u ad=0.0816p as=0.0528p pd=1.16u ps=0.68u
    I_MXI1_I72_I7_MN1 (XI1_I72_I7_n1 I1_b2_7 VSS VSS) gpdk090_nmos1v w=0.24u l=0.1u ad=0.0528p as=0.0816p pd=0.68u ps=1.16u
    I_MXI1_I72_I7_MN0 (I1_I72_gn7 I1_p1_6 XI1_I72_I7_n1 VSS) gpdk090_nmos1v w=0.24u l=0.1u ad=0.0816p as=0.0528p pd=1.16u ps=0.68u
    I_MXI1_I60_I7_MN1 (XI1_I60_I7_n1 I1_b1_7 VSS VSS) gpdk090_nmos1v w=0.24u l=0.1u ad=0.0528p as=0.0816p pd=0.68u ps=1.16u
    I_MXI1_I60_I7_MN0 (I1_I60_gn7 I1_p0_6 XI1_I60_I7_n1 VSS) gpdk090_nmos1v w=0.24u l=0.1u ad=0.0816p as=0.0528p pd=1.16u ps=0.68u
    I_MXI1_I48_I7_MN1 (XI1_I48_I7_n1 I1_b0_7 VSS VSS) gpdk090_nmos1v w=0.24u l=0.1u ad=0.0528p as=0.0816p pd=0.68u ps=1.16u
    I_MXI1_I48_I7_MN0 (I1_I48_gn7 VSS XI1_I48_I7_n1 VSS) gpdk090_nmos1v w=0.24u l=0.1u ad=0.0816p as=0.0528p pd=1.16u ps=0.68u
    I_MXI2_I4_I7_MN0 (I2_I4_za7 Y_14 VSS VSS) gpdk090_nmos1v w=0.12u l=0.1u ad=0.0408p as=0.0696p pd=0.68u ps=1.16u
    I_MXI2_I4_I7_MN1 (VSS Y_15 I2_I4_za7 VSS) gpdk090_nmos1v w=0.12u l=0.1u ad=0.0696p as=0.0408p pd=1.16u ps=0.68u
    I_MXI0_I77_I25_XP_MN0 (I0_I77_P7_6 I0_I77_pn7 VSS VSS) gpdk090_nmos1v w=0.12u l=0.1u ad=0.0408p as=0.0696p pd=0.68u ps=1.16u
    I_MXI0_I77_I25_XP_MN1 (VSS I0_I77_pn6 I0_I77_P7_6 VSS) gpdk090_nmos1v w=0.12u l=0.1u ad=0.0696p as=0.0408p pd=1.16u ps=0.68u
    I_MXI2_I4_I6_MN0 (I2_I4_za6 Y_12 VSS VSS) gpdk090_nmos1v w=0.12u l=0.1u ad=0.0408p as=0.0696p pd=0.68u ps=1.16u
    I_MXI2_I4_I6_MN1 (VSS Y_13 I2_I4_za6 VSS) gpdk090_nmos1v w=0.12u l=0.1u ad=0.0696p as=0.0408p pd=1.16u ps=0.68u
    I_MXI2_I4_I5_MN0 (I2_I4_za5 Y_10 VSS VSS) gpdk090_nmos1v w=0.12u l=0.1u ad=0.0408p as=0.0696p pd=0.68u ps=1.16u
    I_MXI2_I4_I5_MN1 (VSS Y_11 I2_I4_za5 VSS) gpdk090_nmos1v w=0.12u l=0.1u ad=0.0696p as=0.0408p pd=1.16u ps=0.68u
    I_MXI2_I4_I13_MN0 (I2_I4_zc1 I2_I4_zb2 VSS VSS) gpdk090_nmos1v w=0.12u l=0.1u ad=0.0408p as=0.0696p pd=0.68u ps=1.16u
    I_MXI2_I4_I13_MN1 (VSS I2_I4_zb3 I2_I4_zc1 VSS) gpdk090_nmos1v w=0.12u l=0.1u ad=0.0696p as=0.0408p pd=1.16u ps=0.68u
    I_MXI0_I77_I24_XP_MN0 (I0_I77_P6_5 I0_I77_pn6 VSS VSS) gpdk090_nmos1v w=0.12u l=0.1u ad=0.0408p as=0.0696p pd=0.68u ps=1.16u
    I_MXI0_I77_I24_XP_MN1 (VSS I0_I77_pn5 I0_I77_P6_5 VSS) gpdk090_nmos1v w=0.12u l=0.1u ad=0.0696p as=0.0408p pd=1.16u ps=0.68u
    I_MXI0_I77_I23_XP_MN0 (I0_I77_P5_4 I0_I77_pn5 VSS VSS) gpdk090_nmos1v w=0.12u l=0.1u ad=0.0408p as=0.0696p pd=0.68u ps=1.16u
    I_MXI0_I77_I23_XP_MN1 (VSS I0_I77_pn4 I0_I77_P5_4 VSS) gpdk090_nmos1v w=0.12u l=0.1u ad=0.0696p as=0.0408p pd=1.16u ps=0.68u
    I_MXI2_I0_I17_MN0 (I2_SEL_DIV I2_I0_h10 VSS VSS) gpdk090_nmos1v w=0.12u l=0.1u ad=0.0408p as=0.0696p pd=0.68u ps=1.16u
    I_MXI2_I0_I17_MN1 (VSS I2_I0_l11 I2_SEL_DIV VSS) gpdk090_nmos1v w=0.12u l=0.1u ad=0.0696p as=0.0408p pd=1.16u ps=0.68u
    I_MXI2_I0_I16_MN0 (I2_SEL_MUL I2_I0_h10 VSS VSS) gpdk090_nmos1v w=0.12u l=0.1u ad=0.0408p as=0.0696p pd=0.68u ps=1.16u
    I_MXI2_I0_I16_MN1 (VSS I2_I0_l01 I2_SEL_MUL VSS) gpdk090_nmos1v w=0.12u l=0.1u ad=0.0696p as=0.0408p pd=1.16u ps=0.68u
    I_MXI2_I0_I15_MN0 (I2_SEL_NOT I2_I0_h01 VSS VSS) gpdk090_nmos1v w=0.12u l=0.1u ad=0.0408p as=0.0696p pd=0.68u ps=1.16u
    I_MXI2_I0_I15_MN1 (VSS I2_I0_l01 I2_SEL_NOT VSS) gpdk090_nmos1v w=0.12u l=0.1u ad=0.0696p as=0.0408p pd=1.16u ps=0.68u
    I_MXI2_I0_I14_MN0 (I2_SEL_XOR I2_I0_h01 VSS VSS) gpdk090_nmos1v w=0.12u l=0.1u ad=0.0408p as=0.0696p pd=0.68u ps=1.16u
    I_MXI2_I0_I14_MN1 (VSS I2_I0_l00 I2_SEL_XOR VSS) gpdk090_nmos1v w=0.12u l=0.1u ad=0.0696p as=0.0408p pd=1.16u ps=0.68u
    I_MXI0_I77_I22_XP_MN0 (I0_I77_P4_3 I0_I77_pn4 VSS VSS) gpdk090_nmos1v w=0.12u l=0.1u ad=0.0408p as=0.0696p pd=0.68u ps=1.16u
    I_MXI0_I77_I22_XP_MN1 (VSS I0_I77_pn3 I0_I77_P4_3 VSS) gpdk090_nmos1v w=0.12u l=0.1u ad=0.0696p as=0.0408p pd=1.16u ps=0.68u
    I_MXI0_I77_I21_XP_MN0 (I0_I77_P3_2 I0_I77_pn3 VSS VSS) gpdk090_nmos1v w=0.12u l=0.1u ad=0.0408p as=0.0696p pd=0.68u ps=1.16u
    I_MXI0_I77_I21_XP_MN1 (VSS I0_I77_pn2 I0_I77_P3_2 VSS) gpdk090_nmos1v w=0.12u l=0.1u ad=0.0696p as=0.0408p pd=1.16u ps=0.68u
    I_MXI2_I2_I44_MN0 (I2_I2_nor7 A_7 VSS VSS) gpdk090_nmos1v w=0.12u l=0.1u ad=0.0408p as=0.0696p pd=0.68u ps=1.16u
    I_MXI2_I2_I44_MN1 (VSS B_7 I2_I2_nor7 VSS) gpdk090_nmos1v w=0.12u l=0.1u ad=0.0696p as=0.0408p pd=1.16u ps=0.68u
    I_MXI2_I3_I93_MN0 (I2_I3_q7_1 I2_I3_o7_0 VSS VSS) gpdk090_nmos1v w=0.12u l=0.1u ad=0.0408p as=0.0696p pd=0.68u ps=1.16u
    I_MXI2_I3_I93_MN1 (VSS I2_I3_o7_1 I2_I3_q7_1 VSS) gpdk090_nmos1v w=0.12u l=0.1u ad=0.0696p as=0.0408p pd=1.16u ps=0.68u
    I_MXI2_I0_I13_MN0 (I2_SEL_OR I2_I0_h00 VSS VSS) gpdk090_nmos1v w=0.12u l=0.1u ad=0.0408p as=0.0696p pd=0.68u ps=1.16u
    I_MXI2_I0_I13_MN1 (VSS I2_I0_l11 I2_SEL_OR VSS) gpdk090_nmos1v w=0.12u l=0.1u ad=0.0696p as=0.0408p pd=1.16u ps=0.68u
    I_MXI2_I0_I11_MN0 (I2_SEL_AS I2_I0_h00 VSS VSS) gpdk090_nmos1v w=0.12u l=0.1u ad=0.0408p as=0.0696p pd=0.68u ps=1.16u
    I_MXI2_I0_I11_MN1 (VSS OP_1 I2_SEL_AS VSS) gpdk090_nmos1v w=0.12u l=0.1u ad=0.0696p as=0.0408p pd=1.16u ps=0.68u
    I_MXI2_I0_I12_MN0 (I2_SEL_AND I2_I0_h00 VSS VSS) gpdk090_nmos1v w=0.12u l=0.1u ad=0.0408p as=0.0696p pd=0.68u ps=1.16u
    I_MXI2_I0_I12_MN1 (VSS I2_I0_l10 I2_SEL_AND VSS) gpdk090_nmos1v w=0.12u l=0.1u ad=0.0696p as=0.0408p pd=1.16u ps=0.68u
    I_MXI1_I152_I25_XP_MN0 (I1_I152_P7_6 I1_I152_pn7 VSS VSS) gpdk090_nmos1v w=0.12u l=0.1u ad=0.0408p as=0.0696p pd=0.68u ps=1.16u
    I_MXI1_I152_I25_XP_MN1 (VSS I1_I152_pn6 I1_I152_P7_6 VSS) gpdk090_nmos1v w=0.12u l=0.1u ad=0.0696p as=0.0408p pd=1.16u ps=0.68u
    I_MXI1_I152_I23_XP_MN0 (I1_I152_P5_4 I1_I152_pn5 VSS VSS) gpdk090_nmos1v w=0.12u l=0.1u ad=0.0408p as=0.0696p pd=0.68u ps=1.16u
    I_MXI1_I152_I23_XP_MN1 (VSS I1_I152_pn4 I1_I152_P5_4 VSS) gpdk090_nmos1v w=0.12u l=0.1u ad=0.0696p as=0.0408p pd=1.16u ps=0.68u
    I_MXI1_I152_I21_XP_MN0 (I1_I152_P3_2 I1_I152_pn3 VSS VSS) gpdk090_nmos1v w=0.12u l=0.1u ad=0.0408p as=0.0696p pd=0.68u ps=1.16u
    I_MXI1_I152_I21_XP_MN1 (VSS I1_I152_pn2 I1_I152_P3_2 VSS) gpdk090_nmos1v w=0.12u l=0.1u ad=0.0696p as=0.0408p pd=1.16u ps=0.68u
    I_MXI2_I4_I4_MN0 (I2_I4_za4 Y_8 VSS VSS) gpdk090_nmos1v w=0.12u l=0.1u ad=0.0408p as=0.0696p pd=0.68u ps=1.16u
    I_MXI2_I4_I4_MN1 (VSS Y_9 I2_I4_za4 VSS) gpdk090_nmos1v w=0.12u l=0.1u ad=0.0696p as=0.0408p pd=1.16u ps=0.68u
    I_MXI0_I77_I20_XP_MN0 (I0_I77_P2_1 I0_I77_pn2 VSS VSS) gpdk090_nmos1v w=0.12u l=0.1u ad=0.0408p as=0.0696p pd=0.68u ps=1.16u
    I_MXI0_I77_I20_XP_MN1 (VSS I0_I77_pn1 I0_I77_P2_1 VSS) gpdk090_nmos1v w=0.12u l=0.1u ad=0.0696p as=0.0408p pd=1.16u ps=0.68u
    I_MXI2_I3_I81_MN0 (I2_I3_q6_1 I2_I3_o6_0 VSS VSS) gpdk090_nmos1v w=0.12u l=0.1u ad=0.0408p as=0.0696p pd=0.68u ps=1.16u
    I_MXI2_I3_I81_MN1 (VSS I2_I3_o6_1 I2_I3_q6_1 VSS) gpdk090_nmos1v w=0.12u l=0.1u ad=0.0696p as=0.0408p pd=1.16u ps=0.68u
    I_MXI2_I3_I69_MN0 (I2_I3_q5_1 I2_I3_o5_0 VSS VSS) gpdk090_nmos1v w=0.12u l=0.1u ad=0.0408p as=0.0696p pd=0.68u ps=1.16u
    I_MXI2_I3_I69_MN1 (VSS I2_I3_o5_1 I2_I3_q5_1 VSS) gpdk090_nmos1v w=0.12u l=0.1u ad=0.0696p as=0.0408p pd=1.16u ps=0.68u
    I_MXI2_I3_I45_MN0 (I2_I3_q3_1 I2_I3_o3_0 VSS VSS) gpdk090_nmos1v w=0.12u l=0.1u ad=0.0408p as=0.0696p pd=0.68u ps=1.16u
    I_MXI2_I3_I45_MN1 (VSS I2_I3_o3_1 I2_I3_q3_1 VSS) gpdk090_nmos1v w=0.12u l=0.1u ad=0.0696p as=0.0408p pd=1.16u ps=0.68u
    I_MXI2_I2_I32_MN0 (I2_I2_nor5 A_5 VSS VSS) gpdk090_nmos1v w=0.12u l=0.1u ad=0.0408p as=0.0696p pd=0.68u ps=1.16u
    I_MXI2_I2_I32_MN1 (VSS B_5 I2_I2_nor5 VSS) gpdk090_nmos1v w=0.12u l=0.1u ad=0.0696p as=0.0408p pd=1.16u ps=0.68u
    I_MXI1_I152_I24_XP_MN0 (I1_I152_P6_5 I1_I152_pn6 VSS VSS) gpdk090_nmos1v w=0.12u l=0.1u ad=0.0408p as=0.0696p pd=0.68u ps=1.16u
    I_MXI1_I152_I24_XP_MN1 (VSS I1_I152_pn5 I1_I152_P6_5 VSS) gpdk090_nmos1v w=0.12u l=0.1u ad=0.0696p as=0.0408p pd=1.16u ps=0.68u
    I_MXI1_I152_I22_XP_MN0 (I1_I152_P4_3 I1_I152_pn4 VSS VSS) gpdk090_nmos1v w=0.12u l=0.1u ad=0.0408p as=0.0696p pd=0.68u ps=1.16u
    I_MXI1_I152_I22_XP_MN1 (VSS I1_I152_pn3 I1_I152_P4_3 VSS) gpdk090_nmos1v w=0.12u l=0.1u ad=0.0696p as=0.0408p pd=1.16u ps=0.68u
    I_MXI1_I152_I20_XP_MN0 (I1_I152_P2_1 I1_I152_pn2 VSS VSS) gpdk090_nmos1v w=0.12u l=0.1u ad=0.0408p as=0.0696p pd=0.68u ps=1.16u
    I_MXI1_I152_I20_XP_MN1 (VSS I1_I152_pn1 I1_I152_P2_1 VSS) gpdk090_nmos1v w=0.12u l=0.1u ad=0.0696p as=0.0408p pd=1.16u ps=0.68u
    I_MXI2_I2_I38_MN0 (I2_I2_nor6 A_6 VSS VSS) gpdk090_nmos1v w=0.12u l=0.1u ad=0.0408p as=0.0696p pd=0.68u ps=1.16u
    I_MXI2_I2_I38_MN1 (VSS B_6 I2_I2_nor6 VSS) gpdk090_nmos1v w=0.12u l=0.1u ad=0.0696p as=0.0408p pd=1.16u ps=0.68u
    I_MXI2_I2_I20_MN0 (I2_I2_nor3 A_3 VSS VSS) gpdk090_nmos1v w=0.12u l=0.1u ad=0.0408p as=0.0696p pd=0.68u ps=1.16u
    I_MXI2_I2_I20_MN1 (VSS B_3 I2_I2_nor3 VSS) gpdk090_nmos1v w=0.12u l=0.1u ad=0.0696p as=0.0408p pd=1.16u ps=0.68u
    I_MXI2_I1_I8_I25_XP_MN0 (I2_I1_I8_P7_6 I2_I1_I8_pn7 VSS VSS) gpdk090_nmos1v w=0.12u l=0.1u ad=0.0408p as=0.0696p pd=0.68u ps=1.16u
    I_MXI2_I1_I8_I25_XP_MN1 (VSS I2_I1_I8_pn6 I2_I1_I8_P7_6 VSS) gpdk090_nmos1v w=0.12u l=0.1u ad=0.0696p as=0.0408p pd=1.16u ps=0.68u
    I_MXI2_I1_I8_I24_XP_MN0 (I2_I1_I8_P6_5 I2_I1_I8_pn6 VSS VSS) gpdk090_nmos1v w=0.12u l=0.1u ad=0.0408p as=0.0696p pd=0.68u ps=1.16u
    I_MXI2_I1_I8_I24_XP_MN1 (VSS I2_I1_I8_pn5 I2_I1_I8_P6_5 VSS) gpdk090_nmos1v w=0.12u l=0.1u ad=0.0696p as=0.0408p pd=1.16u ps=0.68u
    I_MXI1_I132_I25_XP_MN0 (I1_I132_P7_6 I1_I132_pn7 VSS VSS) gpdk090_nmos1v w=0.12u l=0.1u ad=0.0408p as=0.0696p pd=0.68u ps=1.16u
    I_MXI1_I132_I25_XP_MN1 (VSS I1_I132_pn6 I1_I132_P7_6 VSS) gpdk090_nmos1v w=0.12u l=0.1u ad=0.0696p as=0.0408p pd=1.16u ps=0.68u
    I_MXI1_I132_I23_XP_MN0 (I1_I132_P5_4 I1_I132_pn5 VSS VSS) gpdk090_nmos1v w=0.12u l=0.1u ad=0.0408p as=0.0696p pd=0.68u ps=1.16u
    I_MXI1_I132_I23_XP_MN1 (VSS I1_I132_pn4 I1_I132_P5_4 VSS) gpdk090_nmos1v w=0.12u l=0.1u ad=0.0696p as=0.0408p pd=1.16u ps=0.68u
    I_MXI1_I132_I21_XP_MN0 (I1_I132_P3_2 I1_I132_pn3 VSS VSS) gpdk090_nmos1v w=0.12u l=0.1u ad=0.0408p as=0.0696p pd=0.68u ps=1.16u
    I_MXI1_I132_I21_XP_MN1 (VSS I1_I132_pn2 I1_I132_P3_2 VSS) gpdk090_nmos1v w=0.12u l=0.1u ad=0.0696p as=0.0408p pd=1.16u ps=0.68u
    I_MXI2_I4_I3_MN0 (I2_I4_za3 Y_6 VSS VSS) gpdk090_nmos1v w=0.12u l=0.1u ad=0.0408p as=0.0696p pd=0.68u ps=1.16u
    I_MXI2_I4_I3_MN1 (VSS Y_7 I2_I4_za3 VSS) gpdk090_nmos1v w=0.12u l=0.1u ad=0.0696p as=0.0408p pd=1.16u ps=0.68u
    I_MXI2_I1_I8_I23_XP_MN0 (I2_I1_I8_P5_4 I2_I1_I8_pn5 VSS VSS) gpdk090_nmos1v w=0.12u l=0.1u ad=0.0408p as=0.0696p pd=0.68u ps=1.16u
    I_MXI2_I1_I8_I23_XP_MN1 (VSS I2_I1_I8_pn4 I2_I1_I8_P5_4 VSS) gpdk090_nmos1v w=0.12u l=0.1u ad=0.0696p as=0.0408p pd=1.16u ps=0.68u
    I_MXI1_I132_I24_XP_MN0 (I1_I132_P6_5 I1_I132_pn6 VSS VSS) gpdk090_nmos1v w=0.12u l=0.1u ad=0.0408p as=0.0696p pd=0.68u ps=1.16u
    I_MXI1_I132_I24_XP_MN1 (VSS I1_I132_pn5 I1_I132_P6_5 VSS) gpdk090_nmos1v w=0.12u l=0.1u ad=0.0696p as=0.0408p pd=1.16u ps=0.68u
    I_MXI1_I132_I22_XP_MN0 (I1_I132_P4_3 I1_I132_pn4 VSS VSS) gpdk090_nmos1v w=0.12u l=0.1u ad=0.0408p as=0.0696p pd=0.68u ps=1.16u
    I_MXI1_I132_I22_XP_MN1 (VSS I1_I132_pn3 I1_I132_P4_3 VSS) gpdk090_nmos1v w=0.12u l=0.1u ad=0.0696p as=0.0408p pd=1.16u ps=0.68u
    I_MXI1_I132_I20_XP_MN0 (I1_I132_P2_1 I1_I132_pn2 VSS VSS) gpdk090_nmos1v w=0.12u l=0.1u ad=0.0408p as=0.0696p pd=0.68u ps=1.16u
    I_MXI1_I132_I20_XP_MN1 (VSS I1_I132_pn1 I1_I132_P2_1 VSS) gpdk090_nmos1v w=0.12u l=0.1u ad=0.0696p as=0.0408p pd=1.16u ps=0.68u
    I_MXI2_I4_I2_MN0 (I2_I4_za2 Y_4 VSS VSS) gpdk090_nmos1v w=0.12u l=0.1u ad=0.0408p as=0.0696p pd=0.68u ps=1.16u
    I_MXI2_I4_I2_MN1 (VSS Y_5 I2_I4_za2 VSS) gpdk090_nmos1v w=0.12u l=0.1u ad=0.0696p as=0.0408p pd=1.16u ps=0.68u
    I_MXI2_I1_I8_I21_XP_MN0 (I2_I1_I8_P3_2 I2_I1_I8_pn3 VSS VSS) gpdk090_nmos1v w=0.12u l=0.1u ad=0.0408p as=0.0696p pd=0.68u ps=1.16u
    I_MXI2_I1_I8_I21_XP_MN1 (VSS I2_I1_I8_pn2 I2_I1_I8_P3_2 VSS) gpdk090_nmos1v w=0.12u l=0.1u ad=0.0696p as=0.0408p pd=1.16u ps=0.68u
    I_MXI2_I1_I8_I22_XP_MN0 (I2_I1_I8_P4_3 I2_I1_I8_pn4 VSS VSS) gpdk090_nmos1v w=0.12u l=0.1u ad=0.0408p as=0.0696p pd=0.68u ps=1.16u
    I_MXI2_I1_I8_I22_XP_MN1 (VSS I2_I1_I8_pn3 I2_I1_I8_P4_3 VSS) gpdk090_nmos1v w=0.12u l=0.1u ad=0.0696p as=0.0408p pd=1.16u ps=0.68u
    I_MXI1_I197_MN0 (I1_z1_3 B_6 VSS VSS) gpdk090_nmos1v w=0.12u l=0.1u ad=0.0408p as=0.0696p pd=0.68u ps=1.16u
    I_MXI1_I197_MN1 (VSS B_7 I1_z1_3 VSS) gpdk090_nmos1v w=0.12u l=0.1u ad=0.0696p as=0.0408p pd=1.16u ps=0.68u
    I_MXI2_I4_I12_MN0 (I2_I4_zc0 I2_I4_zb0 VSS VSS) gpdk090_nmos1v w=0.12u l=0.1u ad=0.0408p as=0.0696p pd=0.68u ps=1.16u
    I_MXI2_I4_I12_MN1 (VSS I2_I4_zb1 I2_I4_zc0 VSS) gpdk090_nmos1v w=0.12u l=0.1u ad=0.0696p as=0.0408p pd=1.16u ps=0.68u
    I_MXI1_I196_MN0 (I1_z1_2 B_4 VSS VSS) gpdk090_nmos1v w=0.12u l=0.1u ad=0.0408p as=0.0696p pd=0.68u ps=1.16u
    I_MXI1_I196_MN1 (VSS B_5 I1_z1_2 VSS) gpdk090_nmos1v w=0.12u l=0.1u ad=0.0696p as=0.0408p pd=1.16u ps=0.68u
    I_MXI1_I203_MN0 (DIVV I1_vn VSS VSS) gpdk090_nmos1v w=0.12u l=0.1u ad=0.0408p as=0.0696p pd=0.68u ps=1.16u
    I_MXI1_I203_MN1 (VSS DIVDZ DIVV VSS) gpdk090_nmos1v w=0.12u l=0.1u ad=0.0696p as=0.0408p pd=1.16u ps=0.68u
    I_MXI2_I1_I8_I20_XP_MN0 (I2_I1_I8_P2_1 I2_I1_I8_pn2 VSS VSS) gpdk090_nmos1v w=0.12u l=0.1u ad=0.0408p as=0.0696p pd=0.68u ps=1.16u
    I_MXI2_I1_I8_I20_XP_MN1 (VSS I2_I1_I8_pn1 I2_I1_I8_P2_1 VSS) gpdk090_nmos1v w=0.12u l=0.1u ad=0.0696p as=0.0408p pd=1.16u ps=0.68u
    I_MXI1_I120_I24_XP_MN0 (I1_I120_P6_5 I1_I120_pn6 VSS VSS) gpdk090_nmos1v w=0.12u l=0.1u ad=0.0408p as=0.0696p pd=0.68u ps=1.16u
    I_MXI1_I120_I24_XP_MN1 (VSS I1_I120_pn5 I1_I120_P6_5 VSS) gpdk090_nmos1v w=0.12u l=0.1u ad=0.0696p as=0.0408p pd=1.16u ps=0.68u
    I_MXI1_I120_I20_XP_MN0 (I1_I120_P2_1 I1_I120_pn2 VSS VSS) gpdk090_nmos1v w=0.12u l=0.1u ad=0.0408p as=0.0696p pd=0.68u ps=1.16u
    I_MXI1_I120_I20_XP_MN1 (VSS I1_I120_pn1 I1_I120_P2_1 VSS) gpdk090_nmos1v w=0.12u l=0.1u ad=0.0696p as=0.0408p pd=1.16u ps=0.68u
    I_MXI1_I194_MN0 (I1_z1_0 B_0 VSS VSS) gpdk090_nmos1v w=0.12u l=0.1u ad=0.0408p as=0.0696p pd=0.68u ps=1.16u
    I_MXI1_I194_MN1 (VSS B_1 I1_z1_0 VSS) gpdk090_nmos1v w=0.12u l=0.1u ad=0.0696p as=0.0408p pd=1.16u ps=0.68u
    I_MXI1_I200_MN0 (DIVDZ I1_z2_0 VSS VSS) gpdk090_nmos1v w=0.12u l=0.1u ad=0.0408p as=0.0696p pd=0.68u ps=1.16u
    I_MXI1_I200_MN1 (VSS I1_z2_1 DIVDZ VSS) gpdk090_nmos1v w=0.12u l=0.1u ad=0.0696p as=0.0408p pd=1.16u ps=0.68u
    I_MXI1_I195_MN0 (I1_z1_1 B_2 VSS VSS) gpdk090_nmos1v w=0.12u l=0.1u ad=0.0408p as=0.0696p pd=0.68u ps=1.16u
    I_MXI1_I195_MN1 (VSS B_3 I1_z1_1 VSS) gpdk090_nmos1v w=0.12u l=0.1u ad=0.0696p as=0.0408p pd=1.16u ps=0.68u
    I_MXI2_I4_I1_MN0 (I2_I4_za1 Y_2 VSS VSS) gpdk090_nmos1v w=0.12u l=0.1u ad=0.0408p as=0.0696p pd=0.68u ps=1.16u
    I_MXI2_I4_I1_MN1 (VSS Y_3 I2_I4_za1 VSS) gpdk090_nmos1v w=0.12u l=0.1u ad=0.0696p as=0.0408p pd=1.16u ps=0.68u
    I_MXI1_I120_I25_XP_MN0 (I1_I120_P7_6 I1_I120_pn7 VSS VSS) gpdk090_nmos1v w=0.12u l=0.1u ad=0.0408p as=0.0696p pd=0.68u ps=1.16u
    I_MXI1_I120_I25_XP_MN1 (VSS I1_I120_pn6 I1_I120_P7_6 VSS) gpdk090_nmos1v w=0.12u l=0.1u ad=0.0696p as=0.0408p pd=1.16u ps=0.68u
    I_MXI1_I120_I23_XP_MN0 (I1_I120_P5_4 I1_I120_pn5 VSS VSS) gpdk090_nmos1v w=0.12u l=0.1u ad=0.0408p as=0.0696p pd=0.68u ps=1.16u
    I_MXI1_I120_I23_XP_MN1 (VSS I1_I120_pn4 I1_I120_P5_4 VSS) gpdk090_nmos1v w=0.12u l=0.1u ad=0.0696p as=0.0408p pd=1.16u ps=0.68u
    I_MXI1_I120_I22_XP_MN0 (I1_I120_P4_3 I1_I120_pn4 VSS VSS) gpdk090_nmos1v w=0.12u l=0.1u ad=0.0408p as=0.0696p pd=0.68u ps=1.16u
    I_MXI1_I120_I22_XP_MN1 (VSS I1_I120_pn3 I1_I120_P4_3 VSS) gpdk090_nmos1v w=0.12u l=0.1u ad=0.0696p as=0.0408p pd=1.16u ps=0.68u
    I_MXI1_I120_I21_XP_MN0 (I1_I120_P3_2 I1_I120_pn3 VSS VSS) gpdk090_nmos1v w=0.12u l=0.1u ad=0.0408p as=0.0696p pd=0.68u ps=1.16u
    I_MXI1_I120_I21_XP_MN1 (VSS I1_I120_pn2 I1_I120_P3_2 VSS) gpdk090_nmos1v w=0.12u l=0.1u ad=0.0696p as=0.0408p pd=1.16u ps=0.68u
    I_MXI2_I3_I9_MN0 (I2_I3_q0_1 I2_I3_o0_0 VSS VSS) gpdk090_nmos1v w=0.12u l=0.1u ad=0.0408p as=0.0696p pd=0.68u ps=1.16u
    I_MXI2_I3_I9_MN1 (VSS I2_I3_o0_1 I2_I3_q0_1 VSS) gpdk090_nmos1v w=0.12u l=0.1u ad=0.0696p as=0.0408p pd=1.16u ps=0.68u
    I_MXI2_I4_I0_MN0 (I2_I4_za0 Y_0 VSS VSS) gpdk090_nmos1v w=0.12u l=0.1u ad=0.0408p as=0.0696p pd=0.68u ps=1.16u
    I_MXI2_I4_I0_MN1 (VSS Y_1 I2_I4_za0 VSS) gpdk090_nmos1v w=0.12u l=0.1u ad=0.0696p as=0.0408p pd=1.16u ps=0.68u
    I_MXI2_I3_I21_MN0 (I2_I3_q1_1 I2_I3_o1_0 VSS VSS) gpdk090_nmos1v w=0.12u l=0.1u ad=0.0408p as=0.0696p pd=0.68u ps=1.16u
    I_MXI2_I3_I21_MN1 (VSS I2_I3_o1_1 I2_I3_q1_1 VSS) gpdk090_nmos1v w=0.12u l=0.1u ad=0.0696p as=0.0408p pd=1.16u ps=0.68u
    I_MXI2_I3_I57_MN0 (I2_I3_q4_1 I2_I3_o4_0 VSS VSS) gpdk090_nmos1v w=0.12u l=0.1u ad=0.0408p as=0.0696p pd=0.68u ps=1.16u
    I_MXI2_I3_I57_MN1 (VSS I2_I3_o4_1 I2_I3_q4_1 VSS) gpdk090_nmos1v w=0.12u l=0.1u ad=0.0696p as=0.0408p pd=1.16u ps=0.68u
    I_MXI2_I2_I2_MN0 (I2_I2_nor0 A_0 VSS VSS) gpdk090_nmos1v w=0.12u l=0.1u ad=0.0408p as=0.0696p pd=0.68u ps=1.16u
    I_MXI2_I2_I2_MN1 (VSS B_0 I2_I2_nor0 VSS) gpdk090_nmos1v w=0.12u l=0.1u ad=0.0696p as=0.0408p pd=1.16u ps=0.68u
    I_MXI2_I2_I8_MN0 (I2_I2_nor1 A_1 VSS VSS) gpdk090_nmos1v w=0.12u l=0.1u ad=0.0408p as=0.0696p pd=0.68u ps=1.16u
    I_MXI2_I2_I8_MN1 (VSS B_1 I2_I2_nor1 VSS) gpdk090_nmos1v w=0.12u l=0.1u ad=0.0696p as=0.0408p pd=1.16u ps=0.68u
    I_MXI2_I3_I33_MN0 (I2_I3_q2_1 I2_I3_o2_0 VSS VSS) gpdk090_nmos1v w=0.12u l=0.1u ad=0.0408p as=0.0696p pd=0.68u ps=1.16u
    I_MXI2_I3_I33_MN1 (VSS I2_I3_o2_1 I2_I3_q2_1 VSS) gpdk090_nmos1v w=0.12u l=0.1u ad=0.0696p as=0.0408p pd=1.16u ps=0.68u
    I_MXI2_I2_I26_MN0 (I2_I2_nor4 A_4 VSS VSS) gpdk090_nmos1v w=0.12u l=0.1u ad=0.0408p as=0.0696p pd=0.68u ps=1.16u
    I_MXI2_I2_I26_MN1 (VSS B_4 I2_I2_nor4 VSS) gpdk090_nmos1v w=0.12u l=0.1u ad=0.0696p as=0.0408p pd=1.16u ps=0.68u
    I_MXI1_I108_I20_XP_MN0 (I1_I108_P2_1 I1_I108_pn2 VSS VSS) gpdk090_nmos1v w=0.12u l=0.1u ad=0.0408p as=0.0696p pd=0.68u ps=1.16u
    I_MXI1_I108_I20_XP_MN1 (VSS I1_I108_pn1 I1_I108_P2_1 VSS) gpdk090_nmos1v w=0.12u l=0.1u ad=0.0696p as=0.0408p pd=1.16u ps=0.68u
    I_MXI2_I2_I14_MN0 (I2_I2_nor2 A_2 VSS VSS) gpdk090_nmos1v w=0.12u l=0.1u ad=0.0408p as=0.0696p pd=0.68u ps=1.16u
    I_MXI2_I2_I14_MN1 (VSS B_2 I2_I2_nor2 VSS) gpdk090_nmos1v w=0.12u l=0.1u ad=0.0696p as=0.0408p pd=1.16u ps=0.68u
    I_MXI1_I108_I21_XP_MN0 (I1_I108_P3_2 I1_I108_pn3 VSS VSS) gpdk090_nmos1v w=0.12u l=0.1u ad=0.0408p as=0.0696p pd=0.68u ps=1.16u
    I_MXI1_I108_I21_XP_MN1 (VSS I1_I108_pn2 I1_I108_P3_2 VSS) gpdk090_nmos1v w=0.12u l=0.1u ad=0.0696p as=0.0408p pd=1.16u ps=0.68u
    I_MXI1_I108_I24_XP_MN0 (I1_I108_P6_5 I1_I108_pn6 VSS VSS) gpdk090_nmos1v w=0.12u l=0.1u ad=0.0408p as=0.0696p pd=0.68u ps=1.16u
    I_MXI1_I108_I24_XP_MN1 (VSS I1_I108_pn5 I1_I108_P6_5 VSS) gpdk090_nmos1v w=0.12u l=0.1u ad=0.0696p as=0.0408p pd=1.16u ps=0.68u
    I_MXI1_I108_I22_XP_MN0 (I1_I108_P4_3 I1_I108_pn4 VSS VSS) gpdk090_nmos1v w=0.12u l=0.1u ad=0.0408p as=0.0696p pd=0.68u ps=1.16u
    I_MXI1_I108_I22_XP_MN1 (VSS I1_I108_pn3 I1_I108_P4_3 VSS) gpdk090_nmos1v w=0.12u l=0.1u ad=0.0696p as=0.0408p pd=1.16u ps=0.68u
    I_MXI1_I84_I20_XP_MN0 (I1_I84_P2_1 I1_I84_pn2 VSS VSS) gpdk090_nmos1v w=0.12u l=0.1u ad=0.0408p as=0.0696p pd=0.68u ps=1.16u
    I_MXI1_I84_I20_XP_MN1 (VSS I1_I84_pn1 I1_I84_P2_1 VSS) gpdk090_nmos1v w=0.12u l=0.1u ad=0.0696p as=0.0408p pd=1.16u ps=0.68u
    I_MXI1_I72_I20_XP_MN0 (I1_I72_P2_1 I1_I72_pn2 VSS VSS) gpdk090_nmos1v w=0.12u l=0.1u ad=0.0408p as=0.0696p pd=0.68u ps=1.16u
    I_MXI1_I72_I20_XP_MN1 (VSS I1_I72_pn1 I1_I72_P2_1 VSS) gpdk090_nmos1v w=0.12u l=0.1u ad=0.0696p as=0.0408p pd=1.16u ps=0.68u
    I_MXI1_I48_I20_XP_MN0 (I1_I48_P2_1 I1_I48_pn2 VSS VSS) gpdk090_nmos1v w=0.12u l=0.1u ad=0.0408p as=0.0696p pd=0.68u ps=1.16u
    I_MXI1_I48_I20_XP_MN1 (VSS I1_I48_pn1 I1_I48_P2_1 VSS) gpdk090_nmos1v w=0.12u l=0.1u ad=0.0696p as=0.0408p pd=1.16u ps=0.68u
    I_MXI1_I108_I23_XP_MN0 (I1_I108_P5_4 I1_I108_pn5 VSS VSS) gpdk090_nmos1v w=0.12u l=0.1u ad=0.0408p as=0.0696p pd=0.68u ps=1.16u
    I_MXI1_I108_I23_XP_MN1 (VSS I1_I108_pn4 I1_I108_P5_4 VSS) gpdk090_nmos1v w=0.12u l=0.1u ad=0.0696p as=0.0408p pd=1.16u ps=0.68u
    I_MXI1_I96_I20_XP_MN0 (I1_I96_P2_1 I1_I96_pn2 VSS VSS) gpdk090_nmos1v w=0.12u l=0.1u ad=0.0408p as=0.0696p pd=0.68u ps=1.16u
    I_MXI1_I96_I20_XP_MN1 (VSS I1_I96_pn1 I1_I96_P2_1 VSS) gpdk090_nmos1v w=0.12u l=0.1u ad=0.0696p as=0.0408p pd=1.16u ps=0.68u
    I_MXI1_I84_I21_XP_MN0 (I1_I84_P3_2 I1_I84_pn3 VSS VSS) gpdk090_nmos1v w=0.12u l=0.1u ad=0.0408p as=0.0696p pd=0.68u ps=1.16u
    I_MXI1_I84_I21_XP_MN1 (VSS I1_I84_pn2 I1_I84_P3_2 VSS) gpdk090_nmos1v w=0.12u l=0.1u ad=0.0696p as=0.0408p pd=1.16u ps=0.68u
    I_MXI1_I72_I21_XP_MN0 (I1_I72_P3_2 I1_I72_pn3 VSS VSS) gpdk090_nmos1v w=0.12u l=0.1u ad=0.0408p as=0.0696p pd=0.68u ps=1.16u
    I_MXI1_I72_I21_XP_MN1 (VSS I1_I72_pn2 I1_I72_P3_2 VSS) gpdk090_nmos1v w=0.12u l=0.1u ad=0.0696p as=0.0408p pd=1.16u ps=0.68u
    I_MXI1_I60_I20_XP_MN0 (I1_I60_P2_1 I1_I60_pn2 VSS VSS) gpdk090_nmos1v w=0.12u l=0.1u ad=0.0408p as=0.0696p pd=0.68u ps=1.16u
    I_MXI1_I60_I20_XP_MN1 (VSS I1_I60_pn1 I1_I60_P2_1 VSS) gpdk090_nmos1v w=0.12u l=0.1u ad=0.0696p as=0.0408p pd=1.16u ps=0.68u
    I_MXI1_I60_I21_XP_MN0 (I1_I60_P3_2 I1_I60_pn3 VSS VSS) gpdk090_nmos1v w=0.12u l=0.1u ad=0.0408p as=0.0696p pd=0.68u ps=1.16u
    I_MXI1_I60_I21_XP_MN1 (VSS I1_I60_pn2 I1_I60_P3_2 VSS) gpdk090_nmos1v w=0.12u l=0.1u ad=0.0696p as=0.0408p pd=1.16u ps=0.68u
    I_MXI1_I48_I21_XP_MN0 (I1_I48_P3_2 I1_I48_pn3 VSS VSS) gpdk090_nmos1v w=0.12u l=0.1u ad=0.0408p as=0.0696p pd=0.68u ps=1.16u
    I_MXI1_I48_I21_XP_MN1 (VSS I1_I48_pn2 I1_I48_P3_2 VSS) gpdk090_nmos1v w=0.12u l=0.1u ad=0.0696p as=0.0408p pd=1.16u ps=0.68u
    I_MXI1_I48_I22_XP_MN0 (I1_I48_P4_3 I1_I48_pn4 VSS VSS) gpdk090_nmos1v w=0.12u l=0.1u ad=0.0408p as=0.0696p pd=0.68u ps=1.16u
    I_MXI1_I48_I22_XP_MN1 (VSS I1_I48_pn3 I1_I48_P4_3 VSS) gpdk090_nmos1v w=0.12u l=0.1u ad=0.0696p as=0.0408p pd=1.16u ps=0.68u
    I_MXI1_I108_I25_XP_MN0 (I1_I108_P7_6 I1_I108_pn7 VSS VSS) gpdk090_nmos1v w=0.12u l=0.1u ad=0.0408p as=0.0696p pd=0.68u ps=1.16u
    I_MXI1_I108_I25_XP_MN1 (VSS I1_I108_pn6 I1_I108_P7_6 VSS) gpdk090_nmos1v w=0.12u l=0.1u ad=0.0696p as=0.0408p pd=1.16u ps=0.68u
    I_MXI1_I96_I21_XP_MN0 (I1_I96_P3_2 I1_I96_pn3 VSS VSS) gpdk090_nmos1v w=0.12u l=0.1u ad=0.0408p as=0.0696p pd=0.68u ps=1.16u
    I_MXI1_I96_I21_XP_MN1 (VSS I1_I96_pn2 I1_I96_P3_2 VSS) gpdk090_nmos1v w=0.12u l=0.1u ad=0.0696p as=0.0408p pd=1.16u ps=0.68u
    I_MXI1_I96_I22_XP_MN0 (I1_I96_P4_3 I1_I96_pn4 VSS VSS) gpdk090_nmos1v w=0.12u l=0.1u ad=0.0408p as=0.0696p pd=0.68u ps=1.16u
    I_MXI1_I96_I22_XP_MN1 (VSS I1_I96_pn3 I1_I96_P4_3 VSS) gpdk090_nmos1v w=0.12u l=0.1u ad=0.0696p as=0.0408p pd=1.16u ps=0.68u
    I_MXI1_I84_I22_XP_MN0 (I1_I84_P4_3 I1_I84_pn4 VSS VSS) gpdk090_nmos1v w=0.12u l=0.1u ad=0.0408p as=0.0696p pd=0.68u ps=1.16u
    I_MXI1_I84_I22_XP_MN1 (VSS I1_I84_pn3 I1_I84_P4_3 VSS) gpdk090_nmos1v w=0.12u l=0.1u ad=0.0696p as=0.0408p pd=1.16u ps=0.68u
    I_MXI1_I72_I22_XP_MN0 (I1_I72_P4_3 I1_I72_pn4 VSS VSS) gpdk090_nmos1v w=0.12u l=0.1u ad=0.0408p as=0.0696p pd=0.68u ps=1.16u
    I_MXI1_I72_I22_XP_MN1 (VSS I1_I72_pn3 I1_I72_P4_3 VSS) gpdk090_nmos1v w=0.12u l=0.1u ad=0.0696p as=0.0408p pd=1.16u ps=0.68u
    I_MXI1_I60_I22_XP_MN0 (I1_I60_P4_3 I1_I60_pn4 VSS VSS) gpdk090_nmos1v w=0.12u l=0.1u ad=0.0408p as=0.0696p pd=0.68u ps=1.16u
    I_MXI1_I60_I22_XP_MN1 (VSS I1_I60_pn3 I1_I60_P4_3 VSS) gpdk090_nmos1v w=0.12u l=0.1u ad=0.0696p as=0.0408p pd=1.16u ps=0.68u
    I_MXI1_I48_I24_XP_MN0 (I1_I48_P6_5 I1_I48_pn6 VSS VSS) gpdk090_nmos1v w=0.12u l=0.1u ad=0.0408p as=0.0696p pd=0.68u ps=1.16u
    I_MXI1_I48_I24_XP_MN1 (VSS I1_I48_pn5 I1_I48_P6_5 VSS) gpdk090_nmos1v w=0.12u l=0.1u ad=0.0696p as=0.0408p pd=1.16u ps=0.68u
    I_MXI1_I48_I23_XP_MN0 (I1_I48_P5_4 I1_I48_pn5 VSS VSS) gpdk090_nmos1v w=0.12u l=0.1u ad=0.0408p as=0.0696p pd=0.68u ps=1.16u
    I_MXI1_I48_I23_XP_MN1 (VSS I1_I48_pn4 I1_I48_P5_4 VSS) gpdk090_nmos1v w=0.12u l=0.1u ad=0.0696p as=0.0408p pd=1.16u ps=0.68u
    I_MXI1_I96_I23_XP_MN0 (I1_I96_P5_4 I1_I96_pn5 VSS VSS) gpdk090_nmos1v w=0.12u l=0.1u ad=0.0408p as=0.0696p pd=0.68u ps=1.16u
    I_MXI1_I96_I23_XP_MN1 (VSS I1_I96_pn4 I1_I96_P5_4 VSS) gpdk090_nmos1v w=0.12u l=0.1u ad=0.0696p as=0.0408p pd=1.16u ps=0.68u
    I_MXI1_I96_I24_XP_MN0 (I1_I96_P6_5 I1_I96_pn6 VSS VSS) gpdk090_nmos1v w=0.12u l=0.1u ad=0.0408p as=0.0696p pd=0.68u ps=1.16u
    I_MXI1_I96_I24_XP_MN1 (VSS I1_I96_pn5 I1_I96_P6_5 VSS) gpdk090_nmos1v w=0.12u l=0.1u ad=0.0696p as=0.0408p pd=1.16u ps=0.68u
    I_MXI1_I84_I23_XP_MN0 (I1_I84_P5_4 I1_I84_pn5 VSS VSS) gpdk090_nmos1v w=0.12u l=0.1u ad=0.0408p as=0.0696p pd=0.68u ps=1.16u
    I_MXI1_I84_I23_XP_MN1 (VSS I1_I84_pn4 I1_I84_P5_4 VSS) gpdk090_nmos1v w=0.12u l=0.1u ad=0.0696p as=0.0408p pd=1.16u ps=0.68u
    I_MXI1_I84_I24_XP_MN0 (I1_I84_P6_5 I1_I84_pn6 VSS VSS) gpdk090_nmos1v w=0.12u l=0.1u ad=0.0408p as=0.0696p pd=0.68u ps=1.16u
    I_MXI1_I84_I24_XP_MN1 (VSS I1_I84_pn5 I1_I84_P6_5 VSS) gpdk090_nmos1v w=0.12u l=0.1u ad=0.0696p as=0.0408p pd=1.16u ps=0.68u
    I_MXI1_I72_I24_XP_MN0 (I1_I72_P6_5 I1_I72_pn6 VSS VSS) gpdk090_nmos1v w=0.12u l=0.1u ad=0.0408p as=0.0696p pd=0.68u ps=1.16u
    I_MXI1_I72_I24_XP_MN1 (VSS I1_I72_pn5 I1_I72_P6_5 VSS) gpdk090_nmos1v w=0.12u l=0.1u ad=0.0696p as=0.0408p pd=1.16u ps=0.68u
    I_MXI1_I72_I23_XP_MN0 (I1_I72_P5_4 I1_I72_pn5 VSS VSS) gpdk090_nmos1v w=0.12u l=0.1u ad=0.0408p as=0.0696p pd=0.68u ps=1.16u
    I_MXI1_I72_I23_XP_MN1 (VSS I1_I72_pn4 I1_I72_P5_4 VSS) gpdk090_nmos1v w=0.12u l=0.1u ad=0.0696p as=0.0408p pd=1.16u ps=0.68u
    I_MXI1_I60_I24_XP_MN0 (I1_I60_P6_5 I1_I60_pn6 VSS VSS) gpdk090_nmos1v w=0.12u l=0.1u ad=0.0408p as=0.0696p pd=0.68u ps=1.16u
    I_MXI1_I60_I24_XP_MN1 (VSS I1_I60_pn5 I1_I60_P6_5 VSS) gpdk090_nmos1v w=0.12u l=0.1u ad=0.0696p as=0.0408p pd=1.16u ps=0.68u
    I_MXI1_I60_I23_XP_MN0 (I1_I60_P5_4 I1_I60_pn5 VSS VSS) gpdk090_nmos1v w=0.12u l=0.1u ad=0.0408p as=0.0696p pd=0.68u ps=1.16u
    I_MXI1_I60_I23_XP_MN1 (VSS I1_I60_pn4 I1_I60_P5_4 VSS) gpdk090_nmos1v w=0.12u l=0.1u ad=0.0696p as=0.0408p pd=1.16u ps=0.68u
    I_MXI1_I96_I25_XP_MN0 (I1_I96_P7_6 I1_I96_pn7 VSS VSS) gpdk090_nmos1v w=0.12u l=0.1u ad=0.0408p as=0.0696p pd=0.68u ps=1.16u
    I_MXI1_I96_I25_XP_MN1 (VSS I1_I96_pn6 I1_I96_P7_6 VSS) gpdk090_nmos1v w=0.12u l=0.1u ad=0.0696p as=0.0408p pd=1.16u ps=0.68u
    I_MXI1_I84_I25_XP_MN0 (I1_I84_P7_6 I1_I84_pn7 VSS VSS) gpdk090_nmos1v w=0.12u l=0.1u ad=0.0408p as=0.0696p pd=0.68u ps=1.16u
    I_MXI1_I84_I25_XP_MN1 (VSS I1_I84_pn6 I1_I84_P7_6 VSS) gpdk090_nmos1v w=0.12u l=0.1u ad=0.0696p as=0.0408p pd=1.16u ps=0.68u
    I_MXI1_I72_I25_XP_MN0 (I1_I72_P7_6 I1_I72_pn7 VSS VSS) gpdk090_nmos1v w=0.12u l=0.1u ad=0.0408p as=0.0696p pd=0.68u ps=1.16u
    I_MXI1_I72_I25_XP_MN1 (VSS I1_I72_pn6 I1_I72_P7_6 VSS) gpdk090_nmos1v w=0.12u l=0.1u ad=0.0696p as=0.0408p pd=1.16u ps=0.68u
    I_MXI1_I60_I25_XP_MN0 (I1_I60_P7_6 I1_I60_pn7 VSS VSS) gpdk090_nmos1v w=0.12u l=0.1u ad=0.0408p as=0.0696p pd=0.68u ps=1.16u
    I_MXI1_I60_I25_XP_MN1 (VSS I1_I60_pn6 I1_I60_P7_6 VSS) gpdk090_nmos1v w=0.12u l=0.1u ad=0.0696p as=0.0408p pd=1.16u ps=0.68u
    I_MXI1_I48_I25_XP_MN0 (I1_I48_P7_6 I1_I48_pn7 VSS VSS) gpdk090_nmos1v w=0.12u l=0.1u ad=0.0408p as=0.0696p pd=0.68u ps=1.16u
    I_MXI1_I48_I25_XP_MN1 (VSS I1_I48_pn6 I1_I48_P7_6 VSS) gpdk090_nmos1v w=0.12u l=0.1u ad=0.0696p as=0.0408p pd=1.16u ps=0.68u
    I_MXI0_I53_MN34 (XI0_I53_bn3 XI0_I53_s1 VSS VSS) gpdk090_nmos1v w=0.24u l=0.1u ad=0.0528p as=0.0498p pd=0.68u ps=0.68u
    I_MXI0_I53_MN35 (VSS I0_pp3_5 XI0_I53_bn3 VSS) gpdk090_nmos1v w=0.24u l=0.1u ad=0.0528p as=0.0528p pd=0.68u ps=0.68u
    I_MXI0_I53_MN36 (XI0_I53_bn3 I0_cm9_2 VSS VSS) gpdk090_nmos1v w=0.24u l=0.1u ad=0.0528p as=0.0528p pd=0.68u ps=0.68u
    I_MXI0_I53_MN37 (XI0_I53_bsn XI0_I53_bcon XI0_I53_bn3 VSS) gpdk090_nmos1v w=0.24u l=0.1u ad=0.0498p as=0.0528p pd=0.68u ps=0.68u
    I_MXI0_I53_MN40 (XI0_I53_bn5 I0_cm9_2 XI0_I53_bsn VSS) gpdk090_nmos1v w=0.18u l=0.1u ad=0.0468p as=0.0498p pd=0.68u ps=0.68u
    I_MXI0_I53_MN39 (XI0_I53_bn4 I0_pp3_5 XI0_I53_bn5 VSS) gpdk090_nmos1v w=0.18u l=0.1u ad=0.0468p as=0.0468p pd=0.68u ps=0.68u
    I_MXI0_I53_MN39_1 (XI0_I53_bn5 I0_pp3_5 XI0_I53_bn4 VSS) gpdk090_nmos1v w=0.18u l=0.1u ad=0.0468p as=0.0468p pd=0.68u ps=0.68u
    I_MXI0_I53_MN40_1 (XI0_I53_bsn I0_cm9_2 XI0_I53_bn5 VSS) gpdk090_nmos1v w=0.18u l=0.1u ad=0.0756p as=0.0468p pd=1.16u ps=0.68u
    I_MXI0_I53_MN53 (VSS XI0_I53_bsn I0_cm10_0 VSS) gpdk090_nmos1v w=0.12u l=0.1u ad=0.0696p as=0.0696p pd=1.16u ps=1.16u
    I_MXI0_I53_MN29 (XI0_I53_bn1 XI0_I53_s1 VSS VSS) gpdk090_nmos1v w=0.24u l=0.1u ad=0.0528p as=0.0468p pd=0.68u ps=0.68u
    I_MXI0_I53_MN30 (XI0_I53_bcon I0_pp3_5 XI0_I53_bn1 VSS) gpdk090_nmos1v w=0.24u l=0.1u ad=0.0528p as=0.0528p pd=0.68u ps=0.68u
    I_MXI0_I53_MN33 (XI0_I53_bn2 I0_cm9_2 XI0_I53_bcon VSS) gpdk090_nmos1v w=0.24u l=0.1u ad=0.0528p as=0.0528p pd=0.68u ps=0.68u
    I_MXI0_I53_MN31 (VSS XI0_I53_s1 XI0_I53_bn2 VSS) gpdk090_nmos1v w=0.24u l=0.1u ad=0.0528p as=0.0528p pd=0.68u ps=0.68u
    I_MXI0_I53_MN32 (XI0_I53_bn2 I0_pp3_5 VSS VSS) gpdk090_nmos1v w=0.24u l=0.1u ad=0.0816p as=0.0528p pd=1.16u ps=0.68u
    I_MXI0_I53_MN55 (VSS XI0_I53_bcon I0_cm10_1 VSS) gpdk090_nmos1v w=0.12u l=0.1u ad=0.0438p as=0.0696p pd=0.68u ps=1.16u
    I_MXI0_I53_MN38 (XI0_I53_bn4 XI0_I53_s1 VSS VSS) gpdk090_nmos1v w=0.18u l=0.1u ad=0.0954p as=0.0438p pd=1.22u ps=0.68u
    I_MXI0_I53_MN38_1 (VSS XI0_I53_s1 XI0_I53_bn4 VSS) gpdk090_nmos1v w=0.18u l=0.1u ad=0.0498p as=0.0954p pd=0.68u ps=1.22u
    I_MXI0_I53_MN25 (VSS XI0_I53_asn XI0_I53_s1 VSS) gpdk090_nmos1v w=0.12u l=0.1u ad=0.0468p as=0.0696p pd=0.68u ps=1.16u
    I_MXI0_I53_MN10 (VSS I0_sn0 XI0_I53_an4 VSS) gpdk090_nmos1v w=0.18u l=0.1u ad=0.0498p as=0.0468p pd=0.68u ps=0.68u
    I_MXI0_I53_MN6 (XI0_I53_an3 I0_sn0 VSS VSS) gpdk090_nmos1v w=0.24u l=0.1u ad=0.0528p as=0.0498p pd=0.68u ps=0.68u
    I_MXI0_I53_MN9 (XI0_I53_asn XI0_I53_acon XI0_I53_an3 VSS) gpdk090_nmos1v w=0.24u l=0.1u ad=0.0498p as=0.0528p pd=0.68u ps=0.68u
    I_MXI0_I53_MN12 (XI0_I53_an5 I0_pp2_7 XI0_I53_asn VSS) gpdk090_nmos1v w=0.18u l=0.1u ad=0.0468p as=0.0498p pd=0.68u ps=0.68u
    I_MXI0_I53_MN11 (XI0_I53_an4 I0_sn1 XI0_I53_an5 VSS) gpdk090_nmos1v w=0.18u l=0.1u ad=0.144p as=0.0468p pd=1.76u ps=0.68u
    I_MXI0_I53_MN11_1 (XI0_I53_an5 I0_sn1 XI0_I53_an4 VSS) gpdk090_nmos1v w=0.18u l=0.1u ad=0.0468p as=0.144p pd=0.68u ps=1.76u
    I_MXI0_I53_MN12_1 (XI0_I53_asn I0_pp2_7 XI0_I53_an5 VSS) gpdk090_nmos1v w=0.18u l=0.1u ad=0.0756p as=0.0468p pd=1.16u ps=0.68u
    I_MXI0_I53_MN10_1 (XI0_I53_an4 I0_sn0 VSS VSS) gpdk090_nmos1v w=0.18u l=0.1u ad=0.0468p as=0.0498p pd=0.68u ps=0.68u
    I_MXI0_I53_MN5 (XI0_I53_acon I0_pp2_7 XI0_I53_an2 VSS) gpdk090_nmos1v w=0.24u l=0.1u ad=0.0528p as=0.0816p pd=0.68u ps=1.16u
    I_MXI0_I53_MN2 (XI0_I53_an1 I0_sn1 XI0_I53_acon VSS) gpdk090_nmos1v w=0.24u l=0.1u ad=0.0528p as=0.0528p pd=0.68u ps=0.68u
    I_MXI0_I53_MN1 (VSS I0_sn0 XI0_I53_an1 VSS) gpdk090_nmos1v w=0.24u l=0.1u ad=0.0528p as=0.0528p pd=0.68u ps=0.68u
    I_MXI0_I53_MN3 (XI0_I53_an2 I0_sn0 VSS VSS) gpdk090_nmos1v w=0.24u l=0.1u ad=0.0528p as=0.0528p pd=0.68u ps=0.68u
    I_MXI0_I53_MN4 (VSS I0_sn1 XI0_I53_an2 VSS) gpdk090_nmos1v w=0.24u l=0.1u ad=0.0468p as=0.0528p pd=0.68u ps=0.68u
    I_MXI0_I53_MN27 (I0_cm10_2 XI0_I53_acon VSS VSS) gpdk090_nmos1v w=0.12u l=0.1u ad=0.0696p as=0.0468p pd=1.16u ps=0.68u
    I_MXI0_I53_MN7 (XI0_I53_an3 I0_sn1 VSS VSS) gpdk090_nmos1v w=0.24u l=0.1u ad=0.0528p as=0.0816p pd=0.68u ps=1.16u
    I_MXI0_I53_MN8 (VSS I0_pp2_7 XI0_I53_an3 VSS) gpdk090_nmos1v w=0.24u l=0.1u ad=0.0498p as=0.0528p pd=0.68u ps=0.68u
    I_MXI0_I54_MN34 (XI0_I54_bn3 XI0_I54_s1 VSS VSS) gpdk090_nmos1v w=0.24u l=0.1u ad=0.0528p as=0.0498p pd=0.68u ps=0.68u
    I_MXI0_I54_MN35 (VSS VSS XI0_I54_bn3 VSS) gpdk090_nmos1v w=0.24u l=0.1u ad=0.0528p as=0.0528p pd=0.68u ps=0.68u
    I_MXI0_I54_MN36 (XI0_I54_bn3 I0_cm10_2 VSS VSS) gpdk090_nmos1v w=0.24u l=0.1u ad=0.0528p as=0.0528p pd=0.68u ps=0.68u
    I_MXI0_I54_MN37 (XI0_I54_bsn XI0_I54_bcon XI0_I54_bn3 VSS) gpdk090_nmos1v w=0.24u l=0.1u ad=0.0498p as=0.0528p pd=0.68u ps=0.68u
    I_MXI0_I54_MN40 (XI0_I54_bn5 I0_cm10_2 XI0_I54_bsn VSS) gpdk090_nmos1v w=0.18u l=0.1u ad=0.0468p as=0.0498p pd=0.68u ps=0.68u
    I_MXI0_I54_MN39 (XI0_I54_bn4 VSS XI0_I54_bn5 VSS) gpdk090_nmos1v w=0.18u l=0.1u ad=0.0468p as=0.0468p pd=0.68u ps=0.68u
    I_MXI0_I54_MN39_1 (XI0_I54_bn5 VSS XI0_I54_bn4 VSS) gpdk090_nmos1v w=0.18u l=0.1u ad=0.0468p as=0.0468p pd=0.68u ps=0.68u
    I_MXI0_I54_MN40_1 (XI0_I54_bsn I0_cm10_2 XI0_I54_bn5 VSS) gpdk090_nmos1v w=0.18u l=0.1u ad=0.0756p as=0.0468p pd=1.16u ps=0.68u
    I_MXI0_I54_MN53 (VSS XI0_I54_bsn I0_cm11_0 VSS) gpdk090_nmos1v w=0.12u l=0.1u ad=0.0696p as=0.0696p pd=1.16u ps=1.16u
    I_MXI0_I54_MN29 (XI0_I54_bn1 XI0_I54_s1 VSS VSS) gpdk090_nmos1v w=0.24u l=0.1u ad=0.0528p as=0.0468p pd=0.68u ps=0.68u
    I_MXI0_I54_MN30 (XI0_I54_bcon VSS XI0_I54_bn1 VSS) gpdk090_nmos1v w=0.24u l=0.1u ad=0.0528p as=0.0528p pd=0.68u ps=0.68u
    I_MXI0_I54_MN33 (XI0_I54_bn2 I0_cm10_2 XI0_I54_bcon VSS) gpdk090_nmos1v w=0.24u l=0.1u ad=0.0528p as=0.0528p pd=0.68u ps=0.68u
    I_MXI0_I54_MN31 (VSS XI0_I54_s1 XI0_I54_bn2 VSS) gpdk090_nmos1v w=0.24u l=0.1u ad=0.0528p as=0.0528p pd=0.68u ps=0.68u
    I_MXI0_I54_MN32 (XI0_I54_bn2 VSS VSS VSS) gpdk090_nmos1v w=0.24u l=0.1u ad=0.0816p as=0.0528p pd=1.16u ps=0.68u
    I_MXI0_I54_MN55 (VSS XI0_I54_bcon I0_cm11_1 VSS) gpdk090_nmos1v w=0.12u l=0.1u ad=0.0438p as=0.0696p pd=0.68u ps=1.16u
    I_MXI0_I54_MN38 (XI0_I54_bn4 XI0_I54_s1 VSS VSS) gpdk090_nmos1v w=0.18u l=0.1u ad=0.0954p as=0.0438p pd=1.22u ps=0.68u
    I_MXI0_I54_MN38_1 (VSS XI0_I54_s1 XI0_I54_bn4 VSS) gpdk090_nmos1v w=0.18u l=0.1u ad=0.0498p as=0.0954p pd=0.68u ps=1.22u
    I_MXI0_I54_MN25 (VSS XI0_I54_asn XI0_I54_s1 VSS) gpdk090_nmos1v w=0.12u l=0.1u ad=0.0468p as=0.0696p pd=0.68u ps=1.16u
    I_MXI0_I54_MN10 (VSS VDD XI0_I54_an4 VSS) gpdk090_nmos1v w=0.18u l=0.1u ad=0.0498p as=0.0468p pd=0.68u ps=0.68u
    I_MXI0_I54_MN6 (XI0_I54_an3 VDD VSS VSS) gpdk090_nmos1v w=0.24u l=0.1u ad=0.0528p as=0.0498p pd=0.68u ps=0.68u
    I_MXI0_I54_MN9 (XI0_I54_asn XI0_I54_acon XI0_I54_an3 VSS) gpdk090_nmos1v w=0.24u l=0.1u ad=0.0498p as=0.0528p pd=0.68u ps=0.68u
    I_MXI0_I54_MN12 (XI0_I54_an5 I0_pp3_6 XI0_I54_asn VSS) gpdk090_nmos1v w=0.18u l=0.1u ad=0.0468p as=0.0498p pd=0.68u ps=0.68u
    I_MXI0_I54_MN11 (XI0_I54_an4 I0_pp2_8 XI0_I54_an5 VSS) gpdk090_nmos1v w=0.18u l=0.1u ad=0.144p as=0.0468p pd=1.76u ps=0.68u
    I_MXI0_I54_MN11_1 (XI0_I54_an5 I0_pp2_8 XI0_I54_an4 VSS) gpdk090_nmos1v w=0.18u l=0.1u ad=0.0468p as=0.144p pd=0.68u ps=1.76u
    I_MXI0_I54_MN12_1 (XI0_I54_asn I0_pp3_6 XI0_I54_an5 VSS) gpdk090_nmos1v w=0.18u l=0.1u ad=0.0756p as=0.0468p pd=1.16u ps=0.68u
    I_MXI0_I54_MN10_1 (XI0_I54_an4 VDD VSS VSS) gpdk090_nmos1v w=0.18u l=0.1u ad=0.0468p as=0.0498p pd=0.68u ps=0.68u
    I_MXI0_I54_MN5 (XI0_I54_acon I0_pp3_6 XI0_I54_an2 VSS) gpdk090_nmos1v w=0.24u l=0.1u ad=0.0528p as=0.0816p pd=0.68u ps=1.16u
    I_MXI0_I54_MN2 (XI0_I54_an1 I0_pp2_8 XI0_I54_acon VSS) gpdk090_nmos1v w=0.24u l=0.1u ad=0.0528p as=0.0528p pd=0.68u ps=0.68u
    I_MXI0_I54_MN1 (VSS VDD XI0_I54_an1 VSS) gpdk090_nmos1v w=0.24u l=0.1u ad=0.0528p as=0.0528p pd=0.68u ps=0.68u
    I_MXI0_I54_MN3 (XI0_I54_an2 VDD VSS VSS) gpdk090_nmos1v w=0.24u l=0.1u ad=0.0528p as=0.0528p pd=0.68u ps=0.68u
    I_MXI0_I54_MN4 (VSS I0_pp2_8 XI0_I54_an2 VSS) gpdk090_nmos1v w=0.24u l=0.1u ad=0.0468p as=0.0528p pd=0.68u ps=0.68u
    I_MXI0_I54_MN27 (I0_cm11_2 XI0_I54_acon VSS VSS) gpdk090_nmos1v w=0.12u l=0.1u ad=0.0696p as=0.0468p pd=1.16u ps=0.68u
    I_MXI0_I54_MN7 (XI0_I54_an3 I0_pp2_8 VSS VSS) gpdk090_nmos1v w=0.24u l=0.1u ad=0.0528p as=0.0816p pd=0.68u ps=1.16u
    I_MXI0_I54_MN8 (VSS I0_pp3_6 XI0_I54_an3 VSS) gpdk090_nmos1v w=0.24u l=0.1u ad=0.0498p as=0.0528p pd=0.68u ps=0.68u
    I_MXI0_I52_MN34 (XI0_I52_bn3 XI0_I52_s1 VSS VSS) gpdk090_nmos1v w=0.24u l=0.1u ad=0.0528p as=0.0498p pd=0.68u ps=0.68u
    I_MXI0_I52_MN35 (VSS I0_pp3_4 XI0_I52_bn3 VSS) gpdk090_nmos1v w=0.24u l=0.1u ad=0.0528p as=0.0528p pd=0.68u ps=0.68u
    I_MXI0_I52_MN36 (XI0_I52_bn3 I0_cm8_2 VSS VSS) gpdk090_nmos1v w=0.24u l=0.1u ad=0.0528p as=0.0528p pd=0.68u ps=0.68u
    I_MXI0_I52_MN37 (XI0_I52_bsn XI0_I52_bcon XI0_I52_bn3 VSS) gpdk090_nmos1v w=0.24u l=0.1u ad=0.0498p as=0.0528p pd=0.68u ps=0.68u
    I_MXI0_I52_MN40 (XI0_I52_bn5 I0_cm8_2 XI0_I52_bsn VSS) gpdk090_nmos1v w=0.18u l=0.1u ad=0.0468p as=0.0498p pd=0.68u ps=0.68u
    I_MXI0_I52_MN39 (XI0_I52_bn4 I0_pp3_4 XI0_I52_bn5 VSS) gpdk090_nmos1v w=0.18u l=0.1u ad=0.0468p as=0.0468p pd=0.68u ps=0.68u
    I_MXI0_I52_MN39_1 (XI0_I52_bn5 I0_pp3_4 XI0_I52_bn4 VSS) gpdk090_nmos1v w=0.18u l=0.1u ad=0.0468p as=0.0468p pd=0.68u ps=0.68u
    I_MXI0_I52_MN40_1 (XI0_I52_bsn I0_cm8_2 XI0_I52_bn5 VSS) gpdk090_nmos1v w=0.18u l=0.1u ad=0.0756p as=0.0468p pd=1.16u ps=0.68u
    I_MXI0_I52_MN53 (VSS XI0_I52_bsn I0_cm9_0 VSS) gpdk090_nmos1v w=0.12u l=0.1u ad=0.0696p as=0.0696p pd=1.16u ps=1.16u
    I_MXI0_I52_MN29 (XI0_I52_bn1 XI0_I52_s1 VSS VSS) gpdk090_nmos1v w=0.24u l=0.1u ad=0.0528p as=0.0468p pd=0.68u ps=0.68u
    I_MXI0_I52_MN30 (XI0_I52_bcon I0_pp3_4 XI0_I52_bn1 VSS) gpdk090_nmos1v w=0.24u l=0.1u ad=0.0528p as=0.0528p pd=0.68u ps=0.68u
    I_MXI0_I52_MN33 (XI0_I52_bn2 I0_cm8_2 XI0_I52_bcon VSS) gpdk090_nmos1v w=0.24u l=0.1u ad=0.0528p as=0.0528p pd=0.68u ps=0.68u
    I_MXI0_I52_MN31 (VSS XI0_I52_s1 XI0_I52_bn2 VSS) gpdk090_nmos1v w=0.24u l=0.1u ad=0.0528p as=0.0528p pd=0.68u ps=0.68u
    I_MXI0_I52_MN32 (XI0_I52_bn2 I0_pp3_4 VSS VSS) gpdk090_nmos1v w=0.24u l=0.1u ad=0.0816p as=0.0528p pd=1.16u ps=0.68u
    I_MXI0_I52_MN55 (VSS XI0_I52_bcon I0_cm9_1 VSS) gpdk090_nmos1v w=0.12u l=0.1u ad=0.0438p as=0.0696p pd=0.68u ps=1.16u
    I_MXI0_I52_MN38 (XI0_I52_bn4 XI0_I52_s1 VSS VSS) gpdk090_nmos1v w=0.18u l=0.1u ad=0.0954p as=0.0438p pd=1.22u ps=0.68u
    I_MXI0_I52_MN38_1 (VSS XI0_I52_s1 XI0_I52_bn4 VSS) gpdk090_nmos1v w=0.18u l=0.1u ad=0.0498p as=0.0954p pd=0.68u ps=1.22u
    I_MXI0_I52_MN25 (VSS XI0_I52_asn XI0_I52_s1 VSS) gpdk090_nmos1v w=0.12u l=0.1u ad=0.0468p as=0.0696p pd=0.68u ps=1.16u
    I_MXI0_I52_MN10 (VSS I0_pp0_8 XI0_I52_an4 VSS) gpdk090_nmos1v w=0.18u l=0.1u ad=0.0498p as=0.0468p pd=0.68u ps=0.68u
    I_MXI0_I52_MN6 (XI0_I52_an3 I0_pp0_8 VSS VSS) gpdk090_nmos1v w=0.24u l=0.1u ad=0.0528p as=0.0498p pd=0.68u ps=0.68u
    I_MXI0_I52_MN9 (XI0_I52_asn XI0_I52_acon XI0_I52_an3 VSS) gpdk090_nmos1v w=0.24u l=0.1u ad=0.0498p as=0.0528p pd=0.68u ps=0.68u
    I_MXI0_I52_MN12 (XI0_I52_an5 I0_pp2_6 XI0_I52_asn VSS) gpdk090_nmos1v w=0.18u l=0.1u ad=0.0468p as=0.0498p pd=0.68u ps=0.68u
    I_MXI0_I52_MN11 (XI0_I52_an4 I0_pp1_8 XI0_I52_an5 VSS) gpdk090_nmos1v w=0.18u l=0.1u ad=0.144p as=0.0468p pd=1.76u ps=0.68u
    I_MXI0_I52_MN11_1 (XI0_I52_an5 I0_pp1_8 XI0_I52_an4 VSS) gpdk090_nmos1v w=0.18u l=0.1u ad=0.0468p as=0.144p pd=0.68u ps=1.76u
    I_MXI0_I52_MN12_1 (XI0_I52_asn I0_pp2_6 XI0_I52_an5 VSS) gpdk090_nmos1v w=0.18u l=0.1u ad=0.0756p as=0.0468p pd=1.16u ps=0.68u
    I_MXI0_I52_MN10_1 (XI0_I52_an4 I0_pp0_8 VSS VSS) gpdk090_nmos1v w=0.18u l=0.1u ad=0.0468p as=0.0498p pd=0.68u ps=0.68u
    I_MXI0_I52_MN5 (XI0_I52_acon I0_pp2_6 XI0_I52_an2 VSS) gpdk090_nmos1v w=0.24u l=0.1u ad=0.0528p as=0.0816p pd=0.68u ps=1.16u
    I_MXI0_I52_MN2 (XI0_I52_an1 I0_pp1_8 XI0_I52_acon VSS) gpdk090_nmos1v w=0.24u l=0.1u ad=0.0528p as=0.0528p pd=0.68u ps=0.68u
    I_MXI0_I52_MN1 (VSS I0_pp0_8 XI0_I52_an1 VSS) gpdk090_nmos1v w=0.24u l=0.1u ad=0.0528p as=0.0528p pd=0.68u ps=0.68u
    I_MXI0_I52_MN3 (XI0_I52_an2 I0_pp0_8 VSS VSS) gpdk090_nmos1v w=0.24u l=0.1u ad=0.0528p as=0.0528p pd=0.68u ps=0.68u
    I_MXI0_I52_MN4 (VSS I0_pp1_8 XI0_I52_an2 VSS) gpdk090_nmos1v w=0.24u l=0.1u ad=0.0468p as=0.0528p pd=0.68u ps=0.68u
    I_MXI0_I52_MN27 (I0_cm9_2 XI0_I52_acon VSS VSS) gpdk090_nmos1v w=0.12u l=0.1u ad=0.0696p as=0.0468p pd=1.16u ps=0.68u
    I_MXI0_I52_MN7 (XI0_I52_an3 I0_pp1_8 VSS VSS) gpdk090_nmos1v w=0.24u l=0.1u ad=0.0528p as=0.0816p pd=0.68u ps=1.16u
    I_MXI0_I52_MN8 (VSS I0_pp2_6 XI0_I52_an3 VSS) gpdk090_nmos1v w=0.24u l=0.1u ad=0.0498p as=0.0528p pd=0.68u ps=0.68u
    I_MXI0_I51_MN34 (XI0_I51_bn3 XI0_I51_s1 VSS VSS) gpdk090_nmos1v w=0.24u l=0.1u ad=0.0528p as=0.0498p pd=0.68u ps=0.68u
    I_MXI0_I51_MN35 (VSS I0_pp3_3 XI0_I51_bn3 VSS) gpdk090_nmos1v w=0.24u l=0.1u ad=0.0528p as=0.0528p pd=0.68u ps=0.68u
    I_MXI0_I51_MN36 (XI0_I51_bn3 I0_cm7_2 VSS VSS) gpdk090_nmos1v w=0.24u l=0.1u ad=0.0528p as=0.0528p pd=0.68u ps=0.68u
    I_MXI0_I51_MN37 (XI0_I51_bsn XI0_I51_bcon XI0_I51_bn3 VSS) gpdk090_nmos1v w=0.24u l=0.1u ad=0.0498p as=0.0528p pd=0.68u ps=0.68u
    I_MXI0_I51_MN40 (XI0_I51_bn5 I0_cm7_2 XI0_I51_bsn VSS) gpdk090_nmos1v w=0.18u l=0.1u ad=0.0468p as=0.0498p pd=0.68u ps=0.68u
    I_MXI0_I51_MN39 (XI0_I51_bn4 I0_pp3_3 XI0_I51_bn5 VSS) gpdk090_nmos1v w=0.18u l=0.1u ad=0.0468p as=0.0468p pd=0.68u ps=0.68u
    I_MXI0_I51_MN39_1 (XI0_I51_bn5 I0_pp3_3 XI0_I51_bn4 VSS) gpdk090_nmos1v w=0.18u l=0.1u ad=0.0468p as=0.0468p pd=0.68u ps=0.68u
    I_MXI0_I51_MN40_1 (XI0_I51_bsn I0_cm7_2 XI0_I51_bn5 VSS) gpdk090_nmos1v w=0.18u l=0.1u ad=0.0756p as=0.0468p pd=1.16u ps=0.68u
    I_MXI0_I51_MN53 (VSS XI0_I51_bsn I0_cm8_0 VSS) gpdk090_nmos1v w=0.12u l=0.1u ad=0.0696p as=0.0696p pd=1.16u ps=1.16u
    I_MXI0_I51_MN29 (XI0_I51_bn1 XI0_I51_s1 VSS VSS) gpdk090_nmos1v w=0.24u l=0.1u ad=0.0528p as=0.0468p pd=0.68u ps=0.68u
    I_MXI0_I51_MN30 (XI0_I51_bcon I0_pp3_3 XI0_I51_bn1 VSS) gpdk090_nmos1v w=0.24u l=0.1u ad=0.0528p as=0.0528p pd=0.68u ps=0.68u
    I_MXI0_I51_MN33 (XI0_I51_bn2 I0_cm7_2 XI0_I51_bcon VSS) gpdk090_nmos1v w=0.24u l=0.1u ad=0.0528p as=0.0528p pd=0.68u ps=0.68u
    I_MXI0_I51_MN31 (VSS XI0_I51_s1 XI0_I51_bn2 VSS) gpdk090_nmos1v w=0.24u l=0.1u ad=0.0528p as=0.0528p pd=0.68u ps=0.68u
    I_MXI0_I51_MN32 (XI0_I51_bn2 I0_pp3_3 VSS VSS) gpdk090_nmos1v w=0.24u l=0.1u ad=0.0816p as=0.0528p pd=1.16u ps=0.68u
    I_MXI0_I51_MN55 (VSS XI0_I51_bcon I0_cm8_1 VSS) gpdk090_nmos1v w=0.12u l=0.1u ad=0.0438p as=0.0696p pd=0.68u ps=1.16u
    I_MXI0_I51_MN38 (XI0_I51_bn4 XI0_I51_s1 VSS VSS) gpdk090_nmos1v w=0.18u l=0.1u ad=0.0954p as=0.0438p pd=1.22u ps=0.68u
    I_MXI0_I51_MN38_1 (VSS XI0_I51_s1 XI0_I51_bn4 VSS) gpdk090_nmos1v w=0.18u l=0.1u ad=0.0498p as=0.0954p pd=0.68u ps=1.22u
    I_MXI0_I51_MN25 (VSS XI0_I51_asn XI0_I51_s1 VSS) gpdk090_nmos1v w=0.12u l=0.1u ad=0.0468p as=0.0696p pd=0.68u ps=1.16u
    I_MXI0_I51_MN10 (VSS I0_pp0_8 XI0_I51_an4 VSS) gpdk090_nmos1v w=0.18u l=0.1u ad=0.0498p as=0.0468p pd=0.68u ps=0.68u
    I_MXI0_I51_MN6 (XI0_I51_an3 I0_pp0_8 VSS VSS) gpdk090_nmos1v w=0.24u l=0.1u ad=0.0528p as=0.0498p pd=0.68u ps=0.68u
    I_MXI0_I51_MN9 (XI0_I51_asn XI0_I51_acon XI0_I51_an3 VSS) gpdk090_nmos1v w=0.24u l=0.1u ad=0.0498p as=0.0528p pd=0.68u ps=0.68u
    I_MXI0_I51_MN12 (XI0_I51_an5 I0_pp2_5 XI0_I51_asn VSS) gpdk090_nmos1v w=0.18u l=0.1u ad=0.0468p as=0.0498p pd=0.68u ps=0.68u
    I_MXI0_I51_MN11 (XI0_I51_an4 I0_pp1_7 XI0_I51_an5 VSS) gpdk090_nmos1v w=0.18u l=0.1u ad=0.144p as=0.0468p pd=1.76u ps=0.68u
    I_MXI0_I51_MN11_1 (XI0_I51_an5 I0_pp1_7 XI0_I51_an4 VSS) gpdk090_nmos1v w=0.18u l=0.1u ad=0.0468p as=0.144p pd=0.68u ps=1.76u
    I_MXI0_I51_MN12_1 (XI0_I51_asn I0_pp2_5 XI0_I51_an5 VSS) gpdk090_nmos1v w=0.18u l=0.1u ad=0.0756p as=0.0468p pd=1.16u ps=0.68u
    I_MXI0_I51_MN10_1 (XI0_I51_an4 I0_pp0_8 VSS VSS) gpdk090_nmos1v w=0.18u l=0.1u ad=0.0468p as=0.0498p pd=0.68u ps=0.68u
    I_MXI0_I51_MN5 (XI0_I51_acon I0_pp2_5 XI0_I51_an2 VSS) gpdk090_nmos1v w=0.24u l=0.1u ad=0.0528p as=0.0816p pd=0.68u ps=1.16u
    I_MXI0_I51_MN2 (XI0_I51_an1 I0_pp1_7 XI0_I51_acon VSS) gpdk090_nmos1v w=0.24u l=0.1u ad=0.0528p as=0.0528p pd=0.68u ps=0.68u
    I_MXI0_I51_MN1 (VSS I0_pp0_8 XI0_I51_an1 VSS) gpdk090_nmos1v w=0.24u l=0.1u ad=0.0528p as=0.0528p pd=0.68u ps=0.68u
    I_MXI0_I51_MN3 (XI0_I51_an2 I0_pp0_8 VSS VSS) gpdk090_nmos1v w=0.24u l=0.1u ad=0.0528p as=0.0528p pd=0.68u ps=0.68u
    I_MXI0_I51_MN4 (VSS I0_pp1_7 XI0_I51_an2 VSS) gpdk090_nmos1v w=0.24u l=0.1u ad=0.0468p as=0.0528p pd=0.68u ps=0.68u
    I_MXI0_I51_MN27 (I0_cm8_2 XI0_I51_acon VSS VSS) gpdk090_nmos1v w=0.12u l=0.1u ad=0.0696p as=0.0468p pd=1.16u ps=0.68u
    I_MXI0_I51_MN7 (XI0_I51_an3 I0_pp1_7 VSS VSS) gpdk090_nmos1v w=0.24u l=0.1u ad=0.0528p as=0.0816p pd=0.68u ps=1.16u
    I_MXI0_I51_MN8 (VSS I0_pp2_5 XI0_I51_an3 VSS) gpdk090_nmos1v w=0.24u l=0.1u ad=0.0498p as=0.0528p pd=0.68u ps=0.68u
    I_MXI0_I50_MN34 (XI0_I50_bn3 XI0_I50_s1 VSS VSS) gpdk090_nmos1v w=0.24u l=0.1u ad=0.0528p as=0.0498p pd=0.68u ps=0.68u
    I_MXI0_I50_MN35 (VSS I0_pp3_2 XI0_I50_bn3 VSS) gpdk090_nmos1v w=0.24u l=0.1u ad=0.0528p as=0.0528p pd=0.68u ps=0.68u
    I_MXI0_I50_MN36 (XI0_I50_bn3 I0_cm6_2 VSS VSS) gpdk090_nmos1v w=0.24u l=0.1u ad=0.0528p as=0.0528p pd=0.68u ps=0.68u
    I_MXI0_I50_MN37 (XI0_I50_bsn XI0_I50_bcon XI0_I50_bn3 VSS) gpdk090_nmos1v w=0.24u l=0.1u ad=0.0498p as=0.0528p pd=0.68u ps=0.68u
    I_MXI0_I50_MN40 (XI0_I50_bn5 I0_cm6_2 XI0_I50_bsn VSS) gpdk090_nmos1v w=0.18u l=0.1u ad=0.0468p as=0.0498p pd=0.68u ps=0.68u
    I_MXI0_I50_MN39 (XI0_I50_bn4 I0_pp3_2 XI0_I50_bn5 VSS) gpdk090_nmos1v w=0.18u l=0.1u ad=0.0468p as=0.0468p pd=0.68u ps=0.68u
    I_MXI0_I50_MN39_1 (XI0_I50_bn5 I0_pp3_2 XI0_I50_bn4 VSS) gpdk090_nmos1v w=0.18u l=0.1u ad=0.0468p as=0.0468p pd=0.68u ps=0.68u
    I_MXI0_I50_MN40_1 (XI0_I50_bsn I0_cm6_2 XI0_I50_bn5 VSS) gpdk090_nmos1v w=0.18u l=0.1u ad=0.0756p as=0.0468p pd=1.16u ps=0.68u
    I_MXI0_I50_MN53 (VSS XI0_I50_bsn I0_cm7_0 VSS) gpdk090_nmos1v w=0.12u l=0.1u ad=0.0696p as=0.0696p pd=1.16u ps=1.16u
    I_MXI0_I50_MN29 (XI0_I50_bn1 XI0_I50_s1 VSS VSS) gpdk090_nmos1v w=0.24u l=0.1u ad=0.0528p as=0.0468p pd=0.68u ps=0.68u
    I_MXI0_I50_MN30 (XI0_I50_bcon I0_pp3_2 XI0_I50_bn1 VSS) gpdk090_nmos1v w=0.24u l=0.1u ad=0.0528p as=0.0528p pd=0.68u ps=0.68u
    I_MXI0_I50_MN33 (XI0_I50_bn2 I0_cm6_2 XI0_I50_bcon VSS) gpdk090_nmos1v w=0.24u l=0.1u ad=0.0528p as=0.0528p pd=0.68u ps=0.68u
    I_MXI0_I50_MN31 (VSS XI0_I50_s1 XI0_I50_bn2 VSS) gpdk090_nmos1v w=0.24u l=0.1u ad=0.0528p as=0.0528p pd=0.68u ps=0.68u
    I_MXI0_I50_MN32 (XI0_I50_bn2 I0_pp3_2 VSS VSS) gpdk090_nmos1v w=0.24u l=0.1u ad=0.0816p as=0.0528p pd=1.16u ps=0.68u
    I_MXI0_I50_MN55 (VSS XI0_I50_bcon I0_cm7_1 VSS) gpdk090_nmos1v w=0.12u l=0.1u ad=0.0438p as=0.0696p pd=0.68u ps=1.16u
    I_MXI0_I50_MN38 (XI0_I50_bn4 XI0_I50_s1 VSS VSS) gpdk090_nmos1v w=0.18u l=0.1u ad=0.0954p as=0.0438p pd=1.22u ps=0.68u
    I_MXI0_I50_MN38_1 (VSS XI0_I50_s1 XI0_I50_bn4 VSS) gpdk090_nmos1v w=0.18u l=0.1u ad=0.0498p as=0.0954p pd=0.68u ps=1.22u
    I_MXI0_I50_MN25 (VSS XI0_I50_asn XI0_I50_s1 VSS) gpdk090_nmos1v w=0.12u l=0.1u ad=0.0468p as=0.0696p pd=0.68u ps=1.16u
    I_MXI0_I50_MN10 (VSS I0_pp0_8 XI0_I50_an4 VSS) gpdk090_nmos1v w=0.18u l=0.1u ad=0.0498p as=0.0468p pd=0.68u ps=0.68u
    I_MXI0_I50_MN6 (XI0_I50_an3 I0_pp0_8 VSS VSS) gpdk090_nmos1v w=0.24u l=0.1u ad=0.0528p as=0.0498p pd=0.68u ps=0.68u
    I_MXI0_I50_MN9 (XI0_I50_asn XI0_I50_acon XI0_I50_an3 VSS) gpdk090_nmos1v w=0.24u l=0.1u ad=0.0498p as=0.0528p pd=0.68u ps=0.68u
    I_MXI0_I50_MN12 (XI0_I50_an5 I0_pp2_4 XI0_I50_asn VSS) gpdk090_nmos1v w=0.18u l=0.1u ad=0.0468p as=0.0498p pd=0.68u ps=0.68u
    I_MXI0_I50_MN11 (XI0_I50_an4 I0_pp1_6 XI0_I50_an5 VSS) gpdk090_nmos1v w=0.18u l=0.1u ad=0.144p as=0.0468p pd=1.76u ps=0.68u
    I_MXI0_I50_MN11_1 (XI0_I50_an5 I0_pp1_6 XI0_I50_an4 VSS) gpdk090_nmos1v w=0.18u l=0.1u ad=0.0468p as=0.144p pd=0.68u ps=1.76u
    I_MXI0_I50_MN12_1 (XI0_I50_asn I0_pp2_4 XI0_I50_an5 VSS) gpdk090_nmos1v w=0.18u l=0.1u ad=0.0756p as=0.0468p pd=1.16u ps=0.68u
    I_MXI0_I50_MN10_1 (XI0_I50_an4 I0_pp0_8 VSS VSS) gpdk090_nmos1v w=0.18u l=0.1u ad=0.0468p as=0.0498p pd=0.68u ps=0.68u
    I_MXI0_I50_MN5 (XI0_I50_acon I0_pp2_4 XI0_I50_an2 VSS) gpdk090_nmos1v w=0.24u l=0.1u ad=0.0528p as=0.0816p pd=0.68u ps=1.16u
    I_MXI0_I50_MN2 (XI0_I50_an1 I0_pp1_6 XI0_I50_acon VSS) gpdk090_nmos1v w=0.24u l=0.1u ad=0.0528p as=0.0528p pd=0.68u ps=0.68u
    I_MXI0_I50_MN1 (VSS I0_pp0_8 XI0_I50_an1 VSS) gpdk090_nmos1v w=0.24u l=0.1u ad=0.0528p as=0.0528p pd=0.68u ps=0.68u
    I_MXI0_I50_MN3 (XI0_I50_an2 I0_pp0_8 VSS VSS) gpdk090_nmos1v w=0.24u l=0.1u ad=0.0528p as=0.0528p pd=0.68u ps=0.68u
    I_MXI0_I50_MN4 (VSS I0_pp1_6 XI0_I50_an2 VSS) gpdk090_nmos1v w=0.24u l=0.1u ad=0.0468p as=0.0528p pd=0.68u ps=0.68u
    I_MXI0_I50_MN27 (I0_cm7_2 XI0_I50_acon VSS VSS) gpdk090_nmos1v w=0.12u l=0.1u ad=0.0696p as=0.0468p pd=1.16u ps=0.68u
    I_MXI0_I50_MN7 (XI0_I50_an3 I0_pp1_6 VSS VSS) gpdk090_nmos1v w=0.24u l=0.1u ad=0.0528p as=0.0816p pd=0.68u ps=1.16u
    I_MXI0_I50_MN8 (VSS I0_pp2_4 XI0_I50_an3 VSS) gpdk090_nmos1v w=0.24u l=0.1u ad=0.0498p as=0.0528p pd=0.68u ps=0.68u
    I_MXI0_I49_MN34 (XI0_I49_bn3 XI0_I49_s1 VSS VSS) gpdk090_nmos1v w=0.24u l=0.1u ad=0.0528p as=0.0498p pd=0.68u ps=0.68u
    I_MXI0_I49_MN35 (VSS I0_pp3_1 XI0_I49_bn3 VSS) gpdk090_nmos1v w=0.24u l=0.1u ad=0.0528p as=0.0528p pd=0.68u ps=0.68u
    I_MXI0_I49_MN36 (XI0_I49_bn3 I0_cm5_2 VSS VSS) gpdk090_nmos1v w=0.24u l=0.1u ad=0.0528p as=0.0528p pd=0.68u ps=0.68u
    I_MXI0_I49_MN37 (XI0_I49_bsn XI0_I49_bcon XI0_I49_bn3 VSS) gpdk090_nmos1v w=0.24u l=0.1u ad=0.0498p as=0.0528p pd=0.68u ps=0.68u
    I_MXI0_I49_MN40 (XI0_I49_bn5 I0_cm5_2 XI0_I49_bsn VSS) gpdk090_nmos1v w=0.18u l=0.1u ad=0.0468p as=0.0498p pd=0.68u ps=0.68u
    I_MXI0_I49_MN39 (XI0_I49_bn4 I0_pp3_1 XI0_I49_bn5 VSS) gpdk090_nmos1v w=0.18u l=0.1u ad=0.0468p as=0.0468p pd=0.68u ps=0.68u
    I_MXI0_I49_MN39_1 (XI0_I49_bn5 I0_pp3_1 XI0_I49_bn4 VSS) gpdk090_nmos1v w=0.18u l=0.1u ad=0.0468p as=0.0468p pd=0.68u ps=0.68u
    I_MXI0_I49_MN40_1 (XI0_I49_bsn I0_cm5_2 XI0_I49_bn5 VSS) gpdk090_nmos1v w=0.18u l=0.1u ad=0.0756p as=0.0468p pd=1.16u ps=0.68u
    I_MXI0_I49_MN53 (VSS XI0_I49_bsn I0_cm6_0 VSS) gpdk090_nmos1v w=0.12u l=0.1u ad=0.0696p as=0.0696p pd=1.16u ps=1.16u
    I_MXI0_I49_MN29 (XI0_I49_bn1 XI0_I49_s1 VSS VSS) gpdk090_nmos1v w=0.24u l=0.1u ad=0.0528p as=0.0468p pd=0.68u ps=0.68u
    I_MXI0_I49_MN30 (XI0_I49_bcon I0_pp3_1 XI0_I49_bn1 VSS) gpdk090_nmos1v w=0.24u l=0.1u ad=0.0528p as=0.0528p pd=0.68u ps=0.68u
    I_MXI0_I49_MN33 (XI0_I49_bn2 I0_cm5_2 XI0_I49_bcon VSS) gpdk090_nmos1v w=0.24u l=0.1u ad=0.0528p as=0.0528p pd=0.68u ps=0.68u
    I_MXI0_I49_MN31 (VSS XI0_I49_s1 XI0_I49_bn2 VSS) gpdk090_nmos1v w=0.24u l=0.1u ad=0.0528p as=0.0528p pd=0.68u ps=0.68u
    I_MXI0_I49_MN32 (XI0_I49_bn2 I0_pp3_1 VSS VSS) gpdk090_nmos1v w=0.24u l=0.1u ad=0.0816p as=0.0528p pd=1.16u ps=0.68u
    I_MXI0_I49_MN55 (VSS XI0_I49_bcon I0_cm6_1 VSS) gpdk090_nmos1v w=0.12u l=0.1u ad=0.0438p as=0.0696p pd=0.68u ps=1.16u
    I_MXI0_I49_MN38 (XI0_I49_bn4 XI0_I49_s1 VSS VSS) gpdk090_nmos1v w=0.18u l=0.1u ad=0.0954p as=0.0438p pd=1.22u ps=0.68u
    I_MXI0_I49_MN38_1 (VSS XI0_I49_s1 XI0_I49_bn4 VSS) gpdk090_nmos1v w=0.18u l=0.1u ad=0.0498p as=0.0954p pd=0.68u ps=1.22u
    I_MXI0_I49_MN25 (VSS XI0_I49_asn XI0_I49_s1 VSS) gpdk090_nmos1v w=0.12u l=0.1u ad=0.0468p as=0.0696p pd=0.68u ps=1.16u
    I_MXI0_I49_MN10 (VSS I0_pp0_7 XI0_I49_an4 VSS) gpdk090_nmos1v w=0.18u l=0.1u ad=0.0498p as=0.0468p pd=0.68u ps=0.68u
    I_MXI0_I49_MN6 (XI0_I49_an3 I0_pp0_7 VSS VSS) gpdk090_nmos1v w=0.24u l=0.1u ad=0.0528p as=0.0498p pd=0.68u ps=0.68u
    I_MXI0_I49_MN9 (XI0_I49_asn XI0_I49_acon XI0_I49_an3 VSS) gpdk090_nmos1v w=0.24u l=0.1u ad=0.0498p as=0.0528p pd=0.68u ps=0.68u
    I_MXI0_I49_MN12 (XI0_I49_an5 I0_pp2_3 XI0_I49_asn VSS) gpdk090_nmos1v w=0.18u l=0.1u ad=0.0468p as=0.0498p pd=0.68u ps=0.68u
    I_MXI0_I49_MN11 (XI0_I49_an4 I0_pp1_5 XI0_I49_an5 VSS) gpdk090_nmos1v w=0.18u l=0.1u ad=0.144p as=0.0468p pd=1.76u ps=0.68u
    I_MXI0_I49_MN11_1 (XI0_I49_an5 I0_pp1_5 XI0_I49_an4 VSS) gpdk090_nmos1v w=0.18u l=0.1u ad=0.0468p as=0.144p pd=0.68u ps=1.76u
    I_MXI0_I49_MN12_1 (XI0_I49_asn I0_pp2_3 XI0_I49_an5 VSS) gpdk090_nmos1v w=0.18u l=0.1u ad=0.0756p as=0.0468p pd=1.16u ps=0.68u
    I_MXI0_I49_MN10_1 (XI0_I49_an4 I0_pp0_7 VSS VSS) gpdk090_nmos1v w=0.18u l=0.1u ad=0.0468p as=0.0498p pd=0.68u ps=0.68u
    I_MXI0_I49_MN5 (XI0_I49_acon I0_pp2_3 XI0_I49_an2 VSS) gpdk090_nmos1v w=0.24u l=0.1u ad=0.0528p as=0.0816p pd=0.68u ps=1.16u
    I_MXI0_I49_MN2 (XI0_I49_an1 I0_pp1_5 XI0_I49_acon VSS) gpdk090_nmos1v w=0.24u l=0.1u ad=0.0528p as=0.0528p pd=0.68u ps=0.68u
    I_MXI0_I49_MN1 (VSS I0_pp0_7 XI0_I49_an1 VSS) gpdk090_nmos1v w=0.24u l=0.1u ad=0.0528p as=0.0528p pd=0.68u ps=0.68u
    I_MXI0_I49_MN3 (XI0_I49_an2 I0_pp0_7 VSS VSS) gpdk090_nmos1v w=0.24u l=0.1u ad=0.0528p as=0.0528p pd=0.68u ps=0.68u
    I_MXI0_I49_MN4 (VSS I0_pp1_5 XI0_I49_an2 VSS) gpdk090_nmos1v w=0.24u l=0.1u ad=0.0468p as=0.0528p pd=0.68u ps=0.68u
    I_MXI0_I49_MN27 (I0_cm6_2 XI0_I49_acon VSS VSS) gpdk090_nmos1v w=0.12u l=0.1u ad=0.0696p as=0.0468p pd=1.16u ps=0.68u
    I_MXI0_I49_MN7 (XI0_I49_an3 I0_pp1_5 VSS VSS) gpdk090_nmos1v w=0.24u l=0.1u ad=0.0528p as=0.0816p pd=0.68u ps=1.16u
    I_MXI0_I49_MN8 (VSS I0_pp2_3 XI0_I49_an3 VSS) gpdk090_nmos1v w=0.24u l=0.1u ad=0.0498p as=0.0528p pd=0.68u ps=0.68u
    I_MXI0_I48_MN34 (XI0_I48_bn3 XI0_I48_s1 VSS VSS) gpdk090_nmos1v w=0.24u l=0.1u ad=0.0528p as=0.0498p pd=0.68u ps=0.68u
    I_MXI0_I48_MN35 (VSS I0_pp3_0 XI0_I48_bn3 VSS) gpdk090_nmos1v w=0.24u l=0.1u ad=0.0528p as=0.0528p pd=0.68u ps=0.68u
    I_MXI0_I48_MN36 (XI0_I48_bn3 B_7 VSS VSS) gpdk090_nmos1v w=0.24u l=0.1u ad=0.0528p as=0.0528p pd=0.68u ps=0.68u
    I_MXI0_I48_MN37 (XI0_I48_bsn XI0_I48_bcon XI0_I48_bn3 VSS) gpdk090_nmos1v w=0.24u l=0.1u ad=0.0498p as=0.0528p pd=0.68u ps=0.68u
    I_MXI0_I48_MN40 (XI0_I48_bn5 B_7 XI0_I48_bsn VSS) gpdk090_nmos1v w=0.18u l=0.1u ad=0.0468p as=0.0498p pd=0.68u ps=0.68u
    I_MXI0_I48_MN39 (XI0_I48_bn4 I0_pp3_0 XI0_I48_bn5 VSS) gpdk090_nmos1v w=0.18u l=0.1u ad=0.0468p as=0.0468p pd=0.68u ps=0.68u
    I_MXI0_I48_MN39_1 (XI0_I48_bn5 I0_pp3_0 XI0_I48_bn4 VSS) gpdk090_nmos1v w=0.18u l=0.1u ad=0.0468p as=0.0468p pd=0.68u ps=0.68u
    I_MXI0_I48_MN40_1 (XI0_I48_bsn B_7 XI0_I48_bn5 VSS) gpdk090_nmos1v w=0.18u l=0.1u ad=0.0756p as=0.0468p pd=1.16u ps=0.68u
    I_MXI0_I48_MN53 (VSS XI0_I48_bsn I0_cm5_0 VSS) gpdk090_nmos1v w=0.12u l=0.1u ad=0.0696p as=0.0696p pd=1.16u ps=1.16u
    I_MXI0_I48_MN29 (XI0_I48_bn1 XI0_I48_s1 VSS VSS) gpdk090_nmos1v w=0.24u l=0.1u ad=0.0528p as=0.0468p pd=0.68u ps=0.68u
    I_MXI0_I48_MN30 (XI0_I48_bcon I0_pp3_0 XI0_I48_bn1 VSS) gpdk090_nmos1v w=0.24u l=0.1u ad=0.0528p as=0.0528p pd=0.68u ps=0.68u
    I_MXI0_I48_MN33 (XI0_I48_bn2 B_7 XI0_I48_bcon VSS) gpdk090_nmos1v w=0.24u l=0.1u ad=0.0528p as=0.0528p pd=0.68u ps=0.68u
    I_MXI0_I48_MN31 (VSS XI0_I48_s1 XI0_I48_bn2 VSS) gpdk090_nmos1v w=0.24u l=0.1u ad=0.0528p as=0.0528p pd=0.68u ps=0.68u
    I_MXI0_I48_MN32 (XI0_I48_bn2 I0_pp3_0 VSS VSS) gpdk090_nmos1v w=0.24u l=0.1u ad=0.0816p as=0.0528p pd=1.16u ps=0.68u
    I_MXI0_I48_MN55 (VSS XI0_I48_bcon I0_cm5_1 VSS) gpdk090_nmos1v w=0.12u l=0.1u ad=0.0438p as=0.0696p pd=0.68u ps=1.16u
    I_MXI0_I48_MN38 (XI0_I48_bn4 XI0_I48_s1 VSS VSS) gpdk090_nmos1v w=0.18u l=0.1u ad=0.0954p as=0.0438p pd=1.22u ps=0.68u
    I_MXI0_I48_MN38_1 (VSS XI0_I48_s1 XI0_I48_bn4 VSS) gpdk090_nmos1v w=0.18u l=0.1u ad=0.0498p as=0.0954p pd=0.68u ps=1.22u
    I_MXI0_I48_MN25 (VSS XI0_I48_asn XI0_I48_s1 VSS) gpdk090_nmos1v w=0.12u l=0.1u ad=0.0468p as=0.0696p pd=0.68u ps=1.16u
    I_MXI0_I48_MN10 (VSS I0_pp0_6 XI0_I48_an4 VSS) gpdk090_nmos1v w=0.18u l=0.1u ad=0.0498p as=0.0468p pd=0.68u ps=0.68u
    I_MXI0_I48_MN6 (XI0_I48_an3 I0_pp0_6 VSS VSS) gpdk090_nmos1v w=0.24u l=0.1u ad=0.0528p as=0.0498p pd=0.68u ps=0.68u
    I_MXI0_I48_MN9 (XI0_I48_asn XI0_I48_acon XI0_I48_an3 VSS) gpdk090_nmos1v w=0.24u l=0.1u ad=0.0498p as=0.0528p pd=0.68u ps=0.68u
    I_MXI0_I48_MN12 (XI0_I48_an5 I0_pp2_2 XI0_I48_asn VSS) gpdk090_nmos1v w=0.18u l=0.1u ad=0.0468p as=0.0498p pd=0.68u ps=0.68u
    I_MXI0_I48_MN11 (XI0_I48_an4 I0_pp1_4 XI0_I48_an5 VSS) gpdk090_nmos1v w=0.18u l=0.1u ad=0.144p as=0.0468p pd=1.76u ps=0.68u
    I_MXI0_I48_MN11_1 (XI0_I48_an5 I0_pp1_4 XI0_I48_an4 VSS) gpdk090_nmos1v w=0.18u l=0.1u ad=0.0468p as=0.144p pd=0.68u ps=1.76u
    I_MXI0_I48_MN12_1 (XI0_I48_asn I0_pp2_2 XI0_I48_an5 VSS) gpdk090_nmos1v w=0.18u l=0.1u ad=0.0756p as=0.0468p pd=1.16u ps=0.68u
    I_MXI0_I48_MN10_1 (XI0_I48_an4 I0_pp0_6 VSS VSS) gpdk090_nmos1v w=0.18u l=0.1u ad=0.0468p as=0.0498p pd=0.68u ps=0.68u
    I_MXI0_I48_MN5 (XI0_I48_acon I0_pp2_2 XI0_I48_an2 VSS) gpdk090_nmos1v w=0.24u l=0.1u ad=0.0528p as=0.0816p pd=0.68u ps=1.16u
    I_MXI0_I48_MN2 (XI0_I48_an1 I0_pp1_4 XI0_I48_acon VSS) gpdk090_nmos1v w=0.24u l=0.1u ad=0.0528p as=0.0528p pd=0.68u ps=0.68u
    I_MXI0_I48_MN1 (VSS I0_pp0_6 XI0_I48_an1 VSS) gpdk090_nmos1v w=0.24u l=0.1u ad=0.0528p as=0.0528p pd=0.68u ps=0.68u
    I_MXI0_I48_MN3 (XI0_I48_an2 I0_pp0_6 VSS VSS) gpdk090_nmos1v w=0.24u l=0.1u ad=0.0528p as=0.0528p pd=0.68u ps=0.68u
    I_MXI0_I48_MN4 (VSS I0_pp1_4 XI0_I48_an2 VSS) gpdk090_nmos1v w=0.24u l=0.1u ad=0.0468p as=0.0528p pd=0.68u ps=0.68u
    I_MXI0_I48_MN27 (I0_cm5_2 XI0_I48_acon VSS VSS) gpdk090_nmos1v w=0.12u l=0.1u ad=0.0696p as=0.0468p pd=1.16u ps=0.68u
    I_MXI0_I48_MN7 (XI0_I48_an3 I0_pp1_4 VSS VSS) gpdk090_nmos1v w=0.24u l=0.1u ad=0.0528p as=0.0816p pd=0.68u ps=1.16u
    I_MXI0_I48_MN8 (VSS I0_pp2_2 XI0_I48_an3 VSS) gpdk090_nmos1v w=0.24u l=0.1u ad=0.0498p as=0.0528p pd=0.68u ps=0.68u
    I_MXI2_I4_I15_MN0 (Z I2_I4_zd VSS VSS) gpdk090_nmos1v w=0.12u l=0.1u ad=0.0696p as=0.0696p pd=1.16u ps=1.16u
    I_MXI2_I0_I3_MN0 (I2_I0_opn3 OP_3 VSS VSS) gpdk090_nmos1v w=0.12u l=0.1u ad=0.0696p as=0.0696p pd=1.16u ps=1.16u
    I_MXI2_I0_I2_MN0 (I2_I0_opn2 OP_2 VSS VSS) gpdk090_nmos1v w=0.12u l=0.1u ad=0.0696p as=0.0696p pd=1.16u ps=1.16u
    I_MXI1_I191_MN0 (I1_nrk6 I1_nrkn6 VSS VSS) gpdk090_nmos1v w=0.12u l=0.1u ad=0.0696p as=0.0696p pd=1.16u ps=1.16u
    I_MXI0_I77_I33_MN0 (I0_I77_G1_0n I0_I77_G1_0 VSS VSS) gpdk090_nmos1v w=0.12u l=0.1u ad=0.0696p as=0.0696p pd=1.16u ps=1.16u
    I_MXI0_I43_MN0 (I0_sn3 I0_pp3_8 VSS VSS) gpdk090_nmos1v w=0.12u l=0.1u ad=0.0696p as=0.0696p pd=1.16u ps=1.16u
    I_MXI2_I2_I47_MN0 (I2_NOT_7 A_7 VSS VSS) gpdk090_nmos1v w=0.12u l=0.1u ad=0.0696p as=0.0696p pd=1.16u ps=1.16u
    I_MXI2_I0_I1_MN0 (I2_I0_opn1 OP_1 VSS VSS) gpdk090_nmos1v w=0.12u l=0.1u ad=0.0696p as=0.0696p pd=1.16u ps=1.16u
    I_MXI1_I152_I33_MN0 (I1_I152_G1_0n I1_I152_G1_0 VSS VSS) gpdk090_nmos1v w=0.12u l=0.1u ad=0.0696p as=0.0696p pd=1.16u ps=1.16u
    I_MXI1_I188_MN0 (I1_nrk5 I1_nrkn5 VSS VSS) gpdk090_nmos1v w=0.12u l=0.1u ad=0.0696p as=0.0696p pd=1.16u ps=1.16u
    I_MXI1_I185_MN0 (I1_nrk4 I1_nrkn4 VSS VSS) gpdk090_nmos1v w=0.12u l=0.1u ad=0.0696p as=0.0696p pd=1.16u ps=1.16u
    I_MXI1_I182_MN0 (I1_nrk3 I1_nrkn3 VSS VSS) gpdk090_nmos1v w=0.12u l=0.1u ad=0.0696p as=0.0696p pd=1.16u ps=1.16u
    I_MXI0_I32_MN0 (I0_sn2 I0_pp2_8 VSS VSS) gpdk090_nmos1v w=0.12u l=0.1u ad=0.0696p as=0.0696p pd=1.16u ps=1.16u
    I_MXI2_I2_I45_MN0 (I2_OR_7 I2_I2_nor7 VSS VSS) gpdk090_nmos1v w=0.12u l=0.1u ad=0.0696p as=0.0696p pd=1.16u ps=1.16u
    I_MXI2_I2_I43_MN0 (I2_AND_7 I2_I2_nand7 VSS VSS) gpdk090_nmos1v w=0.12u l=0.1u ad=0.0696p as=0.0696p pd=1.16u ps=1.16u
    I_MXI2_I0_I0_MN0 (I2_I0_opn0 OP_0 VSS VSS) gpdk090_nmos1v w=0.12u l=0.1u ad=0.0696p as=0.0696p pd=1.16u ps=1.16u
    I_MXI2_I2_I31_MN0 (I2_AND_5 I2_I2_nand5 VSS VSS) gpdk090_nmos1v w=0.12u l=0.1u ad=0.0696p as=0.0696p pd=1.16u ps=1.16u
    I_MXI1_I179_MN0 (I1_nrk2 I1_nrkn2 VSS VSS) gpdk090_nmos1v w=0.12u l=0.1u ad=0.0696p as=0.0696p pd=1.16u ps=1.16u
    I_MXI0_I77_I18_MN0 (I0_I77_G0_0n I0_I77_G0_0 VSS VSS) gpdk090_nmos1v w=0.12u l=0.1u ad=0.0696p as=0.0696p pd=1.16u ps=1.16u
    I_MXI0_I21_MN0 (I0_sn1 I0_pp1_8 VSS VSS) gpdk090_nmos1v w=0.12u l=0.1u ad=0.0696p as=0.0696p pd=1.16u ps=1.16u
    I_MXI0_I10_MN0 (I0_sn0 I0_pp0_8 VSS VSS) gpdk090_nmos1v w=0.12u l=0.1u ad=0.0696p as=0.0696p pd=1.16u ps=1.16u
    I_MXI2_I2_I37_MN0 (I2_AND_6 I2_I2_nand6 VSS VSS) gpdk090_nmos1v w=0.12u l=0.1u ad=0.0696p as=0.0696p pd=1.16u ps=1.16u
    I_MXI2_I2_I35_MN0 (I2_NOT_5 A_5 VSS VSS) gpdk090_nmos1v w=0.12u l=0.1u ad=0.0696p as=0.0696p pd=1.16u ps=1.16u
    I_MXI2_I2_I41_MN0 (I2_NOT_6 A_6 VSS VSS) gpdk090_nmos1v w=0.12u l=0.1u ad=0.0696p as=0.0696p pd=1.16u ps=1.16u
    I_MXI2_I2_I33_MN0 (I2_OR_5 I2_I2_nor5 VSS VSS) gpdk090_nmos1v w=0.12u l=0.1u ad=0.0696p as=0.0696p pd=1.16u ps=1.16u
    I_MXI1_I151_MN0 (I1_dm7 I1_dmn7 VSS VSS) gpdk090_nmos1v w=0.12u l=0.1u ad=0.0696p as=0.0696p pd=1.16u ps=1.16u
    I_MXI1_I152_I18_MN0 (I1_I152_G0_0n I1_I152_G0_0 VSS VSS) gpdk090_nmos1v w=0.12u l=0.1u ad=0.0696p as=0.0696p pd=1.16u ps=1.16u
    I_MXI1_I176_MN0 (I1_nrk1 I1_nrkn1 VSS VSS) gpdk090_nmos1v w=0.12u l=0.1u ad=0.0696p as=0.0696p pd=1.16u ps=1.16u
    I_MXI0_I77_I16_MN0 (I0_I77_cinn I0_rc8 VSS VSS) gpdk090_nmos1v w=0.12u l=0.1u ad=0.0696p as=0.0696p pd=1.16u ps=1.16u
    I_MXI2_I2_I39_MN0 (I2_OR_6 I2_I2_nor6 VSS VSS) gpdk090_nmos1v w=0.12u l=0.1u ad=0.0696p as=0.0696p pd=1.16u ps=1.16u
    I_MXI2_I2_I21_MN0 (I2_OR_3 I2_I2_nor3 VSS VSS) gpdk090_nmos1v w=0.12u l=0.1u ad=0.0696p as=0.0696p pd=1.16u ps=1.16u
    I_MXI2_I2_I19_MN0 (I2_AND_3 I2_I2_nand3 VSS VSS) gpdk090_nmos1v w=0.12u l=0.1u ad=0.0696p as=0.0696p pd=1.16u ps=1.16u
    I_MXI2_I2_I23_MN0 (I2_NOT_3 A_3 VSS VSS) gpdk090_nmos1v w=0.12u l=0.1u ad=0.0696p as=0.0696p pd=1.16u ps=1.16u
    I_MXI1_I149_MN0 (I1_dm6 I1_dmn6 VSS VSS) gpdk090_nmos1v w=0.12u l=0.1u ad=0.0696p as=0.0696p pd=1.16u ps=1.16u
    I_MXI1_I147_MN0 (I1_dm5 I1_dmn5 VSS VSS) gpdk090_nmos1v w=0.12u l=0.1u ad=0.0696p as=0.0696p pd=1.16u ps=1.16u
    I_MXI1_I152_I16_MN0 (I1_I152_cinn VSS VSS VSS) gpdk090_nmos1v w=0.12u l=0.1u ad=0.0696p as=0.0696p pd=1.16u ps=1.16u
    I_MXI1_I132_I33_MN0 (I1_I132_G1_0n I1_I132_G1_0 VSS VSS) gpdk090_nmos1v w=0.12u l=0.1u ad=0.0696p as=0.0696p pd=1.16u ps=1.16u
    I_MXI1_I145_MN0 (I1_dm4 I1_dmn4 VSS VSS) gpdk090_nmos1v w=0.12u l=0.1u ad=0.0696p as=0.0696p pd=1.16u ps=1.16u
    I_MXI1_I143_MN0 (I1_dm3 I1_dmn3 VSS VSS) gpdk090_nmos1v w=0.12u l=0.1u ad=0.0696p as=0.0696p pd=1.16u ps=1.16u
    I_MXI1_I141_MN0 (I1_dm2 I1_dmn2 VSS VSS) gpdk090_nmos1v w=0.12u l=0.1u ad=0.0696p as=0.0696p pd=1.16u ps=1.16u
    I_MXI1_I139_MN0 (I1_dm1 I1_dmn1 VSS VSS) gpdk090_nmos1v w=0.12u l=0.1u ad=0.0696p as=0.0696p pd=1.16u ps=1.16u
    I_MXI1_I132_I18_MN0 (I1_I132_G0_0n I1_I132_G0_0 VSS VSS) gpdk090_nmos1v w=0.12u l=0.1u ad=0.0696p as=0.0696p pd=1.16u ps=1.16u
    I_MXI1_I137_MN0 (I1_dm0 I1_dmn0 VSS VSS) gpdk090_nmos1v w=0.12u l=0.1u ad=0.0696p as=0.0696p pd=1.16u ps=1.16u
    I_MXI1_I37_MN0 (I1_nbk6 I1_nbkn6 VSS VSS) gpdk090_nmos1v w=0.12u l=0.1u ad=0.0696p as=0.0696p pd=1.16u ps=1.16u
    I_MXI2_I4_I17_MN0 (C I2_I4_cn VSS VSS) gpdk090_nmos1v w=0.12u l=0.1u ad=0.0696p as=0.0696p pd=1.16u ps=1.16u
    I_MXI2_I1_I8_I33_MN0 (I2_I1_I8_G1_0n I2_I1_I8_G1_0 VSS VSS) gpdk090_nmos1v w=0.12u l=0.1u ad=0.0696p as=0.0696p pd=1.16u ps=1.16u
    I_MXI1_I132_I16_MN0 (I1_I132_cinn I1_qu1 VSS VSS) gpdk090_nmos1v w=0.12u l=0.1u ad=0.0696p as=0.0696p pd=1.16u ps=1.16u
    I_MXI1_I34_MN0 (I1_nbk5 I1_nbkn5 VSS VSS) gpdk090_nmos1v w=0.12u l=0.1u ad=0.0696p as=0.0696p pd=1.16u ps=1.16u
    I_MXI1_I135_MN0 (DIVQ_0 I1_p7_8 VSS VSS) gpdk090_nmos1v w=0.12u l=0.1u ad=0.0696p as=0.0696p pd=1.16u ps=1.16u
    I_MXI1_I156_MN0 (I1_nqk1 I1_nqkn1 VSS VSS) gpdk090_nmos1v w=0.12u l=0.1u ad=0.0696p as=0.0696p pd=1.16u ps=1.16u
    I_MXI2_I4_I23_MN0 (DZ I2_I4_dzn VSS VSS) gpdk090_nmos1v w=0.12u l=0.1u ad=0.0696p as=0.0696p pd=1.16u ps=1.16u
    I_MXI2_I1_I8_I16_MN0 (I2_I1_I8_cinn OP_0 VSS VSS) gpdk090_nmos1v w=0.12u l=0.1u ad=0.0696p as=0.0696p pd=1.16u ps=1.16u
    I_MXI2_I1_I8_I18_MN0 (I2_I1_I8_G0_0n I2_I1_I8_G0_0 VSS VSS) gpdk090_nmos1v w=0.12u l=0.1u ad=0.0696p as=0.0696p pd=1.16u ps=1.16u
    I_MXI1_I120_I33_MN0 (I1_I120_G1_0n I1_I120_G1_0 VSS VSS) gpdk090_nmos1v w=0.12u l=0.1u ad=0.0696p as=0.0696p pd=1.16u ps=1.16u
    I_MXI1_I120_I18_MN0 (I1_I120_G0_0n I1_I120_G0_0 VSS VSS) gpdk090_nmos1v w=0.12u l=0.1u ad=0.0696p as=0.0696p pd=1.16u ps=1.16u
    I_MXI1_I120_I16_MN0 (I1_I120_cinn I1_qu2 VSS VSS) gpdk090_nmos1v w=0.12u l=0.1u ad=0.0696p as=0.0696p pd=1.16u ps=1.16u
    I_MXI1_I201_MN0 (I1_sqn I1_sq VSS VSS) gpdk090_nmos1v w=0.12u l=0.1u ad=0.0696p as=0.0696p pd=1.16u ps=1.16u
    I_MXI1_I31_MN0 (I1_nbk4 I1_nbkn4 VSS VSS) gpdk090_nmos1v w=0.12u l=0.1u ad=0.0696p as=0.0696p pd=1.16u ps=1.16u
    I_MXI1_I159_MN0 (I1_nqk2 I1_nqkn2 VSS VSS) gpdk090_nmos1v w=0.12u l=0.1u ad=0.0696p as=0.0696p pd=1.16u ps=1.16u
    I_MXI1_I28_MN0 (I1_nbk3 I1_nbkn3 VSS VSS) gpdk090_nmos1v w=0.12u l=0.1u ad=0.0696p as=0.0696p pd=1.16u ps=1.16u
    I_MXI2_I2_I5_MN0 (I2_NOT_0 A_0 VSS VSS) gpdk090_nmos1v w=0.12u l=0.1u ad=0.0696p as=0.0696p pd=1.16u ps=1.16u
    I_MXI2_I2_I29_MN0 (I2_NOT_4 A_4 VSS VSS) gpdk090_nmos1v w=0.12u l=0.1u ad=0.0696p as=0.0696p pd=1.16u ps=1.16u
    I_MXI1_I108_I16_MN0 (I1_I108_cinn I1_qu3 VSS VSS) gpdk090_nmos1v w=0.12u l=0.1u ad=0.0696p as=0.0696p pd=1.16u ps=1.16u
    I_MXI1_I162_MN0 (I1_nqk3 I1_nqkn3 VSS VSS) gpdk090_nmos1v w=0.12u l=0.1u ad=0.0696p as=0.0696p pd=1.16u ps=1.16u
    I_MXI1_I2_MN0 (I1_nak1 I1_nakn1 VSS VSS) gpdk090_nmos1v w=0.12u l=0.1u ad=0.0696p as=0.0696p pd=1.16u ps=1.16u
    I_MXI1_I5_MN0 (I1_nak2 I1_nakn2 VSS VSS) gpdk090_nmos1v w=0.12u l=0.1u ad=0.0696p as=0.0696p pd=1.16u ps=1.16u
    I_MXI1_I8_MN0 (I1_nak3 I1_nakn3 VSS VSS) gpdk090_nmos1v w=0.12u l=0.1u ad=0.0696p as=0.0696p pd=1.16u ps=1.16u
    I_MXI1_I11_MN0 (I1_nak4 I1_nakn4 VSS VSS) gpdk090_nmos1v w=0.12u l=0.1u ad=0.0696p as=0.0696p pd=1.16u ps=1.16u
    I_MXI1_I14_MN0 (I1_nak5 I1_nakn5 VSS VSS) gpdk090_nmos1v w=0.12u l=0.1u ad=0.0696p as=0.0696p pd=1.16u ps=1.16u
    I_MXI1_I22_MN0 (I1_nbk1 I1_nbkn1 VSS VSS) gpdk090_nmos1v w=0.12u l=0.1u ad=0.0696p as=0.0696p pd=1.16u ps=1.16u
    I_MXI1_I25_MN0 (I1_nbk2 I1_nbkn2 VSS VSS) gpdk090_nmos1v w=0.12u l=0.1u ad=0.0696p as=0.0696p pd=1.16u ps=1.16u
    I_MXI2_I2_I1_MN0 (I2_AND_0 I2_I2_nand0 VSS VSS) gpdk090_nmos1v w=0.12u l=0.1u ad=0.0696p as=0.0696p pd=1.16u ps=1.16u
    I_MXI2_I2_I11_MN0 (I2_NOT_1 A_1 VSS VSS) gpdk090_nmos1v w=0.12u l=0.1u ad=0.0696p as=0.0696p pd=1.16u ps=1.16u
    I_MXI2_I2_I27_MN0 (I2_OR_4 I2_I2_nor4 VSS VSS) gpdk090_nmos1v w=0.12u l=0.1u ad=0.0696p as=0.0696p pd=1.16u ps=1.16u
    I_MXI2_I2_I25_MN0 (I2_AND_4 I2_I2_nand4 VSS VSS) gpdk090_nmos1v w=0.12u l=0.1u ad=0.0696p as=0.0696p pd=1.16u ps=1.16u
    I_MXI1_I96_I16_MN0 (I1_I96_cinn I1_qu4 VSS VSS) gpdk090_nmos1v w=0.12u l=0.1u ad=0.0696p as=0.0696p pd=1.16u ps=1.16u
    I_MXI1_I84_I16_MN0 (I1_I84_cinn I1_qu5 VSS VSS) gpdk090_nmos1v w=0.12u l=0.1u ad=0.0696p as=0.0696p pd=1.16u ps=1.16u
    I_MXI1_I165_MN0 (I1_nqk4 I1_nqkn4 VSS VSS) gpdk090_nmos1v w=0.12u l=0.1u ad=0.0696p as=0.0696p pd=1.16u ps=1.16u
    I_MXI1_I168_MN0 (I1_nqk5 I1_nqkn5 VSS VSS) gpdk090_nmos1v w=0.12u l=0.1u ad=0.0696p as=0.0696p pd=1.16u ps=1.16u
    I_MXI1_I171_MN0 (I1_nqk6 I1_nqkn6 VSS VSS) gpdk090_nmos1v w=0.12u l=0.1u ad=0.0696p as=0.0696p pd=1.16u ps=1.16u
    I_MXI1_I17_MN0 (I1_nak6 I1_nakn6 VSS VSS) gpdk090_nmos1v w=0.12u l=0.1u ad=0.0696p as=0.0696p pd=1.16u ps=1.16u
    I_MXI2_I2_I3_MN0 (I2_OR_0 I2_I2_nor0 VSS VSS) gpdk090_nmos1v w=0.12u l=0.1u ad=0.0696p as=0.0696p pd=1.16u ps=1.16u
    I_MXI2_I2_I9_MN0 (I2_OR_1 I2_I2_nor1 VSS VSS) gpdk090_nmos1v w=0.12u l=0.1u ad=0.0696p as=0.0696p pd=1.16u ps=1.16u
    I_MXI2_I2_I7_MN0 (I2_AND_1 I2_I2_nand1 VSS VSS) gpdk090_nmos1v w=0.12u l=0.1u ad=0.0696p as=0.0696p pd=1.16u ps=1.16u
    I_MXI2_I2_I17_MN0 (I2_NOT_2 A_2 VSS VSS) gpdk090_nmos1v w=0.12u l=0.1u ad=0.0696p as=0.0696p pd=1.16u ps=1.16u
    I_MXI2_I2_I13_MN0 (I2_AND_2 I2_I2_nand2 VSS VSS) gpdk090_nmos1v w=0.12u l=0.1u ad=0.0696p as=0.0696p pd=1.16u ps=1.16u
    I_MXI1_I108_I18_MN0 (I1_I108_G0_0n I1_I108_G0_0 VSS VSS) gpdk090_nmos1v w=0.12u l=0.1u ad=0.0696p as=0.0696p pd=1.16u ps=1.16u
    I_MXI1_I72_I16_MN0 (I1_I72_cinn I1_qu6 VSS VSS) gpdk090_nmos1v w=0.12u l=0.1u ad=0.0696p as=0.0696p pd=1.16u ps=1.16u
    I_MXI1_I60_I16_MN0 (I1_I60_cinn I1_qu7 VSS VSS) gpdk090_nmos1v w=0.12u l=0.1u ad=0.0696p as=0.0696p pd=1.16u ps=1.16u
    I_MXI1_I48_I16_MN0 (I1_I48_cinn VDD VSS VSS) gpdk090_nmos1v w=0.12u l=0.1u ad=0.0696p as=0.0696p pd=1.16u ps=1.16u
    I_MXI2_I2_I15_MN0 (I2_OR_2 I2_I2_nor2 VSS VSS) gpdk090_nmos1v w=0.12u l=0.1u ad=0.0696p as=0.0696p pd=1.16u ps=1.16u
    I_MXI1_I108_I33_MN0 (I1_I108_G1_0n I1_I108_G1_0 VSS VSS) gpdk090_nmos1v w=0.12u l=0.1u ad=0.0696p as=0.0696p pd=1.16u ps=1.16u
    I_MXI1_I84_I18_MN0 (I1_I84_G0_0n I1_I84_G0_0 VSS VSS) gpdk090_nmos1v w=0.12u l=0.1u ad=0.0696p as=0.0696p pd=1.16u ps=1.16u
    I_MXI1_I72_I18_MN0 (I1_I72_G0_0n I1_I72_G0_0 VSS VSS) gpdk090_nmos1v w=0.12u l=0.1u ad=0.0696p as=0.0696p pd=1.16u ps=1.16u
    I_MXI1_I48_I18_MN0 (I1_I48_G0_0n I1_I48_G0_0 VSS VSS) gpdk090_nmos1v w=0.12u l=0.1u ad=0.0696p as=0.0696p pd=1.16u ps=1.16u
    I_MXI1_I96_I18_MN0 (I1_I96_G0_0n I1_I96_G0_0 VSS VSS) gpdk090_nmos1v w=0.12u l=0.1u ad=0.0696p as=0.0696p pd=1.16u ps=1.16u
    I_MXI1_I60_I18_MN0 (I1_I60_G0_0n I1_I60_G0_0 VSS VSS) gpdk090_nmos1v w=0.12u l=0.1u ad=0.0696p as=0.0696p pd=1.16u ps=1.16u
    I_MXI1_I48_I33_MN0 (I1_I48_G1_0n I1_I48_G1_0 VSS VSS) gpdk090_nmos1v w=0.12u l=0.1u ad=0.0696p as=0.0696p pd=1.16u ps=1.16u
    I_MXI1_I84_I33_MN0 (I1_I84_G1_0n I1_I84_G1_0 VSS VSS) gpdk090_nmos1v w=0.12u l=0.1u ad=0.0696p as=0.0696p pd=1.16u ps=1.16u
    I_MXI1_I96_I33_MN0 (I1_I96_G1_0n I1_I96_G1_0 VSS VSS) gpdk090_nmos1v w=0.12u l=0.1u ad=0.0696p as=0.0696p pd=1.16u ps=1.16u
    I_MXI1_I72_I33_MN0 (I1_I72_G1_0n I1_I72_G1_0 VSS VSS) gpdk090_nmos1v w=0.12u l=0.1u ad=0.0696p as=0.0696p pd=1.16u ps=1.16u
    I_MXI1_I60_I33_MN0 (I1_I60_G1_0n I1_I60_G1_0 VSS VSS) gpdk090_nmos1v w=0.12u l=0.1u ad=0.0696p as=0.0696p pd=1.16u ps=1.16u
    I_MXI0_I33_MN5 (I0_one3 B_6 XI0_I33_an1 VSS) gpdk090_nmos1v w=0.24u l=0.1u ad=0.0528p as=0.0816p pd=0.68u ps=1.16u
    I_MXI0_I33_MN7 (XI0_I33_an2 XI0_I33_aan I0_one3 VSS) gpdk090_nmos1v w=0.24u l=0.1u ad=0.0528p as=0.0528p pd=0.68u ps=0.68u
    I_MXI0_I33_MN8 (VSS XI0_I33_abn XI0_I33_an2 VSS) gpdk090_nmos1v w=0.24u l=0.1u ad=0.0528p as=0.0528p pd=0.68u ps=0.68u
    I_MXI0_I33_MN6 (XI0_I33_an1 B_5 VSS VSS) gpdk090_nmos1v w=0.24u l=0.1u ad=0.0816p as=0.0528p pd=1.16u ps=0.68u
    I_MXI0_I33_MN1 (XI0_I33_aan B_6 VSS VSS) gpdk090_nmos1v w=0.12u l=0.1u ad=0.0696p as=0.0696p pd=1.16u ps=1.16u
    I_MXI0_I33_MN3 (VSS B_5 XI0_I33_abn VSS) gpdk090_nmos1v w=0.12u l=0.1u ad=0.0696p as=0.0696p pd=1.16u ps=1.16u
    I_MXI0_I33_MN15 (XI0_I33_bbn B_6 VSS VSS) gpdk090_nmos1v w=0.12u l=0.1u ad=0.0696p as=0.0408p pd=1.16u ps=0.68u
    I_MXI0_I33_MN13 (XI0_I33_ban B_7 VSS VSS) gpdk090_nmos1v w=0.12u l=0.1u ad=0.0696p as=0.0696p pd=1.16u ps=1.16u
    I_MXI0_I33_MN19 (XI0_I33_bn2 XI0_I33_ban XI0_I33_e VSS) gpdk090_nmos1v w=0.24u l=0.1u ad=0.0528p as=0.0816p pd=0.68u ps=1.16u
    I_MXI0_I33_MN20 (VSS B_6 XI0_I33_bn2 VSS) gpdk090_nmos1v w=0.24u l=0.1u ad=0.0528p as=0.0528p pd=0.68u ps=0.68u
    I_MXI0_I33_MN18 (XI0_I33_bn1 XI0_I33_bbn VSS VSS) gpdk090_nmos1v w=0.24u l=0.1u ad=0.0528p as=0.0528p pd=0.68u ps=0.68u
    I_MXI0_I33_MN17 (XI0_I33_e B_7 XI0_I33_bn1 VSS) gpdk090_nmos1v w=0.24u l=0.1u ad=0.0816p as=0.0528p pd=1.16u ps=0.68u
    I_MXI0_I33_MN26 (I0_two3 I0_one3 VSS VSS) gpdk090_nmos1v w=0.12u l=0.1u ad=0.0408p as=0.0696p pd=0.68u ps=1.16u
    I_MXI0_I33_MN25 (VSS XI0_I33_e I0_two3 VSS) gpdk090_nmos1v w=0.12u l=0.1u ad=0.0408p as=0.0408p pd=0.68u ps=0.68u
    I_MXI0_I22_MN5 (I0_one2 B_4 XI0_I22_an1 VSS) gpdk090_nmos1v w=0.24u l=0.1u ad=0.0528p as=0.0816p pd=0.68u ps=1.16u
    I_MXI0_I22_MN7 (XI0_I22_an2 XI0_I22_aan I0_one2 VSS) gpdk090_nmos1v w=0.24u l=0.1u ad=0.0528p as=0.0528p pd=0.68u ps=0.68u
    I_MXI0_I22_MN8 (VSS XI0_I22_abn XI0_I22_an2 VSS) gpdk090_nmos1v w=0.24u l=0.1u ad=0.0528p as=0.0528p pd=0.68u ps=0.68u
    I_MXI0_I22_MN6 (XI0_I22_an1 B_3 VSS VSS) gpdk090_nmos1v w=0.24u l=0.1u ad=0.0816p as=0.0528p pd=1.16u ps=0.68u
    I_MXI0_I22_MN1 (XI0_I22_aan B_4 VSS VSS) gpdk090_nmos1v w=0.12u l=0.1u ad=0.0696p as=0.0696p pd=1.16u ps=1.16u
    I_MXI0_I22_MN3 (VSS B_3 XI0_I22_abn VSS) gpdk090_nmos1v w=0.12u l=0.1u ad=0.0696p as=0.0696p pd=1.16u ps=1.16u
    I_MXI0_I22_MN15 (XI0_I22_bbn B_4 VSS VSS) gpdk090_nmos1v w=0.12u l=0.1u ad=0.0696p as=0.0408p pd=1.16u ps=0.68u
    I_MXI0_I22_MN13 (XI0_I22_ban B_5 VSS VSS) gpdk090_nmos1v w=0.12u l=0.1u ad=0.0696p as=0.0696p pd=1.16u ps=1.16u
    I_MXI0_I22_MN19 (XI0_I22_bn2 XI0_I22_ban XI0_I22_e VSS) gpdk090_nmos1v w=0.24u l=0.1u ad=0.0528p as=0.0816p pd=0.68u ps=1.16u
    I_MXI0_I22_MN20 (VSS B_4 XI0_I22_bn2 VSS) gpdk090_nmos1v w=0.24u l=0.1u ad=0.0528p as=0.0528p pd=0.68u ps=0.68u
    I_MXI0_I22_MN18 (XI0_I22_bn1 XI0_I22_bbn VSS VSS) gpdk090_nmos1v w=0.24u l=0.1u ad=0.0528p as=0.0528p pd=0.68u ps=0.68u
    I_MXI0_I22_MN17 (XI0_I22_e B_5 XI0_I22_bn1 VSS) gpdk090_nmos1v w=0.24u l=0.1u ad=0.0816p as=0.0528p pd=1.16u ps=0.68u
    I_MXI0_I22_MN26 (I0_two2 I0_one2 VSS VSS) gpdk090_nmos1v w=0.12u l=0.1u ad=0.0408p as=0.0696p pd=0.68u ps=1.16u
    I_MXI0_I22_MN25 (VSS XI0_I22_e I0_two2 VSS) gpdk090_nmos1v w=0.12u l=0.1u ad=0.0408p as=0.0408p pd=0.68u ps=0.68u
    I_MXI0_I11_MN5 (I0_one1 B_2 XI0_I11_an1 VSS) gpdk090_nmos1v w=0.24u l=0.1u ad=0.0528p as=0.0816p pd=0.68u ps=1.16u
    I_MXI0_I11_MN7 (XI0_I11_an2 XI0_I11_aan I0_one1 VSS) gpdk090_nmos1v w=0.24u l=0.1u ad=0.0528p as=0.0528p pd=0.68u ps=0.68u
    I_MXI0_I11_MN8 (VSS XI0_I11_abn XI0_I11_an2 VSS) gpdk090_nmos1v w=0.24u l=0.1u ad=0.0528p as=0.0528p pd=0.68u ps=0.68u
    I_MXI0_I11_MN6 (XI0_I11_an1 B_1 VSS VSS) gpdk090_nmos1v w=0.24u l=0.1u ad=0.0816p as=0.0528p pd=1.16u ps=0.68u
    I_MXI0_I11_MN1 (XI0_I11_aan B_2 VSS VSS) gpdk090_nmos1v w=0.12u l=0.1u ad=0.0696p as=0.0696p pd=1.16u ps=1.16u
    I_MXI0_I11_MN3 (VSS B_1 XI0_I11_abn VSS) gpdk090_nmos1v w=0.12u l=0.1u ad=0.0696p as=0.0696p pd=1.16u ps=1.16u
    I_MXI0_I11_MN15 (XI0_I11_bbn B_2 VSS VSS) gpdk090_nmos1v w=0.12u l=0.1u ad=0.0696p as=0.0408p pd=1.16u ps=0.68u
    I_MXI0_I11_MN13 (XI0_I11_ban B_3 VSS VSS) gpdk090_nmos1v w=0.12u l=0.1u ad=0.0696p as=0.0696p pd=1.16u ps=1.16u
    I_MXI0_I11_MN19 (XI0_I11_bn2 XI0_I11_ban XI0_I11_e VSS) gpdk090_nmos1v w=0.24u l=0.1u ad=0.0528p as=0.0816p pd=0.68u ps=1.16u
    I_MXI0_I11_MN20 (VSS B_2 XI0_I11_bn2 VSS) gpdk090_nmos1v w=0.24u l=0.1u ad=0.0528p as=0.0528p pd=0.68u ps=0.68u
    I_MXI0_I11_MN18 (XI0_I11_bn1 XI0_I11_bbn VSS VSS) gpdk090_nmos1v w=0.24u l=0.1u ad=0.0528p as=0.0528p pd=0.68u ps=0.68u
    I_MXI0_I11_MN17 (XI0_I11_e B_3 XI0_I11_bn1 VSS) gpdk090_nmos1v w=0.24u l=0.1u ad=0.0816p as=0.0528p pd=1.16u ps=0.68u
    I_MXI0_I11_MN26 (I0_two1 I0_one1 VSS VSS) gpdk090_nmos1v w=0.12u l=0.1u ad=0.0408p as=0.0696p pd=0.68u ps=1.16u
    I_MXI0_I11_MN25 (VSS XI0_I11_e I0_two1 VSS) gpdk090_nmos1v w=0.12u l=0.1u ad=0.0408p as=0.0408p pd=0.68u ps=0.68u
    I_MXI0_I0_MN5 (I0_one0 B_0 XI0_I0_an1 VSS) gpdk090_nmos1v w=0.24u l=0.1u ad=0.0528p as=0.0816p pd=0.68u ps=1.16u
    I_MXI0_I0_MN7 (XI0_I0_an2 XI0_I0_aan I0_one0 VSS) gpdk090_nmos1v w=0.24u l=0.1u ad=0.0528p as=0.0528p pd=0.68u ps=0.68u
    I_MXI0_I0_MN8 (VSS XI0_I0_abn XI0_I0_an2 VSS) gpdk090_nmos1v w=0.24u l=0.1u ad=0.0528p as=0.0528p pd=0.68u ps=0.68u
    I_MXI0_I0_MN6 (XI0_I0_an1 VSS VSS VSS) gpdk090_nmos1v w=0.24u l=0.1u ad=0.0816p as=0.0528p pd=1.16u ps=0.68u
    I_MXI0_I0_MN1 (XI0_I0_aan B_0 VSS VSS) gpdk090_nmos1v w=0.12u l=0.1u ad=0.0696p as=0.0696p pd=1.16u ps=1.16u
    I_MXI0_I0_MN3 (VSS VSS XI0_I0_abn VSS) gpdk090_nmos1v w=0.12u l=0.1u ad=0.0696p as=0.0696p pd=1.16u ps=1.16u
    I_MXI0_I0_MN15 (XI0_I0_bbn B_0 VSS VSS) gpdk090_nmos1v w=0.12u l=0.1u ad=0.0696p as=0.0408p pd=1.16u ps=0.68u
    I_MXI0_I0_MN13 (XI0_I0_ban B_1 VSS VSS) gpdk090_nmos1v w=0.12u l=0.1u ad=0.0696p as=0.0696p pd=1.16u ps=1.16u
    I_MXI0_I0_MN19 (XI0_I0_bn2 XI0_I0_ban XI0_I0_e VSS) gpdk090_nmos1v w=0.24u l=0.1u ad=0.0528p as=0.0816p pd=0.68u ps=1.16u
    I_MXI0_I0_MN20 (VSS B_0 XI0_I0_bn2 VSS) gpdk090_nmos1v w=0.24u l=0.1u ad=0.0528p as=0.0528p pd=0.68u ps=0.68u
    I_MXI0_I0_MN18 (XI0_I0_bn1 XI0_I0_bbn VSS VSS) gpdk090_nmos1v w=0.24u l=0.1u ad=0.0528p as=0.0528p pd=0.68u ps=0.68u
    I_MXI0_I0_MN17 (XI0_I0_e B_1 XI0_I0_bn1 VSS) gpdk090_nmos1v w=0.24u l=0.1u ad=0.0816p as=0.0528p pd=1.16u ps=0.68u
    I_MXI0_I0_MN26 (I0_two0 I0_one0 VSS VSS) gpdk090_nmos1v w=0.12u l=0.1u ad=0.0408p as=0.0696p pd=0.68u ps=1.16u
    I_MXI0_I0_MN25 (VSS XI0_I0_e I0_two0 VSS) gpdk090_nmos1v w=0.12u l=0.1u ad=0.0408p as=0.0408p pd=0.68u ps=0.68u
    I_MXI0_I77_I41_MN1 (XI0_I77_I41_Bn I0_I77_G3_0n VSS VSS) gpdk090_nmos1v w=0.12u l=0.1u ad=0.0696p as=0.0696p pd=1.16u ps=1.16u
    I_MXI0_I77_I41_MN5 (XI0_I77_I41_n2 XI0_I77_I41_Bn VSS VSS) gpdk090_nmos1v w=0.24u l=0.1u ad=0.0528p as=0.0816p pd=0.68u ps=1.16u
    I_MXI0_I77_I41_MN4 (MULP_12 XI0_I77_I41_An XI0_I77_I41_n2 VSS) gpdk090_nmos1v w=0.24u l=0.1u ad=0.0528p as=0.0528p pd=0.68u ps=0.68u
    I_MXI0_I77_I41_MN2 (XI0_I77_I41_n1 I0_I77_pn4 MULP_12 VSS) gpdk090_nmos1v w=0.24u l=0.1u ad=0.0528p as=0.0528p pd=0.68u ps=0.68u
    I_MXI0_I77_I41_MN3 (VSS I0_I77_G3_0n XI0_I77_I41_n1 VSS) gpdk090_nmos1v w=0.24u l=0.1u ad=0.0816p as=0.0528p pd=1.16u ps=0.68u
    I_MXI0_I77_I41_MN0 (XI0_I77_I41_An I0_I77_pn4 VSS VSS) gpdk090_nmos1v w=0.12u l=0.1u ad=0.0696p as=0.0696p pd=1.16u ps=1.16u
    I_MXI1_I152_I41_MN1 (XI1_I152_I41_Bn I1_I152_G3_0n VSS VSS) gpdk090_nmos1v w=0.12u l=0.1u ad=0.0696p as=0.0696p pd=1.16u ps=1.16u
    I_MXI1_I152_I41_MN5 (XI1_I152_I41_n2 XI1_I152_I41_Bn VSS VSS) gpdk090_nmos1v w=0.24u l=0.1u ad=0.0528p as=0.0816p pd=0.68u ps=1.16u
    I_MXI1_I152_I41_MN4 (I1_ru4 XI1_I152_I41_An XI1_I152_I41_n2 VSS) gpdk090_nmos1v w=0.24u l=0.1u ad=0.0528p as=0.0528p pd=0.68u ps=0.68u
    I_MXI1_I152_I41_MN2 (XI1_I152_I41_n1 I1_I152_pn4 I1_ru4 VSS) gpdk090_nmos1v w=0.24u l=0.1u ad=0.0528p as=0.0528p pd=0.68u ps=0.68u
    I_MXI1_I152_I41_MN3 (VSS I1_I152_G3_0n XI1_I152_I41_n1 VSS) gpdk090_nmos1v w=0.24u l=0.1u ad=0.0816p as=0.0528p pd=1.16u ps=0.68u
    I_MXI1_I152_I41_MN0 (XI1_I152_I41_An I1_I152_pn4 VSS VSS) gpdk090_nmos1v w=0.12u l=0.1u ad=0.0696p as=0.0696p pd=1.16u ps=1.16u
    I_MXI0_I77_I40_MN1 (XI0_I77_I40_Bn I0_I77_G2_0n VSS VSS) gpdk090_nmos1v w=0.12u l=0.1u ad=0.0696p as=0.0696p pd=1.16u ps=1.16u
    I_MXI0_I77_I40_MN5 (XI0_I77_I40_n2 XI0_I77_I40_Bn VSS VSS) gpdk090_nmos1v w=0.24u l=0.1u ad=0.0528p as=0.0816p pd=0.68u ps=1.16u
    I_MXI0_I77_I40_MN4 (MULP_11 XI0_I77_I40_An XI0_I77_I40_n2 VSS) gpdk090_nmos1v w=0.24u l=0.1u ad=0.0528p as=0.0528p pd=0.68u ps=0.68u
    I_MXI0_I77_I40_MN2 (XI0_I77_I40_n1 I0_I77_pn3 MULP_11 VSS) gpdk090_nmos1v w=0.24u l=0.1u ad=0.0528p as=0.0528p pd=0.68u ps=0.68u
    I_MXI0_I77_I40_MN3 (VSS I0_I77_G2_0n XI0_I77_I40_n1 VSS) gpdk090_nmos1v w=0.24u l=0.1u ad=0.0816p as=0.0528p pd=1.16u ps=0.68u
    I_MXI0_I77_I40_MN0 (XI0_I77_I40_An I0_I77_pn3 VSS VSS) gpdk090_nmos1v w=0.12u l=0.1u ad=0.0696p as=0.0696p pd=1.16u ps=1.16u
    I_MXI2_I2_I46_MN1 (XI2_I2_I46_Bn B_7 VSS VSS) gpdk090_nmos1v w=0.12u l=0.1u ad=0.0696p as=0.0696p pd=1.16u ps=1.16u
    I_MXI2_I2_I46_MN5 (XI2_I2_I46_n2 XI2_I2_I46_Bn VSS VSS) gpdk090_nmos1v w=0.24u l=0.1u ad=0.0528p as=0.0816p pd=0.68u ps=1.16u
    I_MXI2_I2_I46_MN4 (I2_XOR_7 XI2_I2_I46_An XI2_I2_I46_n2 VSS) gpdk090_nmos1v w=0.24u l=0.1u ad=0.0528p as=0.0528p pd=0.68u ps=0.68u
    I_MXI2_I2_I46_MN2 (XI2_I2_I46_n1 A_7 I2_XOR_7 VSS) gpdk090_nmos1v w=0.24u l=0.1u ad=0.0528p as=0.0528p pd=0.68u ps=0.68u
    I_MXI2_I2_I46_MN3 (VSS B_7 XI2_I2_I46_n1 VSS) gpdk090_nmos1v w=0.24u l=0.1u ad=0.0816p as=0.0528p pd=1.16u ps=0.68u
    I_MXI2_I2_I46_MN0 (XI2_I2_I46_An A_7 VSS VSS) gpdk090_nmos1v w=0.12u l=0.1u ad=0.0696p as=0.0696p pd=1.16u ps=1.16u
    I_MXI2_I2_I34_MN1 (XI2_I2_I34_Bn B_5 VSS VSS) gpdk090_nmos1v w=0.12u l=0.1u ad=0.0696p as=0.0696p pd=1.16u ps=1.16u
    I_MXI2_I2_I34_MN5 (XI2_I2_I34_n2 XI2_I2_I34_Bn VSS VSS) gpdk090_nmos1v w=0.24u l=0.1u ad=0.0528p as=0.0816p pd=0.68u ps=1.16u
    I_MXI2_I2_I34_MN4 (I2_XOR_5 XI2_I2_I34_An XI2_I2_I34_n2 VSS) gpdk090_nmos1v w=0.24u l=0.1u ad=0.0528p as=0.0528p pd=0.68u ps=0.68u
    I_MXI2_I2_I34_MN2 (XI2_I2_I34_n1 A_5 I2_XOR_5 VSS) gpdk090_nmos1v w=0.24u l=0.1u ad=0.0528p as=0.0528p pd=0.68u ps=0.68u
    I_MXI2_I2_I34_MN3 (VSS B_5 XI2_I2_I34_n1 VSS) gpdk090_nmos1v w=0.24u l=0.1u ad=0.0816p as=0.0528p pd=1.16u ps=0.68u
    I_MXI2_I2_I34_MN0 (XI2_I2_I34_An A_5 VSS VSS) gpdk090_nmos1v w=0.12u l=0.1u ad=0.0696p as=0.0696p pd=1.16u ps=1.16u
    I_MXI1_I152_I40_MN1 (XI1_I152_I40_Bn I1_I152_G2_0n VSS VSS) gpdk090_nmos1v w=0.12u l=0.1u ad=0.0696p as=0.0696p pd=1.16u ps=1.16u
    I_MXI1_I152_I40_MN5 (XI1_I152_I40_n2 XI1_I152_I40_Bn VSS VSS) gpdk090_nmos1v w=0.24u l=0.1u ad=0.0528p as=0.0816p pd=0.68u ps=1.16u
    I_MXI1_I152_I40_MN4 (I1_ru3 XI1_I152_I40_An XI1_I152_I40_n2 VSS) gpdk090_nmos1v w=0.24u l=0.1u ad=0.0528p as=0.0528p pd=0.68u ps=0.68u
    I_MXI1_I152_I40_MN2 (XI1_I152_I40_n1 I1_I152_pn3 I1_ru3 VSS) gpdk090_nmos1v w=0.24u l=0.1u ad=0.0528p as=0.0528p pd=0.68u ps=0.68u
    I_MXI1_I152_I40_MN3 (VSS I1_I152_G2_0n XI1_I152_I40_n1 VSS) gpdk090_nmos1v w=0.24u l=0.1u ad=0.0816p as=0.0528p pd=1.16u ps=0.68u
    I_MXI1_I152_I40_MN0 (XI1_I152_I40_An I1_I152_pn3 VSS VSS) gpdk090_nmos1v w=0.12u l=0.1u ad=0.0696p as=0.0696p pd=1.16u ps=1.16u
    I_MXI2_I1_I7_MN1 (XI2_I1_I7_Bn OP_0 VSS VSS) gpdk090_nmos1v w=0.12u l=0.1u ad=0.0696p as=0.0696p pd=1.16u ps=1.16u
    I_MXI2_I1_I7_MN5 (XI2_I1_I7_n2 XI2_I1_I7_Bn VSS VSS) gpdk090_nmos1v w=0.24u l=0.1u ad=0.0528p as=0.0816p pd=0.68u ps=1.16u
    I_MXI2_I1_I7_MN4 (I2_I1_bx7 XI2_I1_I7_An XI2_I1_I7_n2 VSS) gpdk090_nmos1v w=0.24u l=0.1u ad=0.0528p as=0.0528p pd=0.68u ps=0.68u
    I_MXI2_I1_I7_MN2 (XI2_I1_I7_n1 B_7 I2_I1_bx7 VSS) gpdk090_nmos1v w=0.24u l=0.1u ad=0.0528p as=0.0528p pd=0.68u ps=0.68u
    I_MXI2_I1_I7_MN3 (VSS OP_0 XI2_I1_I7_n1 VSS) gpdk090_nmos1v w=0.24u l=0.1u ad=0.0816p as=0.0528p pd=1.16u ps=0.68u
    I_MXI2_I1_I7_MN0 (XI2_I1_I7_An B_7 VSS VSS) gpdk090_nmos1v w=0.12u l=0.1u ad=0.0696p as=0.0696p pd=1.16u ps=1.16u
    I_MXI2_I2_I40_MN1 (XI2_I2_I40_Bn B_6 VSS VSS) gpdk090_nmos1v w=0.12u l=0.1u ad=0.0696p as=0.0696p pd=1.16u ps=1.16u
    I_MXI2_I2_I40_MN5 (XI2_I2_I40_n2 XI2_I2_I40_Bn VSS VSS) gpdk090_nmos1v w=0.24u l=0.1u ad=0.0528p as=0.0816p pd=0.68u ps=1.16u
    I_MXI2_I2_I40_MN4 (I2_XOR_6 XI2_I2_I40_An XI2_I2_I40_n2 VSS) gpdk090_nmos1v w=0.24u l=0.1u ad=0.0528p as=0.0528p pd=0.68u ps=0.68u
    I_MXI2_I2_I40_MN2 (XI2_I2_I40_n1 A_6 I2_XOR_6 VSS) gpdk090_nmos1v w=0.24u l=0.1u ad=0.0528p as=0.0528p pd=0.68u ps=0.68u
    I_MXI2_I2_I40_MN3 (VSS B_6 XI2_I2_I40_n1 VSS) gpdk090_nmos1v w=0.24u l=0.1u ad=0.0816p as=0.0528p pd=1.16u ps=0.68u
    I_MXI2_I2_I40_MN0 (XI2_I2_I40_An A_6 VSS VSS) gpdk090_nmos1v w=0.12u l=0.1u ad=0.0696p as=0.0696p pd=1.16u ps=1.16u
    I_MXI2_I1_I6_MN1 (XI2_I1_I6_Bn OP_0 VSS VSS) gpdk090_nmos1v w=0.12u l=0.1u ad=0.0696p as=0.0696p pd=1.16u ps=1.16u
    I_MXI2_I1_I6_MN5 (XI2_I1_I6_n2 XI2_I1_I6_Bn VSS VSS) gpdk090_nmos1v w=0.24u l=0.1u ad=0.0528p as=0.0816p pd=0.68u ps=1.16u
    I_MXI2_I1_I6_MN4 (I2_I1_bx6 XI2_I1_I6_An XI2_I1_I6_n2 VSS) gpdk090_nmos1v w=0.24u l=0.1u ad=0.0528p as=0.0528p pd=0.68u ps=0.68u
    I_MXI2_I1_I6_MN2 (XI2_I1_I6_n1 B_6 I2_I1_bx6 VSS) gpdk090_nmos1v w=0.24u l=0.1u ad=0.0528p as=0.0528p pd=0.68u ps=0.68u
    I_MXI2_I1_I6_MN3 (VSS OP_0 XI2_I1_I6_n1 VSS) gpdk090_nmos1v w=0.24u l=0.1u ad=0.0816p as=0.0528p pd=1.16u ps=0.68u
    I_MXI2_I1_I6_MN0 (XI2_I1_I6_An B_6 VSS VSS) gpdk090_nmos1v w=0.12u l=0.1u ad=0.0696p as=0.0696p pd=1.16u ps=1.16u
    I_MXI2_I2_I22_MN1 (XI2_I2_I22_Bn B_3 VSS VSS) gpdk090_nmos1v w=0.12u l=0.1u ad=0.0696p as=0.0696p pd=1.16u ps=1.16u
    I_MXI2_I2_I22_MN5 (XI2_I2_I22_n2 XI2_I2_I22_Bn VSS VSS) gpdk090_nmos1v w=0.24u l=0.1u ad=0.0528p as=0.0816p pd=0.68u ps=1.16u
    I_MXI2_I2_I22_MN4 (I2_XOR_3 XI2_I2_I22_An XI2_I2_I22_n2 VSS) gpdk090_nmos1v w=0.24u l=0.1u ad=0.0528p as=0.0528p pd=0.68u ps=0.68u
    I_MXI2_I2_I22_MN2 (XI2_I2_I22_n1 A_3 I2_XOR_3 VSS) gpdk090_nmos1v w=0.24u l=0.1u ad=0.0528p as=0.0528p pd=0.68u ps=0.68u
    I_MXI2_I2_I22_MN3 (VSS B_3 XI2_I2_I22_n1 VSS) gpdk090_nmos1v w=0.24u l=0.1u ad=0.0816p as=0.0528p pd=1.16u ps=0.68u
    I_MXI2_I2_I22_MN0 (XI2_I2_I22_An A_3 VSS VSS) gpdk090_nmos1v w=0.12u l=0.1u ad=0.0696p as=0.0696p pd=1.16u ps=1.16u
    I_MXI2_I1_I5_MN1 (XI2_I1_I5_Bn OP_0 VSS VSS) gpdk090_nmos1v w=0.12u l=0.1u ad=0.0696p as=0.0696p pd=1.16u ps=1.16u
    I_MXI2_I1_I5_MN5 (XI2_I1_I5_n2 XI2_I1_I5_Bn VSS VSS) gpdk090_nmos1v w=0.24u l=0.1u ad=0.0528p as=0.0816p pd=0.68u ps=1.16u
    I_MXI2_I1_I5_MN4 (I2_I1_bx5 XI2_I1_I5_An XI2_I1_I5_n2 VSS) gpdk090_nmos1v w=0.24u l=0.1u ad=0.0528p as=0.0528p pd=0.68u ps=0.68u
    I_MXI2_I1_I5_MN2 (XI2_I1_I5_n1 B_5 I2_I1_bx5 VSS) gpdk090_nmos1v w=0.24u l=0.1u ad=0.0528p as=0.0528p pd=0.68u ps=0.68u
    I_MXI2_I1_I5_MN3 (VSS OP_0 XI2_I1_I5_n1 VSS) gpdk090_nmos1v w=0.24u l=0.1u ad=0.0816p as=0.0528p pd=1.16u ps=0.68u
    I_MXI2_I1_I5_MN0 (XI2_I1_I5_An B_5 VSS VSS) gpdk090_nmos1v w=0.12u l=0.1u ad=0.0696p as=0.0696p pd=1.16u ps=1.16u
    I_MXI1_I132_I41_MN1 (XI1_I132_I41_Bn I1_I132_G3_0n VSS VSS) gpdk090_nmos1v w=0.12u l=0.1u ad=0.0696p as=0.0696p pd=1.16u ps=1.16u
    I_MXI1_I132_I41_MN5 (XI1_I132_I41_n2 XI1_I132_I41_Bn VSS VSS) gpdk090_nmos1v w=0.24u l=0.1u ad=0.0528p as=0.0816p pd=0.68u ps=1.16u
    I_MXI1_I132_I41_MN4 (I1_p7_4 XI1_I132_I41_An XI1_I132_I41_n2 VSS) gpdk090_nmos1v w=0.24u l=0.1u ad=0.0528p as=0.0528p pd=0.68u ps=0.68u
    I_MXI1_I132_I41_MN2 (XI1_I132_I41_n1 I1_I132_pn4 I1_p7_4 VSS) gpdk090_nmos1v w=0.24u l=0.1u ad=0.0528p as=0.0528p pd=0.68u ps=0.68u
    I_MXI1_I132_I41_MN3 (VSS I1_I132_G3_0n XI1_I132_I41_n1 VSS) gpdk090_nmos1v w=0.24u l=0.1u ad=0.0816p as=0.0528p pd=1.16u ps=0.68u
    I_MXI1_I132_I41_MN0 (XI1_I132_I41_An I1_I132_pn4 VSS VSS) gpdk090_nmos1v w=0.12u l=0.1u ad=0.0696p as=0.0696p pd=1.16u ps=1.16u
    I_MXI1_I132_I40_MN1 (XI1_I132_I40_Bn I1_I132_G2_0n VSS VSS) gpdk090_nmos1v w=0.12u l=0.1u ad=0.0696p as=0.0696p pd=1.16u ps=1.16u
    I_MXI1_I132_I40_MN5 (XI1_I132_I40_n2 XI1_I132_I40_Bn VSS VSS) gpdk090_nmos1v w=0.24u l=0.1u ad=0.0528p as=0.0816p pd=0.68u ps=1.16u
    I_MXI1_I132_I40_MN4 (I1_p7_3 XI1_I132_I40_An XI1_I132_I40_n2 VSS) gpdk090_nmos1v w=0.24u l=0.1u ad=0.0528p as=0.0528p pd=0.68u ps=0.68u
    I_MXI1_I132_I40_MN2 (XI1_I132_I40_n1 I1_I132_pn3 I1_p7_3 VSS) gpdk090_nmos1v w=0.24u l=0.1u ad=0.0528p as=0.0528p pd=0.68u ps=0.68u
    I_MXI1_I132_I40_MN3 (VSS I1_I132_G2_0n XI1_I132_I40_n1 VSS) gpdk090_nmos1v w=0.24u l=0.1u ad=0.0816p as=0.0528p pd=1.16u ps=0.68u
    I_MXI1_I132_I40_MN0 (XI1_I132_I40_An I1_I132_pn3 VSS VSS) gpdk090_nmos1v w=0.12u l=0.1u ad=0.0696p as=0.0696p pd=1.16u ps=1.16u
    I_MXI2_I1_I3_MN1 (XI2_I1_I3_Bn OP_0 VSS VSS) gpdk090_nmos1v w=0.12u l=0.1u ad=0.0696p as=0.0696p pd=1.16u ps=1.16u
    I_MXI2_I1_I3_MN5 (XI2_I1_I3_n2 XI2_I1_I3_Bn VSS VSS) gpdk090_nmos1v w=0.24u l=0.1u ad=0.0528p as=0.0816p pd=0.68u ps=1.16u
    I_MXI2_I1_I3_MN4 (I2_I1_bx3 XI2_I1_I3_An XI2_I1_I3_n2 VSS) gpdk090_nmos1v w=0.24u l=0.1u ad=0.0528p as=0.0528p pd=0.68u ps=0.68u
    I_MXI2_I1_I3_MN2 (XI2_I1_I3_n1 B_3 I2_I1_bx3 VSS) gpdk090_nmos1v w=0.24u l=0.1u ad=0.0528p as=0.0528p pd=0.68u ps=0.68u
    I_MXI2_I1_I3_MN3 (VSS OP_0 XI2_I1_I3_n1 VSS) gpdk090_nmos1v w=0.24u l=0.1u ad=0.0816p as=0.0528p pd=1.16u ps=0.68u
    I_MXI2_I1_I3_MN0 (XI2_I1_I3_An B_3 VSS VSS) gpdk090_nmos1v w=0.12u l=0.1u ad=0.0696p as=0.0696p pd=1.16u ps=1.16u
    I_MXI1_I131_MN1 (XI1_I131_Bn I1_qu1 VSS VSS) gpdk090_nmos1v w=0.12u l=0.1u ad=0.0696p as=0.0696p pd=1.16u ps=1.16u
    I_MXI1_I131_MN5 (XI1_I131_n2 XI1_I131_Bn VSS VSS) gpdk090_nmos1v w=0.24u l=0.1u ad=0.0528p as=0.0816p pd=0.68u ps=1.16u
    I_MXI1_I131_MN4 (I1_b7_7 XI1_I131_An XI1_I131_n2 VSS) gpdk090_nmos1v w=0.24u l=0.1u ad=0.0528p as=0.0528p pd=0.68u ps=0.68u
    I_MXI1_I131_MN2 (XI1_I131_n1 I1_dd7 I1_b7_7 VSS) gpdk090_nmos1v w=0.24u l=0.1u ad=0.0528p as=0.0528p pd=0.68u ps=0.68u
    I_MXI1_I131_MN3 (VSS I1_qu1 XI1_I131_n1 VSS) gpdk090_nmos1v w=0.24u l=0.1u ad=0.0816p as=0.0528p pd=1.16u ps=0.68u
    I_MXI1_I131_MN0 (XI1_I131_An I1_dd7 VSS VSS) gpdk090_nmos1v w=0.12u l=0.1u ad=0.0696p as=0.0696p pd=1.16u ps=1.16u
    I_MXI1_I134_MN1 (XI1_I134_Bn I1_c7_8 VSS VSS) gpdk090_nmos1v w=0.12u l=0.1u ad=0.0696p as=0.0696p pd=1.16u ps=1.16u
    I_MXI1_I134_MN5 (XI1_I134_n2 XI1_I134_Bn VSS VSS) gpdk090_nmos1v w=0.24u l=0.1u ad=0.0528p as=0.0816p pd=0.68u ps=1.16u
    I_MXI1_I134_MN4 (I1_p7_8 XI1_I134_An XI1_I134_n2 VSS) gpdk090_nmos1v w=0.24u l=0.1u ad=0.0528p as=0.0528p pd=0.68u ps=0.68u
    I_MXI1_I134_MN2 (XI1_I134_n1 I1_h7 I1_p7_8 VSS) gpdk090_nmos1v w=0.24u l=0.1u ad=0.0528p as=0.0528p pd=0.68u ps=0.68u
    I_MXI1_I134_MN3 (VSS I1_c7_8 XI1_I134_n1 VSS) gpdk090_nmos1v w=0.24u l=0.1u ad=0.0816p as=0.0528p pd=1.16u ps=0.68u
    I_MXI1_I134_MN0 (XI1_I134_An I1_h7 VSS VSS) gpdk090_nmos1v w=0.12u l=0.1u ad=0.0696p as=0.0696p pd=1.16u ps=1.16u
    I_MXI2_I4_I18_MN1 (XI2_I4_I18_Bn I2_C8 VSS VSS) gpdk090_nmos1v w=0.12u l=0.1u ad=0.0696p as=0.0696p pd=1.16u ps=1.16u
    I_MXI2_I4_I18_MN5 (XI2_I4_I18_n2 XI2_I4_I18_Bn VSS VSS) gpdk090_nmos1v w=0.24u l=0.1u ad=0.0528p as=0.0816p pd=0.68u ps=1.16u
    I_MXI2_I4_I18_MN4 (I2_I4_ovf XI2_I4_I18_An XI2_I4_I18_n2 VSS) gpdk090_nmos1v w=0.24u l=0.1u ad=0.0528p as=0.0528p pd=0.68u ps=0.68u
    I_MXI2_I4_I18_MN2 (XI2_I4_I18_n1 I2_C7 I2_I4_ovf VSS) gpdk090_nmos1v w=0.24u l=0.1u ad=0.0528p as=0.0528p pd=0.68u ps=0.68u
    I_MXI2_I4_I18_MN3 (VSS I2_C8 XI2_I4_I18_n1 VSS) gpdk090_nmos1v w=0.24u l=0.1u ad=0.0816p as=0.0528p pd=1.16u ps=0.68u
    I_MXI2_I4_I18_MN0 (XI2_I4_I18_An I2_C7 VSS VSS) gpdk090_nmos1v w=0.12u l=0.1u ad=0.0696p as=0.0696p pd=1.16u ps=1.16u
    I_MXI1_I124_MN1 (XI1_I124_Bn I1_qu1 VSS VSS) gpdk090_nmos1v w=0.12u l=0.1u ad=0.0696p as=0.0696p pd=1.16u ps=1.16u
    I_MXI1_I124_MN5 (XI1_I124_n2 XI1_I124_Bn VSS VSS) gpdk090_nmos1v w=0.24u l=0.1u ad=0.0528p as=0.0816p pd=0.68u ps=1.16u
    I_MXI1_I124_MN4 (I1_b7_0 XI1_I124_An XI1_I124_n2 VSS) gpdk090_nmos1v w=0.24u l=0.1u ad=0.0528p as=0.0528p pd=0.68u ps=0.68u
    I_MXI1_I124_MN2 (XI1_I124_n1 B_0 I1_b7_0 VSS) gpdk090_nmos1v w=0.24u l=0.1u ad=0.0528p as=0.0528p pd=0.68u ps=0.68u
    I_MXI1_I124_MN3 (VSS I1_qu1 XI1_I124_n1 VSS) gpdk090_nmos1v w=0.24u l=0.1u ad=0.0816p as=0.0528p pd=1.16u ps=0.68u
    I_MXI1_I124_MN0 (XI1_I124_An B_0 VSS VSS) gpdk090_nmos1v w=0.12u l=0.1u ad=0.0696p as=0.0696p pd=1.16u ps=1.16u
    I_MXI2_I1_I8_I41_MN1 (XI2_I1_I8_I41_Bn I2_I1_I8_G3_0n VSS VSS) gpdk090_nmos1v w=0.12u l=0.1u ad=0.0696p as=0.0696p pd=1.16u ps=1.16u
    I_MXI2_I1_I8_I41_MN5 (XI2_I1_I8_I41_n2 XI2_I1_I8_I41_Bn VSS VSS) gpdk090_nmos1v w=0.24u l=0.1u ad=0.0528p as=0.0816p pd=0.68u ps=1.16u
    I_MXI2_I1_I8_I41_MN4 (I2_S_4 XI2_I1_I8_I41_An XI2_I1_I8_I41_n2 VSS) gpdk090_nmos1v w=0.24u l=0.1u ad=0.0528p as=0.0528p pd=0.68u ps=0.68u
    I_MXI2_I1_I8_I41_MN2 (XI2_I1_I8_I41_n1 I2_I1_I8_pn4 I2_S_4 VSS) gpdk090_nmos1v w=0.24u l=0.1u ad=0.0528p as=0.0528p pd=0.68u ps=0.68u
    I_MXI2_I1_I8_I41_MN3 (VSS I2_I1_I8_G3_0n XI2_I1_I8_I41_n1 VSS) gpdk090_nmos1v w=0.24u l=0.1u ad=0.0816p as=0.0528p pd=1.16u ps=0.68u
    I_MXI2_I1_I8_I41_MN0 (XI2_I1_I8_I41_An I2_I1_I8_pn4 VSS VSS) gpdk090_nmos1v w=0.12u l=0.1u ad=0.0696p as=0.0696p pd=1.16u ps=1.16u
    I_MXI2_I1_I8_I40_MN1 (XI2_I1_I8_I40_Bn I2_I1_I8_G2_0n VSS VSS) gpdk090_nmos1v w=0.12u l=0.1u ad=0.0696p as=0.0696p pd=1.16u ps=1.16u
    I_MXI2_I1_I8_I40_MN5 (XI2_I1_I8_I40_n2 XI2_I1_I8_I40_Bn VSS VSS) gpdk090_nmos1v w=0.24u l=0.1u ad=0.0528p as=0.0816p pd=0.68u ps=1.16u
    I_MXI2_I1_I8_I40_MN4 (I2_S_3 XI2_I1_I8_I40_An XI2_I1_I8_I40_n2 VSS) gpdk090_nmos1v w=0.24u l=0.1u ad=0.0528p as=0.0528p pd=0.68u ps=0.68u
    I_MXI2_I1_I8_I40_MN2 (XI2_I1_I8_I40_n1 I2_I1_I8_pn3 I2_S_3 VSS) gpdk090_nmos1v w=0.24u l=0.1u ad=0.0528p as=0.0528p pd=0.68u ps=0.68u
    I_MXI2_I1_I8_I40_MN3 (VSS I2_I1_I8_G2_0n XI2_I1_I8_I40_n1 VSS) gpdk090_nmos1v w=0.24u l=0.1u ad=0.0816p as=0.0528p pd=1.16u ps=0.68u
    I_MXI2_I1_I8_I40_MN0 (XI2_I1_I8_I40_An I2_I1_I8_pn3 VSS VSS) gpdk090_nmos1v w=0.12u l=0.1u ad=0.0696p as=0.0696p pd=1.16u ps=1.16u
    I_MXI2_I1_I4_MN1 (XI2_I1_I4_Bn OP_0 VSS VSS) gpdk090_nmos1v w=0.12u l=0.1u ad=0.0696p as=0.0696p pd=1.16u ps=1.16u
    I_MXI2_I1_I4_MN5 (XI2_I1_I4_n2 XI2_I1_I4_Bn VSS VSS) gpdk090_nmos1v w=0.24u l=0.1u ad=0.0528p as=0.0816p pd=0.68u ps=1.16u
    I_MXI2_I1_I4_MN4 (I2_I1_bx4 XI2_I1_I4_An XI2_I1_I4_n2 VSS) gpdk090_nmos1v w=0.24u l=0.1u ad=0.0528p as=0.0528p pd=0.68u ps=0.68u
    I_MXI2_I1_I4_MN2 (XI2_I1_I4_n1 B_4 I2_I1_bx4 VSS) gpdk090_nmos1v w=0.24u l=0.1u ad=0.0528p as=0.0528p pd=0.68u ps=0.68u
    I_MXI2_I1_I4_MN3 (VSS OP_0 XI2_I1_I4_n1 VSS) gpdk090_nmos1v w=0.24u l=0.1u ad=0.0816p as=0.0528p pd=1.16u ps=0.68u
    I_MXI2_I1_I4_MN0 (XI2_I1_I4_An B_4 VSS VSS) gpdk090_nmos1v w=0.12u l=0.1u ad=0.0696p as=0.0696p pd=1.16u ps=1.16u
    I_MXI1_I133_MN1 (XI1_I133_Bn I1_qu1 VSS VSS) gpdk090_nmos1v w=0.12u l=0.1u ad=0.0696p as=0.0696p pd=1.16u ps=1.16u
    I_MXI1_I133_MN5 (XI1_I133_n2 XI1_I133_Bn VSS VSS) gpdk090_nmos1v w=0.24u l=0.1u ad=0.0528p as=0.0816p pd=0.68u ps=1.16u
    I_MXI1_I133_MN4 (I1_h7 XI1_I133_An XI1_I133_n2 VSS) gpdk090_nmos1v w=0.24u l=0.1u ad=0.0528p as=0.0528p pd=0.68u ps=0.68u
    I_MXI1_I133_MN2 (XI1_I133_n1 I1_p6_7 I1_h7 VSS) gpdk090_nmos1v w=0.24u l=0.1u ad=0.0528p as=0.0528p pd=0.68u ps=0.68u
    I_MXI1_I133_MN3 (VSS I1_qu1 XI1_I133_n1 VSS) gpdk090_nmos1v w=0.24u l=0.1u ad=0.0816p as=0.0528p pd=1.16u ps=0.68u
    I_MXI1_I133_MN0 (XI1_I133_An I1_p6_7 VSS VSS) gpdk090_nmos1v w=0.12u l=0.1u ad=0.0696p as=0.0696p pd=1.16u ps=1.16u
    I_MXI1_I130_MN1 (XI1_I130_Bn I1_qu1 VSS VSS) gpdk090_nmos1v w=0.12u l=0.1u ad=0.0696p as=0.0696p pd=1.16u ps=1.16u
    I_MXI1_I130_MN5 (XI1_I130_n2 XI1_I130_Bn VSS VSS) gpdk090_nmos1v w=0.24u l=0.1u ad=0.0528p as=0.0816p pd=0.68u ps=1.16u
    I_MXI1_I130_MN4 (I1_b7_6 XI1_I130_An XI1_I130_n2 VSS) gpdk090_nmos1v w=0.24u l=0.1u ad=0.0528p as=0.0528p pd=0.68u ps=0.68u
    I_MXI1_I130_MN2 (XI1_I130_n1 I1_dd6 I1_b7_6 VSS) gpdk090_nmos1v w=0.24u l=0.1u ad=0.0528p as=0.0528p pd=0.68u ps=0.68u
    I_MXI1_I130_MN3 (VSS I1_qu1 XI1_I130_n1 VSS) gpdk090_nmos1v w=0.24u l=0.1u ad=0.0816p as=0.0528p pd=1.16u ps=0.68u
    I_MXI1_I130_MN0 (XI1_I130_An I1_dd6 VSS VSS) gpdk090_nmos1v w=0.12u l=0.1u ad=0.0696p as=0.0696p pd=1.16u ps=1.16u
    I_MXI1_I129_MN1 (XI1_I129_Bn I1_qu1 VSS VSS) gpdk090_nmos1v w=0.12u l=0.1u ad=0.0696p as=0.0696p pd=1.16u ps=1.16u
    I_MXI1_I129_MN5 (XI1_I129_n2 XI1_I129_Bn VSS VSS) gpdk090_nmos1v w=0.24u l=0.1u ad=0.0528p as=0.0816p pd=0.68u ps=1.16u
    I_MXI1_I129_MN4 (I1_b7_5 XI1_I129_An XI1_I129_n2 VSS) gpdk090_nmos1v w=0.24u l=0.1u ad=0.0528p as=0.0528p pd=0.68u ps=0.68u
    I_MXI1_I129_MN2 (XI1_I129_n1 I1_dd5 I1_b7_5 VSS) gpdk090_nmos1v w=0.24u l=0.1u ad=0.0528p as=0.0528p pd=0.68u ps=0.68u
    I_MXI1_I129_MN3 (VSS I1_qu1 XI1_I129_n1 VSS) gpdk090_nmos1v w=0.24u l=0.1u ad=0.0816p as=0.0528p pd=1.16u ps=0.68u
    I_MXI1_I129_MN0 (XI1_I129_An I1_dd5 VSS VSS) gpdk090_nmos1v w=0.12u l=0.1u ad=0.0696p as=0.0696p pd=1.16u ps=1.16u
    I_MXI1_I128_MN1 (XI1_I128_Bn I1_qu1 VSS VSS) gpdk090_nmos1v w=0.12u l=0.1u ad=0.0696p as=0.0696p pd=1.16u ps=1.16u
    I_MXI1_I128_MN5 (XI1_I128_n2 XI1_I128_Bn VSS VSS) gpdk090_nmos1v w=0.24u l=0.1u ad=0.0528p as=0.0816p pd=0.68u ps=1.16u
    I_MXI1_I128_MN4 (I1_b7_4 XI1_I128_An XI1_I128_n2 VSS) gpdk090_nmos1v w=0.24u l=0.1u ad=0.0528p as=0.0528p pd=0.68u ps=0.68u
    I_MXI1_I128_MN2 (XI1_I128_n1 I1_dd4 I1_b7_4 VSS) gpdk090_nmos1v w=0.24u l=0.1u ad=0.0528p as=0.0528p pd=0.68u ps=0.68u
    I_MXI1_I128_MN3 (VSS I1_qu1 XI1_I128_n1 VSS) gpdk090_nmos1v w=0.24u l=0.1u ad=0.0816p as=0.0528p pd=1.16u ps=0.68u
    I_MXI1_I128_MN0 (XI1_I128_An I1_dd4 VSS VSS) gpdk090_nmos1v w=0.12u l=0.1u ad=0.0696p as=0.0696p pd=1.16u ps=1.16u
    I_MXI1_I127_MN1 (XI1_I127_Bn I1_qu1 VSS VSS) gpdk090_nmos1v w=0.12u l=0.1u ad=0.0696p as=0.0696p pd=1.16u ps=1.16u
    I_MXI1_I127_MN5 (XI1_I127_n2 XI1_I127_Bn VSS VSS) gpdk090_nmos1v w=0.24u l=0.1u ad=0.0528p as=0.0816p pd=0.68u ps=1.16u
    I_MXI1_I127_MN4 (I1_b7_3 XI1_I127_An XI1_I127_n2 VSS) gpdk090_nmos1v w=0.24u l=0.1u ad=0.0528p as=0.0528p pd=0.68u ps=0.68u
    I_MXI1_I127_MN2 (XI1_I127_n1 I1_dd3 I1_b7_3 VSS) gpdk090_nmos1v w=0.24u l=0.1u ad=0.0528p as=0.0528p pd=0.68u ps=0.68u
    I_MXI1_I127_MN3 (VSS I1_qu1 XI1_I127_n1 VSS) gpdk090_nmos1v w=0.24u l=0.1u ad=0.0816p as=0.0528p pd=1.16u ps=0.68u
    I_MXI1_I127_MN0 (XI1_I127_An I1_dd3 VSS VSS) gpdk090_nmos1v w=0.12u l=0.1u ad=0.0696p as=0.0696p pd=1.16u ps=1.16u
    I_MXI1_I126_MN1 (XI1_I126_Bn I1_qu1 VSS VSS) gpdk090_nmos1v w=0.12u l=0.1u ad=0.0696p as=0.0696p pd=1.16u ps=1.16u
    I_MXI1_I126_MN5 (XI1_I126_n2 XI1_I126_Bn VSS VSS) gpdk090_nmos1v w=0.24u l=0.1u ad=0.0528p as=0.0816p pd=0.68u ps=1.16u
    I_MXI1_I126_MN4 (I1_b7_2 XI1_I126_An XI1_I126_n2 VSS) gpdk090_nmos1v w=0.24u l=0.1u ad=0.0528p as=0.0528p pd=0.68u ps=0.68u
    I_MXI1_I126_MN2 (XI1_I126_n1 I1_dd2 I1_b7_2 VSS) gpdk090_nmos1v w=0.24u l=0.1u ad=0.0528p as=0.0528p pd=0.68u ps=0.68u
    I_MXI1_I126_MN3 (VSS I1_qu1 XI1_I126_n1 VSS) gpdk090_nmos1v w=0.24u l=0.1u ad=0.0816p as=0.0528p pd=1.16u ps=0.68u
    I_MXI1_I126_MN0 (XI1_I126_An I1_dd2 VSS VSS) gpdk090_nmos1v w=0.12u l=0.1u ad=0.0696p as=0.0696p pd=1.16u ps=1.16u
    I_MXI1_I125_MN1 (XI1_I125_Bn I1_qu1 VSS VSS) gpdk090_nmos1v w=0.12u l=0.1u ad=0.0696p as=0.0696p pd=1.16u ps=1.16u
    I_MXI1_I125_MN5 (XI1_I125_n2 XI1_I125_Bn VSS VSS) gpdk090_nmos1v w=0.24u l=0.1u ad=0.0528p as=0.0816p pd=0.68u ps=1.16u
    I_MXI1_I125_MN4 (I1_b7_1 XI1_I125_An XI1_I125_n2 VSS) gpdk090_nmos1v w=0.24u l=0.1u ad=0.0528p as=0.0528p pd=0.68u ps=0.68u
    I_MXI1_I125_MN2 (XI1_I125_n1 I1_dd1 I1_b7_1 VSS) gpdk090_nmos1v w=0.24u l=0.1u ad=0.0528p as=0.0528p pd=0.68u ps=0.68u
    I_MXI1_I125_MN3 (VSS I1_qu1 XI1_I125_n1 VSS) gpdk090_nmos1v w=0.24u l=0.1u ad=0.0816p as=0.0528p pd=1.16u ps=0.68u
    I_MXI1_I125_MN0 (XI1_I125_An I1_dd1 VSS VSS) gpdk090_nmos1v w=0.12u l=0.1u ad=0.0696p as=0.0696p pd=1.16u ps=1.16u
    I_MXI2_I1_I0_MN1 (XI2_I1_I0_Bn OP_0 VSS VSS) gpdk090_nmos1v w=0.12u l=0.1u ad=0.0696p as=0.0696p pd=1.16u ps=1.16u
    I_MXI2_I1_I0_MN5 (XI2_I1_I0_n2 XI2_I1_I0_Bn VSS VSS) gpdk090_nmos1v w=0.24u l=0.1u ad=0.0528p as=0.0816p pd=0.68u ps=1.16u
    I_MXI2_I1_I0_MN4 (I2_I1_bx0 XI2_I1_I0_An XI2_I1_I0_n2 VSS) gpdk090_nmos1v w=0.24u l=0.1u ad=0.0528p as=0.0528p pd=0.68u ps=0.68u
    I_MXI2_I1_I0_MN2 (XI2_I1_I0_n1 B_0 I2_I1_bx0 VSS) gpdk090_nmos1v w=0.24u l=0.1u ad=0.0528p as=0.0528p pd=0.68u ps=0.68u
    I_MXI2_I1_I0_MN3 (VSS OP_0 XI2_I1_I0_n1 VSS) gpdk090_nmos1v w=0.24u l=0.1u ad=0.0816p as=0.0528p pd=1.16u ps=0.68u
    I_MXI2_I1_I0_MN0 (XI2_I1_I0_An B_0 VSS VSS) gpdk090_nmos1v w=0.12u l=0.1u ad=0.0696p as=0.0696p pd=1.16u ps=1.16u
    I_MXI1_I122_MN1 (XI1_I122_Bn I1_c6_8 VSS VSS) gpdk090_nmos1v w=0.12u l=0.1u ad=0.0696p as=0.0696p pd=1.16u ps=1.16u
    I_MXI1_I122_MN5 (XI1_I122_n2 XI1_I122_Bn VSS VSS) gpdk090_nmos1v w=0.24u l=0.1u ad=0.0528p as=0.0816p pd=0.68u ps=1.16u
    I_MXI1_I122_MN4 (I1_p6_8 XI1_I122_An XI1_I122_n2 VSS) gpdk090_nmos1v w=0.24u l=0.1u ad=0.0528p as=0.0528p pd=0.68u ps=0.68u
    I_MXI1_I122_MN2 (XI1_I122_n1 I1_h6 I1_p6_8 VSS) gpdk090_nmos1v w=0.24u l=0.1u ad=0.0528p as=0.0528p pd=0.68u ps=0.68u
    I_MXI1_I122_MN3 (VSS I1_c6_8 XI1_I122_n1 VSS) gpdk090_nmos1v w=0.24u l=0.1u ad=0.0816p as=0.0528p pd=1.16u ps=0.68u
    I_MXI1_I122_MN0 (XI1_I122_An I1_h6 VSS VSS) gpdk090_nmos1v w=0.12u l=0.1u ad=0.0696p as=0.0696p pd=1.16u ps=1.16u
    I_MXI1_I120_I41_MN1 (XI1_I120_I41_Bn I1_I120_G3_0n VSS VSS) gpdk090_nmos1v w=0.12u l=0.1u ad=0.0696p as=0.0696p pd=1.16u ps=1.16u
    I_MXI1_I120_I41_MN5 (XI1_I120_I41_n2 XI1_I120_I41_Bn VSS VSS) gpdk090_nmos1v w=0.24u l=0.1u ad=0.0528p as=0.0816p pd=0.68u ps=1.16u
    I_MXI1_I120_I41_MN4 (I1_p6_4 XI1_I120_I41_An XI1_I120_I41_n2 VSS) gpdk090_nmos1v w=0.24u l=0.1u ad=0.0528p as=0.0528p pd=0.68u ps=0.68u
    I_MXI1_I120_I41_MN2 (XI1_I120_I41_n1 I1_I120_pn4 I1_p6_4 VSS) gpdk090_nmos1v w=0.24u l=0.1u ad=0.0528p as=0.0528p pd=0.68u ps=0.68u
    I_MXI1_I120_I41_MN3 (VSS I1_I120_G3_0n XI1_I120_I41_n1 VSS) gpdk090_nmos1v w=0.24u l=0.1u ad=0.0816p as=0.0528p pd=1.16u ps=0.68u
    I_MXI1_I120_I41_MN0 (XI1_I120_I41_An I1_I120_pn4 VSS VSS) gpdk090_nmos1v w=0.12u l=0.1u ad=0.0696p as=0.0696p pd=1.16u ps=1.16u
    I_MXI1_I120_I40_MN1 (XI1_I120_I40_Bn I1_I120_G2_0n VSS VSS) gpdk090_nmos1v w=0.12u l=0.1u ad=0.0696p as=0.0696p pd=1.16u ps=1.16u
    I_MXI1_I120_I40_MN5 (XI1_I120_I40_n2 XI1_I120_I40_Bn VSS VSS) gpdk090_nmos1v w=0.24u l=0.1u ad=0.0528p as=0.0816p pd=0.68u ps=1.16u
    I_MXI1_I120_I40_MN4 (I1_p6_3 XI1_I120_I40_An XI1_I120_I40_n2 VSS) gpdk090_nmos1v w=0.24u l=0.1u ad=0.0528p as=0.0528p pd=0.68u ps=0.68u
    I_MXI1_I120_I40_MN2 (XI1_I120_I40_n1 I1_I120_pn3 I1_p6_3 VSS) gpdk090_nmos1v w=0.24u l=0.1u ad=0.0528p as=0.0528p pd=0.68u ps=0.68u
    I_MXI1_I120_I40_MN3 (VSS I1_I120_G2_0n XI1_I120_I40_n1 VSS) gpdk090_nmos1v w=0.24u l=0.1u ad=0.0816p as=0.0528p pd=1.16u ps=0.68u
    I_MXI1_I120_I40_MN0 (XI1_I120_I40_An I1_I120_pn3 VSS VSS) gpdk090_nmos1v w=0.12u l=0.1u ad=0.0696p as=0.0696p pd=1.16u ps=1.16u
    I_MXI2_I1_I1_MN1 (XI2_I1_I1_Bn OP_0 VSS VSS) gpdk090_nmos1v w=0.12u l=0.1u ad=0.0696p as=0.0696p pd=1.16u ps=1.16u
    I_MXI2_I1_I1_MN5 (XI2_I1_I1_n2 XI2_I1_I1_Bn VSS VSS) gpdk090_nmos1v w=0.24u l=0.1u ad=0.0528p as=0.0816p pd=0.68u ps=1.16u
    I_MXI2_I1_I1_MN4 (I2_I1_bx1 XI2_I1_I1_An XI2_I1_I1_n2 VSS) gpdk090_nmos1v w=0.24u l=0.1u ad=0.0528p as=0.0528p pd=0.68u ps=0.68u
    I_MXI2_I1_I1_MN2 (XI2_I1_I1_n1 B_1 I2_I1_bx1 VSS) gpdk090_nmos1v w=0.24u l=0.1u ad=0.0528p as=0.0528p pd=0.68u ps=0.68u
    I_MXI2_I1_I1_MN3 (VSS OP_0 XI2_I1_I1_n1 VSS) gpdk090_nmos1v w=0.24u l=0.1u ad=0.0816p as=0.0528p pd=1.16u ps=0.68u
    I_MXI2_I1_I1_MN0 (XI2_I1_I1_An B_1 VSS VSS) gpdk090_nmos1v w=0.12u l=0.1u ad=0.0696p as=0.0696p pd=1.16u ps=1.16u
    I_MXI2_I2_I28_MN1 (XI2_I2_I28_Bn B_4 VSS VSS) gpdk090_nmos1v w=0.12u l=0.1u ad=0.0696p as=0.0696p pd=1.16u ps=1.16u
    I_MXI2_I2_I28_MN5 (XI2_I2_I28_n2 XI2_I2_I28_Bn VSS VSS) gpdk090_nmos1v w=0.24u l=0.1u ad=0.0528p as=0.0816p pd=0.68u ps=1.16u
    I_MXI2_I2_I28_MN4 (I2_XOR_4 XI2_I2_I28_An XI2_I2_I28_n2 VSS) gpdk090_nmos1v w=0.24u l=0.1u ad=0.0528p as=0.0528p pd=0.68u ps=0.68u
    I_MXI2_I2_I28_MN2 (XI2_I2_I28_n1 A_4 I2_XOR_4 VSS) gpdk090_nmos1v w=0.24u l=0.1u ad=0.0528p as=0.0528p pd=0.68u ps=0.68u
    I_MXI2_I2_I28_MN3 (VSS B_4 XI2_I2_I28_n1 VSS) gpdk090_nmos1v w=0.24u l=0.1u ad=0.0816p as=0.0528p pd=1.16u ps=0.68u
    I_MXI2_I2_I28_MN0 (XI2_I2_I28_An A_4 VSS VSS) gpdk090_nmos1v w=0.12u l=0.1u ad=0.0696p as=0.0696p pd=1.16u ps=1.16u
    I_MXI2_I1_I2_MN1 (XI2_I1_I2_Bn OP_0 VSS VSS) gpdk090_nmos1v w=0.12u l=0.1u ad=0.0696p as=0.0696p pd=1.16u ps=1.16u
    I_MXI2_I1_I2_MN5 (XI2_I1_I2_n2 XI2_I1_I2_Bn VSS VSS) gpdk090_nmos1v w=0.24u l=0.1u ad=0.0528p as=0.0816p pd=0.68u ps=1.16u
    I_MXI2_I1_I2_MN4 (I2_I1_bx2 XI2_I1_I2_An XI2_I1_I2_n2 VSS) gpdk090_nmos1v w=0.24u l=0.1u ad=0.0528p as=0.0528p pd=0.68u ps=0.68u
    I_MXI2_I1_I2_MN2 (XI2_I1_I2_n1 B_2 I2_I1_bx2 VSS) gpdk090_nmos1v w=0.24u l=0.1u ad=0.0528p as=0.0528p pd=0.68u ps=0.68u
    I_MXI2_I1_I2_MN3 (VSS OP_0 XI2_I1_I2_n1 VSS) gpdk090_nmos1v w=0.24u l=0.1u ad=0.0816p as=0.0528p pd=1.16u ps=0.68u
    I_MXI2_I1_I2_MN0 (XI2_I1_I2_An B_2 VSS VSS) gpdk090_nmos1v w=0.12u l=0.1u ad=0.0696p as=0.0696p pd=1.16u ps=1.16u
    I_MXI1_I114_MN1 (XI1_I114_Bn I1_qu2 VSS VSS) gpdk090_nmos1v w=0.12u l=0.1u ad=0.0696p as=0.0696p pd=1.16u ps=1.16u
    I_MXI1_I114_MN5 (XI1_I114_n2 XI1_I114_Bn VSS VSS) gpdk090_nmos1v w=0.24u l=0.1u ad=0.0528p as=0.0816p pd=0.68u ps=1.16u
    I_MXI1_I114_MN4 (I1_b6_2 XI1_I114_An XI1_I114_n2 VSS) gpdk090_nmos1v w=0.24u l=0.1u ad=0.0528p as=0.0528p pd=0.68u ps=0.68u
    I_MXI1_I114_MN2 (XI1_I114_n1 I1_dd2 I1_b6_2 VSS) gpdk090_nmos1v w=0.24u l=0.1u ad=0.0528p as=0.0528p pd=0.68u ps=0.68u
    I_MXI1_I114_MN3 (VSS I1_qu2 XI1_I114_n1 VSS) gpdk090_nmos1v w=0.24u l=0.1u ad=0.0816p as=0.0528p pd=1.16u ps=0.68u
    I_MXI1_I114_MN0 (XI1_I114_An I1_dd2 VSS VSS) gpdk090_nmos1v w=0.12u l=0.1u ad=0.0696p as=0.0696p pd=1.16u ps=1.16u
    I_MXI1_I113_MN1 (XI1_I113_Bn I1_qu2 VSS VSS) gpdk090_nmos1v w=0.12u l=0.1u ad=0.0696p as=0.0696p pd=1.16u ps=1.16u
    I_MXI1_I113_MN5 (XI1_I113_n2 XI1_I113_Bn VSS VSS) gpdk090_nmos1v w=0.24u l=0.1u ad=0.0528p as=0.0816p pd=0.68u ps=1.16u
    I_MXI1_I113_MN4 (I1_b6_1 XI1_I113_An XI1_I113_n2 VSS) gpdk090_nmos1v w=0.24u l=0.1u ad=0.0528p as=0.0528p pd=0.68u ps=0.68u
    I_MXI1_I113_MN2 (XI1_I113_n1 I1_dd1 I1_b6_1 VSS) gpdk090_nmos1v w=0.24u l=0.1u ad=0.0528p as=0.0528p pd=0.68u ps=0.68u
    I_MXI1_I113_MN3 (VSS I1_qu2 XI1_I113_n1 VSS) gpdk090_nmos1v w=0.24u l=0.1u ad=0.0816p as=0.0528p pd=1.16u ps=0.68u
    I_MXI1_I113_MN0 (XI1_I113_An I1_dd1 VSS VSS) gpdk090_nmos1v w=0.12u l=0.1u ad=0.0696p as=0.0696p pd=1.16u ps=1.16u
    I_MXI1_I112_MN1 (XI1_I112_Bn I1_qu2 VSS VSS) gpdk090_nmos1v w=0.12u l=0.1u ad=0.0696p as=0.0696p pd=1.16u ps=1.16u
    I_MXI1_I112_MN5 (XI1_I112_n2 XI1_I112_Bn VSS VSS) gpdk090_nmos1v w=0.24u l=0.1u ad=0.0528p as=0.0816p pd=0.68u ps=1.16u
    I_MXI1_I112_MN4 (I1_b6_0 XI1_I112_An XI1_I112_n2 VSS) gpdk090_nmos1v w=0.24u l=0.1u ad=0.0528p as=0.0528p pd=0.68u ps=0.68u
    I_MXI1_I112_MN2 (XI1_I112_n1 B_0 I1_b6_0 VSS) gpdk090_nmos1v w=0.24u l=0.1u ad=0.0528p as=0.0528p pd=0.68u ps=0.68u
    I_MXI1_I112_MN3 (VSS I1_qu2 XI1_I112_n1 VSS) gpdk090_nmos1v w=0.24u l=0.1u ad=0.0816p as=0.0528p pd=1.16u ps=0.68u
    I_MXI1_I112_MN0 (XI1_I112_An B_0 VSS VSS) gpdk090_nmos1v w=0.12u l=0.1u ad=0.0696p as=0.0696p pd=1.16u ps=1.16u
    I_MXI2_I2_I10_MN1 (XI2_I2_I10_Bn B_1 VSS VSS) gpdk090_nmos1v w=0.12u l=0.1u ad=0.0696p as=0.0696p pd=1.16u ps=1.16u
    I_MXI2_I2_I10_MN5 (XI2_I2_I10_n2 XI2_I2_I10_Bn VSS VSS) gpdk090_nmos1v w=0.24u l=0.1u ad=0.0528p as=0.0816p pd=0.68u ps=1.16u
    I_MXI2_I2_I10_MN4 (I2_XOR_1 XI2_I2_I10_An XI2_I2_I10_n2 VSS) gpdk090_nmos1v w=0.24u l=0.1u ad=0.0528p as=0.0528p pd=0.68u ps=0.68u
    I_MXI2_I2_I10_MN2 (XI2_I2_I10_n1 A_1 I2_XOR_1 VSS) gpdk090_nmos1v w=0.24u l=0.1u ad=0.0528p as=0.0528p pd=0.68u ps=0.68u
    I_MXI2_I2_I10_MN3 (VSS B_1 XI2_I2_I10_n1 VSS) gpdk090_nmos1v w=0.24u l=0.1u ad=0.0816p as=0.0528p pd=1.16u ps=0.68u
    I_MXI2_I2_I10_MN0 (XI2_I2_I10_An A_1 VSS VSS) gpdk090_nmos1v w=0.12u l=0.1u ad=0.0696p as=0.0696p pd=1.16u ps=1.16u
    I_MXI1_I116_MN1 (XI1_I116_Bn I1_qu2 VSS VSS) gpdk090_nmos1v w=0.12u l=0.1u ad=0.0696p as=0.0696p pd=1.16u ps=1.16u
    I_MXI1_I116_MN5 (XI1_I116_n2 XI1_I116_Bn VSS VSS) gpdk090_nmos1v w=0.24u l=0.1u ad=0.0528p as=0.0816p pd=0.68u ps=1.16u
    I_MXI1_I116_MN4 (I1_b6_4 XI1_I116_An XI1_I116_n2 VSS) gpdk090_nmos1v w=0.24u l=0.1u ad=0.0528p as=0.0528p pd=0.68u ps=0.68u
    I_MXI1_I116_MN2 (XI1_I116_n1 I1_dd4 I1_b6_4 VSS) gpdk090_nmos1v w=0.24u l=0.1u ad=0.0528p as=0.0528p pd=0.68u ps=0.68u
    I_MXI1_I116_MN3 (VSS I1_qu2 XI1_I116_n1 VSS) gpdk090_nmos1v w=0.24u l=0.1u ad=0.0816p as=0.0528p pd=1.16u ps=0.68u
    I_MXI1_I116_MN0 (XI1_I116_An I1_dd4 VSS VSS) gpdk090_nmos1v w=0.12u l=0.1u ad=0.0696p as=0.0696p pd=1.16u ps=1.16u
    I_MXI1_I115_MN1 (XI1_I115_Bn I1_qu2 VSS VSS) gpdk090_nmos1v w=0.12u l=0.1u ad=0.0696p as=0.0696p pd=1.16u ps=1.16u
    I_MXI1_I115_MN5 (XI1_I115_n2 XI1_I115_Bn VSS VSS) gpdk090_nmos1v w=0.24u l=0.1u ad=0.0528p as=0.0816p pd=0.68u ps=1.16u
    I_MXI1_I115_MN4 (I1_b6_3 XI1_I115_An XI1_I115_n2 VSS) gpdk090_nmos1v w=0.24u l=0.1u ad=0.0528p as=0.0528p pd=0.68u ps=0.68u
    I_MXI1_I115_MN2 (XI1_I115_n1 I1_dd3 I1_b6_3 VSS) gpdk090_nmos1v w=0.24u l=0.1u ad=0.0528p as=0.0528p pd=0.68u ps=0.68u
    I_MXI1_I115_MN3 (VSS I1_qu2 XI1_I115_n1 VSS) gpdk090_nmos1v w=0.24u l=0.1u ad=0.0816p as=0.0528p pd=1.16u ps=0.68u
    I_MXI1_I115_MN0 (XI1_I115_An I1_dd3 VSS VSS) gpdk090_nmos1v w=0.12u l=0.1u ad=0.0696p as=0.0696p pd=1.16u ps=1.16u
    I_MXI1_I100_MN1 (XI1_I100_Bn I1_qu3 VSS VSS) gpdk090_nmos1v w=0.12u l=0.1u ad=0.0696p as=0.0696p pd=1.16u ps=1.16u
    I_MXI1_I100_MN5 (XI1_I100_n2 XI1_I100_Bn VSS VSS) gpdk090_nmos1v w=0.24u l=0.1u ad=0.0528p as=0.0816p pd=0.68u ps=1.16u
    I_MXI1_I100_MN4 (I1_b5_0 XI1_I100_An XI1_I100_n2 VSS) gpdk090_nmos1v w=0.24u l=0.1u ad=0.0528p as=0.0528p pd=0.68u ps=0.68u
    I_MXI1_I100_MN2 (XI1_I100_n1 B_0 I1_b5_0 VSS) gpdk090_nmos1v w=0.24u l=0.1u ad=0.0528p as=0.0528p pd=0.68u ps=0.68u
    I_MXI1_I100_MN3 (VSS I1_qu3 XI1_I100_n1 VSS) gpdk090_nmos1v w=0.24u l=0.1u ad=0.0816p as=0.0528p pd=1.16u ps=0.68u
    I_MXI1_I100_MN0 (XI1_I100_An B_0 VSS VSS) gpdk090_nmos1v w=0.12u l=0.1u ad=0.0696p as=0.0696p pd=1.16u ps=1.16u
    I_MXI1_I153_MN1 (XI1_I153_Bn B_7 VSS VSS) gpdk090_nmos1v w=0.12u l=0.1u ad=0.0696p as=0.0696p pd=1.16u ps=1.16u
    I_MXI1_I153_MN5 (XI1_I153_n2 XI1_I153_Bn VSS VSS) gpdk090_nmos1v w=0.24u l=0.1u ad=0.0528p as=0.0816p pd=0.68u ps=1.16u
    I_MXI1_I153_MN4 (I1_sq XI1_I153_An XI1_I153_n2 VSS) gpdk090_nmos1v w=0.24u l=0.1u ad=0.0528p as=0.0528p pd=0.68u ps=0.68u
    I_MXI1_I153_MN2 (XI1_I153_n1 A_7 I1_sq VSS) gpdk090_nmos1v w=0.24u l=0.1u ad=0.0528p as=0.0528p pd=0.68u ps=0.68u
    I_MXI1_I153_MN3 (VSS B_7 XI1_I153_n1 VSS) gpdk090_nmos1v w=0.24u l=0.1u ad=0.0816p as=0.0528p pd=1.16u ps=0.68u
    I_MXI1_I153_MN0 (XI1_I153_An A_7 VSS VSS) gpdk090_nmos1v w=0.12u l=0.1u ad=0.0696p as=0.0696p pd=1.16u ps=1.16u
    I_MXI2_I2_I4_MN1 (XI2_I2_I4_Bn B_0 VSS VSS) gpdk090_nmos1v w=0.12u l=0.1u ad=0.0696p as=0.0696p pd=1.16u ps=1.16u
    I_MXI2_I2_I4_MN5 (XI2_I2_I4_n2 XI2_I2_I4_Bn VSS VSS) gpdk090_nmos1v w=0.24u l=0.1u ad=0.0528p as=0.0816p pd=0.68u ps=1.16u
    I_MXI2_I2_I4_MN4 (I2_XOR_0 XI2_I2_I4_An XI2_I2_I4_n2 VSS) gpdk090_nmos1v w=0.24u l=0.1u ad=0.0528p as=0.0528p pd=0.68u ps=0.68u
    I_MXI2_I2_I4_MN2 (XI2_I2_I4_n1 A_0 I2_XOR_0 VSS) gpdk090_nmos1v w=0.24u l=0.1u ad=0.0528p as=0.0528p pd=0.68u ps=0.68u
    I_MXI2_I2_I4_MN3 (VSS B_0 XI2_I2_I4_n1 VSS) gpdk090_nmos1v w=0.24u l=0.1u ad=0.0816p as=0.0528p pd=1.16u ps=0.68u
    I_MXI2_I2_I4_MN0 (XI2_I2_I4_An A_0 VSS VSS) gpdk090_nmos1v w=0.12u l=0.1u ad=0.0696p as=0.0696p pd=1.16u ps=1.16u
    I_MXI1_I119_MN1 (XI1_I119_Bn I1_qu2 VSS VSS) gpdk090_nmos1v w=0.12u l=0.1u ad=0.0696p as=0.0696p pd=1.16u ps=1.16u
    I_MXI1_I119_MN5 (XI1_I119_n2 XI1_I119_Bn VSS VSS) gpdk090_nmos1v w=0.24u l=0.1u ad=0.0528p as=0.0816p pd=0.68u ps=1.16u
    I_MXI1_I119_MN4 (I1_b6_7 XI1_I119_An XI1_I119_n2 VSS) gpdk090_nmos1v w=0.24u l=0.1u ad=0.0528p as=0.0528p pd=0.68u ps=0.68u
    I_MXI1_I119_MN2 (XI1_I119_n1 I1_dd7 I1_b6_7 VSS) gpdk090_nmos1v w=0.24u l=0.1u ad=0.0528p as=0.0528p pd=0.68u ps=0.68u
    I_MXI1_I119_MN3 (VSS I1_qu2 XI1_I119_n1 VSS) gpdk090_nmos1v w=0.24u l=0.1u ad=0.0816p as=0.0528p pd=1.16u ps=0.68u
    I_MXI1_I119_MN0 (XI1_I119_An I1_dd7 VSS VSS) gpdk090_nmos1v w=0.12u l=0.1u ad=0.0696p as=0.0696p pd=1.16u ps=1.16u
    I_MXI1_I118_MN1 (XI1_I118_Bn I1_qu2 VSS VSS) gpdk090_nmos1v w=0.12u l=0.1u ad=0.0696p as=0.0696p pd=1.16u ps=1.16u
    I_MXI1_I118_MN5 (XI1_I118_n2 XI1_I118_Bn VSS VSS) gpdk090_nmos1v w=0.24u l=0.1u ad=0.0528p as=0.0816p pd=0.68u ps=1.16u
    I_MXI1_I118_MN4 (I1_b6_6 XI1_I118_An XI1_I118_n2 VSS) gpdk090_nmos1v w=0.24u l=0.1u ad=0.0528p as=0.0528p pd=0.68u ps=0.68u
    I_MXI1_I118_MN2 (XI1_I118_n1 I1_dd6 I1_b6_6 VSS) gpdk090_nmos1v w=0.24u l=0.1u ad=0.0528p as=0.0528p pd=0.68u ps=0.68u
    I_MXI1_I118_MN3 (VSS I1_qu2 XI1_I118_n1 VSS) gpdk090_nmos1v w=0.24u l=0.1u ad=0.0816p as=0.0528p pd=1.16u ps=0.68u
    I_MXI1_I118_MN0 (XI1_I118_An I1_dd6 VSS VSS) gpdk090_nmos1v w=0.12u l=0.1u ad=0.0696p as=0.0696p pd=1.16u ps=1.16u
    I_MXI1_I117_MN1 (XI1_I117_Bn I1_qu2 VSS VSS) gpdk090_nmos1v w=0.12u l=0.1u ad=0.0696p as=0.0696p pd=1.16u ps=1.16u
    I_MXI1_I117_MN5 (XI1_I117_n2 XI1_I117_Bn VSS VSS) gpdk090_nmos1v w=0.24u l=0.1u ad=0.0528p as=0.0816p pd=0.68u ps=1.16u
    I_MXI1_I117_MN4 (I1_b6_5 XI1_I117_An XI1_I117_n2 VSS) gpdk090_nmos1v w=0.24u l=0.1u ad=0.0528p as=0.0528p pd=0.68u ps=0.68u
    I_MXI1_I117_MN2 (XI1_I117_n1 I1_dd5 I1_b6_5 VSS) gpdk090_nmos1v w=0.24u l=0.1u ad=0.0528p as=0.0528p pd=0.68u ps=0.68u
    I_MXI1_I117_MN3 (VSS I1_qu2 XI1_I117_n1 VSS) gpdk090_nmos1v w=0.24u l=0.1u ad=0.0816p as=0.0528p pd=1.16u ps=0.68u
    I_MXI1_I117_MN0 (XI1_I117_An I1_dd5 VSS VSS) gpdk090_nmos1v w=0.12u l=0.1u ad=0.0696p as=0.0696p pd=1.16u ps=1.16u
    I_MXI1_I108_I40_MN1 (XI1_I108_I40_Bn I1_I108_G2_0n VSS VSS) gpdk090_nmos1v w=0.12u l=0.1u ad=0.0696p as=0.0696p pd=1.16u ps=1.16u
    I_MXI1_I108_I40_MN5 (XI1_I108_I40_n2 XI1_I108_I40_Bn VSS VSS) gpdk090_nmos1v w=0.24u l=0.1u ad=0.0528p as=0.0816p pd=0.68u ps=1.16u
    I_MXI1_I108_I40_MN4 (I1_p5_3 XI1_I108_I40_An XI1_I108_I40_n2 VSS) gpdk090_nmos1v w=0.24u l=0.1u ad=0.0528p as=0.0528p pd=0.68u ps=0.68u
    I_MXI1_I108_I40_MN2 (XI1_I108_I40_n1 I1_I108_pn3 I1_p5_3 VSS) gpdk090_nmos1v w=0.24u l=0.1u ad=0.0528p as=0.0528p pd=0.68u ps=0.68u
    I_MXI1_I108_I40_MN3 (VSS I1_I108_G2_0n XI1_I108_I40_n1 VSS) gpdk090_nmos1v w=0.24u l=0.1u ad=0.0816p as=0.0528p pd=1.16u ps=0.68u
    I_MXI1_I108_I40_MN0 (XI1_I108_I40_An I1_I108_pn3 VSS VSS) gpdk090_nmos1v w=0.12u l=0.1u ad=0.0696p as=0.0696p pd=1.16u ps=1.16u
    I_MXI1_I101_MN1 (XI1_I101_Bn I1_qu3 VSS VSS) gpdk090_nmos1v w=0.12u l=0.1u ad=0.0696p as=0.0696p pd=1.16u ps=1.16u
    I_MXI1_I101_MN5 (XI1_I101_n2 XI1_I101_Bn VSS VSS) gpdk090_nmos1v w=0.24u l=0.1u ad=0.0528p as=0.0816p pd=0.68u ps=1.16u
    I_MXI1_I101_MN4 (I1_b5_1 XI1_I101_An XI1_I101_n2 VSS) gpdk090_nmos1v w=0.24u l=0.1u ad=0.0528p as=0.0528p pd=0.68u ps=0.68u
    I_MXI1_I101_MN2 (XI1_I101_n1 I1_dd1 I1_b5_1 VSS) gpdk090_nmos1v w=0.24u l=0.1u ad=0.0528p as=0.0528p pd=0.68u ps=0.68u
    I_MXI1_I101_MN3 (VSS I1_qu3 XI1_I101_n1 VSS) gpdk090_nmos1v w=0.24u l=0.1u ad=0.0816p as=0.0528p pd=1.16u ps=0.68u
    I_MXI1_I101_MN0 (XI1_I101_An I1_dd1 VSS VSS) gpdk090_nmos1v w=0.12u l=0.1u ad=0.0696p as=0.0696p pd=1.16u ps=1.16u
    I_MXI1_I64_MN1 (XI1_I64_Bn I1_qu6 VSS VSS) gpdk090_nmos1v w=0.12u l=0.1u ad=0.0696p as=0.0696p pd=1.16u ps=1.16u
    I_MXI1_I64_MN5 (XI1_I64_n2 XI1_I64_Bn VSS VSS) gpdk090_nmos1v w=0.24u l=0.1u ad=0.0528p as=0.0816p pd=0.68u ps=1.16u
    I_MXI1_I64_MN4 (I1_b2_0 XI1_I64_An XI1_I64_n2 VSS) gpdk090_nmos1v w=0.24u l=0.1u ad=0.0528p as=0.0528p pd=0.68u ps=0.68u
    I_MXI1_I64_MN2 (XI1_I64_n1 B_0 I1_b2_0 VSS) gpdk090_nmos1v w=0.24u l=0.1u ad=0.0528p as=0.0528p pd=0.68u ps=0.68u
    I_MXI1_I64_MN3 (VSS I1_qu6 XI1_I64_n1 VSS) gpdk090_nmos1v w=0.24u l=0.1u ad=0.0816p as=0.0528p pd=1.16u ps=0.68u
    I_MXI1_I64_MN0 (XI1_I64_An B_0 VSS VSS) gpdk090_nmos1v w=0.12u l=0.1u ad=0.0696p as=0.0696p pd=1.16u ps=1.16u
    I_MXI1_I52_MN1 (XI1_I52_Bn I1_qu7 VSS VSS) gpdk090_nmos1v w=0.12u l=0.1u ad=0.0696p as=0.0696p pd=1.16u ps=1.16u
    I_MXI1_I52_MN5 (XI1_I52_n2 XI1_I52_Bn VSS VSS) gpdk090_nmos1v w=0.24u l=0.1u ad=0.0528p as=0.0816p pd=0.68u ps=1.16u
    I_MXI1_I52_MN4 (I1_b1_0 XI1_I52_An XI1_I52_n2 VSS) gpdk090_nmos1v w=0.24u l=0.1u ad=0.0528p as=0.0528p pd=0.68u ps=0.68u
    I_MXI1_I52_MN2 (XI1_I52_n1 B_0 I1_b1_0 VSS) gpdk090_nmos1v w=0.24u l=0.1u ad=0.0528p as=0.0528p pd=0.68u ps=0.68u
    I_MXI1_I52_MN3 (VSS I1_qu7 XI1_I52_n1 VSS) gpdk090_nmos1v w=0.24u l=0.1u ad=0.0816p as=0.0528p pd=1.16u ps=0.68u
    I_MXI1_I52_MN0 (XI1_I52_An B_0 VSS VSS) gpdk090_nmos1v w=0.12u l=0.1u ad=0.0696p as=0.0696p pd=1.16u ps=1.16u
    I_MXI1_I40_MN1 (XI1_I40_Bn VDD VSS VSS) gpdk090_nmos1v w=0.12u l=0.1u ad=0.0696p as=0.0696p pd=1.16u ps=1.16u
    I_MXI1_I40_MN5 (XI1_I40_n2 XI1_I40_Bn VSS VSS) gpdk090_nmos1v w=0.24u l=0.1u ad=0.0528p as=0.0816p pd=0.68u ps=1.16u
    I_MXI1_I40_MN4 (I1_b0_0 XI1_I40_An XI1_I40_n2 VSS) gpdk090_nmos1v w=0.24u l=0.1u ad=0.0528p as=0.0528p pd=0.68u ps=0.68u
    I_MXI1_I40_MN2 (XI1_I40_n1 B_0 I1_b0_0 VSS) gpdk090_nmos1v w=0.24u l=0.1u ad=0.0528p as=0.0528p pd=0.68u ps=0.68u
    I_MXI1_I40_MN3 (VSS VDD XI1_I40_n1 VSS) gpdk090_nmos1v w=0.24u l=0.1u ad=0.0816p as=0.0528p pd=1.16u ps=0.68u
    I_MXI1_I40_MN0 (XI1_I40_An B_0 VSS VSS) gpdk090_nmos1v w=0.12u l=0.1u ad=0.0696p as=0.0696p pd=1.16u ps=1.16u
    I_MXI2_I2_I16_MN1 (XI2_I2_I16_Bn B_2 VSS VSS) gpdk090_nmos1v w=0.12u l=0.1u ad=0.0696p as=0.0696p pd=1.16u ps=1.16u
    I_MXI2_I2_I16_MN5 (XI2_I2_I16_n2 XI2_I2_I16_Bn VSS VSS) gpdk090_nmos1v w=0.24u l=0.1u ad=0.0528p as=0.0816p pd=0.68u ps=1.16u
    I_MXI2_I2_I16_MN4 (I2_XOR_2 XI2_I2_I16_An XI2_I2_I16_n2 VSS) gpdk090_nmos1v w=0.24u l=0.1u ad=0.0528p as=0.0528p pd=0.68u ps=0.68u
    I_MXI2_I2_I16_MN2 (XI2_I2_I16_n1 A_2 I2_XOR_2 VSS) gpdk090_nmos1v w=0.24u l=0.1u ad=0.0528p as=0.0528p pd=0.68u ps=0.68u
    I_MXI2_I2_I16_MN3 (VSS B_2 XI2_I2_I16_n1 VSS) gpdk090_nmos1v w=0.24u l=0.1u ad=0.0816p as=0.0528p pd=1.16u ps=0.68u
    I_MXI2_I2_I16_MN0 (XI2_I2_I16_An A_2 VSS VSS) gpdk090_nmos1v w=0.12u l=0.1u ad=0.0696p as=0.0696p pd=1.16u ps=1.16u
    I_MXI1_I121_MN1 (XI1_I121_Bn I1_qu2 VSS VSS) gpdk090_nmos1v w=0.12u l=0.1u ad=0.0696p as=0.0696p pd=1.16u ps=1.16u
    I_MXI1_I121_MN5 (XI1_I121_n2 XI1_I121_Bn VSS VSS) gpdk090_nmos1v w=0.24u l=0.1u ad=0.0528p as=0.0816p pd=0.68u ps=1.16u
    I_MXI1_I121_MN4 (I1_h6 XI1_I121_An XI1_I121_n2 VSS) gpdk090_nmos1v w=0.24u l=0.1u ad=0.0528p as=0.0528p pd=0.68u ps=0.68u
    I_MXI1_I121_MN2 (XI1_I121_n1 I1_p5_7 I1_h6 VSS) gpdk090_nmos1v w=0.24u l=0.1u ad=0.0528p as=0.0528p pd=0.68u ps=0.68u
    I_MXI1_I121_MN3 (VSS I1_qu2 XI1_I121_n1 VSS) gpdk090_nmos1v w=0.24u l=0.1u ad=0.0816p as=0.0528p pd=1.16u ps=0.68u
    I_MXI1_I121_MN0 (XI1_I121_An I1_p5_7 VSS VSS) gpdk090_nmos1v w=0.12u l=0.1u ad=0.0696p as=0.0696p pd=1.16u ps=1.16u
    I_MXI1_I108_I41_MN1 (XI1_I108_I41_Bn I1_I108_G3_0n VSS VSS) gpdk090_nmos1v w=0.12u l=0.1u ad=0.0696p as=0.0696p pd=1.16u ps=1.16u
    I_MXI1_I108_I41_MN5 (XI1_I108_I41_n2 XI1_I108_I41_Bn VSS VSS) gpdk090_nmos1v w=0.24u l=0.1u ad=0.0528p as=0.0816p pd=0.68u ps=1.16u
    I_MXI1_I108_I41_MN4 (I1_p5_4 XI1_I108_I41_An XI1_I108_I41_n2 VSS) gpdk090_nmos1v w=0.24u l=0.1u ad=0.0528p as=0.0528p pd=0.68u ps=0.68u
    I_MXI1_I108_I41_MN2 (XI1_I108_I41_n1 I1_I108_pn4 I1_p5_4 VSS) gpdk090_nmos1v w=0.24u l=0.1u ad=0.0528p as=0.0528p pd=0.68u ps=0.68u
    I_MXI1_I108_I41_MN3 (VSS I1_I108_G3_0n XI1_I108_I41_n1 VSS) gpdk090_nmos1v w=0.24u l=0.1u ad=0.0816p as=0.0528p pd=1.16u ps=0.68u
    I_MXI1_I108_I41_MN0 (XI1_I108_I41_An I1_I108_pn4 VSS VSS) gpdk090_nmos1v w=0.12u l=0.1u ad=0.0696p as=0.0696p pd=1.16u ps=1.16u
    I_MXI1_I102_MN1 (XI1_I102_Bn I1_qu3 VSS VSS) gpdk090_nmos1v w=0.12u l=0.1u ad=0.0696p as=0.0696p pd=1.16u ps=1.16u
    I_MXI1_I102_MN5 (XI1_I102_n2 XI1_I102_Bn VSS VSS) gpdk090_nmos1v w=0.24u l=0.1u ad=0.0528p as=0.0816p pd=0.68u ps=1.16u
    I_MXI1_I102_MN4 (I1_b5_2 XI1_I102_An XI1_I102_n2 VSS) gpdk090_nmos1v w=0.24u l=0.1u ad=0.0528p as=0.0528p pd=0.68u ps=0.68u
    I_MXI1_I102_MN2 (XI1_I102_n1 I1_dd2 I1_b5_2 VSS) gpdk090_nmos1v w=0.24u l=0.1u ad=0.0528p as=0.0528p pd=0.68u ps=0.68u
    I_MXI1_I102_MN3 (VSS I1_qu3 XI1_I102_n1 VSS) gpdk090_nmos1v w=0.24u l=0.1u ad=0.0816p as=0.0528p pd=1.16u ps=0.68u
    I_MXI1_I102_MN0 (XI1_I102_An I1_dd2 VSS VSS) gpdk090_nmos1v w=0.12u l=0.1u ad=0.0696p as=0.0696p pd=1.16u ps=1.16u
    I_MXI1_I90_MN1 (XI1_I90_Bn I1_qu4 VSS VSS) gpdk090_nmos1v w=0.12u l=0.1u ad=0.0696p as=0.0696p pd=1.16u ps=1.16u
    I_MXI1_I90_MN5 (XI1_I90_n2 XI1_I90_Bn VSS VSS) gpdk090_nmos1v w=0.24u l=0.1u ad=0.0528p as=0.0816p pd=0.68u ps=1.16u
    I_MXI1_I90_MN4 (I1_b4_2 XI1_I90_An XI1_I90_n2 VSS) gpdk090_nmos1v w=0.24u l=0.1u ad=0.0528p as=0.0528p pd=0.68u ps=0.68u
    I_MXI1_I90_MN2 (XI1_I90_n1 I1_dd2 I1_b4_2 VSS) gpdk090_nmos1v w=0.24u l=0.1u ad=0.0528p as=0.0528p pd=0.68u ps=0.68u
    I_MXI1_I90_MN3 (VSS I1_qu4 XI1_I90_n1 VSS) gpdk090_nmos1v w=0.24u l=0.1u ad=0.0816p as=0.0528p pd=1.16u ps=0.68u
    I_MXI1_I90_MN0 (XI1_I90_An I1_dd2 VSS VSS) gpdk090_nmos1v w=0.12u l=0.1u ad=0.0696p as=0.0696p pd=1.16u ps=1.16u
    I_MXI1_I89_MN1 (XI1_I89_Bn I1_qu4 VSS VSS) gpdk090_nmos1v w=0.12u l=0.1u ad=0.0696p as=0.0696p pd=1.16u ps=1.16u
    I_MXI1_I89_MN5 (XI1_I89_n2 XI1_I89_Bn VSS VSS) gpdk090_nmos1v w=0.24u l=0.1u ad=0.0528p as=0.0816p pd=0.68u ps=1.16u
    I_MXI1_I89_MN4 (I1_b4_1 XI1_I89_An XI1_I89_n2 VSS) gpdk090_nmos1v w=0.24u l=0.1u ad=0.0528p as=0.0528p pd=0.68u ps=0.68u
    I_MXI1_I89_MN2 (XI1_I89_n1 I1_dd1 I1_b4_1 VSS) gpdk090_nmos1v w=0.24u l=0.1u ad=0.0528p as=0.0528p pd=0.68u ps=0.68u
    I_MXI1_I89_MN3 (VSS I1_qu4 XI1_I89_n1 VSS) gpdk090_nmos1v w=0.24u l=0.1u ad=0.0816p as=0.0528p pd=1.16u ps=0.68u
    I_MXI1_I89_MN0 (XI1_I89_An I1_dd1 VSS VSS) gpdk090_nmos1v w=0.12u l=0.1u ad=0.0696p as=0.0696p pd=1.16u ps=1.16u
    I_MXI1_I88_MN1 (XI1_I88_Bn I1_qu4 VSS VSS) gpdk090_nmos1v w=0.12u l=0.1u ad=0.0696p as=0.0696p pd=1.16u ps=1.16u
    I_MXI1_I88_MN5 (XI1_I88_n2 XI1_I88_Bn VSS VSS) gpdk090_nmos1v w=0.24u l=0.1u ad=0.0528p as=0.0816p pd=0.68u ps=1.16u
    I_MXI1_I88_MN4 (I1_b4_0 XI1_I88_An XI1_I88_n2 VSS) gpdk090_nmos1v w=0.24u l=0.1u ad=0.0528p as=0.0528p pd=0.68u ps=0.68u
    I_MXI1_I88_MN2 (XI1_I88_n1 B_0 I1_b4_0 VSS) gpdk090_nmos1v w=0.24u l=0.1u ad=0.0528p as=0.0528p pd=0.68u ps=0.68u
    I_MXI1_I88_MN3 (VSS I1_qu4 XI1_I88_n1 VSS) gpdk090_nmos1v w=0.24u l=0.1u ad=0.0816p as=0.0528p pd=1.16u ps=0.68u
    I_MXI1_I88_MN0 (XI1_I88_An B_0 VSS VSS) gpdk090_nmos1v w=0.12u l=0.1u ad=0.0696p as=0.0696p pd=1.16u ps=1.16u
    I_MXI1_I77_MN1 (XI1_I77_Bn I1_qu5 VSS VSS) gpdk090_nmos1v w=0.12u l=0.1u ad=0.0696p as=0.0696p pd=1.16u ps=1.16u
    I_MXI1_I77_MN5 (XI1_I77_n2 XI1_I77_Bn VSS VSS) gpdk090_nmos1v w=0.24u l=0.1u ad=0.0528p as=0.0816p pd=0.68u ps=1.16u
    I_MXI1_I77_MN4 (I1_b3_1 XI1_I77_An XI1_I77_n2 VSS) gpdk090_nmos1v w=0.24u l=0.1u ad=0.0528p as=0.0528p pd=0.68u ps=0.68u
    I_MXI1_I77_MN2 (XI1_I77_n1 I1_dd1 I1_b3_1 VSS) gpdk090_nmos1v w=0.24u l=0.1u ad=0.0528p as=0.0528p pd=0.68u ps=0.68u
    I_MXI1_I77_MN3 (VSS I1_qu5 XI1_I77_n1 VSS) gpdk090_nmos1v w=0.24u l=0.1u ad=0.0816p as=0.0528p pd=1.16u ps=0.68u
    I_MXI1_I77_MN0 (XI1_I77_An I1_dd1 VSS VSS) gpdk090_nmos1v w=0.12u l=0.1u ad=0.0696p as=0.0696p pd=1.16u ps=1.16u
    I_MXI1_I78_MN1 (XI1_I78_Bn I1_qu5 VSS VSS) gpdk090_nmos1v w=0.12u l=0.1u ad=0.0696p as=0.0696p pd=1.16u ps=1.16u
    I_MXI1_I78_MN5 (XI1_I78_n2 XI1_I78_Bn VSS VSS) gpdk090_nmos1v w=0.24u l=0.1u ad=0.0528p as=0.0816p pd=0.68u ps=1.16u
    I_MXI1_I78_MN4 (I1_b3_2 XI1_I78_An XI1_I78_n2 VSS) gpdk090_nmos1v w=0.24u l=0.1u ad=0.0528p as=0.0528p pd=0.68u ps=0.68u
    I_MXI1_I78_MN2 (XI1_I78_n1 I1_dd2 I1_b3_2 VSS) gpdk090_nmos1v w=0.24u l=0.1u ad=0.0528p as=0.0528p pd=0.68u ps=0.68u
    I_MXI1_I78_MN3 (VSS I1_qu5 XI1_I78_n1 VSS) gpdk090_nmos1v w=0.24u l=0.1u ad=0.0816p as=0.0528p pd=1.16u ps=0.68u
    I_MXI1_I78_MN0 (XI1_I78_An I1_dd2 VSS VSS) gpdk090_nmos1v w=0.12u l=0.1u ad=0.0696p as=0.0696p pd=1.16u ps=1.16u
    I_MXI1_I76_MN1 (XI1_I76_Bn I1_qu5 VSS VSS) gpdk090_nmos1v w=0.12u l=0.1u ad=0.0696p as=0.0696p pd=1.16u ps=1.16u
    I_MXI1_I76_MN5 (XI1_I76_n2 XI1_I76_Bn VSS VSS) gpdk090_nmos1v w=0.24u l=0.1u ad=0.0528p as=0.0816p pd=0.68u ps=1.16u
    I_MXI1_I76_MN4 (I1_b3_0 XI1_I76_An XI1_I76_n2 VSS) gpdk090_nmos1v w=0.24u l=0.1u ad=0.0528p as=0.0528p pd=0.68u ps=0.68u
    I_MXI1_I76_MN2 (XI1_I76_n1 B_0 I1_b3_0 VSS) gpdk090_nmos1v w=0.24u l=0.1u ad=0.0528p as=0.0528p pd=0.68u ps=0.68u
    I_MXI1_I76_MN3 (VSS I1_qu5 XI1_I76_n1 VSS) gpdk090_nmos1v w=0.24u l=0.1u ad=0.0816p as=0.0528p pd=1.16u ps=0.68u
    I_MXI1_I76_MN0 (XI1_I76_An B_0 VSS VSS) gpdk090_nmos1v w=0.12u l=0.1u ad=0.0696p as=0.0696p pd=1.16u ps=1.16u
    I_MXI1_I65_MN1 (XI1_I65_Bn I1_qu6 VSS VSS) gpdk090_nmos1v w=0.12u l=0.1u ad=0.0696p as=0.0696p pd=1.16u ps=1.16u
    I_MXI1_I65_MN5 (XI1_I65_n2 XI1_I65_Bn VSS VSS) gpdk090_nmos1v w=0.24u l=0.1u ad=0.0528p as=0.0816p pd=0.68u ps=1.16u
    I_MXI1_I65_MN4 (I1_b2_1 XI1_I65_An XI1_I65_n2 VSS) gpdk090_nmos1v w=0.24u l=0.1u ad=0.0528p as=0.0528p pd=0.68u ps=0.68u
    I_MXI1_I65_MN2 (XI1_I65_n1 I1_dd1 I1_b2_1 VSS) gpdk090_nmos1v w=0.24u l=0.1u ad=0.0528p as=0.0528p pd=0.68u ps=0.68u
    I_MXI1_I65_MN3 (VSS I1_qu6 XI1_I65_n1 VSS) gpdk090_nmos1v w=0.24u l=0.1u ad=0.0816p as=0.0528p pd=1.16u ps=0.68u
    I_MXI1_I65_MN0 (XI1_I65_An I1_dd1 VSS VSS) gpdk090_nmos1v w=0.12u l=0.1u ad=0.0696p as=0.0696p pd=1.16u ps=1.16u
    I_MXI1_I66_MN1 (XI1_I66_Bn I1_qu6 VSS VSS) gpdk090_nmos1v w=0.12u l=0.1u ad=0.0696p as=0.0696p pd=1.16u ps=1.16u
    I_MXI1_I66_MN5 (XI1_I66_n2 XI1_I66_Bn VSS VSS) gpdk090_nmos1v w=0.24u l=0.1u ad=0.0528p as=0.0816p pd=0.68u ps=1.16u
    I_MXI1_I66_MN4 (I1_b2_2 XI1_I66_An XI1_I66_n2 VSS) gpdk090_nmos1v w=0.24u l=0.1u ad=0.0528p as=0.0528p pd=0.68u ps=0.68u
    I_MXI1_I66_MN2 (XI1_I66_n1 I1_dd2 I1_b2_2 VSS) gpdk090_nmos1v w=0.24u l=0.1u ad=0.0528p as=0.0528p pd=0.68u ps=0.68u
    I_MXI1_I66_MN3 (VSS I1_qu6 XI1_I66_n1 VSS) gpdk090_nmos1v w=0.24u l=0.1u ad=0.0816p as=0.0528p pd=1.16u ps=0.68u
    I_MXI1_I66_MN0 (XI1_I66_An I1_dd2 VSS VSS) gpdk090_nmos1v w=0.12u l=0.1u ad=0.0696p as=0.0696p pd=1.16u ps=1.16u
    I_MXI1_I53_MN1 (XI1_I53_Bn I1_qu7 VSS VSS) gpdk090_nmos1v w=0.12u l=0.1u ad=0.0696p as=0.0696p pd=1.16u ps=1.16u
    I_MXI1_I53_MN5 (XI1_I53_n2 XI1_I53_Bn VSS VSS) gpdk090_nmos1v w=0.24u l=0.1u ad=0.0528p as=0.0816p pd=0.68u ps=1.16u
    I_MXI1_I53_MN4 (I1_b1_1 XI1_I53_An XI1_I53_n2 VSS) gpdk090_nmos1v w=0.24u l=0.1u ad=0.0528p as=0.0528p pd=0.68u ps=0.68u
    I_MXI1_I53_MN2 (XI1_I53_n1 I1_dd1 I1_b1_1 VSS) gpdk090_nmos1v w=0.24u l=0.1u ad=0.0528p as=0.0528p pd=0.68u ps=0.68u
    I_MXI1_I53_MN3 (VSS I1_qu7 XI1_I53_n1 VSS) gpdk090_nmos1v w=0.24u l=0.1u ad=0.0816p as=0.0528p pd=1.16u ps=0.68u
    I_MXI1_I53_MN0 (XI1_I53_An I1_dd1 VSS VSS) gpdk090_nmos1v w=0.12u l=0.1u ad=0.0696p as=0.0696p pd=1.16u ps=1.16u
    I_MXI1_I54_MN1 (XI1_I54_Bn I1_qu7 VSS VSS) gpdk090_nmos1v w=0.12u l=0.1u ad=0.0696p as=0.0696p pd=1.16u ps=1.16u
    I_MXI1_I54_MN5 (XI1_I54_n2 XI1_I54_Bn VSS VSS) gpdk090_nmos1v w=0.24u l=0.1u ad=0.0528p as=0.0816p pd=0.68u ps=1.16u
    I_MXI1_I54_MN4 (I1_b1_2 XI1_I54_An XI1_I54_n2 VSS) gpdk090_nmos1v w=0.24u l=0.1u ad=0.0528p as=0.0528p pd=0.68u ps=0.68u
    I_MXI1_I54_MN2 (XI1_I54_n1 I1_dd2 I1_b1_2 VSS) gpdk090_nmos1v w=0.24u l=0.1u ad=0.0528p as=0.0528p pd=0.68u ps=0.68u
    I_MXI1_I54_MN3 (VSS I1_qu7 XI1_I54_n1 VSS) gpdk090_nmos1v w=0.24u l=0.1u ad=0.0816p as=0.0528p pd=1.16u ps=0.68u
    I_MXI1_I54_MN0 (XI1_I54_An I1_dd2 VSS VSS) gpdk090_nmos1v w=0.12u l=0.1u ad=0.0696p as=0.0696p pd=1.16u ps=1.16u
    I_MXI1_I43_MN1 (XI1_I43_Bn VDD VSS VSS) gpdk090_nmos1v w=0.12u l=0.1u ad=0.0696p as=0.0696p pd=1.16u ps=1.16u
    I_MXI1_I43_MN5 (XI1_I43_n2 XI1_I43_Bn VSS VSS) gpdk090_nmos1v w=0.24u l=0.1u ad=0.0528p as=0.0816p pd=0.68u ps=1.16u
    I_MXI1_I43_MN4 (I1_b0_3 XI1_I43_An XI1_I43_n2 VSS) gpdk090_nmos1v w=0.24u l=0.1u ad=0.0528p as=0.0528p pd=0.68u ps=0.68u
    I_MXI1_I43_MN2 (XI1_I43_n1 I1_dd3 I1_b0_3 VSS) gpdk090_nmos1v w=0.24u l=0.1u ad=0.0528p as=0.0528p pd=0.68u ps=0.68u
    I_MXI1_I43_MN3 (VSS VDD XI1_I43_n1 VSS) gpdk090_nmos1v w=0.24u l=0.1u ad=0.0816p as=0.0528p pd=1.16u ps=0.68u
    I_MXI1_I43_MN0 (XI1_I43_An I1_dd3 VSS VSS) gpdk090_nmos1v w=0.12u l=0.1u ad=0.0696p as=0.0696p pd=1.16u ps=1.16u
    I_MXI1_I41_MN1 (XI1_I41_Bn VDD VSS VSS) gpdk090_nmos1v w=0.12u l=0.1u ad=0.0696p as=0.0696p pd=1.16u ps=1.16u
    I_MXI1_I41_MN5 (XI1_I41_n2 XI1_I41_Bn VSS VSS) gpdk090_nmos1v w=0.24u l=0.1u ad=0.0528p as=0.0816p pd=0.68u ps=1.16u
    I_MXI1_I41_MN4 (I1_b0_1 XI1_I41_An XI1_I41_n2 VSS) gpdk090_nmos1v w=0.24u l=0.1u ad=0.0528p as=0.0528p pd=0.68u ps=0.68u
    I_MXI1_I41_MN2 (XI1_I41_n1 I1_dd1 I1_b0_1 VSS) gpdk090_nmos1v w=0.24u l=0.1u ad=0.0528p as=0.0528p pd=0.68u ps=0.68u
    I_MXI1_I41_MN3 (VSS VDD XI1_I41_n1 VSS) gpdk090_nmos1v w=0.24u l=0.1u ad=0.0816p as=0.0528p pd=1.16u ps=0.68u
    I_MXI1_I41_MN0 (XI1_I41_An I1_dd1 VSS VSS) gpdk090_nmos1v w=0.12u l=0.1u ad=0.0696p as=0.0696p pd=1.16u ps=1.16u
    I_MXI1_I42_MN1 (XI1_I42_Bn VDD VSS VSS) gpdk090_nmos1v w=0.12u l=0.1u ad=0.0696p as=0.0696p pd=1.16u ps=1.16u
    I_MXI1_I42_MN5 (XI1_I42_n2 XI1_I42_Bn VSS VSS) gpdk090_nmos1v w=0.24u l=0.1u ad=0.0528p as=0.0816p pd=0.68u ps=1.16u
    I_MXI1_I42_MN4 (I1_b0_2 XI1_I42_An XI1_I42_n2 VSS) gpdk090_nmos1v w=0.24u l=0.1u ad=0.0528p as=0.0528p pd=0.68u ps=0.68u
    I_MXI1_I42_MN2 (XI1_I42_n1 I1_dd2 I1_b0_2 VSS) gpdk090_nmos1v w=0.24u l=0.1u ad=0.0528p as=0.0528p pd=0.68u ps=0.68u
    I_MXI1_I42_MN3 (VSS VDD XI1_I42_n1 VSS) gpdk090_nmos1v w=0.24u l=0.1u ad=0.0816p as=0.0528p pd=1.16u ps=0.68u
    I_MXI1_I42_MN0 (XI1_I42_An I1_dd2 VSS VSS) gpdk090_nmos1v w=0.12u l=0.1u ad=0.0696p as=0.0696p pd=1.16u ps=1.16u
    I_MXI1_I103_MN1 (XI1_I103_Bn I1_qu3 VSS VSS) gpdk090_nmos1v w=0.12u l=0.1u ad=0.0696p as=0.0696p pd=1.16u ps=1.16u
    I_MXI1_I103_MN5 (XI1_I103_n2 XI1_I103_Bn VSS VSS) gpdk090_nmos1v w=0.24u l=0.1u ad=0.0528p as=0.0816p pd=0.68u ps=1.16u
    I_MXI1_I103_MN4 (I1_b5_3 XI1_I103_An XI1_I103_n2 VSS) gpdk090_nmos1v w=0.24u l=0.1u ad=0.0528p as=0.0528p pd=0.68u ps=0.68u
    I_MXI1_I103_MN2 (XI1_I103_n1 I1_dd3 I1_b5_3 VSS) gpdk090_nmos1v w=0.24u l=0.1u ad=0.0528p as=0.0528p pd=0.68u ps=0.68u
    I_MXI1_I103_MN3 (VSS I1_qu3 XI1_I103_n1 VSS) gpdk090_nmos1v w=0.24u l=0.1u ad=0.0816p as=0.0528p pd=1.16u ps=0.68u
    I_MXI1_I103_MN0 (XI1_I103_An I1_dd3 VSS VSS) gpdk090_nmos1v w=0.12u l=0.1u ad=0.0696p as=0.0696p pd=1.16u ps=1.16u
    I_MXI1_I91_MN1 (XI1_I91_Bn I1_qu4 VSS VSS) gpdk090_nmos1v w=0.12u l=0.1u ad=0.0696p as=0.0696p pd=1.16u ps=1.16u
    I_MXI1_I91_MN5 (XI1_I91_n2 XI1_I91_Bn VSS VSS) gpdk090_nmos1v w=0.24u l=0.1u ad=0.0528p as=0.0816p pd=0.68u ps=1.16u
    I_MXI1_I91_MN4 (I1_b4_3 XI1_I91_An XI1_I91_n2 VSS) gpdk090_nmos1v w=0.24u l=0.1u ad=0.0528p as=0.0528p pd=0.68u ps=0.68u
    I_MXI1_I91_MN2 (XI1_I91_n1 I1_dd3 I1_b4_3 VSS) gpdk090_nmos1v w=0.24u l=0.1u ad=0.0528p as=0.0528p pd=0.68u ps=0.68u
    I_MXI1_I91_MN3 (VSS I1_qu4 XI1_I91_n1 VSS) gpdk090_nmos1v w=0.24u l=0.1u ad=0.0816p as=0.0528p pd=1.16u ps=0.68u
    I_MXI1_I91_MN0 (XI1_I91_An I1_dd3 VSS VSS) gpdk090_nmos1v w=0.12u l=0.1u ad=0.0696p as=0.0696p pd=1.16u ps=1.16u
    I_MXI1_I79_MN1 (XI1_I79_Bn I1_qu5 VSS VSS) gpdk090_nmos1v w=0.12u l=0.1u ad=0.0696p as=0.0696p pd=1.16u ps=1.16u
    I_MXI1_I79_MN5 (XI1_I79_n2 XI1_I79_Bn VSS VSS) gpdk090_nmos1v w=0.24u l=0.1u ad=0.0528p as=0.0816p pd=0.68u ps=1.16u
    I_MXI1_I79_MN4 (I1_b3_3 XI1_I79_An XI1_I79_n2 VSS) gpdk090_nmos1v w=0.24u l=0.1u ad=0.0528p as=0.0528p pd=0.68u ps=0.68u
    I_MXI1_I79_MN2 (XI1_I79_n1 I1_dd3 I1_b3_3 VSS) gpdk090_nmos1v w=0.24u l=0.1u ad=0.0528p as=0.0528p pd=0.68u ps=0.68u
    I_MXI1_I79_MN3 (VSS I1_qu5 XI1_I79_n1 VSS) gpdk090_nmos1v w=0.24u l=0.1u ad=0.0816p as=0.0528p pd=1.16u ps=0.68u
    I_MXI1_I79_MN0 (XI1_I79_An I1_dd3 VSS VSS) gpdk090_nmos1v w=0.12u l=0.1u ad=0.0696p as=0.0696p pd=1.16u ps=1.16u
    I_MXI1_I67_MN1 (XI1_I67_Bn I1_qu6 VSS VSS) gpdk090_nmos1v w=0.12u l=0.1u ad=0.0696p as=0.0696p pd=1.16u ps=1.16u
    I_MXI1_I67_MN5 (XI1_I67_n2 XI1_I67_Bn VSS VSS) gpdk090_nmos1v w=0.24u l=0.1u ad=0.0528p as=0.0816p pd=0.68u ps=1.16u
    I_MXI1_I67_MN4 (I1_b2_3 XI1_I67_An XI1_I67_n2 VSS) gpdk090_nmos1v w=0.24u l=0.1u ad=0.0528p as=0.0528p pd=0.68u ps=0.68u
    I_MXI1_I67_MN2 (XI1_I67_n1 I1_dd3 I1_b2_3 VSS) gpdk090_nmos1v w=0.24u l=0.1u ad=0.0528p as=0.0528p pd=0.68u ps=0.68u
    I_MXI1_I67_MN3 (VSS I1_qu6 XI1_I67_n1 VSS) gpdk090_nmos1v w=0.24u l=0.1u ad=0.0816p as=0.0528p pd=1.16u ps=0.68u
    I_MXI1_I67_MN0 (XI1_I67_An I1_dd3 VSS VSS) gpdk090_nmos1v w=0.12u l=0.1u ad=0.0696p as=0.0696p pd=1.16u ps=1.16u
    I_MXI1_I55_MN1 (XI1_I55_Bn I1_qu7 VSS VSS) gpdk090_nmos1v w=0.12u l=0.1u ad=0.0696p as=0.0696p pd=1.16u ps=1.16u
    I_MXI1_I55_MN5 (XI1_I55_n2 XI1_I55_Bn VSS VSS) gpdk090_nmos1v w=0.24u l=0.1u ad=0.0528p as=0.0816p pd=0.68u ps=1.16u
    I_MXI1_I55_MN4 (I1_b1_3 XI1_I55_An XI1_I55_n2 VSS) gpdk090_nmos1v w=0.24u l=0.1u ad=0.0528p as=0.0528p pd=0.68u ps=0.68u
    I_MXI1_I55_MN2 (XI1_I55_n1 I1_dd3 I1_b1_3 VSS) gpdk090_nmos1v w=0.24u l=0.1u ad=0.0528p as=0.0528p pd=0.68u ps=0.68u
    I_MXI1_I55_MN3 (VSS I1_qu7 XI1_I55_n1 VSS) gpdk090_nmos1v w=0.24u l=0.1u ad=0.0816p as=0.0528p pd=1.16u ps=0.68u
    I_MXI1_I55_MN0 (XI1_I55_An I1_dd3 VSS VSS) gpdk090_nmos1v w=0.12u l=0.1u ad=0.0696p as=0.0696p pd=1.16u ps=1.16u
    I_MXI1_I104_MN1 (XI1_I104_Bn I1_qu3 VSS VSS) gpdk090_nmos1v w=0.12u l=0.1u ad=0.0696p as=0.0696p pd=1.16u ps=1.16u
    I_MXI1_I104_MN5 (XI1_I104_n2 XI1_I104_Bn VSS VSS) gpdk090_nmos1v w=0.24u l=0.1u ad=0.0528p as=0.0816p pd=0.68u ps=1.16u
    I_MXI1_I104_MN4 (I1_b5_4 XI1_I104_An XI1_I104_n2 VSS) gpdk090_nmos1v w=0.24u l=0.1u ad=0.0528p as=0.0528p pd=0.68u ps=0.68u
    I_MXI1_I104_MN2 (XI1_I104_n1 I1_dd4 I1_b5_4 VSS) gpdk090_nmos1v w=0.24u l=0.1u ad=0.0528p as=0.0528p pd=0.68u ps=0.68u
    I_MXI1_I104_MN3 (VSS I1_qu3 XI1_I104_n1 VSS) gpdk090_nmos1v w=0.24u l=0.1u ad=0.0816p as=0.0528p pd=1.16u ps=0.68u
    I_MXI1_I104_MN0 (XI1_I104_An I1_dd4 VSS VSS) gpdk090_nmos1v w=0.12u l=0.1u ad=0.0696p as=0.0696p pd=1.16u ps=1.16u
    I_MXI1_I96_I40_MN1 (XI1_I96_I40_Bn I1_I96_G2_0n VSS VSS) gpdk090_nmos1v w=0.12u l=0.1u ad=0.0696p as=0.0696p pd=1.16u ps=1.16u
    I_MXI1_I96_I40_MN5 (XI1_I96_I40_n2 XI1_I96_I40_Bn VSS VSS) gpdk090_nmos1v w=0.24u l=0.1u ad=0.0528p as=0.0816p pd=0.68u ps=1.16u
    I_MXI1_I96_I40_MN4 (I1_p4_3 XI1_I96_I40_An XI1_I96_I40_n2 VSS) gpdk090_nmos1v w=0.24u l=0.1u ad=0.0528p as=0.0528p pd=0.68u ps=0.68u
    I_MXI1_I96_I40_MN2 (XI1_I96_I40_n1 I1_I96_pn3 I1_p4_3 VSS) gpdk090_nmos1v w=0.24u l=0.1u ad=0.0528p as=0.0528p pd=0.68u ps=0.68u
    I_MXI1_I96_I40_MN3 (VSS I1_I96_G2_0n XI1_I96_I40_n1 VSS) gpdk090_nmos1v w=0.24u l=0.1u ad=0.0816p as=0.0528p pd=1.16u ps=0.68u
    I_MXI1_I96_I40_MN0 (XI1_I96_I40_An I1_I96_pn3 VSS VSS) gpdk090_nmos1v w=0.12u l=0.1u ad=0.0696p as=0.0696p pd=1.16u ps=1.16u
    I_MXI1_I80_MN1 (XI1_I80_Bn I1_qu5 VSS VSS) gpdk090_nmos1v w=0.12u l=0.1u ad=0.0696p as=0.0696p pd=1.16u ps=1.16u
    I_MXI1_I80_MN5 (XI1_I80_n2 XI1_I80_Bn VSS VSS) gpdk090_nmos1v w=0.24u l=0.1u ad=0.0528p as=0.0816p pd=0.68u ps=1.16u
    I_MXI1_I80_MN4 (I1_b3_4 XI1_I80_An XI1_I80_n2 VSS) gpdk090_nmos1v w=0.24u l=0.1u ad=0.0528p as=0.0528p pd=0.68u ps=0.68u
    I_MXI1_I80_MN2 (XI1_I80_n1 I1_dd4 I1_b3_4 VSS) gpdk090_nmos1v w=0.24u l=0.1u ad=0.0528p as=0.0528p pd=0.68u ps=0.68u
    I_MXI1_I80_MN3 (VSS I1_qu5 XI1_I80_n1 VSS) gpdk090_nmos1v w=0.24u l=0.1u ad=0.0816p as=0.0528p pd=1.16u ps=0.68u
    I_MXI1_I80_MN0 (XI1_I80_An I1_dd4 VSS VSS) gpdk090_nmos1v w=0.12u l=0.1u ad=0.0696p as=0.0696p pd=1.16u ps=1.16u
    I_MXI1_I68_MN1 (XI1_I68_Bn I1_qu6 VSS VSS) gpdk090_nmos1v w=0.12u l=0.1u ad=0.0696p as=0.0696p pd=1.16u ps=1.16u
    I_MXI1_I68_MN5 (XI1_I68_n2 XI1_I68_Bn VSS VSS) gpdk090_nmos1v w=0.24u l=0.1u ad=0.0528p as=0.0816p pd=0.68u ps=1.16u
    I_MXI1_I68_MN4 (I1_b2_4 XI1_I68_An XI1_I68_n2 VSS) gpdk090_nmos1v w=0.24u l=0.1u ad=0.0528p as=0.0528p pd=0.68u ps=0.68u
    I_MXI1_I68_MN2 (XI1_I68_n1 I1_dd4 I1_b2_4 VSS) gpdk090_nmos1v w=0.24u l=0.1u ad=0.0528p as=0.0528p pd=0.68u ps=0.68u
    I_MXI1_I68_MN3 (VSS I1_qu6 XI1_I68_n1 VSS) gpdk090_nmos1v w=0.24u l=0.1u ad=0.0816p as=0.0528p pd=1.16u ps=0.68u
    I_MXI1_I68_MN0 (XI1_I68_An I1_dd4 VSS VSS) gpdk090_nmos1v w=0.12u l=0.1u ad=0.0696p as=0.0696p pd=1.16u ps=1.16u
    I_MXI1_I44_MN1 (XI1_I44_Bn VDD VSS VSS) gpdk090_nmos1v w=0.12u l=0.1u ad=0.0696p as=0.0696p pd=1.16u ps=1.16u
    I_MXI1_I44_MN5 (XI1_I44_n2 XI1_I44_Bn VSS VSS) gpdk090_nmos1v w=0.24u l=0.1u ad=0.0528p as=0.0816p pd=0.68u ps=1.16u
    I_MXI1_I44_MN4 (I1_b0_4 XI1_I44_An XI1_I44_n2 VSS) gpdk090_nmos1v w=0.24u l=0.1u ad=0.0528p as=0.0528p pd=0.68u ps=0.68u
    I_MXI1_I44_MN2 (XI1_I44_n1 I1_dd4 I1_b0_4 VSS) gpdk090_nmos1v w=0.24u l=0.1u ad=0.0528p as=0.0528p pd=0.68u ps=0.68u
    I_MXI1_I44_MN3 (VSS VDD XI1_I44_n1 VSS) gpdk090_nmos1v w=0.24u l=0.1u ad=0.0816p as=0.0528p pd=1.16u ps=0.68u
    I_MXI1_I44_MN0 (XI1_I44_An I1_dd4 VSS VSS) gpdk090_nmos1v w=0.12u l=0.1u ad=0.0696p as=0.0696p pd=1.16u ps=1.16u
    I_MXI1_I56_MN1 (XI1_I56_Bn I1_qu7 VSS VSS) gpdk090_nmos1v w=0.12u l=0.1u ad=0.0696p as=0.0696p pd=1.16u ps=1.16u
    I_MXI1_I56_MN5 (XI1_I56_n2 XI1_I56_Bn VSS VSS) gpdk090_nmos1v w=0.24u l=0.1u ad=0.0528p as=0.0816p pd=0.68u ps=1.16u
    I_MXI1_I56_MN4 (I1_b1_4 XI1_I56_An XI1_I56_n2 VSS) gpdk090_nmos1v w=0.24u l=0.1u ad=0.0528p as=0.0528p pd=0.68u ps=0.68u
    I_MXI1_I56_MN2 (XI1_I56_n1 I1_dd4 I1_b1_4 VSS) gpdk090_nmos1v w=0.24u l=0.1u ad=0.0528p as=0.0528p pd=0.68u ps=0.68u
    I_MXI1_I56_MN3 (VSS I1_qu7 XI1_I56_n1 VSS) gpdk090_nmos1v w=0.24u l=0.1u ad=0.0816p as=0.0528p pd=1.16u ps=0.68u
    I_MXI1_I56_MN0 (XI1_I56_An I1_dd4 VSS VSS) gpdk090_nmos1v w=0.12u l=0.1u ad=0.0696p as=0.0696p pd=1.16u ps=1.16u
    I_MXI1_I110_MN1 (XI1_I110_Bn I1_c5_8 VSS VSS) gpdk090_nmos1v w=0.12u l=0.1u ad=0.0696p as=0.0696p pd=1.16u ps=1.16u
    I_MXI1_I110_MN5 (XI1_I110_n2 XI1_I110_Bn VSS VSS) gpdk090_nmos1v w=0.24u l=0.1u ad=0.0528p as=0.0816p pd=0.68u ps=1.16u
    I_MXI1_I110_MN4 (I1_p5_8 XI1_I110_An XI1_I110_n2 VSS) gpdk090_nmos1v w=0.24u l=0.1u ad=0.0528p as=0.0528p pd=0.68u ps=0.68u
    I_MXI1_I110_MN2 (XI1_I110_n1 I1_h5 I1_p5_8 VSS) gpdk090_nmos1v w=0.24u l=0.1u ad=0.0528p as=0.0528p pd=0.68u ps=0.68u
    I_MXI1_I110_MN3 (VSS I1_c5_8 XI1_I110_n1 VSS) gpdk090_nmos1v w=0.24u l=0.1u ad=0.0816p as=0.0528p pd=1.16u ps=0.68u
    I_MXI1_I110_MN0 (XI1_I110_An I1_h5 VSS VSS) gpdk090_nmos1v w=0.12u l=0.1u ad=0.0696p as=0.0696p pd=1.16u ps=1.16u
    I_MXI1_I96_I41_MN1 (XI1_I96_I41_Bn I1_I96_G3_0n VSS VSS) gpdk090_nmos1v w=0.12u l=0.1u ad=0.0696p as=0.0696p pd=1.16u ps=1.16u
    I_MXI1_I96_I41_MN5 (XI1_I96_I41_n2 XI1_I96_I41_Bn VSS VSS) gpdk090_nmos1v w=0.24u l=0.1u ad=0.0528p as=0.0816p pd=0.68u ps=1.16u
    I_MXI1_I96_I41_MN4 (I1_p4_4 XI1_I96_I41_An XI1_I96_I41_n2 VSS) gpdk090_nmos1v w=0.24u l=0.1u ad=0.0528p as=0.0528p pd=0.68u ps=0.68u
    I_MXI1_I96_I41_MN2 (XI1_I96_I41_n1 I1_I96_pn4 I1_p4_4 VSS) gpdk090_nmos1v w=0.24u l=0.1u ad=0.0528p as=0.0528p pd=0.68u ps=0.68u
    I_MXI1_I96_I41_MN3 (VSS I1_I96_G3_0n XI1_I96_I41_n1 VSS) gpdk090_nmos1v w=0.24u l=0.1u ad=0.0816p as=0.0528p pd=1.16u ps=0.68u
    I_MXI1_I96_I41_MN0 (XI1_I96_I41_An I1_I96_pn4 VSS VSS) gpdk090_nmos1v w=0.12u l=0.1u ad=0.0696p as=0.0696p pd=1.16u ps=1.16u
    I_MXI1_I92_MN1 (XI1_I92_Bn I1_qu4 VSS VSS) gpdk090_nmos1v w=0.12u l=0.1u ad=0.0696p as=0.0696p pd=1.16u ps=1.16u
    I_MXI1_I92_MN5 (XI1_I92_n2 XI1_I92_Bn VSS VSS) gpdk090_nmos1v w=0.24u l=0.1u ad=0.0528p as=0.0816p pd=0.68u ps=1.16u
    I_MXI1_I92_MN4 (I1_b4_4 XI1_I92_An XI1_I92_n2 VSS) gpdk090_nmos1v w=0.24u l=0.1u ad=0.0528p as=0.0528p pd=0.68u ps=0.68u
    I_MXI1_I92_MN2 (XI1_I92_n1 I1_dd4 I1_b4_4 VSS) gpdk090_nmos1v w=0.24u l=0.1u ad=0.0528p as=0.0528p pd=0.68u ps=0.68u
    I_MXI1_I92_MN3 (VSS I1_qu4 XI1_I92_n1 VSS) gpdk090_nmos1v w=0.24u l=0.1u ad=0.0816p as=0.0528p pd=1.16u ps=0.68u
    I_MXI1_I92_MN0 (XI1_I92_An I1_dd4 VSS VSS) gpdk090_nmos1v w=0.12u l=0.1u ad=0.0696p as=0.0696p pd=1.16u ps=1.16u
    I_MXI1_I84_I40_MN1 (XI1_I84_I40_Bn I1_I84_G2_0n VSS VSS) gpdk090_nmos1v w=0.12u l=0.1u ad=0.0696p as=0.0696p pd=1.16u ps=1.16u
    I_MXI1_I84_I40_MN5 (XI1_I84_I40_n2 XI1_I84_I40_Bn VSS VSS) gpdk090_nmos1v w=0.24u l=0.1u ad=0.0528p as=0.0816p pd=0.68u ps=1.16u
    I_MXI1_I84_I40_MN4 (I1_p3_3 XI1_I84_I40_An XI1_I84_I40_n2 VSS) gpdk090_nmos1v w=0.24u l=0.1u ad=0.0528p as=0.0528p pd=0.68u ps=0.68u
    I_MXI1_I84_I40_MN2 (XI1_I84_I40_n1 I1_I84_pn3 I1_p3_3 VSS) gpdk090_nmos1v w=0.24u l=0.1u ad=0.0528p as=0.0528p pd=0.68u ps=0.68u
    I_MXI1_I84_I40_MN3 (VSS I1_I84_G2_0n XI1_I84_I40_n1 VSS) gpdk090_nmos1v w=0.24u l=0.1u ad=0.0816p as=0.0528p pd=1.16u ps=0.68u
    I_MXI1_I84_I40_MN0 (XI1_I84_I40_An I1_I84_pn3 VSS VSS) gpdk090_nmos1v w=0.12u l=0.1u ad=0.0696p as=0.0696p pd=1.16u ps=1.16u
    I_MXI1_I72_I40_MN1 (XI1_I72_I40_Bn I1_I72_G2_0n VSS VSS) gpdk090_nmos1v w=0.12u l=0.1u ad=0.0696p as=0.0696p pd=1.16u ps=1.16u
    I_MXI1_I72_I40_MN5 (XI1_I72_I40_n2 XI1_I72_I40_Bn VSS VSS) gpdk090_nmos1v w=0.24u l=0.1u ad=0.0528p as=0.0816p pd=0.68u ps=1.16u
    I_MXI1_I72_I40_MN4 (I1_p2_3 XI1_I72_I40_An XI1_I72_I40_n2 VSS) gpdk090_nmos1v w=0.24u l=0.1u ad=0.0528p as=0.0528p pd=0.68u ps=0.68u
    I_MXI1_I72_I40_MN2 (XI1_I72_I40_n1 I1_I72_pn3 I1_p2_3 VSS) gpdk090_nmos1v w=0.24u l=0.1u ad=0.0528p as=0.0528p pd=0.68u ps=0.68u
    I_MXI1_I72_I40_MN3 (VSS I1_I72_G2_0n XI1_I72_I40_n1 VSS) gpdk090_nmos1v w=0.24u l=0.1u ad=0.0816p as=0.0528p pd=1.16u ps=0.68u
    I_MXI1_I72_I40_MN0 (XI1_I72_I40_An I1_I72_pn3 VSS VSS) gpdk090_nmos1v w=0.12u l=0.1u ad=0.0696p as=0.0696p pd=1.16u ps=1.16u
    I_MXI1_I69_MN1 (XI1_I69_Bn I1_qu6 VSS VSS) gpdk090_nmos1v w=0.12u l=0.1u ad=0.0696p as=0.0696p pd=1.16u ps=1.16u
    I_MXI1_I69_MN5 (XI1_I69_n2 XI1_I69_Bn VSS VSS) gpdk090_nmos1v w=0.24u l=0.1u ad=0.0528p as=0.0816p pd=0.68u ps=1.16u
    I_MXI1_I69_MN4 (I1_b2_5 XI1_I69_An XI1_I69_n2 VSS) gpdk090_nmos1v w=0.24u l=0.1u ad=0.0528p as=0.0528p pd=0.68u ps=0.68u
    I_MXI1_I69_MN2 (XI1_I69_n1 I1_dd5 I1_b2_5 VSS) gpdk090_nmos1v w=0.24u l=0.1u ad=0.0528p as=0.0528p pd=0.68u ps=0.68u
    I_MXI1_I69_MN3 (VSS I1_qu6 XI1_I69_n1 VSS) gpdk090_nmos1v w=0.24u l=0.1u ad=0.0816p as=0.0528p pd=1.16u ps=0.68u
    I_MXI1_I69_MN0 (XI1_I69_An I1_dd5 VSS VSS) gpdk090_nmos1v w=0.12u l=0.1u ad=0.0696p as=0.0696p pd=1.16u ps=1.16u
    I_MXI1_I60_I40_MN1 (XI1_I60_I40_Bn I1_I60_G2_0n VSS VSS) gpdk090_nmos1v w=0.12u l=0.1u ad=0.0696p as=0.0696p pd=1.16u ps=1.16u
    I_MXI1_I60_I40_MN5 (XI1_I60_I40_n2 XI1_I60_I40_Bn VSS VSS) gpdk090_nmos1v w=0.24u l=0.1u ad=0.0528p as=0.0816p pd=0.68u ps=1.16u
    I_MXI1_I60_I40_MN4 (I1_p1_3 XI1_I60_I40_An XI1_I60_I40_n2 VSS) gpdk090_nmos1v w=0.24u l=0.1u ad=0.0528p as=0.0528p pd=0.68u ps=0.68u
    I_MXI1_I60_I40_MN2 (XI1_I60_I40_n1 I1_I60_pn3 I1_p1_3 VSS) gpdk090_nmos1v w=0.24u l=0.1u ad=0.0528p as=0.0528p pd=0.68u ps=0.68u
    I_MXI1_I60_I40_MN3 (VSS I1_I60_G2_0n XI1_I60_I40_n1 VSS) gpdk090_nmos1v w=0.24u l=0.1u ad=0.0816p as=0.0528p pd=1.16u ps=0.68u
    I_MXI1_I60_I40_MN0 (XI1_I60_I40_An I1_I60_pn3 VSS VSS) gpdk090_nmos1v w=0.12u l=0.1u ad=0.0696p as=0.0696p pd=1.16u ps=1.16u
    I_MXI1_I57_MN1 (XI1_I57_Bn I1_qu7 VSS VSS) gpdk090_nmos1v w=0.12u l=0.1u ad=0.0696p as=0.0696p pd=1.16u ps=1.16u
    I_MXI1_I57_MN5 (XI1_I57_n2 XI1_I57_Bn VSS VSS) gpdk090_nmos1v w=0.24u l=0.1u ad=0.0528p as=0.0816p pd=0.68u ps=1.16u
    I_MXI1_I57_MN4 (I1_b1_5 XI1_I57_An XI1_I57_n2 VSS) gpdk090_nmos1v w=0.24u l=0.1u ad=0.0528p as=0.0528p pd=0.68u ps=0.68u
    I_MXI1_I57_MN2 (XI1_I57_n1 I1_dd5 I1_b1_5 VSS) gpdk090_nmos1v w=0.24u l=0.1u ad=0.0528p as=0.0528p pd=0.68u ps=0.68u
    I_MXI1_I57_MN3 (VSS I1_qu7 XI1_I57_n1 VSS) gpdk090_nmos1v w=0.24u l=0.1u ad=0.0816p as=0.0528p pd=1.16u ps=0.68u
    I_MXI1_I57_MN0 (XI1_I57_An I1_dd5 VSS VSS) gpdk090_nmos1v w=0.12u l=0.1u ad=0.0696p as=0.0696p pd=1.16u ps=1.16u
    I_MXI1_I48_I40_MN1 (XI1_I48_I40_Bn I1_I48_G2_0n VSS VSS) gpdk090_nmos1v w=0.12u l=0.1u ad=0.0696p as=0.0696p pd=1.16u ps=1.16u
    I_MXI1_I48_I40_MN5 (XI1_I48_I40_n2 XI1_I48_I40_Bn VSS VSS) gpdk090_nmos1v w=0.24u l=0.1u ad=0.0528p as=0.0816p pd=0.68u ps=1.16u
    I_MXI1_I48_I40_MN4 (I1_p0_3 XI1_I48_I40_An XI1_I48_I40_n2 VSS) gpdk090_nmos1v w=0.24u l=0.1u ad=0.0528p as=0.0528p pd=0.68u ps=0.68u
    I_MXI1_I48_I40_MN2 (XI1_I48_I40_n1 I1_I48_pn3 I1_p0_3 VSS) gpdk090_nmos1v w=0.24u l=0.1u ad=0.0528p as=0.0528p pd=0.68u ps=0.68u
    I_MXI1_I48_I40_MN3 (VSS I1_I48_G2_0n XI1_I48_I40_n1 VSS) gpdk090_nmos1v w=0.24u l=0.1u ad=0.0816p as=0.0528p pd=1.16u ps=0.68u
    I_MXI1_I48_I40_MN0 (XI1_I48_I40_An I1_I48_pn3 VSS VSS) gpdk090_nmos1v w=0.12u l=0.1u ad=0.0696p as=0.0696p pd=1.16u ps=1.16u
    I_MXI1_I105_MN1 (XI1_I105_Bn I1_qu3 VSS VSS) gpdk090_nmos1v w=0.12u l=0.1u ad=0.0696p as=0.0696p pd=1.16u ps=1.16u
    I_MXI1_I105_MN5 (XI1_I105_n2 XI1_I105_Bn VSS VSS) gpdk090_nmos1v w=0.24u l=0.1u ad=0.0528p as=0.0816p pd=0.68u ps=1.16u
    I_MXI1_I105_MN4 (I1_b5_5 XI1_I105_An XI1_I105_n2 VSS) gpdk090_nmos1v w=0.24u l=0.1u ad=0.0528p as=0.0528p pd=0.68u ps=0.68u
    I_MXI1_I105_MN2 (XI1_I105_n1 I1_dd5 I1_b5_5 VSS) gpdk090_nmos1v w=0.24u l=0.1u ad=0.0528p as=0.0528p pd=0.68u ps=0.68u
    I_MXI1_I105_MN3 (VSS I1_qu3 XI1_I105_n1 VSS) gpdk090_nmos1v w=0.24u l=0.1u ad=0.0816p as=0.0528p pd=1.16u ps=0.68u
    I_MXI1_I105_MN0 (XI1_I105_An I1_dd5 VSS VSS) gpdk090_nmos1v w=0.12u l=0.1u ad=0.0696p as=0.0696p pd=1.16u ps=1.16u
    I_MXI1_I93_MN1 (XI1_I93_Bn I1_qu4 VSS VSS) gpdk090_nmos1v w=0.12u l=0.1u ad=0.0696p as=0.0696p pd=1.16u ps=1.16u
    I_MXI1_I93_MN5 (XI1_I93_n2 XI1_I93_Bn VSS VSS) gpdk090_nmos1v w=0.24u l=0.1u ad=0.0528p as=0.0816p pd=0.68u ps=1.16u
    I_MXI1_I93_MN4 (I1_b4_5 XI1_I93_An XI1_I93_n2 VSS) gpdk090_nmos1v w=0.24u l=0.1u ad=0.0528p as=0.0528p pd=0.68u ps=0.68u
    I_MXI1_I93_MN2 (XI1_I93_n1 I1_dd5 I1_b4_5 VSS) gpdk090_nmos1v w=0.24u l=0.1u ad=0.0528p as=0.0528p pd=0.68u ps=0.68u
    I_MXI1_I93_MN3 (VSS I1_qu4 XI1_I93_n1 VSS) gpdk090_nmos1v w=0.24u l=0.1u ad=0.0816p as=0.0528p pd=1.16u ps=0.68u
    I_MXI1_I93_MN0 (XI1_I93_An I1_dd5 VSS VSS) gpdk090_nmos1v w=0.12u l=0.1u ad=0.0696p as=0.0696p pd=1.16u ps=1.16u
    I_MXI1_I81_MN1 (XI1_I81_Bn I1_qu5 VSS VSS) gpdk090_nmos1v w=0.12u l=0.1u ad=0.0696p as=0.0696p pd=1.16u ps=1.16u
    I_MXI1_I81_MN5 (XI1_I81_n2 XI1_I81_Bn VSS VSS) gpdk090_nmos1v w=0.24u l=0.1u ad=0.0528p as=0.0816p pd=0.68u ps=1.16u
    I_MXI1_I81_MN4 (I1_b3_5 XI1_I81_An XI1_I81_n2 VSS) gpdk090_nmos1v w=0.24u l=0.1u ad=0.0528p as=0.0528p pd=0.68u ps=0.68u
    I_MXI1_I81_MN2 (XI1_I81_n1 I1_dd5 I1_b3_5 VSS) gpdk090_nmos1v w=0.24u l=0.1u ad=0.0528p as=0.0528p pd=0.68u ps=0.68u
    I_MXI1_I81_MN3 (VSS I1_qu5 XI1_I81_n1 VSS) gpdk090_nmos1v w=0.24u l=0.1u ad=0.0816p as=0.0528p pd=1.16u ps=0.68u
    I_MXI1_I81_MN0 (XI1_I81_An I1_dd5 VSS VSS) gpdk090_nmos1v w=0.12u l=0.1u ad=0.0696p as=0.0696p pd=1.16u ps=1.16u
    I_MXI1_I72_I41_MN1 (XI1_I72_I41_Bn I1_I72_G3_0n VSS VSS) gpdk090_nmos1v w=0.12u l=0.1u ad=0.0696p as=0.0696p pd=1.16u ps=1.16u
    I_MXI1_I72_I41_MN5 (XI1_I72_I41_n2 XI1_I72_I41_Bn VSS VSS) gpdk090_nmos1v w=0.24u l=0.1u ad=0.0528p as=0.0816p pd=0.68u ps=1.16u
    I_MXI1_I72_I41_MN4 (I1_p2_4 XI1_I72_I41_An XI1_I72_I41_n2 VSS) gpdk090_nmos1v w=0.24u l=0.1u ad=0.0528p as=0.0528p pd=0.68u ps=0.68u
    I_MXI1_I72_I41_MN2 (XI1_I72_I41_n1 I1_I72_pn4 I1_p2_4 VSS) gpdk090_nmos1v w=0.24u l=0.1u ad=0.0528p as=0.0528p pd=0.68u ps=0.68u
    I_MXI1_I72_I41_MN3 (VSS I1_I72_G3_0n XI1_I72_I41_n1 VSS) gpdk090_nmos1v w=0.24u l=0.1u ad=0.0816p as=0.0528p pd=1.16u ps=0.68u
    I_MXI1_I72_I41_MN0 (XI1_I72_I41_An I1_I72_pn4 VSS VSS) gpdk090_nmos1v w=0.12u l=0.1u ad=0.0696p as=0.0696p pd=1.16u ps=1.16u
    I_MXI1_I60_I41_MN1 (XI1_I60_I41_Bn I1_I60_G3_0n VSS VSS) gpdk090_nmos1v w=0.12u l=0.1u ad=0.0696p as=0.0696p pd=1.16u ps=1.16u
    I_MXI1_I60_I41_MN5 (XI1_I60_I41_n2 XI1_I60_I41_Bn VSS VSS) gpdk090_nmos1v w=0.24u l=0.1u ad=0.0528p as=0.0816p pd=0.68u ps=1.16u
    I_MXI1_I60_I41_MN4 (I1_p1_4 XI1_I60_I41_An XI1_I60_I41_n2 VSS) gpdk090_nmos1v w=0.24u l=0.1u ad=0.0528p as=0.0528p pd=0.68u ps=0.68u
    I_MXI1_I60_I41_MN2 (XI1_I60_I41_n1 I1_I60_pn4 I1_p1_4 VSS) gpdk090_nmos1v w=0.24u l=0.1u ad=0.0528p as=0.0528p pd=0.68u ps=0.68u
    I_MXI1_I60_I41_MN3 (VSS I1_I60_G3_0n XI1_I60_I41_n1 VSS) gpdk090_nmos1v w=0.24u l=0.1u ad=0.0816p as=0.0528p pd=1.16u ps=0.68u
    I_MXI1_I60_I41_MN0 (XI1_I60_I41_An I1_I60_pn4 VSS VSS) gpdk090_nmos1v w=0.12u l=0.1u ad=0.0696p as=0.0696p pd=1.16u ps=1.16u
    I_MXI1_I45_MN1 (XI1_I45_Bn VDD VSS VSS) gpdk090_nmos1v w=0.12u l=0.1u ad=0.0696p as=0.0696p pd=1.16u ps=1.16u
    I_MXI1_I45_MN5 (XI1_I45_n2 XI1_I45_Bn VSS VSS) gpdk090_nmos1v w=0.24u l=0.1u ad=0.0528p as=0.0816p pd=0.68u ps=1.16u
    I_MXI1_I45_MN4 (I1_b0_5 XI1_I45_An XI1_I45_n2 VSS) gpdk090_nmos1v w=0.24u l=0.1u ad=0.0528p as=0.0528p pd=0.68u ps=0.68u
    I_MXI1_I45_MN2 (XI1_I45_n1 I1_dd5 I1_b0_5 VSS) gpdk090_nmos1v w=0.24u l=0.1u ad=0.0528p as=0.0528p pd=0.68u ps=0.68u
    I_MXI1_I45_MN3 (VSS VDD XI1_I45_n1 VSS) gpdk090_nmos1v w=0.24u l=0.1u ad=0.0816p as=0.0528p pd=1.16u ps=0.68u
    I_MXI1_I45_MN0 (XI1_I45_An I1_dd5 VSS VSS) gpdk090_nmos1v w=0.12u l=0.1u ad=0.0696p as=0.0696p pd=1.16u ps=1.16u
    I_MXI1_I48_I41_MN1 (XI1_I48_I41_Bn I1_I48_G3_0n VSS VSS) gpdk090_nmos1v w=0.12u l=0.1u ad=0.0696p as=0.0696p pd=1.16u ps=1.16u
    I_MXI1_I48_I41_MN5 (XI1_I48_I41_n2 XI1_I48_I41_Bn VSS VSS) gpdk090_nmos1v w=0.24u l=0.1u ad=0.0528p as=0.0816p pd=0.68u ps=1.16u
    I_MXI1_I48_I41_MN4 (I1_p0_4 XI1_I48_I41_An XI1_I48_I41_n2 VSS) gpdk090_nmos1v w=0.24u l=0.1u ad=0.0528p as=0.0528p pd=0.68u ps=0.68u
    I_MXI1_I48_I41_MN2 (XI1_I48_I41_n1 I1_I48_pn4 I1_p0_4 VSS) gpdk090_nmos1v w=0.24u l=0.1u ad=0.0528p as=0.0528p pd=0.68u ps=0.68u
    I_MXI1_I48_I41_MN3 (VSS I1_I48_G3_0n XI1_I48_I41_n1 VSS) gpdk090_nmos1v w=0.24u l=0.1u ad=0.0816p as=0.0528p pd=1.16u ps=0.68u
    I_MXI1_I48_I41_MN0 (XI1_I48_I41_An I1_I48_pn4 VSS VSS) gpdk090_nmos1v w=0.12u l=0.1u ad=0.0696p as=0.0696p pd=1.16u ps=1.16u
    I_MXI1_I106_MN1 (XI1_I106_Bn I1_qu3 VSS VSS) gpdk090_nmos1v w=0.12u l=0.1u ad=0.0696p as=0.0696p pd=1.16u ps=1.16u
    I_MXI1_I106_MN5 (XI1_I106_n2 XI1_I106_Bn VSS VSS) gpdk090_nmos1v w=0.24u l=0.1u ad=0.0528p as=0.0816p pd=0.68u ps=1.16u
    I_MXI1_I106_MN4 (I1_b5_6 XI1_I106_An XI1_I106_n2 VSS) gpdk090_nmos1v w=0.24u l=0.1u ad=0.0528p as=0.0528p pd=0.68u ps=0.68u
    I_MXI1_I106_MN2 (XI1_I106_n1 I1_dd6 I1_b5_6 VSS) gpdk090_nmos1v w=0.24u l=0.1u ad=0.0528p as=0.0528p pd=0.68u ps=0.68u
    I_MXI1_I106_MN3 (VSS I1_qu3 XI1_I106_n1 VSS) gpdk090_nmos1v w=0.24u l=0.1u ad=0.0816p as=0.0528p pd=1.16u ps=0.68u
    I_MXI1_I106_MN0 (XI1_I106_An I1_dd6 VSS VSS) gpdk090_nmos1v w=0.12u l=0.1u ad=0.0696p as=0.0696p pd=1.16u ps=1.16u
    I_MXI1_I109_MN1 (XI1_I109_Bn I1_qu3 VSS VSS) gpdk090_nmos1v w=0.12u l=0.1u ad=0.0696p as=0.0696p pd=1.16u ps=1.16u
    I_MXI1_I109_MN5 (XI1_I109_n2 XI1_I109_Bn VSS VSS) gpdk090_nmos1v w=0.24u l=0.1u ad=0.0528p as=0.0816p pd=0.68u ps=1.16u
    I_MXI1_I109_MN4 (I1_h5 XI1_I109_An XI1_I109_n2 VSS) gpdk090_nmos1v w=0.24u l=0.1u ad=0.0528p as=0.0528p pd=0.68u ps=0.68u
    I_MXI1_I109_MN2 (XI1_I109_n1 I1_p4_7 I1_h5 VSS) gpdk090_nmos1v w=0.24u l=0.1u ad=0.0528p as=0.0528p pd=0.68u ps=0.68u
    I_MXI1_I109_MN3 (VSS I1_qu3 XI1_I109_n1 VSS) gpdk090_nmos1v w=0.24u l=0.1u ad=0.0816p as=0.0528p pd=1.16u ps=0.68u
    I_MXI1_I109_MN0 (XI1_I109_An I1_p4_7 VSS VSS) gpdk090_nmos1v w=0.12u l=0.1u ad=0.0696p as=0.0696p pd=1.16u ps=1.16u
    I_MXI1_I94_MN1 (XI1_I94_Bn I1_qu4 VSS VSS) gpdk090_nmos1v w=0.12u l=0.1u ad=0.0696p as=0.0696p pd=1.16u ps=1.16u
    I_MXI1_I94_MN5 (XI1_I94_n2 XI1_I94_Bn VSS VSS) gpdk090_nmos1v w=0.24u l=0.1u ad=0.0528p as=0.0816p pd=0.68u ps=1.16u
    I_MXI1_I94_MN4 (I1_b4_6 XI1_I94_An XI1_I94_n2 VSS) gpdk090_nmos1v w=0.24u l=0.1u ad=0.0528p as=0.0528p pd=0.68u ps=0.68u
    I_MXI1_I94_MN2 (XI1_I94_n1 I1_dd6 I1_b4_6 VSS) gpdk090_nmos1v w=0.24u l=0.1u ad=0.0528p as=0.0528p pd=0.68u ps=0.68u
    I_MXI1_I94_MN3 (VSS I1_qu4 XI1_I94_n1 VSS) gpdk090_nmos1v w=0.24u l=0.1u ad=0.0816p as=0.0528p pd=1.16u ps=0.68u
    I_MXI1_I94_MN0 (XI1_I94_An I1_dd6 VSS VSS) gpdk090_nmos1v w=0.12u l=0.1u ad=0.0696p as=0.0696p pd=1.16u ps=1.16u
    I_MXI1_I84_I41_MN1 (XI1_I84_I41_Bn I1_I84_G3_0n VSS VSS) gpdk090_nmos1v w=0.12u l=0.1u ad=0.0696p as=0.0696p pd=1.16u ps=1.16u
    I_MXI1_I84_I41_MN5 (XI1_I84_I41_n2 XI1_I84_I41_Bn VSS VSS) gpdk090_nmos1v w=0.24u l=0.1u ad=0.0528p as=0.0816p pd=0.68u ps=1.16u
    I_MXI1_I84_I41_MN4 (I1_p3_4 XI1_I84_I41_An XI1_I84_I41_n2 VSS) gpdk090_nmos1v w=0.24u l=0.1u ad=0.0528p as=0.0528p pd=0.68u ps=0.68u
    I_MXI1_I84_I41_MN2 (XI1_I84_I41_n1 I1_I84_pn4 I1_p3_4 VSS) gpdk090_nmos1v w=0.24u l=0.1u ad=0.0528p as=0.0528p pd=0.68u ps=0.68u
    I_MXI1_I84_I41_MN3 (VSS I1_I84_G3_0n XI1_I84_I41_n1 VSS) gpdk090_nmos1v w=0.24u l=0.1u ad=0.0816p as=0.0528p pd=1.16u ps=0.68u
    I_MXI1_I84_I41_MN0 (XI1_I84_I41_An I1_I84_pn4 VSS VSS) gpdk090_nmos1v w=0.12u l=0.1u ad=0.0696p as=0.0696p pd=1.16u ps=1.16u
    I_MXI1_I70_MN1 (XI1_I70_Bn I1_qu6 VSS VSS) gpdk090_nmos1v w=0.12u l=0.1u ad=0.0696p as=0.0696p pd=1.16u ps=1.16u
    I_MXI1_I70_MN5 (XI1_I70_n2 XI1_I70_Bn VSS VSS) gpdk090_nmos1v w=0.24u l=0.1u ad=0.0528p as=0.0816p pd=0.68u ps=1.16u
    I_MXI1_I70_MN4 (I1_b2_6 XI1_I70_An XI1_I70_n2 VSS) gpdk090_nmos1v w=0.24u l=0.1u ad=0.0528p as=0.0528p pd=0.68u ps=0.68u
    I_MXI1_I70_MN2 (XI1_I70_n1 I1_dd6 I1_b2_6 VSS) gpdk090_nmos1v w=0.24u l=0.1u ad=0.0528p as=0.0528p pd=0.68u ps=0.68u
    I_MXI1_I70_MN3 (VSS I1_qu6 XI1_I70_n1 VSS) gpdk090_nmos1v w=0.24u l=0.1u ad=0.0816p as=0.0528p pd=1.16u ps=0.68u
    I_MXI1_I70_MN0 (XI1_I70_An I1_dd6 VSS VSS) gpdk090_nmos1v w=0.12u l=0.1u ad=0.0696p as=0.0696p pd=1.16u ps=1.16u
    I_MXI1_I58_MN1 (XI1_I58_Bn I1_qu7 VSS VSS) gpdk090_nmos1v w=0.12u l=0.1u ad=0.0696p as=0.0696p pd=1.16u ps=1.16u
    I_MXI1_I58_MN5 (XI1_I58_n2 XI1_I58_Bn VSS VSS) gpdk090_nmos1v w=0.24u l=0.1u ad=0.0528p as=0.0816p pd=0.68u ps=1.16u
    I_MXI1_I58_MN4 (I1_b1_6 XI1_I58_An XI1_I58_n2 VSS) gpdk090_nmos1v w=0.24u l=0.1u ad=0.0528p as=0.0528p pd=0.68u ps=0.68u
    I_MXI1_I58_MN2 (XI1_I58_n1 I1_dd6 I1_b1_6 VSS) gpdk090_nmos1v w=0.24u l=0.1u ad=0.0528p as=0.0528p pd=0.68u ps=0.68u
    I_MXI1_I58_MN3 (VSS I1_qu7 XI1_I58_n1 VSS) gpdk090_nmos1v w=0.24u l=0.1u ad=0.0816p as=0.0528p pd=1.16u ps=0.68u
    I_MXI1_I58_MN0 (XI1_I58_An I1_dd6 VSS VSS) gpdk090_nmos1v w=0.12u l=0.1u ad=0.0696p as=0.0696p pd=1.16u ps=1.16u
    I_MXI1_I46_MN1 (XI1_I46_Bn VDD VSS VSS) gpdk090_nmos1v w=0.12u l=0.1u ad=0.0696p as=0.0696p pd=1.16u ps=1.16u
    I_MXI1_I46_MN5 (XI1_I46_n2 XI1_I46_Bn VSS VSS) gpdk090_nmos1v w=0.24u l=0.1u ad=0.0528p as=0.0816p pd=0.68u ps=1.16u
    I_MXI1_I46_MN4 (I1_b0_6 XI1_I46_An XI1_I46_n2 VSS) gpdk090_nmos1v w=0.24u l=0.1u ad=0.0528p as=0.0528p pd=0.68u ps=0.68u
    I_MXI1_I46_MN2 (XI1_I46_n1 I1_dd6 I1_b0_6 VSS) gpdk090_nmos1v w=0.24u l=0.1u ad=0.0528p as=0.0528p pd=0.68u ps=0.68u
    I_MXI1_I46_MN3 (VSS VDD XI1_I46_n1 VSS) gpdk090_nmos1v w=0.24u l=0.1u ad=0.0816p as=0.0528p pd=1.16u ps=0.68u
    I_MXI1_I46_MN0 (XI1_I46_An I1_dd6 VSS VSS) gpdk090_nmos1v w=0.12u l=0.1u ad=0.0696p as=0.0696p pd=1.16u ps=1.16u
    I_MXI1_I50_MN1 (XI1_I50_Bn I1_c0_8 VSS VSS) gpdk090_nmos1v w=0.12u l=0.1u ad=0.0696p as=0.0696p pd=1.16u ps=1.16u
    I_MXI1_I50_MN5 (XI1_I50_n2 XI1_I50_Bn VSS VSS) gpdk090_nmos1v w=0.24u l=0.1u ad=0.0528p as=0.0816p pd=0.68u ps=1.16u
    I_MXI1_I50_MN4 (I1_p0_8 XI1_I50_An XI1_I50_n2 VSS) gpdk090_nmos1v w=0.24u l=0.1u ad=0.0528p as=0.0528p pd=0.68u ps=0.68u
    I_MXI1_I50_MN2 (XI1_I50_n1 I1_h0 I1_p0_8 VSS) gpdk090_nmos1v w=0.24u l=0.1u ad=0.0528p as=0.0528p pd=0.68u ps=0.68u
    I_MXI1_I50_MN3 (VSS I1_c0_8 XI1_I50_n1 VSS) gpdk090_nmos1v w=0.24u l=0.1u ad=0.0816p as=0.0528p pd=1.16u ps=0.68u
    I_MXI1_I50_MN0 (XI1_I50_An I1_h0 VSS VSS) gpdk090_nmos1v w=0.12u l=0.1u ad=0.0696p as=0.0696p pd=1.16u ps=1.16u
    I_MXI1_I107_MN1 (XI1_I107_Bn I1_qu3 VSS VSS) gpdk090_nmos1v w=0.12u l=0.1u ad=0.0696p as=0.0696p pd=1.16u ps=1.16u
    I_MXI1_I107_MN5 (XI1_I107_n2 XI1_I107_Bn VSS VSS) gpdk090_nmos1v w=0.24u l=0.1u ad=0.0528p as=0.0816p pd=0.68u ps=1.16u
    I_MXI1_I107_MN4 (I1_b5_7 XI1_I107_An XI1_I107_n2 VSS) gpdk090_nmos1v w=0.24u l=0.1u ad=0.0528p as=0.0528p pd=0.68u ps=0.68u
    I_MXI1_I107_MN2 (XI1_I107_n1 I1_dd7 I1_b5_7 VSS) gpdk090_nmos1v w=0.24u l=0.1u ad=0.0528p as=0.0528p pd=0.68u ps=0.68u
    I_MXI1_I107_MN3 (VSS I1_qu3 XI1_I107_n1 VSS) gpdk090_nmos1v w=0.24u l=0.1u ad=0.0816p as=0.0528p pd=1.16u ps=0.68u
    I_MXI1_I107_MN0 (XI1_I107_An I1_dd7 VSS VSS) gpdk090_nmos1v w=0.12u l=0.1u ad=0.0696p as=0.0696p pd=1.16u ps=1.16u
    I_MXI1_I98_MN1 (XI1_I98_Bn I1_c4_8 VSS VSS) gpdk090_nmos1v w=0.12u l=0.1u ad=0.0696p as=0.0696p pd=1.16u ps=1.16u
    I_MXI1_I98_MN5 (XI1_I98_n2 XI1_I98_Bn VSS VSS) gpdk090_nmos1v w=0.24u l=0.1u ad=0.0528p as=0.0816p pd=0.68u ps=1.16u
    I_MXI1_I98_MN4 (I1_p4_8 XI1_I98_An XI1_I98_n2 VSS) gpdk090_nmos1v w=0.24u l=0.1u ad=0.0528p as=0.0528p pd=0.68u ps=0.68u
    I_MXI1_I98_MN2 (XI1_I98_n1 I1_h4 I1_p4_8 VSS) gpdk090_nmos1v w=0.24u l=0.1u ad=0.0528p as=0.0528p pd=0.68u ps=0.68u
    I_MXI1_I98_MN3 (VSS I1_c4_8 XI1_I98_n1 VSS) gpdk090_nmos1v w=0.24u l=0.1u ad=0.0816p as=0.0528p pd=1.16u ps=0.68u
    I_MXI1_I98_MN0 (XI1_I98_An I1_h4 VSS VSS) gpdk090_nmos1v w=0.12u l=0.1u ad=0.0696p as=0.0696p pd=1.16u ps=1.16u
    I_MXI1_I95_MN1 (XI1_I95_Bn I1_qu4 VSS VSS) gpdk090_nmos1v w=0.12u l=0.1u ad=0.0696p as=0.0696p pd=1.16u ps=1.16u
    I_MXI1_I95_MN5 (XI1_I95_n2 XI1_I95_Bn VSS VSS) gpdk090_nmos1v w=0.24u l=0.1u ad=0.0528p as=0.0816p pd=0.68u ps=1.16u
    I_MXI1_I95_MN4 (I1_b4_7 XI1_I95_An XI1_I95_n2 VSS) gpdk090_nmos1v w=0.24u l=0.1u ad=0.0528p as=0.0528p pd=0.68u ps=0.68u
    I_MXI1_I95_MN2 (XI1_I95_n1 I1_dd7 I1_b4_7 VSS) gpdk090_nmos1v w=0.24u l=0.1u ad=0.0528p as=0.0528p pd=0.68u ps=0.68u
    I_MXI1_I95_MN3 (VSS I1_qu4 XI1_I95_n1 VSS) gpdk090_nmos1v w=0.24u l=0.1u ad=0.0816p as=0.0528p pd=1.16u ps=0.68u
    I_MXI1_I95_MN0 (XI1_I95_An I1_dd7 VSS VSS) gpdk090_nmos1v w=0.12u l=0.1u ad=0.0696p as=0.0696p pd=1.16u ps=1.16u
    I_MXI1_I97_MN1 (XI1_I97_Bn I1_qu4 VSS VSS) gpdk090_nmos1v w=0.12u l=0.1u ad=0.0696p as=0.0696p pd=1.16u ps=1.16u
    I_MXI1_I97_MN5 (XI1_I97_n2 XI1_I97_Bn VSS VSS) gpdk090_nmos1v w=0.24u l=0.1u ad=0.0528p as=0.0816p pd=0.68u ps=1.16u
    I_MXI1_I97_MN4 (I1_h4 XI1_I97_An XI1_I97_n2 VSS) gpdk090_nmos1v w=0.24u l=0.1u ad=0.0528p as=0.0528p pd=0.68u ps=0.68u
    I_MXI1_I97_MN2 (XI1_I97_n1 I1_p3_7 I1_h4 VSS) gpdk090_nmos1v w=0.24u l=0.1u ad=0.0528p as=0.0528p pd=0.68u ps=0.68u
    I_MXI1_I97_MN3 (VSS I1_qu4 XI1_I97_n1 VSS) gpdk090_nmos1v w=0.24u l=0.1u ad=0.0816p as=0.0528p pd=1.16u ps=0.68u
    I_MXI1_I97_MN0 (XI1_I97_An I1_p3_7 VSS VSS) gpdk090_nmos1v w=0.12u l=0.1u ad=0.0696p as=0.0696p pd=1.16u ps=1.16u
    I_MXI1_I86_MN1 (XI1_I86_Bn I1_c3_8 VSS VSS) gpdk090_nmos1v w=0.12u l=0.1u ad=0.0696p as=0.0696p pd=1.16u ps=1.16u
    I_MXI1_I86_MN5 (XI1_I86_n2 XI1_I86_Bn VSS VSS) gpdk090_nmos1v w=0.24u l=0.1u ad=0.0528p as=0.0816p pd=0.68u ps=1.16u
    I_MXI1_I86_MN4 (I1_p3_8 XI1_I86_An XI1_I86_n2 VSS) gpdk090_nmos1v w=0.24u l=0.1u ad=0.0528p as=0.0528p pd=0.68u ps=0.68u
    I_MXI1_I86_MN2 (XI1_I86_n1 I1_h3 I1_p3_8 VSS) gpdk090_nmos1v w=0.24u l=0.1u ad=0.0528p as=0.0528p pd=0.68u ps=0.68u
    I_MXI1_I86_MN3 (VSS I1_c3_8 XI1_I86_n1 VSS) gpdk090_nmos1v w=0.24u l=0.1u ad=0.0816p as=0.0528p pd=1.16u ps=0.68u
    I_MXI1_I86_MN0 (XI1_I86_An I1_h3 VSS VSS) gpdk090_nmos1v w=0.12u l=0.1u ad=0.0696p as=0.0696p pd=1.16u ps=1.16u
    I_MXI1_I83_MN1 (XI1_I83_Bn I1_qu5 VSS VSS) gpdk090_nmos1v w=0.12u l=0.1u ad=0.0696p as=0.0696p pd=1.16u ps=1.16u
    I_MXI1_I83_MN5 (XI1_I83_n2 XI1_I83_Bn VSS VSS) gpdk090_nmos1v w=0.24u l=0.1u ad=0.0528p as=0.0816p pd=0.68u ps=1.16u
    I_MXI1_I83_MN4 (I1_b3_7 XI1_I83_An XI1_I83_n2 VSS) gpdk090_nmos1v w=0.24u l=0.1u ad=0.0528p as=0.0528p pd=0.68u ps=0.68u
    I_MXI1_I83_MN2 (XI1_I83_n1 I1_dd7 I1_b3_7 VSS) gpdk090_nmos1v w=0.24u l=0.1u ad=0.0528p as=0.0528p pd=0.68u ps=0.68u
    I_MXI1_I83_MN3 (VSS I1_qu5 XI1_I83_n1 VSS) gpdk090_nmos1v w=0.24u l=0.1u ad=0.0816p as=0.0528p pd=1.16u ps=0.68u
    I_MXI1_I83_MN0 (XI1_I83_An I1_dd7 VSS VSS) gpdk090_nmos1v w=0.12u l=0.1u ad=0.0696p as=0.0696p pd=1.16u ps=1.16u
    I_MXI1_I85_MN1 (XI1_I85_Bn I1_qu5 VSS VSS) gpdk090_nmos1v w=0.12u l=0.1u ad=0.0696p as=0.0696p pd=1.16u ps=1.16u
    I_MXI1_I85_MN5 (XI1_I85_n2 XI1_I85_Bn VSS VSS) gpdk090_nmos1v w=0.24u l=0.1u ad=0.0528p as=0.0816p pd=0.68u ps=1.16u
    I_MXI1_I85_MN4 (I1_h3 XI1_I85_An XI1_I85_n2 VSS) gpdk090_nmos1v w=0.24u l=0.1u ad=0.0528p as=0.0528p pd=0.68u ps=0.68u
    I_MXI1_I85_MN2 (XI1_I85_n1 I1_p2_7 I1_h3 VSS) gpdk090_nmos1v w=0.24u l=0.1u ad=0.0528p as=0.0528p pd=0.68u ps=0.68u
    I_MXI1_I85_MN3 (VSS I1_qu5 XI1_I85_n1 VSS) gpdk090_nmos1v w=0.24u l=0.1u ad=0.0816p as=0.0528p pd=1.16u ps=0.68u
    I_MXI1_I85_MN0 (XI1_I85_An I1_p2_7 VSS VSS) gpdk090_nmos1v w=0.12u l=0.1u ad=0.0696p as=0.0696p pd=1.16u ps=1.16u
    I_MXI1_I82_MN1 (XI1_I82_Bn I1_qu5 VSS VSS) gpdk090_nmos1v w=0.12u l=0.1u ad=0.0696p as=0.0696p pd=1.16u ps=1.16u
    I_MXI1_I82_MN5 (XI1_I82_n2 XI1_I82_Bn VSS VSS) gpdk090_nmos1v w=0.24u l=0.1u ad=0.0528p as=0.0816p pd=0.68u ps=1.16u
    I_MXI1_I82_MN4 (I1_b3_6 XI1_I82_An XI1_I82_n2 VSS) gpdk090_nmos1v w=0.24u l=0.1u ad=0.0528p as=0.0528p pd=0.68u ps=0.68u
    I_MXI1_I82_MN2 (XI1_I82_n1 I1_dd6 I1_b3_6 VSS) gpdk090_nmos1v w=0.24u l=0.1u ad=0.0528p as=0.0528p pd=0.68u ps=0.68u
    I_MXI1_I82_MN3 (VSS I1_qu5 XI1_I82_n1 VSS) gpdk090_nmos1v w=0.24u l=0.1u ad=0.0816p as=0.0528p pd=1.16u ps=0.68u
    I_MXI1_I82_MN0 (XI1_I82_An I1_dd6 VSS VSS) gpdk090_nmos1v w=0.12u l=0.1u ad=0.0696p as=0.0696p pd=1.16u ps=1.16u
    I_MXI1_I74_MN1 (XI1_I74_Bn I1_c2_8 VSS VSS) gpdk090_nmos1v w=0.12u l=0.1u ad=0.0696p as=0.0696p pd=1.16u ps=1.16u
    I_MXI1_I74_MN5 (XI1_I74_n2 XI1_I74_Bn VSS VSS) gpdk090_nmos1v w=0.24u l=0.1u ad=0.0528p as=0.0816p pd=0.68u ps=1.16u
    I_MXI1_I74_MN4 (I1_p2_8 XI1_I74_An XI1_I74_n2 VSS) gpdk090_nmos1v w=0.24u l=0.1u ad=0.0528p as=0.0528p pd=0.68u ps=0.68u
    I_MXI1_I74_MN2 (XI1_I74_n1 I1_h2 I1_p2_8 VSS) gpdk090_nmos1v w=0.24u l=0.1u ad=0.0528p as=0.0528p pd=0.68u ps=0.68u
    I_MXI1_I74_MN3 (VSS I1_c2_8 XI1_I74_n1 VSS) gpdk090_nmos1v w=0.24u l=0.1u ad=0.0816p as=0.0528p pd=1.16u ps=0.68u
    I_MXI1_I74_MN0 (XI1_I74_An I1_h2 VSS VSS) gpdk090_nmos1v w=0.12u l=0.1u ad=0.0696p as=0.0696p pd=1.16u ps=1.16u
    I_MXI1_I71_MN1 (XI1_I71_Bn I1_qu6 VSS VSS) gpdk090_nmos1v w=0.12u l=0.1u ad=0.0696p as=0.0696p pd=1.16u ps=1.16u
    I_MXI1_I71_MN5 (XI1_I71_n2 XI1_I71_Bn VSS VSS) gpdk090_nmos1v w=0.24u l=0.1u ad=0.0528p as=0.0816p pd=0.68u ps=1.16u
    I_MXI1_I71_MN4 (I1_b2_7 XI1_I71_An XI1_I71_n2 VSS) gpdk090_nmos1v w=0.24u l=0.1u ad=0.0528p as=0.0528p pd=0.68u ps=0.68u
    I_MXI1_I71_MN2 (XI1_I71_n1 I1_dd7 I1_b2_7 VSS) gpdk090_nmos1v w=0.24u l=0.1u ad=0.0528p as=0.0528p pd=0.68u ps=0.68u
    I_MXI1_I71_MN3 (VSS I1_qu6 XI1_I71_n1 VSS) gpdk090_nmos1v w=0.24u l=0.1u ad=0.0816p as=0.0528p pd=1.16u ps=0.68u
    I_MXI1_I71_MN0 (XI1_I71_An I1_dd7 VSS VSS) gpdk090_nmos1v w=0.12u l=0.1u ad=0.0696p as=0.0696p pd=1.16u ps=1.16u
    I_MXI1_I73_MN1 (XI1_I73_Bn I1_qu6 VSS VSS) gpdk090_nmos1v w=0.12u l=0.1u ad=0.0696p as=0.0696p pd=1.16u ps=1.16u
    I_MXI1_I73_MN5 (XI1_I73_n2 XI1_I73_Bn VSS VSS) gpdk090_nmos1v w=0.24u l=0.1u ad=0.0528p as=0.0816p pd=0.68u ps=1.16u
    I_MXI1_I73_MN4 (I1_h2 XI1_I73_An XI1_I73_n2 VSS) gpdk090_nmos1v w=0.24u l=0.1u ad=0.0528p as=0.0528p pd=0.68u ps=0.68u
    I_MXI1_I73_MN2 (XI1_I73_n1 I1_p1_7 I1_h2 VSS) gpdk090_nmos1v w=0.24u l=0.1u ad=0.0528p as=0.0528p pd=0.68u ps=0.68u
    I_MXI1_I73_MN3 (VSS I1_qu6 XI1_I73_n1 VSS) gpdk090_nmos1v w=0.24u l=0.1u ad=0.0816p as=0.0528p pd=1.16u ps=0.68u
    I_MXI1_I73_MN0 (XI1_I73_An I1_p1_7 VSS VSS) gpdk090_nmos1v w=0.12u l=0.1u ad=0.0696p as=0.0696p pd=1.16u ps=1.16u
    I_MXI1_I62_MN1 (XI1_I62_Bn I1_c1_8 VSS VSS) gpdk090_nmos1v w=0.12u l=0.1u ad=0.0696p as=0.0696p pd=1.16u ps=1.16u
    I_MXI1_I62_MN5 (XI1_I62_n2 XI1_I62_Bn VSS VSS) gpdk090_nmos1v w=0.24u l=0.1u ad=0.0528p as=0.0816p pd=0.68u ps=1.16u
    I_MXI1_I62_MN4 (I1_p1_8 XI1_I62_An XI1_I62_n2 VSS) gpdk090_nmos1v w=0.24u l=0.1u ad=0.0528p as=0.0528p pd=0.68u ps=0.68u
    I_MXI1_I62_MN2 (XI1_I62_n1 I1_h1 I1_p1_8 VSS) gpdk090_nmos1v w=0.24u l=0.1u ad=0.0528p as=0.0528p pd=0.68u ps=0.68u
    I_MXI1_I62_MN3 (VSS I1_c1_8 XI1_I62_n1 VSS) gpdk090_nmos1v w=0.24u l=0.1u ad=0.0816p as=0.0528p pd=1.16u ps=0.68u
    I_MXI1_I62_MN0 (XI1_I62_An I1_h1 VSS VSS) gpdk090_nmos1v w=0.12u l=0.1u ad=0.0696p as=0.0696p pd=1.16u ps=1.16u
    I_MXI1_I59_MN1 (XI1_I59_Bn I1_qu7 VSS VSS) gpdk090_nmos1v w=0.12u l=0.1u ad=0.0696p as=0.0696p pd=1.16u ps=1.16u
    I_MXI1_I59_MN5 (XI1_I59_n2 XI1_I59_Bn VSS VSS) gpdk090_nmos1v w=0.24u l=0.1u ad=0.0528p as=0.0816p pd=0.68u ps=1.16u
    I_MXI1_I59_MN4 (I1_b1_7 XI1_I59_An XI1_I59_n2 VSS) gpdk090_nmos1v w=0.24u l=0.1u ad=0.0528p as=0.0528p pd=0.68u ps=0.68u
    I_MXI1_I59_MN2 (XI1_I59_n1 I1_dd7 I1_b1_7 VSS) gpdk090_nmos1v w=0.24u l=0.1u ad=0.0528p as=0.0528p pd=0.68u ps=0.68u
    I_MXI1_I59_MN3 (VSS I1_qu7 XI1_I59_n1 VSS) gpdk090_nmos1v w=0.24u l=0.1u ad=0.0816p as=0.0528p pd=1.16u ps=0.68u
    I_MXI1_I59_MN0 (XI1_I59_An I1_dd7 VSS VSS) gpdk090_nmos1v w=0.12u l=0.1u ad=0.0696p as=0.0696p pd=1.16u ps=1.16u
    I_MXI1_I61_MN1 (XI1_I61_Bn I1_qu7 VSS VSS) gpdk090_nmos1v w=0.12u l=0.1u ad=0.0696p as=0.0696p pd=1.16u ps=1.16u
    I_MXI1_I61_MN5 (XI1_I61_n2 XI1_I61_Bn VSS VSS) gpdk090_nmos1v w=0.24u l=0.1u ad=0.0528p as=0.0816p pd=0.68u ps=1.16u
    I_MXI1_I61_MN4 (I1_h1 XI1_I61_An XI1_I61_n2 VSS) gpdk090_nmos1v w=0.24u l=0.1u ad=0.0528p as=0.0528p pd=0.68u ps=0.68u
    I_MXI1_I61_MN2 (XI1_I61_n1 I1_p0_7 I1_h1 VSS) gpdk090_nmos1v w=0.24u l=0.1u ad=0.0528p as=0.0528p pd=0.68u ps=0.68u
    I_MXI1_I61_MN3 (VSS I1_qu7 XI1_I61_n1 VSS) gpdk090_nmos1v w=0.24u l=0.1u ad=0.0816p as=0.0528p pd=1.16u ps=0.68u
    I_MXI1_I61_MN0 (XI1_I61_An I1_p0_7 VSS VSS) gpdk090_nmos1v w=0.12u l=0.1u ad=0.0696p as=0.0696p pd=1.16u ps=1.16u
    I_MXI1_I47_MN1 (XI1_I47_Bn VDD VSS VSS) gpdk090_nmos1v w=0.12u l=0.1u ad=0.0696p as=0.0696p pd=1.16u ps=1.16u
    I_MXI1_I47_MN5 (XI1_I47_n2 XI1_I47_Bn VSS VSS) gpdk090_nmos1v w=0.24u l=0.1u ad=0.0528p as=0.0816p pd=0.68u ps=1.16u
    I_MXI1_I47_MN4 (I1_b0_7 XI1_I47_An XI1_I47_n2 VSS) gpdk090_nmos1v w=0.24u l=0.1u ad=0.0528p as=0.0528p pd=0.68u ps=0.68u
    I_MXI1_I47_MN2 (XI1_I47_n1 I1_dd7 I1_b0_7 VSS) gpdk090_nmos1v w=0.24u l=0.1u ad=0.0528p as=0.0528p pd=0.68u ps=0.68u
    I_MXI1_I47_MN3 (VSS VDD XI1_I47_n1 VSS) gpdk090_nmos1v w=0.24u l=0.1u ad=0.0816p as=0.0528p pd=1.16u ps=0.68u
    I_MXI1_I47_MN0 (XI1_I47_An I1_dd7 VSS VSS) gpdk090_nmos1v w=0.12u l=0.1u ad=0.0696p as=0.0696p pd=1.16u ps=1.16u
    I_MXI1_I49_MN1 (XI1_I49_Bn VDD VSS VSS) gpdk090_nmos1v w=0.12u l=0.1u ad=0.0696p as=0.0696p pd=1.16u ps=1.16u
    I_MXI1_I49_MN5 (XI1_I49_n2 XI1_I49_Bn VSS VSS) gpdk090_nmos1v w=0.24u l=0.1u ad=0.0528p as=0.0816p pd=0.68u ps=1.16u
    I_MXI1_I49_MN4 (I1_h0 XI1_I49_An XI1_I49_n2 VSS) gpdk090_nmos1v w=0.24u l=0.1u ad=0.0528p as=0.0528p pd=0.68u ps=0.68u
    I_MXI1_I49_MN2 (XI1_I49_n1 VSS I1_h0 VSS) gpdk090_nmos1v w=0.24u l=0.1u ad=0.0528p as=0.0528p pd=0.68u ps=0.68u
    I_MXI1_I49_MN3 (VSS VDD XI1_I49_n1 VSS) gpdk090_nmos1v w=0.24u l=0.1u ad=0.0816p as=0.0528p pd=1.16u ps=0.68u
    I_MXI1_I49_MN0 (XI1_I49_An VSS VSS VSS) gpdk090_nmos1v w=0.12u l=0.1u ad=0.0696p as=0.0696p pd=1.16u ps=1.16u
    I_MXI0_I55_MP24 (XI0_I55_sn I0_cm11_2 XI0_I55_p5 VDD) gpdk090_pmos1v w=0.36u l=0.1u ad=0.1224p as=0.0792p pd=1.4u ps=0.8u
    I_MXI0_I55_MP26 (VDD XI0_I55_sn I0_fa12_0 VDD) gpdk090_pmos1v w=0.24u l=0.1u ad=0.0816p as=0.0816p pd=1.16u ps=1.16u
    I_MXI0_I55_MP17 (XI0_I55_con I0_cm11_2 XI0_I55_p2 VDD) gpdk090_pmos1v w=0.48u l=0.1u ad=0.1056p as=0.1632p pd=0.92u ps=1.64u
    I_MXI0_I55_MP14 (XI0_I55_p1 I0_pp3_7 XI0_I55_con VDD) gpdk090_pmos1v w=0.48u l=0.1u ad=0.1056p as=0.1056p pd=0.92u ps=0.92u
    I_MXI0_I55_MP13 (VDD I0_sn2 XI0_I55_p1 VDD) gpdk090_pmos1v w=0.48u l=0.1u ad=0.1056p as=0.1056p pd=0.92u ps=0.92u
    I_MXI0_I55_MP15 (XI0_I55_p2 I0_sn2 VDD VDD) gpdk090_pmos1v w=0.48u l=0.1u ad=0.1056p as=0.1056p pd=0.92u ps=0.92u
    I_MXI0_I55_MP16 (VDD I0_pp3_7 XI0_I55_p2 VDD) gpdk090_pmos1v w=0.48u l=0.1u ad=0.0936p as=0.1056p pd=0.92u ps=0.92u
    I_MXI0_I55_MP28 (I0_fa12_1 XI0_I55_con VDD VDD) gpdk090_pmos1v w=0.24u l=0.1u ad=0.0816p as=0.0936p pd=1.16u ps=0.92u
    I_MXI0_I55_MP22 (XI0_I55_p4 I0_sn2 VDD VDD) gpdk090_pmos1v w=0.36u l=0.1u ad=0.0792p as=0.1224p pd=0.8u ps=1.4u
    I_MXI0_I55_MP23 (XI0_I55_p5 I0_pp3_7 XI0_I55_p4 VDD) gpdk090_pmos1v w=0.36u l=0.1u ad=0.0792p as=0.0792p pd=0.8u ps=0.8u
    I_MXI0_I55_MP23_1 (XI0_I55_p4 I0_pp3_7 XI0_I55_p5 VDD) gpdk090_pmos1v w=0.36u l=0.1u ad=0.0792p as=0.0792p pd=0.8u ps=0.8u
    I_MXI0_I55_MP22_1 (VDD I0_sn2 XI0_I55_p4 VDD) gpdk090_pmos1v w=0.36u l=0.1u ad=0.1968p as=0.0792p pd=1.46u ps=0.8u
    I_MXI0_I55_MP19 (XI0_I55_p3 I0_pp3_7 VDD VDD) gpdk090_pmos1v w=0.48u l=0.1u ad=0.1056p as=0.1968p pd=0.92u ps=1.46u
    I_MXI0_I55_MP18 (VDD I0_sn2 XI0_I55_p3 VDD) gpdk090_pmos1v w=0.48u l=0.1u ad=0.1056p as=0.1056p pd=0.92u ps=0.92u
    I_MXI0_I55_MP20 (XI0_I55_p3 I0_cm11_2 VDD VDD) gpdk090_pmos1v w=0.48u l=0.1u ad=0.1056p as=0.1056p pd=0.92u ps=0.92u
    I_MXI0_I55_MP21 (XI0_I55_sn XI0_I55_con XI0_I55_p3 VDD) gpdk090_pmos1v w=0.48u l=0.1u ad=0.0996p as=0.1056p pd=0.92u ps=0.92u
    I_MXI0_I55_MP24_1 (XI0_I55_p5 I0_cm11_2 XI0_I55_sn VDD) gpdk090_pmos1v w=0.36u l=0.1u ad=0.0792p as=0.0996p pd=0.8u ps=0.92u
    I_MXI0_I76_MP24 (XI0_I76_sn I0_rc7 XI0_I76_p5 VDD) gpdk090_pmos1v w=0.36u l=0.1u ad=0.1224p as=0.0792p pd=1.4u ps=0.8u
    I_MXI0_I76_MP26 (VDD XI0_I76_sn MULP_7 VDD) gpdk090_pmos1v w=0.24u l=0.1u ad=0.0816p as=0.0816p pd=1.16u ps=1.16u
    I_MXI0_I76_MP17 (XI0_I76_con I0_rc7 XI0_I76_p2 VDD) gpdk090_pmos1v w=0.48u l=0.1u ad=0.1056p as=0.1632p pd=0.92u ps=1.64u
    I_MXI0_I76_MP14 (XI0_I76_p1 I0_ha17_0 XI0_I76_con VDD) gpdk090_pmos1v w=0.48u l=0.1u ad=0.1056p as=0.1056p pd=0.92u ps=0.92u
    I_MXI0_I76_MP13 (VDD I0_ha16_1 XI0_I76_p1 VDD) gpdk090_pmos1v w=0.48u l=0.1u ad=0.1056p as=0.1056p pd=0.92u ps=0.92u
    I_MXI0_I76_MP15 (XI0_I76_p2 I0_ha16_1 VDD VDD) gpdk090_pmos1v w=0.48u l=0.1u ad=0.1056p as=0.1056p pd=0.92u ps=0.92u
    I_MXI0_I76_MP16 (VDD I0_ha17_0 XI0_I76_p2 VDD) gpdk090_pmos1v w=0.48u l=0.1u ad=0.0936p as=0.1056p pd=0.92u ps=0.92u
    I_MXI0_I76_MP28 (I0_rc8 XI0_I76_con VDD VDD) gpdk090_pmos1v w=0.24u l=0.1u ad=0.0816p as=0.0936p pd=1.16u ps=0.92u
    I_MXI0_I76_MP22 (XI0_I76_p4 I0_ha16_1 VDD VDD) gpdk090_pmos1v w=0.36u l=0.1u ad=0.0792p as=0.1224p pd=0.8u ps=1.4u
    I_MXI0_I76_MP23 (XI0_I76_p5 I0_ha17_0 XI0_I76_p4 VDD) gpdk090_pmos1v w=0.36u l=0.1u ad=0.0792p as=0.0792p pd=0.8u ps=0.8u
    I_MXI0_I76_MP23_1 (XI0_I76_p4 I0_ha17_0 XI0_I76_p5 VDD) gpdk090_pmos1v w=0.36u l=0.1u ad=0.0792p as=0.0792p pd=0.8u ps=0.8u
    I_MXI0_I76_MP22_1 (VDD I0_ha16_1 XI0_I76_p4 VDD) gpdk090_pmos1v w=0.36u l=0.1u ad=0.1968p as=0.0792p pd=1.46u ps=0.8u
    I_MXI0_I76_MP19 (XI0_I76_p3 I0_ha17_0 VDD VDD) gpdk090_pmos1v w=0.48u l=0.1u ad=0.1056p as=0.1968p pd=0.92u ps=1.46u
    I_MXI0_I76_MP18 (VDD I0_ha16_1 XI0_I76_p3 VDD) gpdk090_pmos1v w=0.48u l=0.1u ad=0.1056p as=0.1056p pd=0.92u ps=0.92u
    I_MXI0_I76_MP20 (XI0_I76_p3 I0_rc7 VDD VDD) gpdk090_pmos1v w=0.48u l=0.1u ad=0.1056p as=0.1056p pd=0.92u ps=0.92u
    I_MXI0_I76_MP21 (XI0_I76_sn XI0_I76_con XI0_I76_p3 VDD) gpdk090_pmos1v w=0.48u l=0.1u ad=0.0996p as=0.1056p pd=0.92u ps=0.92u
    I_MXI0_I76_MP24_1 (XI0_I76_p5 I0_rc7 XI0_I76_sn VDD) gpdk090_pmos1v w=0.36u l=0.1u ad=0.0792p as=0.0996p pd=0.8u ps=0.92u
    I_MXI0_I75_MP24 (XI0_I75_sn I0_rc6 XI0_I75_p5 VDD) gpdk090_pmos1v w=0.36u l=0.1u ad=0.1224p as=0.0792p pd=1.4u ps=0.8u
    I_MXI0_I75_MP26 (VDD XI0_I75_sn MULP_6 VDD) gpdk090_pmos1v w=0.24u l=0.1u ad=0.0816p as=0.0816p pd=1.16u ps=1.16u
    I_MXI0_I75_MP17 (XI0_I75_con I0_rc6 XI0_I75_p2 VDD) gpdk090_pmos1v w=0.48u l=0.1u ad=0.1056p as=0.1632p pd=0.92u ps=1.64u
    I_MXI0_I75_MP14 (XI0_I75_p1 I0_ha16_0 XI0_I75_con VDD) gpdk090_pmos1v w=0.48u l=0.1u ad=0.1056p as=0.1056p pd=0.92u ps=0.92u
    I_MXI0_I75_MP13 (VDD I0_ha15_1 XI0_I75_p1 VDD) gpdk090_pmos1v w=0.48u l=0.1u ad=0.1056p as=0.1056p pd=0.92u ps=0.92u
    I_MXI0_I75_MP15 (XI0_I75_p2 I0_ha15_1 VDD VDD) gpdk090_pmos1v w=0.48u l=0.1u ad=0.1056p as=0.1056p pd=0.92u ps=0.92u
    I_MXI0_I75_MP16 (VDD I0_ha16_0 XI0_I75_p2 VDD) gpdk090_pmos1v w=0.48u l=0.1u ad=0.0936p as=0.1056p pd=0.92u ps=0.92u
    I_MXI0_I75_MP28 (I0_rc7 XI0_I75_con VDD VDD) gpdk090_pmos1v w=0.24u l=0.1u ad=0.0816p as=0.0936p pd=1.16u ps=0.92u
    I_MXI0_I75_MP22 (XI0_I75_p4 I0_ha15_1 VDD VDD) gpdk090_pmos1v w=0.36u l=0.1u ad=0.0792p as=0.1224p pd=0.8u ps=1.4u
    I_MXI0_I75_MP23 (XI0_I75_p5 I0_ha16_0 XI0_I75_p4 VDD) gpdk090_pmos1v w=0.36u l=0.1u ad=0.0792p as=0.0792p pd=0.8u ps=0.8u
    I_MXI0_I75_MP23_1 (XI0_I75_p4 I0_ha16_0 XI0_I75_p5 VDD) gpdk090_pmos1v w=0.36u l=0.1u ad=0.0792p as=0.0792p pd=0.8u ps=0.8u
    I_MXI0_I75_MP22_1 (VDD I0_ha15_1 XI0_I75_p4 VDD) gpdk090_pmos1v w=0.36u l=0.1u ad=0.1968p as=0.0792p pd=1.46u ps=0.8u
    I_MXI0_I75_MP19 (XI0_I75_p3 I0_ha16_0 VDD VDD) gpdk090_pmos1v w=0.48u l=0.1u ad=0.1056p as=0.1968p pd=0.92u ps=1.46u
    I_MXI0_I75_MP18 (VDD I0_ha15_1 XI0_I75_p3 VDD) gpdk090_pmos1v w=0.48u l=0.1u ad=0.1056p as=0.1056p pd=0.92u ps=0.92u
    I_MXI0_I75_MP20 (XI0_I75_p3 I0_rc6 VDD VDD) gpdk090_pmos1v w=0.48u l=0.1u ad=0.1056p as=0.1056p pd=0.92u ps=0.92u
    I_MXI0_I75_MP21 (XI0_I75_sn XI0_I75_con XI0_I75_p3 VDD) gpdk090_pmos1v w=0.48u l=0.1u ad=0.0996p as=0.1056p pd=0.92u ps=0.92u
    I_MXI0_I75_MP24_1 (XI0_I75_p5 I0_rc6 XI0_I75_sn VDD) gpdk090_pmos1v w=0.36u l=0.1u ad=0.0792p as=0.0996p pd=0.8u ps=0.92u
    I_MXI0_I47_MP24 (XI0_I47_sn I0_pp2_1 XI0_I47_p5 VDD) gpdk090_pmos1v w=0.36u l=0.1u ad=0.1224p as=0.0792p pd=1.4u ps=0.8u
    I_MXI0_I47_MP26 (VDD XI0_I47_sn I0_fa4_0 VDD) gpdk090_pmos1v w=0.24u l=0.1u ad=0.0816p as=0.0816p pd=1.16u ps=1.16u
    I_MXI0_I47_MP17 (XI0_I47_con I0_pp2_1 XI0_I47_p2 VDD) gpdk090_pmos1v w=0.48u l=0.1u ad=0.1056p as=0.1632p pd=0.92u ps=1.64u
    I_MXI0_I47_MP14 (XI0_I47_p1 I0_pp1_3 XI0_I47_con VDD) gpdk090_pmos1v w=0.48u l=0.1u ad=0.1056p as=0.1056p pd=0.92u ps=0.92u
    I_MXI0_I47_MP13 (VDD I0_pp0_5 XI0_I47_p1 VDD) gpdk090_pmos1v w=0.48u l=0.1u ad=0.1056p as=0.1056p pd=0.92u ps=0.92u
    I_MXI0_I47_MP15 (XI0_I47_p2 I0_pp0_5 VDD VDD) gpdk090_pmos1v w=0.48u l=0.1u ad=0.1056p as=0.1056p pd=0.92u ps=0.92u
    I_MXI0_I47_MP16 (VDD I0_pp1_3 XI0_I47_p2 VDD) gpdk090_pmos1v w=0.48u l=0.1u ad=0.0936p as=0.1056p pd=0.92u ps=0.92u
    I_MXI0_I47_MP28 (I0_fa4_1 XI0_I47_con VDD VDD) gpdk090_pmos1v w=0.24u l=0.1u ad=0.0816p as=0.0936p pd=1.16u ps=0.92u
    I_MXI0_I47_MP22 (XI0_I47_p4 I0_pp0_5 VDD VDD) gpdk090_pmos1v w=0.36u l=0.1u ad=0.0792p as=0.1224p pd=0.8u ps=1.4u
    I_MXI0_I47_MP23 (XI0_I47_p5 I0_pp1_3 XI0_I47_p4 VDD) gpdk090_pmos1v w=0.36u l=0.1u ad=0.0792p as=0.0792p pd=0.8u ps=0.8u
    I_MXI0_I47_MP23_1 (XI0_I47_p4 I0_pp1_3 XI0_I47_p5 VDD) gpdk090_pmos1v w=0.36u l=0.1u ad=0.0792p as=0.0792p pd=0.8u ps=0.8u
    I_MXI0_I47_MP22_1 (VDD I0_pp0_5 XI0_I47_p4 VDD) gpdk090_pmos1v w=0.36u l=0.1u ad=0.1968p as=0.0792p pd=1.46u ps=0.8u
    I_MXI0_I47_MP19 (XI0_I47_p3 I0_pp1_3 VDD VDD) gpdk090_pmos1v w=0.48u l=0.1u ad=0.1056p as=0.1968p pd=0.92u ps=1.46u
    I_MXI0_I47_MP18 (VDD I0_pp0_5 XI0_I47_p3 VDD) gpdk090_pmos1v w=0.48u l=0.1u ad=0.1056p as=0.1056p pd=0.92u ps=0.92u
    I_MXI0_I47_MP20 (XI0_I47_p3 I0_pp2_1 VDD VDD) gpdk090_pmos1v w=0.48u l=0.1u ad=0.1056p as=0.1056p pd=0.92u ps=0.92u
    I_MXI0_I47_MP21 (XI0_I47_sn XI0_I47_con XI0_I47_p3 VDD) gpdk090_pmos1v w=0.48u l=0.1u ad=0.0996p as=0.1056p pd=0.92u ps=0.92u
    I_MXI0_I47_MP24_1 (XI0_I47_p5 I0_pp2_1 XI0_I47_sn VDD) gpdk090_pmos1v w=0.36u l=0.1u ad=0.0792p as=0.0996p pd=0.8u ps=0.92u
    I_MXI0_I74_MP24 (XI0_I74_sn I0_rc5 XI0_I74_p5 VDD) gpdk090_pmos1v w=0.36u l=0.1u ad=0.1224p as=0.0792p pd=1.4u ps=0.8u
    I_MXI0_I74_MP26 (VDD XI0_I74_sn MULP_5 VDD) gpdk090_pmos1v w=0.24u l=0.1u ad=0.0816p as=0.0816p pd=1.16u ps=1.16u
    I_MXI0_I74_MP17 (XI0_I74_con I0_rc5 XI0_I74_p2 VDD) gpdk090_pmos1v w=0.48u l=0.1u ad=0.1056p as=0.1632p pd=0.92u ps=1.64u
    I_MXI0_I74_MP14 (XI0_I74_p1 I0_ha15_0 XI0_I74_con VDD) gpdk090_pmos1v w=0.48u l=0.1u ad=0.1056p as=0.1056p pd=0.92u ps=0.92u
    I_MXI0_I74_MP13 (VDD I0_fa14_1 XI0_I74_p1 VDD) gpdk090_pmos1v w=0.48u l=0.1u ad=0.1056p as=0.1056p pd=0.92u ps=0.92u
    I_MXI0_I74_MP15 (XI0_I74_p2 I0_fa14_1 VDD VDD) gpdk090_pmos1v w=0.48u l=0.1u ad=0.1056p as=0.1056p pd=0.92u ps=0.92u
    I_MXI0_I74_MP16 (VDD I0_ha15_0 XI0_I74_p2 VDD) gpdk090_pmos1v w=0.48u l=0.1u ad=0.0936p as=0.1056p pd=0.92u ps=0.92u
    I_MXI0_I74_MP28 (I0_rc6 XI0_I74_con VDD VDD) gpdk090_pmos1v w=0.24u l=0.1u ad=0.0816p as=0.0936p pd=1.16u ps=0.92u
    I_MXI0_I74_MP22 (XI0_I74_p4 I0_fa14_1 VDD VDD) gpdk090_pmos1v w=0.36u l=0.1u ad=0.0792p as=0.1224p pd=0.8u ps=1.4u
    I_MXI0_I74_MP23 (XI0_I74_p5 I0_ha15_0 XI0_I74_p4 VDD) gpdk090_pmos1v w=0.36u l=0.1u ad=0.0792p as=0.0792p pd=0.8u ps=0.8u
    I_MXI0_I74_MP23_1 (XI0_I74_p4 I0_ha15_0 XI0_I74_p5 VDD) gpdk090_pmos1v w=0.36u l=0.1u ad=0.0792p as=0.0792p pd=0.8u ps=0.8u
    I_MXI0_I74_MP22_1 (VDD I0_fa14_1 XI0_I74_p4 VDD) gpdk090_pmos1v w=0.36u l=0.1u ad=0.1968p as=0.0792p pd=1.46u ps=0.8u
    I_MXI0_I74_MP19 (XI0_I74_p3 I0_ha15_0 VDD VDD) gpdk090_pmos1v w=0.48u l=0.1u ad=0.1056p as=0.1968p pd=0.92u ps=1.46u
    I_MXI0_I74_MP18 (VDD I0_fa14_1 XI0_I74_p3 VDD) gpdk090_pmos1v w=0.48u l=0.1u ad=0.1056p as=0.1056p pd=0.92u ps=0.92u
    I_MXI0_I74_MP20 (XI0_I74_p3 I0_rc5 VDD VDD) gpdk090_pmos1v w=0.48u l=0.1u ad=0.1056p as=0.1056p pd=0.92u ps=0.92u
    I_MXI0_I74_MP21 (XI0_I74_sn XI0_I74_con XI0_I74_p3 VDD) gpdk090_pmos1v w=0.48u l=0.1u ad=0.0996p as=0.1056p pd=0.92u ps=0.92u
    I_MXI0_I74_MP24_1 (XI0_I74_p5 I0_rc5 XI0_I74_sn VDD) gpdk090_pmos1v w=0.36u l=0.1u ad=0.0792p as=0.0996p pd=0.8u ps=0.92u
    I_MXI0_I57_MP24 (XI0_I57_sn B_5 XI0_I57_p5 VDD) gpdk090_pmos1v w=0.36u l=0.1u ad=0.1224p as=0.0792p pd=1.4u ps=0.8u
    I_MXI0_I57_MP26 (VDD XI0_I57_sn I0_fa14_0 VDD) gpdk090_pmos1v w=0.24u l=0.1u ad=0.0816p as=0.0816p pd=1.16u ps=1.16u
    I_MXI0_I57_MP17 (XI0_I57_con B_5 XI0_I57_p2 VDD) gpdk090_pmos1v w=0.48u l=0.1u ad=0.1056p as=0.1632p pd=0.92u ps=1.64u
    I_MXI0_I57_MP14 (XI0_I57_p1 I0_fa3_0 XI0_I57_con VDD) gpdk090_pmos1v w=0.48u l=0.1u ad=0.1056p as=0.1056p pd=0.92u ps=0.92u
    I_MXI0_I57_MP13 (VDD I0_ha2_1 XI0_I57_p1 VDD) gpdk090_pmos1v w=0.48u l=0.1u ad=0.1056p as=0.1056p pd=0.92u ps=0.92u
    I_MXI0_I57_MP15 (XI0_I57_p2 I0_ha2_1 VDD VDD) gpdk090_pmos1v w=0.48u l=0.1u ad=0.1056p as=0.1056p pd=0.92u ps=0.92u
    I_MXI0_I57_MP16 (VDD I0_fa3_0 XI0_I57_p2 VDD) gpdk090_pmos1v w=0.48u l=0.1u ad=0.0936p as=0.1056p pd=0.92u ps=0.92u
    I_MXI0_I57_MP28 (I0_fa14_1 XI0_I57_con VDD VDD) gpdk090_pmos1v w=0.24u l=0.1u ad=0.0816p as=0.0936p pd=1.16u ps=0.92u
    I_MXI0_I57_MP22 (XI0_I57_p4 I0_ha2_1 VDD VDD) gpdk090_pmos1v w=0.36u l=0.1u ad=0.0792p as=0.1224p pd=0.8u ps=1.4u
    I_MXI0_I57_MP23 (XI0_I57_p5 I0_fa3_0 XI0_I57_p4 VDD) gpdk090_pmos1v w=0.36u l=0.1u ad=0.0792p as=0.0792p pd=0.8u ps=0.8u
    I_MXI0_I57_MP23_1 (XI0_I57_p4 I0_fa3_0 XI0_I57_p5 VDD) gpdk090_pmos1v w=0.36u l=0.1u ad=0.0792p as=0.0792p pd=0.8u ps=0.8u
    I_MXI0_I57_MP22_1 (VDD I0_ha2_1 XI0_I57_p4 VDD) gpdk090_pmos1v w=0.36u l=0.1u ad=0.1968p as=0.0792p pd=1.46u ps=0.8u
    I_MXI0_I57_MP19 (XI0_I57_p3 I0_fa3_0 VDD VDD) gpdk090_pmos1v w=0.48u l=0.1u ad=0.1056p as=0.1968p pd=0.92u ps=1.46u
    I_MXI0_I57_MP18 (VDD I0_ha2_1 XI0_I57_p3 VDD) gpdk090_pmos1v w=0.48u l=0.1u ad=0.1056p as=0.1056p pd=0.92u ps=0.92u
    I_MXI0_I57_MP20 (XI0_I57_p3 B_5 VDD VDD) gpdk090_pmos1v w=0.48u l=0.1u ad=0.1056p as=0.1056p pd=0.92u ps=0.92u
    I_MXI0_I57_MP21 (XI0_I57_sn XI0_I57_con XI0_I57_p3 VDD) gpdk090_pmos1v w=0.48u l=0.1u ad=0.0996p as=0.1056p pd=0.92u ps=0.92u
    I_MXI0_I57_MP24_1 (XI0_I57_p5 B_5 XI0_I57_sn VDD) gpdk090_pmos1v w=0.36u l=0.1u ad=0.0792p as=0.0996p pd=0.8u ps=0.92u
    I_MXI0_I46_MP24 (XI0_I46_sn I0_pp2_0 XI0_I46_p5 VDD) gpdk090_pmos1v w=0.36u l=0.1u ad=0.1224p as=0.0792p pd=1.4u ps=0.8u
    I_MXI0_I46_MP26 (VDD XI0_I46_sn I0_fa3_0 VDD) gpdk090_pmos1v w=0.24u l=0.1u ad=0.0816p as=0.0816p pd=1.16u ps=1.16u
    I_MXI0_I46_MP17 (XI0_I46_con I0_pp2_0 XI0_I46_p2 VDD) gpdk090_pmos1v w=0.48u l=0.1u ad=0.1056p as=0.1632p pd=0.92u ps=1.64u
    I_MXI0_I46_MP14 (XI0_I46_p1 I0_pp1_2 XI0_I46_con VDD) gpdk090_pmos1v w=0.48u l=0.1u ad=0.1056p as=0.1056p pd=0.92u ps=0.92u
    I_MXI0_I46_MP13 (VDD I0_pp0_4 XI0_I46_p1 VDD) gpdk090_pmos1v w=0.48u l=0.1u ad=0.1056p as=0.1056p pd=0.92u ps=0.92u
    I_MXI0_I46_MP15 (XI0_I46_p2 I0_pp0_4 VDD VDD) gpdk090_pmos1v w=0.48u l=0.1u ad=0.1056p as=0.1056p pd=0.92u ps=0.92u
    I_MXI0_I46_MP16 (VDD I0_pp1_2 XI0_I46_p2 VDD) gpdk090_pmos1v w=0.48u l=0.1u ad=0.0936p as=0.1056p pd=0.92u ps=0.92u
    I_MXI0_I46_MP28 (I0_fa3_1 XI0_I46_con VDD VDD) gpdk090_pmos1v w=0.24u l=0.1u ad=0.0816p as=0.0936p pd=1.16u ps=0.92u
    I_MXI0_I46_MP22 (XI0_I46_p4 I0_pp0_4 VDD VDD) gpdk090_pmos1v w=0.36u l=0.1u ad=0.0792p as=0.1224p pd=0.8u ps=1.4u
    I_MXI0_I46_MP23 (XI0_I46_p5 I0_pp1_2 XI0_I46_p4 VDD) gpdk090_pmos1v w=0.36u l=0.1u ad=0.0792p as=0.0792p pd=0.8u ps=0.8u
    I_MXI0_I46_MP23_1 (XI0_I46_p4 I0_pp1_2 XI0_I46_p5 VDD) gpdk090_pmos1v w=0.36u l=0.1u ad=0.0792p as=0.0792p pd=0.8u ps=0.8u
    I_MXI0_I46_MP22_1 (VDD I0_pp0_4 XI0_I46_p4 VDD) gpdk090_pmos1v w=0.36u l=0.1u ad=0.1968p as=0.0792p pd=1.46u ps=0.8u
    I_MXI0_I46_MP19 (XI0_I46_p3 I0_pp1_2 VDD VDD) gpdk090_pmos1v w=0.48u l=0.1u ad=0.1056p as=0.1968p pd=0.92u ps=1.46u
    I_MXI0_I46_MP18 (VDD I0_pp0_4 XI0_I46_p3 VDD) gpdk090_pmos1v w=0.48u l=0.1u ad=0.1056p as=0.1056p pd=0.92u ps=0.92u
    I_MXI0_I46_MP20 (XI0_I46_p3 I0_pp2_0 VDD VDD) gpdk090_pmos1v w=0.48u l=0.1u ad=0.1056p as=0.1056p pd=0.92u ps=0.92u
    I_MXI0_I46_MP21 (XI0_I46_sn XI0_I46_con XI0_I46_p3 VDD) gpdk090_pmos1v w=0.48u l=0.1u ad=0.0996p as=0.1056p pd=0.92u ps=0.92u
    I_MXI0_I46_MP24_1 (XI0_I46_p5 I0_pp2_0 XI0_I46_sn VDD) gpdk090_pmos1v w=0.36u l=0.1u ad=0.0792p as=0.0996p pd=0.8u ps=0.92u
    I_MXI0_I72_MP24 (XI0_I72_sn I0_rc3 XI0_I72_p5 VDD) gpdk090_pmos1v w=0.36u l=0.1u ad=0.1224p as=0.0792p pd=1.4u ps=0.8u
    I_MXI0_I72_MP26 (VDD XI0_I72_sn MULP_3 VDD) gpdk090_pmos1v w=0.24u l=0.1u ad=0.0816p as=0.0816p pd=1.16u ps=1.16u
    I_MXI0_I72_MP17 (XI0_I72_con I0_rc3 XI0_I72_p2 VDD) gpdk090_pmos1v w=0.48u l=0.1u ad=0.1056p as=0.1632p pd=0.92u ps=1.64u
    I_MXI0_I72_MP14 (XI0_I72_p1 I0_ha2_0 XI0_I72_con VDD) gpdk090_pmos1v w=0.48u l=0.1u ad=0.1056p as=0.1056p pd=0.92u ps=0.92u
    I_MXI0_I72_MP13 (VDD I0_fa1_1 XI0_I72_p1 VDD) gpdk090_pmos1v w=0.48u l=0.1u ad=0.1056p as=0.1056p pd=0.92u ps=0.92u
    I_MXI0_I72_MP15 (XI0_I72_p2 I0_fa1_1 VDD VDD) gpdk090_pmos1v w=0.48u l=0.1u ad=0.1056p as=0.1056p pd=0.92u ps=0.92u
    I_MXI0_I72_MP16 (VDD I0_ha2_0 XI0_I72_p2 VDD) gpdk090_pmos1v w=0.48u l=0.1u ad=0.0936p as=0.1056p pd=0.92u ps=0.92u
    I_MXI0_I72_MP28 (I0_rc4 XI0_I72_con VDD VDD) gpdk090_pmos1v w=0.24u l=0.1u ad=0.0816p as=0.0936p pd=1.16u ps=0.92u
    I_MXI0_I72_MP22 (XI0_I72_p4 I0_fa1_1 VDD VDD) gpdk090_pmos1v w=0.36u l=0.1u ad=0.0792p as=0.1224p pd=0.8u ps=1.4u
    I_MXI0_I72_MP23 (XI0_I72_p5 I0_ha2_0 XI0_I72_p4 VDD) gpdk090_pmos1v w=0.36u l=0.1u ad=0.0792p as=0.0792p pd=0.8u ps=0.8u
    I_MXI0_I72_MP23_1 (XI0_I72_p4 I0_ha2_0 XI0_I72_p5 VDD) gpdk090_pmos1v w=0.36u l=0.1u ad=0.0792p as=0.0792p pd=0.8u ps=0.8u
    I_MXI0_I72_MP22_1 (VDD I0_fa1_1 XI0_I72_p4 VDD) gpdk090_pmos1v w=0.36u l=0.1u ad=0.1968p as=0.0792p pd=1.46u ps=0.8u
    I_MXI0_I72_MP19 (XI0_I72_p3 I0_ha2_0 VDD VDD) gpdk090_pmos1v w=0.48u l=0.1u ad=0.1056p as=0.1968p pd=0.92u ps=1.46u
    I_MXI0_I72_MP18 (VDD I0_fa1_1 XI0_I72_p3 VDD) gpdk090_pmos1v w=0.48u l=0.1u ad=0.1056p as=0.1056p pd=0.92u ps=0.92u
    I_MXI0_I72_MP20 (XI0_I72_p3 I0_rc3 VDD VDD) gpdk090_pmos1v w=0.48u l=0.1u ad=0.1056p as=0.1056p pd=0.92u ps=0.92u
    I_MXI0_I72_MP21 (XI0_I72_sn XI0_I72_con XI0_I72_p3 VDD) gpdk090_pmos1v w=0.48u l=0.1u ad=0.0996p as=0.1056p pd=0.92u ps=0.92u
    I_MXI0_I72_MP24_1 (XI0_I72_p5 I0_rc3 XI0_I72_sn VDD) gpdk090_pmos1v w=0.36u l=0.1u ad=0.0792p as=0.0996p pd=0.8u ps=0.92u
    I_MXI0_I44_MP24 (XI0_I44_sn B_3 XI0_I44_p5 VDD) gpdk090_pmos1v w=0.36u l=0.1u ad=0.1224p as=0.0792p pd=1.4u ps=0.8u
    I_MXI0_I44_MP26 (VDD XI0_I44_sn I0_fa1_0 VDD) gpdk090_pmos1v w=0.24u l=0.1u ad=0.0816p as=0.0816p pd=1.16u ps=1.16u
    I_MXI0_I44_MP17 (XI0_I44_con B_3 XI0_I44_p2 VDD) gpdk090_pmos1v w=0.48u l=0.1u ad=0.1056p as=0.1632p pd=0.92u ps=1.64u
    I_MXI0_I44_MP14 (XI0_I44_p1 I0_pp1_0 XI0_I44_con VDD) gpdk090_pmos1v w=0.48u l=0.1u ad=0.1056p as=0.1056p pd=0.92u ps=0.92u
    I_MXI0_I44_MP13 (VDD I0_pp0_2 XI0_I44_p1 VDD) gpdk090_pmos1v w=0.48u l=0.1u ad=0.1056p as=0.1056p pd=0.92u ps=0.92u
    I_MXI0_I44_MP15 (XI0_I44_p2 I0_pp0_2 VDD VDD) gpdk090_pmos1v w=0.48u l=0.1u ad=0.1056p as=0.1056p pd=0.92u ps=0.92u
    I_MXI0_I44_MP16 (VDD I0_pp1_0 XI0_I44_p2 VDD) gpdk090_pmos1v w=0.48u l=0.1u ad=0.0936p as=0.1056p pd=0.92u ps=0.92u
    I_MXI0_I44_MP28 (I0_fa1_1 XI0_I44_con VDD VDD) gpdk090_pmos1v w=0.24u l=0.1u ad=0.0816p as=0.0936p pd=1.16u ps=0.92u
    I_MXI0_I44_MP22 (XI0_I44_p4 I0_pp0_2 VDD VDD) gpdk090_pmos1v w=0.36u l=0.1u ad=0.0792p as=0.1224p pd=0.8u ps=1.4u
    I_MXI0_I44_MP23 (XI0_I44_p5 I0_pp1_0 XI0_I44_p4 VDD) gpdk090_pmos1v w=0.36u l=0.1u ad=0.0792p as=0.0792p pd=0.8u ps=0.8u
    I_MXI0_I44_MP23_1 (XI0_I44_p4 I0_pp1_0 XI0_I44_p5 VDD) gpdk090_pmos1v w=0.36u l=0.1u ad=0.0792p as=0.0792p pd=0.8u ps=0.8u
    I_MXI0_I44_MP22_1 (VDD I0_pp0_2 XI0_I44_p4 VDD) gpdk090_pmos1v w=0.36u l=0.1u ad=0.1968p as=0.0792p pd=1.46u ps=0.8u
    I_MXI0_I44_MP19 (XI0_I44_p3 I0_pp1_0 VDD VDD) gpdk090_pmos1v w=0.48u l=0.1u ad=0.1056p as=0.1968p pd=0.92u ps=1.46u
    I_MXI0_I44_MP18 (VDD I0_pp0_2 XI0_I44_p3 VDD) gpdk090_pmos1v w=0.48u l=0.1u ad=0.1056p as=0.1056p pd=0.92u ps=0.92u
    I_MXI0_I44_MP20 (XI0_I44_p3 B_3 VDD VDD) gpdk090_pmos1v w=0.48u l=0.1u ad=0.1056p as=0.1056p pd=0.92u ps=0.92u
    I_MXI0_I44_MP21 (XI0_I44_sn XI0_I44_con XI0_I44_p3 VDD) gpdk090_pmos1v w=0.48u l=0.1u ad=0.0996p as=0.1056p pd=0.92u ps=0.92u
    I_MXI0_I44_MP24_1 (XI0_I44_p5 B_3 XI0_I44_sn VDD) gpdk090_pmos1v w=0.36u l=0.1u ad=0.0792p as=0.0996p pd=0.8u ps=0.92u
    I_MXI1_I190_MP1 (VDD I1_nrkn6 XI1_I190_Bn VDD) gpdk090_pmos1v w=0.24u l=0.1u ad=0.0816p as=0.0816p pd=1.16u ps=1.16u
    I_MXI1_I190_MP5 (DIVR_6 I1_nrkn6 XI1_I190_p1 VDD) gpdk090_pmos1v w=0.48u l=0.1u ad=0.1056p as=0.1632p pd=0.92u ps=1.64u
    I_MXI1_I190_MP4 (XI1_I190_p1 XI1_I190_An DIVR_6 VDD) gpdk090_pmos1v w=0.48u l=0.1u ad=0.1056p as=0.1056p pd=0.92u ps=0.92u
    I_MXI1_I190_MP2 (VDD I1_ru6 XI1_I190_p1 VDD) gpdk090_pmos1v w=0.48u l=0.1u ad=0.1056p as=0.1056p pd=0.92u ps=0.92u
    I_MXI1_I190_MP3 (XI1_I190_p1 XI1_I190_Bn VDD VDD) gpdk090_pmos1v w=0.48u l=0.1u ad=0.1632p as=0.1056p pd=1.64u ps=0.92u
    I_MXI1_I190_MP0 (VDD I1_ru6 XI1_I190_An VDD) gpdk090_pmos1v w=0.24u l=0.1u ad=0.0816p as=0.0816p pd=1.16u ps=1.16u
    I_MXI0_I77_I44_MP1 (VDD I0_kc7 XI0_I77_I44_Bn VDD) gpdk090_pmos1v w=0.24u l=0.1u ad=0.0816p as=0.0816p pd=1.16u ps=1.16u
    I_MXI0_I77_I44_MP5 (MULP_15 I0_kc7 XI0_I77_I44_p1 VDD) gpdk090_pmos1v w=0.48u l=0.1u ad=0.1056p as=0.1632p pd=0.92u ps=1.64u
    I_MXI0_I77_I44_MP4 (XI0_I77_I44_p1 XI0_I77_I44_An MULP_15 VDD) gpdk090_pmos1v w=0.48u l=0.1u ad=0.1056p as=0.1056p pd=0.92u ps=0.92u
    I_MXI0_I77_I44_MP2 (VDD I0_I77_pn7 XI0_I77_I44_p1 VDD) gpdk090_pmos1v w=0.48u l=0.1u ad=0.1056p as=0.1056p pd=0.92u ps=0.92u
    I_MXI0_I77_I44_MP3 (XI0_I77_I44_p1 XI0_I77_I44_Bn VDD VDD) gpdk090_pmos1v w=0.48u l=0.1u ad=0.1632p as=0.1056p pd=1.64u ps=0.92u
    I_MXI0_I77_I44_MP0 (VDD I0_I77_pn7 XI0_I77_I44_An VDD) gpdk090_pmos1v w=0.24u l=0.1u ad=0.0816p as=0.0816p pd=1.16u ps=1.16u
    I_MXI0_I77_I43_MP1 (VDD I0_I77_G5_0 XI0_I77_I43_Bn VDD) gpdk090_pmos1v w=0.24u l=0.1u ad=0.0816p as=0.0816p pd=1.16u ps=1.16u
    I_MXI0_I77_I43_MP5 (MULP_14 I0_I77_G5_0 XI0_I77_I43_p1 VDD) gpdk090_pmos1v w=0.48u l=0.1u ad=0.1056p as=0.1632p pd=0.92u ps=1.64u
    I_MXI0_I77_I43_MP4 (XI0_I77_I43_p1 XI0_I77_I43_An MULP_14 VDD) gpdk090_pmos1v w=0.48u l=0.1u ad=0.1056p as=0.1056p pd=0.92u ps=0.92u
    I_MXI0_I77_I43_MP2 (VDD I0_I77_pn6 XI0_I77_I43_p1 VDD) gpdk090_pmos1v w=0.48u l=0.1u ad=0.1056p as=0.1056p pd=0.92u ps=0.92u
    I_MXI0_I77_I43_MP3 (XI0_I77_I43_p1 XI0_I77_I43_Bn VDD VDD) gpdk090_pmos1v w=0.48u l=0.1u ad=0.1632p as=0.1056p pd=1.64u ps=0.92u
    I_MXI0_I77_I43_MP0 (VDD I0_I77_pn6 XI0_I77_I43_An VDD) gpdk090_pmos1v w=0.24u l=0.1u ad=0.0816p as=0.0816p pd=1.16u ps=1.16u
    I_MXI0_I77_I14_MP1 (VDD I0_ha24_0 XI0_I77_I14_Bn VDD) gpdk090_pmos1v w=0.24u l=0.1u ad=0.0816p as=0.0816p pd=1.16u ps=1.16u
    I_MXI0_I77_I14_MP5 (I0_I77_pn6 I0_ha24_0 XI0_I77_I14_p1 VDD) gpdk090_pmos1v w=0.48u l=0.1u ad=0.1056p as=0.1632p pd=0.92u ps=1.64u
    I_MXI0_I77_I14_MP4 (XI0_I77_I14_p1 XI0_I77_I14_An I0_I77_pn6 VDD) gpdk090_pmos1v w=0.48u l=0.1u ad=0.1056p as=0.1056p pd=0.92u ps=0.92u
    I_MXI0_I77_I14_MP2 (VDD I0_ha23_1 XI0_I77_I14_p1 VDD) gpdk090_pmos1v w=0.48u l=0.1u ad=0.1056p as=0.1056p pd=0.92u ps=0.92u
    I_MXI0_I77_I14_MP3 (XI0_I77_I14_p1 XI0_I77_I14_Bn VDD VDD) gpdk090_pmos1v w=0.48u l=0.1u ad=0.1632p as=0.1056p pd=1.64u ps=0.92u
    I_MXI0_I77_I14_MP0 (VDD I0_ha23_1 XI0_I77_I14_An VDD) gpdk090_pmos1v w=0.24u l=0.1u ad=0.0816p as=0.0816p pd=1.16u ps=1.16u
    I_MXI0_I77_I15_MP1 (VDD I0_ha25_0 XI0_I77_I15_Bn VDD) gpdk090_pmos1v w=0.24u l=0.1u ad=0.0816p as=0.0816p pd=1.16u ps=1.16u
    I_MXI0_I77_I15_MP5 (I0_I77_pn7 I0_ha25_0 XI0_I77_I15_p1 VDD) gpdk090_pmos1v w=0.48u l=0.1u ad=0.1056p as=0.1632p pd=0.92u ps=1.64u
    I_MXI0_I77_I15_MP4 (XI0_I77_I15_p1 XI0_I77_I15_An I0_I77_pn7 VDD) gpdk090_pmos1v w=0.48u l=0.1u ad=0.1056p as=0.1056p pd=0.92u ps=0.92u
    I_MXI0_I77_I15_MP2 (VDD I0_ha24_1 XI0_I77_I15_p1 VDD) gpdk090_pmos1v w=0.48u l=0.1u ad=0.1056p as=0.1056p pd=0.92u ps=0.92u
    I_MXI0_I77_I15_MP3 (XI0_I77_I15_p1 XI0_I77_I15_Bn VDD VDD) gpdk090_pmos1v w=0.48u l=0.1u ad=0.1632p as=0.1056p pd=1.64u ps=0.92u
    I_MXI0_I77_I15_MP0 (VDD I0_ha24_1 XI0_I77_I15_An VDD) gpdk090_pmos1v w=0.24u l=0.1u ad=0.0816p as=0.0816p pd=1.16u ps=1.16u
    I_MXI1_I152_I43_MP1 (VDD I1_I152_G5_0 XI1_I152_I43_Bn VDD) gpdk090_pmos1v w=0.24u l=0.1u ad=0.0816p as=0.0816p pd=1.16u ps=1.16u
    I_MXI1_I152_I43_MP5 (I1_ru6 I1_I152_G5_0 XI1_I152_I43_p1 VDD) gpdk090_pmos1v w=0.48u l=0.1u ad=0.1056p as=0.1632p pd=0.92u ps=1.64u
    I_MXI1_I152_I43_MP4 (XI1_I152_I43_p1 XI1_I152_I43_An I1_ru6 VDD) gpdk090_pmos1v w=0.48u l=0.1u ad=0.1056p as=0.1056p pd=0.92u ps=0.92u
    I_MXI1_I152_I43_MP2 (VDD I1_I152_pn6 XI1_I152_I43_p1 VDD) gpdk090_pmos1v w=0.48u l=0.1u ad=0.1056p as=0.1056p pd=0.92u ps=0.92u
    I_MXI1_I152_I43_MP3 (XI1_I152_I43_p1 XI1_I152_I43_Bn VDD VDD) gpdk090_pmos1v w=0.48u l=0.1u ad=0.1632p as=0.1056p pd=1.64u ps=0.92u
    I_MXI1_I152_I43_MP0 (VDD I1_I152_pn6 XI1_I152_I43_An VDD) gpdk090_pmos1v w=0.24u l=0.1u ad=0.0816p as=0.0816p pd=1.16u ps=1.16u
    I_MXI1_I193_MP1 (VDD I1_nrkn7 XI1_I193_Bn VDD) gpdk090_pmos1v w=0.24u l=0.1u ad=0.0816p as=0.0816p pd=1.16u ps=1.16u
    I_MXI1_I193_MP5 (DIVR_7 I1_nrkn7 XI1_I193_p1 VDD) gpdk090_pmos1v w=0.48u l=0.1u ad=0.1056p as=0.1632p pd=0.92u ps=1.64u
    I_MXI1_I193_MP4 (XI1_I193_p1 XI1_I193_An DIVR_7 VDD) gpdk090_pmos1v w=0.48u l=0.1u ad=0.1056p as=0.1056p pd=0.92u ps=0.92u
    I_MXI1_I193_MP2 (VDD I1_ru7 XI1_I193_p1 VDD) gpdk090_pmos1v w=0.48u l=0.1u ad=0.1056p as=0.1056p pd=0.92u ps=0.92u
    I_MXI1_I193_MP3 (XI1_I193_p1 XI1_I193_Bn VDD VDD) gpdk090_pmos1v w=0.48u l=0.1u ad=0.1632p as=0.1056p pd=1.64u ps=0.92u
    I_MXI1_I193_MP0 (VDD I1_ru7 XI1_I193_An VDD) gpdk090_pmos1v w=0.24u l=0.1u ad=0.0816p as=0.0816p pd=1.16u ps=1.16u
    I_MXI1_I187_MP1 (VDD I1_nrkn5 XI1_I187_Bn VDD) gpdk090_pmos1v w=0.24u l=0.1u ad=0.0816p as=0.0816p pd=1.16u ps=1.16u
    I_MXI1_I187_MP5 (DIVR_5 I1_nrkn5 XI1_I187_p1 VDD) gpdk090_pmos1v w=0.48u l=0.1u ad=0.1056p as=0.1632p pd=0.92u ps=1.64u
    I_MXI1_I187_MP4 (XI1_I187_p1 XI1_I187_An DIVR_5 VDD) gpdk090_pmos1v w=0.48u l=0.1u ad=0.1056p as=0.1056p pd=0.92u ps=0.92u
    I_MXI1_I187_MP2 (VDD I1_ru5 XI1_I187_p1 VDD) gpdk090_pmos1v w=0.48u l=0.1u ad=0.1056p as=0.1056p pd=0.92u ps=0.92u
    I_MXI1_I187_MP3 (XI1_I187_p1 XI1_I187_Bn VDD VDD) gpdk090_pmos1v w=0.48u l=0.1u ad=0.1632p as=0.1056p pd=1.64u ps=0.92u
    I_MXI1_I187_MP0 (VDD I1_ru5 XI1_I187_An VDD) gpdk090_pmos1v w=0.24u l=0.1u ad=0.0816p as=0.0816p pd=1.16u ps=1.16u
    I_MXI0_I77_I13_MP1 (VDD I0_ha23_0 XI0_I77_I13_Bn VDD) gpdk090_pmos1v w=0.24u l=0.1u ad=0.0816p as=0.0816p pd=1.16u ps=1.16u
    I_MXI0_I77_I13_MP5 (I0_I77_pn5 I0_ha23_0 XI0_I77_I13_p1 VDD) gpdk090_pmos1v w=0.48u l=0.1u ad=0.1056p as=0.1632p pd=0.92u ps=1.64u
    I_MXI0_I77_I13_MP4 (XI0_I77_I13_p1 XI0_I77_I13_An I0_I77_pn5 VDD) gpdk090_pmos1v w=0.48u l=0.1u ad=0.1056p as=0.1056p pd=0.92u ps=0.92u
    I_MXI0_I77_I13_MP2 (VDD I0_ha22_1 XI0_I77_I13_p1 VDD) gpdk090_pmos1v w=0.48u l=0.1u ad=0.1056p as=0.1056p pd=0.92u ps=0.92u
    I_MXI0_I77_I13_MP3 (XI0_I77_I13_p1 XI0_I77_I13_Bn VDD VDD) gpdk090_pmos1v w=0.48u l=0.1u ad=0.1632p as=0.1056p pd=1.64u ps=0.92u
    I_MXI0_I77_I13_MP0 (VDD I0_ha22_1 XI0_I77_I13_An VDD) gpdk090_pmos1v w=0.24u l=0.1u ad=0.0816p as=0.0816p pd=1.16u ps=1.16u
    I_MXI1_I184_MP1 (VDD I1_nrkn4 XI1_I184_Bn VDD) gpdk090_pmos1v w=0.24u l=0.1u ad=0.0816p as=0.0816p pd=1.16u ps=1.16u
    I_MXI1_I184_MP5 (DIVR_4 I1_nrkn4 XI1_I184_p1 VDD) gpdk090_pmos1v w=0.48u l=0.1u ad=0.1056p as=0.1632p pd=0.92u ps=1.64u
    I_MXI1_I184_MP4 (XI1_I184_p1 XI1_I184_An DIVR_4 VDD) gpdk090_pmos1v w=0.48u l=0.1u ad=0.1056p as=0.1056p pd=0.92u ps=0.92u
    I_MXI1_I184_MP2 (VDD I1_ru4 XI1_I184_p1 VDD) gpdk090_pmos1v w=0.48u l=0.1u ad=0.1056p as=0.1056p pd=0.92u ps=0.92u
    I_MXI1_I184_MP3 (XI1_I184_p1 XI1_I184_Bn VDD VDD) gpdk090_pmos1v w=0.48u l=0.1u ad=0.1632p as=0.1056p pd=1.64u ps=0.92u
    I_MXI1_I184_MP0 (VDD I1_ru4 XI1_I184_An VDD) gpdk090_pmos1v w=0.24u l=0.1u ad=0.0816p as=0.0816p pd=1.16u ps=1.16u
    I_MXI1_I181_MP1 (VDD I1_nrkn3 XI1_I181_Bn VDD) gpdk090_pmos1v w=0.24u l=0.1u ad=0.0816p as=0.0816p pd=1.16u ps=1.16u
    I_MXI1_I181_MP5 (DIVR_3 I1_nrkn3 XI1_I181_p1 VDD) gpdk090_pmos1v w=0.48u l=0.1u ad=0.1056p as=0.1632p pd=0.92u ps=1.64u
    I_MXI1_I181_MP4 (XI1_I181_p1 XI1_I181_An DIVR_3 VDD) gpdk090_pmos1v w=0.48u l=0.1u ad=0.1056p as=0.1056p pd=0.92u ps=0.92u
    I_MXI1_I181_MP2 (VDD I1_ru3 XI1_I181_p1 VDD) gpdk090_pmos1v w=0.48u l=0.1u ad=0.1056p as=0.1056p pd=0.92u ps=0.92u
    I_MXI1_I181_MP3 (XI1_I181_p1 XI1_I181_Bn VDD VDD) gpdk090_pmos1v w=0.48u l=0.1u ad=0.1632p as=0.1056p pd=1.64u ps=0.92u
    I_MXI1_I181_MP0 (VDD I1_ru3 XI1_I181_An VDD) gpdk090_pmos1v w=0.24u l=0.1u ad=0.0816p as=0.0816p pd=1.16u ps=1.16u
    I_MXI0_I77_I42_MP1 (VDD I0_I77_G4_0 XI0_I77_I42_Bn VDD) gpdk090_pmos1v w=0.24u l=0.1u ad=0.0816p as=0.0816p pd=1.16u ps=1.16u
    I_MXI0_I77_I42_MP5 (MULP_13 I0_I77_G4_0 XI0_I77_I42_p1 VDD) gpdk090_pmos1v w=0.48u l=0.1u ad=0.1056p as=0.1632p pd=0.92u ps=1.64u
    I_MXI0_I77_I42_MP4 (XI0_I77_I42_p1 XI0_I77_I42_An MULP_13 VDD) gpdk090_pmos1v w=0.48u l=0.1u ad=0.1056p as=0.1056p pd=0.92u ps=0.92u
    I_MXI0_I77_I42_MP2 (VDD I0_I77_pn5 XI0_I77_I42_p1 VDD) gpdk090_pmos1v w=0.48u l=0.1u ad=0.1056p as=0.1056p pd=0.92u ps=0.92u
    I_MXI0_I77_I42_MP3 (XI0_I77_I42_p1 XI0_I77_I42_Bn VDD VDD) gpdk090_pmos1v w=0.48u l=0.1u ad=0.1632p as=0.1056p pd=1.64u ps=0.92u
    I_MXI0_I77_I42_MP0 (VDD I0_I77_pn5 XI0_I77_I42_An VDD) gpdk090_pmos1v w=0.24u l=0.1u ad=0.0816p as=0.0816p pd=1.16u ps=1.16u
    I_MXI0_I77_I12_MP1 (VDD I0_ha22_0 XI0_I77_I12_Bn VDD) gpdk090_pmos1v w=0.24u l=0.1u ad=0.0816p as=0.0816p pd=1.16u ps=1.16u
    I_MXI0_I77_I12_MP5 (I0_I77_pn4 I0_ha22_0 XI0_I77_I12_p1 VDD) gpdk090_pmos1v w=0.48u l=0.1u ad=0.1056p as=0.1632p pd=0.92u ps=1.64u
    I_MXI0_I77_I12_MP4 (XI0_I77_I12_p1 XI0_I77_I12_An I0_I77_pn4 VDD) gpdk090_pmos1v w=0.48u l=0.1u ad=0.1056p as=0.1056p pd=0.92u ps=0.92u
    I_MXI0_I77_I12_MP2 (VDD I0_ha21_1 XI0_I77_I12_p1 VDD) gpdk090_pmos1v w=0.48u l=0.1u ad=0.1056p as=0.1056p pd=0.92u ps=0.92u
    I_MXI0_I77_I12_MP3 (XI0_I77_I12_p1 XI0_I77_I12_Bn VDD VDD) gpdk090_pmos1v w=0.48u l=0.1u ad=0.1632p as=0.1056p pd=1.64u ps=0.92u
    I_MXI0_I77_I12_MP0 (VDD I0_ha21_1 XI0_I77_I12_An VDD) gpdk090_pmos1v w=0.24u l=0.1u ad=0.0816p as=0.0816p pd=1.16u ps=1.16u
    I_MXI0_I77_I11_MP1 (VDD I0_ha21_0 XI0_I77_I11_Bn VDD) gpdk090_pmos1v w=0.24u l=0.1u ad=0.0816p as=0.0816p pd=1.16u ps=1.16u
    I_MXI0_I77_I11_MP5 (I0_I77_pn3 I0_ha21_0 XI0_I77_I11_p1 VDD) gpdk090_pmos1v w=0.48u l=0.1u ad=0.1056p as=0.1632p pd=0.92u ps=1.64u
    I_MXI0_I77_I11_MP4 (XI0_I77_I11_p1 XI0_I77_I11_An I0_I77_pn3 VDD) gpdk090_pmos1v w=0.48u l=0.1u ad=0.1056p as=0.1056p pd=0.92u ps=0.92u
    I_MXI0_I77_I11_MP2 (VDD I0_ha20_1 XI0_I77_I11_p1 VDD) gpdk090_pmos1v w=0.48u l=0.1u ad=0.1056p as=0.1056p pd=0.92u ps=0.92u
    I_MXI0_I77_I11_MP3 (XI0_I77_I11_p1 XI0_I77_I11_Bn VDD VDD) gpdk090_pmos1v w=0.48u l=0.1u ad=0.1632p as=0.1056p pd=1.64u ps=0.92u
    I_MXI0_I77_I11_MP0 (VDD I0_ha20_1 XI0_I77_I11_An VDD) gpdk090_pmos1v w=0.24u l=0.1u ad=0.0816p as=0.0816p pd=1.16u ps=1.16u
    I_MXI1_I152_I15_MP1 (VDD I1_dm7 XI1_I152_I15_Bn VDD) gpdk090_pmos1v w=0.24u l=0.1u ad=0.0816p as=0.0816p pd=1.16u ps=1.16u
    I_MXI1_I152_I15_MP5 (I1_I152_pn7 I1_dm7 XI1_I152_I15_p1 VDD) gpdk090_pmos1v w=0.48u l=0.1u ad=0.1056p as=0.1632p pd=0.92u ps=1.64u
    I_MXI1_I152_I15_MP4 (XI1_I152_I15_p1 XI1_I152_I15_An I1_I152_pn7 VDD) gpdk090_pmos1v w=0.48u l=0.1u ad=0.1056p as=0.1056p pd=0.92u ps=0.92u
    I_MXI1_I152_I15_MP2 (VDD I1_p7_7 XI1_I152_I15_p1 VDD) gpdk090_pmos1v w=0.48u l=0.1u ad=0.1056p as=0.1056p pd=0.92u ps=0.92u
    I_MXI1_I152_I15_MP3 (XI1_I152_I15_p1 XI1_I152_I15_Bn VDD VDD) gpdk090_pmos1v w=0.48u l=0.1u ad=0.1632p as=0.1056p pd=1.64u ps=0.92u
    I_MXI1_I152_I15_MP0 (VDD I1_p7_7 XI1_I152_I15_An VDD) gpdk090_pmos1v w=0.24u l=0.1u ad=0.0816p as=0.0816p pd=1.16u ps=1.16u
    I_MXI1_I152_I44_MP1 (VDD I1_rc6 XI1_I152_I44_Bn VDD) gpdk090_pmos1v w=0.24u l=0.1u ad=0.0816p as=0.0816p pd=1.16u ps=1.16u
    I_MXI1_I152_I44_MP5 (I1_ru7 I1_rc6 XI1_I152_I44_p1 VDD) gpdk090_pmos1v w=0.48u l=0.1u ad=0.1056p as=0.1632p pd=0.92u ps=1.64u
    I_MXI1_I152_I44_MP4 (XI1_I152_I44_p1 XI1_I152_I44_An I1_ru7 VDD) gpdk090_pmos1v w=0.48u l=0.1u ad=0.1056p as=0.1056p pd=0.92u ps=0.92u
    I_MXI1_I152_I44_MP2 (VDD I1_I152_pn7 XI1_I152_I44_p1 VDD) gpdk090_pmos1v w=0.48u l=0.1u ad=0.1056p as=0.1056p pd=0.92u ps=0.92u
    I_MXI1_I152_I44_MP3 (XI1_I152_I44_p1 XI1_I152_I44_Bn VDD VDD) gpdk090_pmos1v w=0.48u l=0.1u ad=0.1632p as=0.1056p pd=1.64u ps=0.92u
    I_MXI1_I152_I44_MP0 (VDD I1_I152_pn7 XI1_I152_I44_An VDD) gpdk090_pmos1v w=0.24u l=0.1u ad=0.0816p as=0.0816p pd=1.16u ps=1.16u
    I_MXI1_I152_I42_MP1 (VDD I1_I152_G4_0 XI1_I152_I42_Bn VDD) gpdk090_pmos1v w=0.24u l=0.1u ad=0.0816p as=0.0816p pd=1.16u ps=1.16u
    I_MXI1_I152_I42_MP5 (I1_ru5 I1_I152_G4_0 XI1_I152_I42_p1 VDD) gpdk090_pmos1v w=0.48u l=0.1u ad=0.1056p as=0.1632p pd=0.92u ps=1.64u
    I_MXI1_I152_I42_MP4 (XI1_I152_I42_p1 XI1_I152_I42_An I1_ru5 VDD) gpdk090_pmos1v w=0.48u l=0.1u ad=0.1056p as=0.1056p pd=0.92u ps=0.92u
    I_MXI1_I152_I42_MP2 (VDD I1_I152_pn5 XI1_I152_I42_p1 VDD) gpdk090_pmos1v w=0.48u l=0.1u ad=0.1056p as=0.1056p pd=0.92u ps=0.92u
    I_MXI1_I152_I42_MP3 (XI1_I152_I42_p1 XI1_I152_I42_Bn VDD VDD) gpdk090_pmos1v w=0.48u l=0.1u ad=0.1632p as=0.1056p pd=1.64u ps=0.92u
    I_MXI1_I152_I42_MP0 (VDD I1_I152_pn5 XI1_I152_I42_An VDD) gpdk090_pmos1v w=0.24u l=0.1u ad=0.0816p as=0.0816p pd=1.16u ps=1.16u
    I_MXI1_I152_I39_MP1 (VDD I1_I152_G1_0 XI1_I152_I39_Bn VDD) gpdk090_pmos1v w=0.24u l=0.1u ad=0.0816p as=0.0816p pd=1.16u ps=1.16u
    I_MXI1_I152_I39_MP5 (I1_ru2 I1_I152_G1_0 XI1_I152_I39_p1 VDD) gpdk090_pmos1v w=0.48u l=0.1u ad=0.1056p as=0.1632p pd=0.92u ps=1.64u
    I_MXI1_I152_I39_MP4 (XI1_I152_I39_p1 XI1_I152_I39_An I1_ru2 VDD) gpdk090_pmos1v w=0.48u l=0.1u ad=0.1056p as=0.1056p pd=0.92u ps=0.92u
    I_MXI1_I152_I39_MP2 (VDD I1_I152_pn2 XI1_I152_I39_p1 VDD) gpdk090_pmos1v w=0.48u l=0.1u ad=0.1056p as=0.1056p pd=0.92u ps=0.92u
    I_MXI1_I152_I39_MP3 (XI1_I152_I39_p1 XI1_I152_I39_Bn VDD VDD) gpdk090_pmos1v w=0.48u l=0.1u ad=0.1632p as=0.1056p pd=1.64u ps=0.92u
    I_MXI1_I152_I39_MP0 (VDD I1_I152_pn2 XI1_I152_I39_An VDD) gpdk090_pmos1v w=0.24u l=0.1u ad=0.0816p as=0.0816p pd=1.16u ps=1.16u
    I_MXI1_I178_MP1 (VDD I1_nrkn2 XI1_I178_Bn VDD) gpdk090_pmos1v w=0.24u l=0.1u ad=0.0816p as=0.0816p pd=1.16u ps=1.16u
    I_MXI1_I178_MP5 (DIVR_2 I1_nrkn2 XI1_I178_p1 VDD) gpdk090_pmos1v w=0.48u l=0.1u ad=0.1056p as=0.1632p pd=0.92u ps=1.64u
    I_MXI1_I178_MP4 (XI1_I178_p1 XI1_I178_An DIVR_2 VDD) gpdk090_pmos1v w=0.48u l=0.1u ad=0.1056p as=0.1056p pd=0.92u ps=0.92u
    I_MXI1_I178_MP2 (VDD I1_ru2 XI1_I178_p1 VDD) gpdk090_pmos1v w=0.48u l=0.1u ad=0.1056p as=0.1056p pd=0.92u ps=0.92u
    I_MXI1_I178_MP3 (XI1_I178_p1 XI1_I178_Bn VDD VDD) gpdk090_pmos1v w=0.48u l=0.1u ad=0.1632p as=0.1056p pd=1.64u ps=0.92u
    I_MXI1_I178_MP0 (VDD I1_ru2 XI1_I178_An VDD) gpdk090_pmos1v w=0.24u l=0.1u ad=0.0816p as=0.0816p pd=1.16u ps=1.16u
    I_MXI0_I77_I39_MP1 (VDD I0_I77_G1_0 XI0_I77_I39_Bn VDD) gpdk090_pmos1v w=0.24u l=0.1u ad=0.0816p as=0.0816p pd=1.16u ps=1.16u
    I_MXI0_I77_I39_MP5 (MULP_10 I0_I77_G1_0 XI0_I77_I39_p1 VDD) gpdk090_pmos1v w=0.48u l=0.1u ad=0.1056p as=0.1632p pd=0.92u ps=1.64u
    I_MXI0_I77_I39_MP4 (XI0_I77_I39_p1 XI0_I77_I39_An MULP_10 VDD) gpdk090_pmos1v w=0.48u l=0.1u ad=0.1056p as=0.1056p pd=0.92u ps=0.92u
    I_MXI0_I77_I39_MP2 (VDD I0_I77_pn2 XI0_I77_I39_p1 VDD) gpdk090_pmos1v w=0.48u l=0.1u ad=0.1056p as=0.1056p pd=0.92u ps=0.92u
    I_MXI0_I77_I39_MP3 (XI0_I77_I39_p1 XI0_I77_I39_Bn VDD VDD) gpdk090_pmos1v w=0.48u l=0.1u ad=0.1632p as=0.1056p pd=1.64u ps=0.92u
    I_MXI0_I77_I39_MP0 (VDD I0_I77_pn2 XI0_I77_I39_An VDD) gpdk090_pmos1v w=0.24u l=0.1u ad=0.0816p as=0.0816p pd=1.16u ps=1.16u
    I_MXI0_I77_I10_MP1 (VDD I0_ha20_0 XI0_I77_I10_Bn VDD) gpdk090_pmos1v w=0.24u l=0.1u ad=0.0816p as=0.0816p pd=1.16u ps=1.16u
    I_MXI0_I77_I10_MP5 (I0_I77_pn2 I0_ha20_0 XI0_I77_I10_p1 VDD) gpdk090_pmos1v w=0.48u l=0.1u ad=0.1056p as=0.1632p pd=0.92u ps=1.64u
    I_MXI0_I77_I10_MP4 (XI0_I77_I10_p1 XI0_I77_I10_An I0_I77_pn2 VDD) gpdk090_pmos1v w=0.48u l=0.1u ad=0.1056p as=0.1056p pd=0.92u ps=0.92u
    I_MXI0_I77_I10_MP2 (VDD I0_ha19_1 XI0_I77_I10_p1 VDD) gpdk090_pmos1v w=0.48u l=0.1u ad=0.1056p as=0.1056p pd=0.92u ps=0.92u
    I_MXI0_I77_I10_MP3 (XI0_I77_I10_p1 XI0_I77_I10_Bn VDD VDD) gpdk090_pmos1v w=0.48u l=0.1u ad=0.1632p as=0.1056p pd=1.64u ps=0.92u
    I_MXI0_I77_I10_MP0 (VDD I0_ha19_1 XI0_I77_I10_An VDD) gpdk090_pmos1v w=0.24u l=0.1u ad=0.0816p as=0.0816p pd=1.16u ps=1.16u
    I_MXI1_I152_I14_MP1 (VDD I1_dm6 XI1_I152_I14_Bn VDD) gpdk090_pmos1v w=0.24u l=0.1u ad=0.0816p as=0.0816p pd=1.16u ps=1.16u
    I_MXI1_I152_I14_MP5 (I1_I152_pn6 I1_dm6 XI1_I152_I14_p1 VDD) gpdk090_pmos1v w=0.48u l=0.1u ad=0.1056p as=0.1632p pd=0.92u ps=1.64u
    I_MXI1_I152_I14_MP4 (XI1_I152_I14_p1 XI1_I152_I14_An I1_I152_pn6 VDD) gpdk090_pmos1v w=0.48u l=0.1u ad=0.1056p as=0.1056p pd=0.92u ps=0.92u
    I_MXI1_I152_I14_MP2 (VDD I1_p7_6 XI1_I152_I14_p1 VDD) gpdk090_pmos1v w=0.48u l=0.1u ad=0.1056p as=0.1056p pd=0.92u ps=0.92u
    I_MXI1_I152_I14_MP3 (XI1_I152_I14_p1 XI1_I152_I14_Bn VDD VDD) gpdk090_pmos1v w=0.48u l=0.1u ad=0.1632p as=0.1056p pd=1.64u ps=0.92u
    I_MXI1_I152_I14_MP0 (VDD I1_p7_6 XI1_I152_I14_An VDD) gpdk090_pmos1v w=0.24u l=0.1u ad=0.0816p as=0.0816p pd=1.16u ps=1.16u
    I_MXI1_I175_MP1 (VDD I1_nrkn1 XI1_I175_Bn VDD) gpdk090_pmos1v w=0.24u l=0.1u ad=0.0816p as=0.0816p pd=1.16u ps=1.16u
    I_MXI1_I175_MP5 (DIVR_1 I1_nrkn1 XI1_I175_p1 VDD) gpdk090_pmos1v w=0.48u l=0.1u ad=0.1056p as=0.1632p pd=0.92u ps=1.64u
    I_MXI1_I175_MP4 (XI1_I175_p1 XI1_I175_An DIVR_1 VDD) gpdk090_pmos1v w=0.48u l=0.1u ad=0.1056p as=0.1056p pd=0.92u ps=0.92u
    I_MXI1_I175_MP2 (VDD I1_ru1 XI1_I175_p1 VDD) gpdk090_pmos1v w=0.48u l=0.1u ad=0.1056p as=0.1056p pd=0.92u ps=0.92u
    I_MXI1_I175_MP3 (XI1_I175_p1 XI1_I175_Bn VDD VDD) gpdk090_pmos1v w=0.48u l=0.1u ad=0.1632p as=0.1056p pd=1.64u ps=0.92u
    I_MXI1_I175_MP0 (VDD I1_ru1 XI1_I175_An VDD) gpdk090_pmos1v w=0.24u l=0.1u ad=0.0816p as=0.0816p pd=1.16u ps=1.16u
    I_MXI0_I77_I38_MP1 (VDD I0_I77_G0_0 XI0_I77_I38_Bn VDD) gpdk090_pmos1v w=0.24u l=0.1u ad=0.0816p as=0.0816p pd=1.16u ps=1.16u
    I_MXI0_I77_I38_MP5 (MULP_9 I0_I77_G0_0 XI0_I77_I38_p1 VDD) gpdk090_pmos1v w=0.48u l=0.1u ad=0.1056p as=0.1632p pd=0.92u ps=1.64u
    I_MXI0_I77_I38_MP4 (XI0_I77_I38_p1 XI0_I77_I38_An MULP_9 VDD) gpdk090_pmos1v w=0.48u l=0.1u ad=0.1056p as=0.1056p pd=0.92u ps=0.92u
    I_MXI0_I77_I38_MP2 (VDD I0_I77_pn1 XI0_I77_I38_p1 VDD) gpdk090_pmos1v w=0.48u l=0.1u ad=0.1056p as=0.1056p pd=0.92u ps=0.92u
    I_MXI0_I77_I38_MP3 (XI0_I77_I38_p1 XI0_I77_I38_Bn VDD VDD) gpdk090_pmos1v w=0.48u l=0.1u ad=0.1632p as=0.1056p pd=1.64u ps=0.92u
    I_MXI0_I77_I38_MP0 (VDD I0_I77_pn1 XI0_I77_I38_An VDD) gpdk090_pmos1v w=0.24u l=0.1u ad=0.0816p as=0.0816p pd=1.16u ps=1.16u
    I_MXI0_I77_I9_MP1 (VDD I0_ha19_0 XI0_I77_I9_Bn VDD) gpdk090_pmos1v w=0.24u l=0.1u ad=0.0816p as=0.0816p pd=1.16u ps=1.16u
    I_MXI0_I77_I9_MP5 (I0_I77_pn1 I0_ha19_0 XI0_I77_I9_p1 VDD) gpdk090_pmos1v w=0.48u l=0.1u ad=0.1056p as=0.1632p pd=0.92u ps=1.64u
    I_MXI0_I77_I9_MP4 (XI0_I77_I9_p1 XI0_I77_I9_An I0_I77_pn1 VDD) gpdk090_pmos1v w=0.48u l=0.1u ad=0.1056p as=0.1056p pd=0.92u ps=0.92u
    I_MXI0_I77_I9_MP2 (VDD I0_ha18_1 XI0_I77_I9_p1 VDD) gpdk090_pmos1v w=0.48u l=0.1u ad=0.1056p as=0.1056p pd=0.92u ps=0.92u
    I_MXI0_I77_I9_MP3 (XI0_I77_I9_p1 XI0_I77_I9_Bn VDD VDD) gpdk090_pmos1v w=0.48u l=0.1u ad=0.1632p as=0.1056p pd=1.64u ps=0.92u
    I_MXI0_I77_I9_MP0 (VDD I0_ha18_1 XI0_I77_I9_An VDD) gpdk090_pmos1v w=0.24u l=0.1u ad=0.0816p as=0.0816p pd=1.16u ps=1.16u
    I_MXI2_I1_I8_I15_MP1 (VDD I2_I1_bx7 XI2_I1_I8_I15_Bn VDD) gpdk090_pmos1v w=0.24u l=0.1u ad=0.0816p as=0.0816p pd=1.16u ps=1.16u
    I_MXI2_I1_I8_I15_MP5 (I2_I1_I8_pn7 I2_I1_bx7 XI2_I1_I8_I15_p1 VDD) gpdk090_pmos1v w=0.48u l=0.1u ad=0.1056p as=0.1632p pd=0.92u ps=1.64u
    I_MXI2_I1_I8_I15_MP4 (XI2_I1_I8_I15_p1 XI2_I1_I8_I15_An I2_I1_I8_pn7 VDD) gpdk090_pmos1v w=0.48u l=0.1u ad=0.1056p as=0.1056p pd=0.92u ps=0.92u
    I_MXI2_I1_I8_I15_MP2 (VDD A_7 XI2_I1_I8_I15_p1 VDD) gpdk090_pmos1v w=0.48u l=0.1u ad=0.1056p as=0.1056p pd=0.92u ps=0.92u
    I_MXI2_I1_I8_I15_MP3 (XI2_I1_I8_I15_p1 XI2_I1_I8_I15_Bn VDD VDD) gpdk090_pmos1v w=0.48u l=0.1u ad=0.1632p as=0.1056p pd=1.64u ps=0.92u
    I_MXI2_I1_I8_I15_MP0 (VDD A_7 XI2_I1_I8_I15_An VDD) gpdk090_pmos1v w=0.24u l=0.1u ad=0.0816p as=0.0816p pd=1.16u ps=1.16u
    I_MXI1_I132_I43_MP1 (VDD I1_I132_G5_0 XI1_I132_I43_Bn VDD) gpdk090_pmos1v w=0.24u l=0.1u ad=0.0816p as=0.0816p pd=1.16u ps=1.16u
    I_MXI1_I132_I43_MP5 (I1_p7_6 I1_I132_G5_0 XI1_I132_I43_p1 VDD) gpdk090_pmos1v w=0.48u l=0.1u ad=0.1056p as=0.1632p pd=0.92u ps=1.64u
    I_MXI1_I132_I43_MP4 (XI1_I132_I43_p1 XI1_I132_I43_An I1_p7_6 VDD) gpdk090_pmos1v w=0.48u l=0.1u ad=0.1056p as=0.1056p pd=0.92u ps=0.92u
    I_MXI1_I132_I43_MP2 (VDD I1_I132_pn6 XI1_I132_I43_p1 VDD) gpdk090_pmos1v w=0.48u l=0.1u ad=0.1056p as=0.1056p pd=0.92u ps=0.92u
    I_MXI1_I132_I43_MP3 (XI1_I132_I43_p1 XI1_I132_I43_Bn VDD VDD) gpdk090_pmos1v w=0.48u l=0.1u ad=0.1632p as=0.1056p pd=1.64u ps=0.92u
    I_MXI1_I132_I43_MP0 (VDD I1_I132_pn6 XI1_I132_I43_An VDD) gpdk090_pmos1v w=0.24u l=0.1u ad=0.0816p as=0.0816p pd=1.16u ps=1.16u
    I_MXI1_I152_I13_MP1 (VDD I1_dm5 XI1_I152_I13_Bn VDD) gpdk090_pmos1v w=0.24u l=0.1u ad=0.0816p as=0.0816p pd=1.16u ps=1.16u
    I_MXI1_I152_I13_MP5 (I1_I152_pn5 I1_dm5 XI1_I152_I13_p1 VDD) gpdk090_pmos1v w=0.48u l=0.1u ad=0.1056p as=0.1632p pd=0.92u ps=1.64u
    I_MXI1_I152_I13_MP4 (XI1_I152_I13_p1 XI1_I152_I13_An I1_I152_pn5 VDD) gpdk090_pmos1v w=0.48u l=0.1u ad=0.1056p as=0.1056p pd=0.92u ps=0.92u
    I_MXI1_I152_I13_MP2 (VDD I1_p7_5 XI1_I152_I13_p1 VDD) gpdk090_pmos1v w=0.48u l=0.1u ad=0.1056p as=0.1056p pd=0.92u ps=0.92u
    I_MXI1_I152_I13_MP3 (XI1_I152_I13_p1 XI1_I152_I13_Bn VDD VDD) gpdk090_pmos1v w=0.48u l=0.1u ad=0.1632p as=0.1056p pd=1.64u ps=0.92u
    I_MXI1_I152_I13_MP0 (VDD I1_p7_5 XI1_I152_I13_An VDD) gpdk090_pmos1v w=0.24u l=0.1u ad=0.0816p as=0.0816p pd=1.16u ps=1.16u
    I_MXI1_I152_I12_MP1 (VDD I1_dm4 XI1_I152_I12_Bn VDD) gpdk090_pmos1v w=0.24u l=0.1u ad=0.0816p as=0.0816p pd=1.16u ps=1.16u
    I_MXI1_I152_I12_MP5 (I1_I152_pn4 I1_dm4 XI1_I152_I12_p1 VDD) gpdk090_pmos1v w=0.48u l=0.1u ad=0.1056p as=0.1632p pd=0.92u ps=1.64u
    I_MXI1_I152_I12_MP4 (XI1_I152_I12_p1 XI1_I152_I12_An I1_I152_pn4 VDD) gpdk090_pmos1v w=0.48u l=0.1u ad=0.1056p as=0.1056p pd=0.92u ps=0.92u
    I_MXI1_I152_I12_MP2 (VDD I1_p7_4 XI1_I152_I12_p1 VDD) gpdk090_pmos1v w=0.48u l=0.1u ad=0.1056p as=0.1056p pd=0.92u ps=0.92u
    I_MXI1_I152_I12_MP3 (XI1_I152_I12_p1 XI1_I152_I12_Bn VDD VDD) gpdk090_pmos1v w=0.48u l=0.1u ad=0.1632p as=0.1056p pd=1.64u ps=0.92u
    I_MXI1_I152_I12_MP0 (VDD I1_p7_4 XI1_I152_I12_An VDD) gpdk090_pmos1v w=0.24u l=0.1u ad=0.0816p as=0.0816p pd=1.16u ps=1.16u
    I_MXI1_I152_I11_MP1 (VDD I1_dm3 XI1_I152_I11_Bn VDD) gpdk090_pmos1v w=0.24u l=0.1u ad=0.0816p as=0.0816p pd=1.16u ps=1.16u
    I_MXI1_I152_I11_MP5 (I1_I152_pn3 I1_dm3 XI1_I152_I11_p1 VDD) gpdk090_pmos1v w=0.48u l=0.1u ad=0.1056p as=0.1632p pd=0.92u ps=1.64u
    I_MXI1_I152_I11_MP4 (XI1_I152_I11_p1 XI1_I152_I11_An I1_I152_pn3 VDD) gpdk090_pmos1v w=0.48u l=0.1u ad=0.1056p as=0.1056p pd=0.92u ps=0.92u
    I_MXI1_I152_I11_MP2 (VDD I1_p7_3 XI1_I152_I11_p1 VDD) gpdk090_pmos1v w=0.48u l=0.1u ad=0.1056p as=0.1056p pd=0.92u ps=0.92u
    I_MXI1_I152_I11_MP3 (XI1_I152_I11_p1 XI1_I152_I11_Bn VDD VDD) gpdk090_pmos1v w=0.48u l=0.1u ad=0.1632p as=0.1056p pd=1.64u ps=0.92u
    I_MXI1_I152_I11_MP0 (VDD I1_p7_3 XI1_I152_I11_An VDD) gpdk090_pmos1v w=0.24u l=0.1u ad=0.0816p as=0.0816p pd=1.16u ps=1.16u
    I_MXI1_I152_I10_MP1 (VDD I1_dm2 XI1_I152_I10_Bn VDD) gpdk090_pmos1v w=0.24u l=0.1u ad=0.0816p as=0.0816p pd=1.16u ps=1.16u
    I_MXI1_I152_I10_MP5 (I1_I152_pn2 I1_dm2 XI1_I152_I10_p1 VDD) gpdk090_pmos1v w=0.48u l=0.1u ad=0.1056p as=0.1632p pd=0.92u ps=1.64u
    I_MXI1_I152_I10_MP4 (XI1_I152_I10_p1 XI1_I152_I10_An I1_I152_pn2 VDD) gpdk090_pmos1v w=0.48u l=0.1u ad=0.1056p as=0.1056p pd=0.92u ps=0.92u
    I_MXI1_I152_I10_MP2 (VDD I1_p7_2 XI1_I152_I10_p1 VDD) gpdk090_pmos1v w=0.48u l=0.1u ad=0.1056p as=0.1056p pd=0.92u ps=0.92u
    I_MXI1_I152_I10_MP3 (XI1_I152_I10_p1 XI1_I152_I10_Bn VDD VDD) gpdk090_pmos1v w=0.48u l=0.1u ad=0.1632p as=0.1056p pd=1.64u ps=0.92u
    I_MXI1_I152_I10_MP0 (VDD I1_p7_2 XI1_I152_I10_An VDD) gpdk090_pmos1v w=0.24u l=0.1u ad=0.0816p as=0.0816p pd=1.16u ps=1.16u
    I_MXI1_I152_I38_MP1 (VDD I1_I152_G0_0 XI1_I152_I38_Bn VDD) gpdk090_pmos1v w=0.24u l=0.1u ad=0.0816p as=0.0816p pd=1.16u ps=1.16u
    I_MXI1_I152_I38_MP5 (I1_ru1 I1_I152_G0_0 XI1_I152_I38_p1 VDD) gpdk090_pmos1v w=0.48u l=0.1u ad=0.1056p as=0.1632p pd=0.92u ps=1.64u
    I_MXI1_I152_I38_MP4 (XI1_I152_I38_p1 XI1_I152_I38_An I1_ru1 VDD) gpdk090_pmos1v w=0.48u l=0.1u ad=0.1056p as=0.1056p pd=0.92u ps=0.92u
    I_MXI1_I152_I38_MP2 (VDD I1_I152_pn1 XI1_I152_I38_p1 VDD) gpdk090_pmos1v w=0.48u l=0.1u ad=0.1056p as=0.1056p pd=0.92u ps=0.92u
    I_MXI1_I152_I38_MP3 (XI1_I152_I38_p1 XI1_I152_I38_Bn VDD VDD) gpdk090_pmos1v w=0.48u l=0.1u ad=0.1632p as=0.1056p pd=1.64u ps=0.92u
    I_MXI1_I152_I38_MP0 (VDD I1_I152_pn1 XI1_I152_I38_An VDD) gpdk090_pmos1v w=0.24u l=0.1u ad=0.0816p as=0.0816p pd=1.16u ps=1.16u
    I_MXI1_I152_I37_MP1 (VDD VSS XI1_I152_I37_Bn VDD) gpdk090_pmos1v w=0.24u l=0.1u ad=0.0816p as=0.0816p pd=1.16u ps=1.16u
    I_MXI1_I152_I37_MP5 (DIVR_0 VSS XI1_I152_I37_p1 VDD) gpdk090_pmos1v w=0.48u l=0.1u ad=0.1056p as=0.1632p pd=0.92u ps=1.64u
    I_MXI1_I152_I37_MP4 (XI1_I152_I37_p1 XI1_I152_I37_An DIVR_0 VDD) gpdk090_pmos1v w=0.48u l=0.1u ad=0.1056p as=0.1056p pd=0.92u ps=0.92u
    I_MXI1_I152_I37_MP2 (VDD I1_I152_pn0 XI1_I152_I37_p1 VDD) gpdk090_pmos1v w=0.48u l=0.1u ad=0.1056p as=0.1056p pd=0.92u ps=0.92u
    I_MXI1_I152_I37_MP3 (XI1_I152_I37_p1 XI1_I152_I37_Bn VDD VDD) gpdk090_pmos1v w=0.48u l=0.1u ad=0.1632p as=0.1056p pd=1.64u ps=0.92u
    I_MXI1_I152_I37_MP0 (VDD I1_I152_pn0 XI1_I152_I37_An VDD) gpdk090_pmos1v w=0.24u l=0.1u ad=0.0816p as=0.0816p pd=1.16u ps=1.16u
    I_MXI0_I77_I37_MP1 (VDD I0_rc8 XI0_I77_I37_Bn VDD) gpdk090_pmos1v w=0.24u l=0.1u ad=0.0816p as=0.0816p pd=1.16u ps=1.16u
    I_MXI0_I77_I37_MP5 (MULP_8 I0_rc8 XI0_I77_I37_p1 VDD) gpdk090_pmos1v w=0.48u l=0.1u ad=0.1056p as=0.1632p pd=0.92u ps=1.64u
    I_MXI0_I77_I37_MP4 (XI0_I77_I37_p1 XI0_I77_I37_An MULP_8 VDD) gpdk090_pmos1v w=0.48u l=0.1u ad=0.1056p as=0.1056p pd=0.92u ps=0.92u
    I_MXI0_I77_I37_MP2 (VDD I0_I77_pn0 XI0_I77_I37_p1 VDD) gpdk090_pmos1v w=0.48u l=0.1u ad=0.1056p as=0.1056p pd=0.92u ps=0.92u
    I_MXI0_I77_I37_MP3 (XI0_I77_I37_p1 XI0_I77_I37_Bn VDD VDD) gpdk090_pmos1v w=0.48u l=0.1u ad=0.1632p as=0.1056p pd=1.64u ps=0.92u
    I_MXI0_I77_I37_MP0 (VDD I0_I77_pn0 XI0_I77_I37_An VDD) gpdk090_pmos1v w=0.24u l=0.1u ad=0.0816p as=0.0816p pd=1.16u ps=1.16u
    I_MXI0_I77_I8_MP1 (VDD I0_ha18_0 XI0_I77_I8_Bn VDD) gpdk090_pmos1v w=0.24u l=0.1u ad=0.0816p as=0.0816p pd=1.16u ps=1.16u
    I_MXI0_I77_I8_MP5 (I0_I77_pn0 I0_ha18_0 XI0_I77_I8_p1 VDD) gpdk090_pmos1v w=0.48u l=0.1u ad=0.1056p as=0.1632p pd=0.92u ps=1.64u
    I_MXI0_I77_I8_MP4 (XI0_I77_I8_p1 XI0_I77_I8_An I0_I77_pn0 VDD) gpdk090_pmos1v w=0.48u l=0.1u ad=0.1056p as=0.1056p pd=0.92u ps=0.92u
    I_MXI0_I77_I8_MP2 (VDD I0_ha17_1 XI0_I77_I8_p1 VDD) gpdk090_pmos1v w=0.48u l=0.1u ad=0.1056p as=0.1056p pd=0.92u ps=0.92u
    I_MXI0_I77_I8_MP3 (XI0_I77_I8_p1 XI0_I77_I8_Bn VDD VDD) gpdk090_pmos1v w=0.48u l=0.1u ad=0.1632p as=0.1056p pd=1.64u ps=0.92u
    I_MXI0_I77_I8_MP0 (VDD I0_ha17_1 XI0_I77_I8_An VDD) gpdk090_pmos1v w=0.24u l=0.1u ad=0.0816p as=0.0816p pd=1.16u ps=1.16u
    I_MXI2_I1_I8_I14_MP1 (VDD I2_I1_bx6 XI2_I1_I8_I14_Bn VDD) gpdk090_pmos1v w=0.24u l=0.1u ad=0.0816p as=0.0816p pd=1.16u ps=1.16u
    I_MXI2_I1_I8_I14_MP5 (I2_I1_I8_pn6 I2_I1_bx6 XI2_I1_I8_I14_p1 VDD) gpdk090_pmos1v w=0.48u l=0.1u ad=0.1056p as=0.1632p pd=0.92u ps=1.64u
    I_MXI2_I1_I8_I14_MP4 (XI2_I1_I8_I14_p1 XI2_I1_I8_I14_An I2_I1_I8_pn6 VDD) gpdk090_pmos1v w=0.48u l=0.1u ad=0.1056p as=0.1056p pd=0.92u ps=0.92u
    I_MXI2_I1_I8_I14_MP2 (VDD A_6 XI2_I1_I8_I14_p1 VDD) gpdk090_pmos1v w=0.48u l=0.1u ad=0.1056p as=0.1056p pd=0.92u ps=0.92u
    I_MXI2_I1_I8_I14_MP3 (XI2_I1_I8_I14_p1 XI2_I1_I8_I14_Bn VDD VDD) gpdk090_pmos1v w=0.48u l=0.1u ad=0.1632p as=0.1056p pd=1.64u ps=0.92u
    I_MXI2_I1_I8_I14_MP0 (VDD A_6 XI2_I1_I8_I14_An VDD) gpdk090_pmos1v w=0.24u l=0.1u ad=0.0816p as=0.0816p pd=1.16u ps=1.16u
    I_MXI2_I1_I8_I13_MP1 (VDD I2_I1_bx5 XI2_I1_I8_I13_Bn VDD) gpdk090_pmos1v w=0.24u l=0.1u ad=0.0816p as=0.0816p pd=1.16u ps=1.16u
    I_MXI2_I1_I8_I13_MP5 (I2_I1_I8_pn5 I2_I1_bx5 XI2_I1_I8_I13_p1 VDD) gpdk090_pmos1v w=0.48u l=0.1u ad=0.1056p as=0.1632p pd=0.92u ps=1.64u
    I_MXI2_I1_I8_I13_MP4 (XI2_I1_I8_I13_p1 XI2_I1_I8_I13_An I2_I1_I8_pn5 VDD) gpdk090_pmos1v w=0.48u l=0.1u ad=0.1056p as=0.1056p pd=0.92u ps=0.92u
    I_MXI2_I1_I8_I13_MP2 (VDD A_5 XI2_I1_I8_I13_p1 VDD) gpdk090_pmos1v w=0.48u l=0.1u ad=0.1056p as=0.1056p pd=0.92u ps=0.92u
    I_MXI2_I1_I8_I13_MP3 (XI2_I1_I8_I13_p1 XI2_I1_I8_I13_Bn VDD VDD) gpdk090_pmos1v w=0.48u l=0.1u ad=0.1632p as=0.1056p pd=1.64u ps=0.92u
    I_MXI2_I1_I8_I13_MP0 (VDD A_5 XI2_I1_I8_I13_An VDD) gpdk090_pmos1v w=0.24u l=0.1u ad=0.0816p as=0.0816p pd=1.16u ps=1.16u
    I_MXI1_I132_I44_MP1 (VDD I1_c7_7 XI1_I132_I44_Bn VDD) gpdk090_pmos1v w=0.24u l=0.1u ad=0.0816p as=0.0816p pd=1.16u ps=1.16u
    I_MXI1_I132_I44_MP5 (I1_p7_7 I1_c7_7 XI1_I132_I44_p1 VDD) gpdk090_pmos1v w=0.48u l=0.1u ad=0.1056p as=0.1632p pd=0.92u ps=1.64u
    I_MXI1_I132_I44_MP4 (XI1_I132_I44_p1 XI1_I132_I44_An I1_p7_7 VDD) gpdk090_pmos1v w=0.48u l=0.1u ad=0.1056p as=0.1056p pd=0.92u ps=0.92u
    I_MXI1_I132_I44_MP2 (VDD I1_I132_pn7 XI1_I132_I44_p1 VDD) gpdk090_pmos1v w=0.48u l=0.1u ad=0.1056p as=0.1056p pd=0.92u ps=0.92u
    I_MXI1_I132_I44_MP3 (XI1_I132_I44_p1 XI1_I132_I44_Bn VDD VDD) gpdk090_pmos1v w=0.48u l=0.1u ad=0.1632p as=0.1056p pd=1.64u ps=0.92u
    I_MXI1_I132_I44_MP0 (VDD I1_I132_pn7 XI1_I132_I44_An VDD) gpdk090_pmos1v w=0.24u l=0.1u ad=0.0816p as=0.0816p pd=1.16u ps=1.16u
    I_MXI1_I132_I42_MP1 (VDD I1_I132_G4_0 XI1_I132_I42_Bn VDD) gpdk090_pmos1v w=0.24u l=0.1u ad=0.0816p as=0.0816p pd=1.16u ps=1.16u
    I_MXI1_I132_I42_MP5 (I1_p7_5 I1_I132_G4_0 XI1_I132_I42_p1 VDD) gpdk090_pmos1v w=0.48u l=0.1u ad=0.1056p as=0.1632p pd=0.92u ps=1.64u
    I_MXI1_I132_I42_MP4 (XI1_I132_I42_p1 XI1_I132_I42_An I1_p7_5 VDD) gpdk090_pmos1v w=0.48u l=0.1u ad=0.1056p as=0.1056p pd=0.92u ps=0.92u
    I_MXI1_I132_I42_MP2 (VDD I1_I132_pn5 XI1_I132_I42_p1 VDD) gpdk090_pmos1v w=0.48u l=0.1u ad=0.1056p as=0.1056p pd=0.92u ps=0.92u
    I_MXI1_I132_I42_MP3 (XI1_I132_I42_p1 XI1_I132_I42_Bn VDD VDD) gpdk090_pmos1v w=0.48u l=0.1u ad=0.1632p as=0.1056p pd=1.64u ps=0.92u
    I_MXI1_I132_I42_MP0 (VDD I1_I132_pn5 XI1_I132_I42_An VDD) gpdk090_pmos1v w=0.24u l=0.1u ad=0.0816p as=0.0816p pd=1.16u ps=1.16u
    I_MXI1_I132_I39_MP1 (VDD I1_I132_G1_0 XI1_I132_I39_Bn VDD) gpdk090_pmos1v w=0.24u l=0.1u ad=0.0816p as=0.0816p pd=1.16u ps=1.16u
    I_MXI1_I132_I39_MP5 (I1_p7_2 I1_I132_G1_0 XI1_I132_I39_p1 VDD) gpdk090_pmos1v w=0.48u l=0.1u ad=0.1056p as=0.1632p pd=0.92u ps=1.64u
    I_MXI1_I132_I39_MP4 (XI1_I132_I39_p1 XI1_I132_I39_An I1_p7_2 VDD) gpdk090_pmos1v w=0.48u l=0.1u ad=0.1056p as=0.1056p pd=0.92u ps=0.92u
    I_MXI1_I132_I39_MP2 (VDD I1_I132_pn2 XI1_I132_I39_p1 VDD) gpdk090_pmos1v w=0.48u l=0.1u ad=0.1056p as=0.1056p pd=0.92u ps=0.92u
    I_MXI1_I132_I39_MP3 (XI1_I132_I39_p1 XI1_I132_I39_Bn VDD VDD) gpdk090_pmos1v w=0.48u l=0.1u ad=0.1632p as=0.1056p pd=1.64u ps=0.92u
    I_MXI1_I132_I39_MP0 (VDD I1_I132_pn2 XI1_I132_I39_An VDD) gpdk090_pmos1v w=0.24u l=0.1u ad=0.0816p as=0.0816p pd=1.16u ps=1.16u
    I_MXI1_I152_I9_MP1 (VDD I1_dm1 XI1_I152_I9_Bn VDD) gpdk090_pmos1v w=0.24u l=0.1u ad=0.0816p as=0.0816p pd=1.16u ps=1.16u
    I_MXI1_I152_I9_MP5 (I1_I152_pn1 I1_dm1 XI1_I152_I9_p1 VDD) gpdk090_pmos1v w=0.48u l=0.1u ad=0.1056p as=0.1632p pd=0.92u ps=1.64u
    I_MXI1_I152_I9_MP4 (XI1_I152_I9_p1 XI1_I152_I9_An I1_I152_pn1 VDD) gpdk090_pmos1v w=0.48u l=0.1u ad=0.1056p as=0.1056p pd=0.92u ps=0.92u
    I_MXI1_I152_I9_MP2 (VDD I1_p7_1 XI1_I152_I9_p1 VDD) gpdk090_pmos1v w=0.48u l=0.1u ad=0.1056p as=0.1056p pd=0.92u ps=0.92u
    I_MXI1_I152_I9_MP3 (XI1_I152_I9_p1 XI1_I152_I9_Bn VDD VDD) gpdk090_pmos1v w=0.48u l=0.1u ad=0.1632p as=0.1056p pd=1.64u ps=0.92u
    I_MXI1_I152_I9_MP0 (VDD I1_p7_1 XI1_I152_I9_An VDD) gpdk090_pmos1v w=0.24u l=0.1u ad=0.0816p as=0.0816p pd=1.16u ps=1.16u
    I_MXI1_I152_I8_MP1 (VDD I1_dm0 XI1_I152_I8_Bn VDD) gpdk090_pmos1v w=0.24u l=0.1u ad=0.0816p as=0.0816p pd=1.16u ps=1.16u
    I_MXI1_I152_I8_MP5 (I1_I152_pn0 I1_dm0 XI1_I152_I8_p1 VDD) gpdk090_pmos1v w=0.48u l=0.1u ad=0.1056p as=0.1632p pd=0.92u ps=1.64u
    I_MXI1_I152_I8_MP4 (XI1_I152_I8_p1 XI1_I152_I8_An I1_I152_pn0 VDD) gpdk090_pmos1v w=0.48u l=0.1u ad=0.1056p as=0.1056p pd=0.92u ps=0.92u
    I_MXI1_I152_I8_MP2 (VDD I1_p7_0 XI1_I152_I8_p1 VDD) gpdk090_pmos1v w=0.48u l=0.1u ad=0.1056p as=0.1056p pd=0.92u ps=0.92u
    I_MXI1_I152_I8_MP3 (XI1_I152_I8_p1 XI1_I152_I8_Bn VDD VDD) gpdk090_pmos1v w=0.48u l=0.1u ad=0.1632p as=0.1056p pd=1.64u ps=0.92u
    I_MXI1_I152_I8_MP0 (VDD I1_p7_0 XI1_I152_I8_An VDD) gpdk090_pmos1v w=0.24u l=0.1u ad=0.0816p as=0.0816p pd=1.16u ps=1.16u
    I_MXI2_I1_I8_I44_MP1 (VDD I2_C7 XI2_I1_I8_I44_Bn VDD) gpdk090_pmos1v w=0.24u l=0.1u ad=0.0816p as=0.0816p pd=1.16u ps=1.16u
    I_MXI2_I1_I8_I44_MP5 (I2_S_7 I2_C7 XI2_I1_I8_I44_p1 VDD) gpdk090_pmos1v w=0.48u l=0.1u ad=0.1056p as=0.1632p pd=0.92u ps=1.64u
    I_MXI2_I1_I8_I44_MP4 (XI2_I1_I8_I44_p1 XI2_I1_I8_I44_An I2_S_7 VDD) gpdk090_pmos1v w=0.48u l=0.1u ad=0.1056p as=0.1056p pd=0.92u ps=0.92u
    I_MXI2_I1_I8_I44_MP2 (VDD I2_I1_I8_pn7 XI2_I1_I8_I44_p1 VDD) gpdk090_pmos1v w=0.48u l=0.1u ad=0.1056p as=0.1056p pd=0.92u ps=0.92u
    I_MXI2_I1_I8_I44_MP3 (XI2_I1_I8_I44_p1 XI2_I1_I8_I44_Bn VDD VDD) gpdk090_pmos1v w=0.48u l=0.1u ad=0.1632p as=0.1056p pd=1.64u ps=0.92u
    I_MXI2_I1_I8_I44_MP0 (VDD I2_I1_I8_pn7 XI2_I1_I8_I44_An VDD) gpdk090_pmos1v w=0.24u l=0.1u ad=0.0816p as=0.0816p pd=1.16u ps=1.16u
    I_MXI2_I1_I8_I43_MP1 (VDD I2_I1_I8_G5_0 XI2_I1_I8_I43_Bn VDD) gpdk090_pmos1v w=0.24u l=0.1u ad=0.0816p as=0.0816p pd=1.16u ps=1.16u
    I_MXI2_I1_I8_I43_MP5 (I2_S_6 I2_I1_I8_G5_0 XI2_I1_I8_I43_p1 VDD) gpdk090_pmos1v w=0.48u l=0.1u ad=0.1056p as=0.1632p pd=0.92u ps=1.64u
    I_MXI2_I1_I8_I43_MP4 (XI2_I1_I8_I43_p1 XI2_I1_I8_I43_An I2_S_6 VDD) gpdk090_pmos1v w=0.48u l=0.1u ad=0.1056p as=0.1056p pd=0.92u ps=0.92u
    I_MXI2_I1_I8_I43_MP2 (VDD I2_I1_I8_pn6 XI2_I1_I8_I43_p1 VDD) gpdk090_pmos1v w=0.48u l=0.1u ad=0.1056p as=0.1056p pd=0.92u ps=0.92u
    I_MXI2_I1_I8_I43_MP3 (XI2_I1_I8_I43_p1 XI2_I1_I8_I43_Bn VDD VDD) gpdk090_pmos1v w=0.48u l=0.1u ad=0.1632p as=0.1056p pd=1.64u ps=0.92u
    I_MXI2_I1_I8_I43_MP0 (VDD I2_I1_I8_pn6 XI2_I1_I8_I43_An VDD) gpdk090_pmos1v w=0.24u l=0.1u ad=0.0816p as=0.0816p pd=1.16u ps=1.16u
    I_MXI1_I132_I9_MP1 (VDD I1_b7_1 XI1_I132_I9_Bn VDD) gpdk090_pmos1v w=0.24u l=0.1u ad=0.0816p as=0.0816p pd=1.16u ps=1.16u
    I_MXI1_I132_I9_MP5 (I1_I132_pn1 I1_b7_1 XI1_I132_I9_p1 VDD) gpdk090_pmos1v w=0.48u l=0.1u ad=0.1056p as=0.1632p pd=0.92u ps=1.64u
    I_MXI1_I132_I9_MP4 (XI1_I132_I9_p1 XI1_I132_I9_An I1_I132_pn1 VDD) gpdk090_pmos1v w=0.48u l=0.1u ad=0.1056p as=0.1056p pd=0.92u ps=0.92u
    I_MXI1_I132_I9_MP2 (VDD I1_p6_0 XI1_I132_I9_p1 VDD) gpdk090_pmos1v w=0.48u l=0.1u ad=0.1056p as=0.1056p pd=0.92u ps=0.92u
    I_MXI1_I132_I9_MP3 (XI1_I132_I9_p1 XI1_I132_I9_Bn VDD VDD) gpdk090_pmos1v w=0.48u l=0.1u ad=0.1632p as=0.1056p pd=1.64u ps=0.92u
    I_MXI1_I132_I9_MP0 (VDD I1_p6_0 XI1_I132_I9_An VDD) gpdk090_pmos1v w=0.24u l=0.1u ad=0.0816p as=0.0816p pd=1.16u ps=1.16u
    I_MXI1_I132_I37_MP1 (VDD I1_qu1 XI1_I132_I37_Bn VDD) gpdk090_pmos1v w=0.24u l=0.1u ad=0.0816p as=0.0816p pd=1.16u ps=1.16u
    I_MXI1_I132_I37_MP5 (I1_p7_0 I1_qu1 XI1_I132_I37_p1 VDD) gpdk090_pmos1v w=0.48u l=0.1u ad=0.1056p as=0.1632p pd=0.92u ps=1.64u
    I_MXI1_I132_I37_MP4 (XI1_I132_I37_p1 XI1_I132_I37_An I1_p7_0 VDD) gpdk090_pmos1v w=0.48u l=0.1u ad=0.1056p as=0.1056p pd=0.92u ps=0.92u
    I_MXI1_I132_I37_MP2 (VDD I1_I132_pn0 XI1_I132_I37_p1 VDD) gpdk090_pmos1v w=0.48u l=0.1u ad=0.1056p as=0.1056p pd=0.92u ps=0.92u
    I_MXI1_I132_I37_MP3 (XI1_I132_I37_p1 XI1_I132_I37_Bn VDD VDD) gpdk090_pmos1v w=0.48u l=0.1u ad=0.1632p as=0.1056p pd=1.64u ps=0.92u
    I_MXI1_I132_I37_MP0 (VDD I1_I132_pn0 XI1_I132_I37_An VDD) gpdk090_pmos1v w=0.24u l=0.1u ad=0.0816p as=0.0816p pd=1.16u ps=1.16u
    I_MXI1_I132_I38_MP1 (VDD I1_I132_G0_0 XI1_I132_I38_Bn VDD) gpdk090_pmos1v w=0.24u l=0.1u ad=0.0816p as=0.0816p pd=1.16u ps=1.16u
    I_MXI1_I132_I38_MP5 (I1_p7_1 I1_I132_G0_0 XI1_I132_I38_p1 VDD) gpdk090_pmos1v w=0.48u l=0.1u ad=0.1056p as=0.1632p pd=0.92u ps=1.64u
    I_MXI1_I132_I38_MP4 (XI1_I132_I38_p1 XI1_I132_I38_An I1_p7_1 VDD) gpdk090_pmos1v w=0.48u l=0.1u ad=0.1056p as=0.1056p pd=0.92u ps=0.92u
    I_MXI1_I132_I38_MP2 (VDD I1_I132_pn1 XI1_I132_I38_p1 VDD) gpdk090_pmos1v w=0.48u l=0.1u ad=0.1056p as=0.1056p pd=0.92u ps=0.92u
    I_MXI1_I132_I38_MP3 (XI1_I132_I38_p1 XI1_I132_I38_Bn VDD VDD) gpdk090_pmos1v w=0.48u l=0.1u ad=0.1632p as=0.1056p pd=1.64u ps=0.92u
    I_MXI1_I132_I38_MP0 (VDD I1_I132_pn1 XI1_I132_I38_An VDD) gpdk090_pmos1v w=0.24u l=0.1u ad=0.0816p as=0.0816p pd=1.16u ps=1.16u
    I_MXI1_I132_I8_MP1 (VDD I1_b7_0 XI1_I132_I8_Bn VDD) gpdk090_pmos1v w=0.24u l=0.1u ad=0.0816p as=0.0816p pd=1.16u ps=1.16u
    I_MXI1_I132_I8_MP5 (I1_I132_pn0 I1_b7_0 XI1_I132_I8_p1 VDD) gpdk090_pmos1v w=0.48u l=0.1u ad=0.1056p as=0.1632p pd=0.92u ps=1.64u
    I_MXI1_I132_I8_MP4 (XI1_I132_I8_p1 XI1_I132_I8_An I1_I132_pn0 VDD) gpdk090_pmos1v w=0.48u l=0.1u ad=0.1056p as=0.1056p pd=0.92u ps=0.92u
    I_MXI1_I132_I8_MP2 (VDD A_0 XI1_I132_I8_p1 VDD) gpdk090_pmos1v w=0.48u l=0.1u ad=0.1056p as=0.1056p pd=0.92u ps=0.92u
    I_MXI1_I132_I8_MP3 (XI1_I132_I8_p1 XI1_I132_I8_Bn VDD VDD) gpdk090_pmos1v w=0.48u l=0.1u ad=0.1632p as=0.1056p pd=1.64u ps=0.92u
    I_MXI1_I132_I8_MP0 (VDD A_0 XI1_I132_I8_An VDD) gpdk090_pmos1v w=0.24u l=0.1u ad=0.0816p as=0.0816p pd=1.16u ps=1.16u
    I_MXI1_I39_MP1 (VDD I1_nbkn7 XI1_I39_Bn VDD) gpdk090_pmos1v w=0.24u l=0.1u ad=0.0816p as=0.0816p pd=1.16u ps=1.16u
    I_MXI1_I39_MP5 (I1_dd7 I1_nbkn7 XI1_I39_p1 VDD) gpdk090_pmos1v w=0.48u l=0.1u ad=0.1056p as=0.1632p pd=0.92u ps=1.64u
    I_MXI1_I39_MP4 (XI1_I39_p1 XI1_I39_An I1_dd7 VDD) gpdk090_pmos1v w=0.48u l=0.1u ad=0.1056p as=0.1056p pd=0.92u ps=0.92u
    I_MXI1_I39_MP2 (VDD B_7 XI1_I39_p1 VDD) gpdk090_pmos1v w=0.48u l=0.1u ad=0.1056p as=0.1056p pd=0.92u ps=0.92u
    I_MXI1_I39_MP3 (XI1_I39_p1 XI1_I39_Bn VDD VDD) gpdk090_pmos1v w=0.48u l=0.1u ad=0.1632p as=0.1056p pd=1.64u ps=0.92u
    I_MXI1_I39_MP0 (VDD B_7 XI1_I39_An VDD) gpdk090_pmos1v w=0.24u l=0.1u ad=0.0816p as=0.0816p pd=1.16u ps=1.16u
    I_MXI2_I1_I8_I11_MP1 (VDD I2_I1_bx3 XI2_I1_I8_I11_Bn VDD) gpdk090_pmos1v w=0.24u l=0.1u ad=0.0816p as=0.0816p pd=1.16u ps=1.16u
    I_MXI2_I1_I8_I11_MP5 (I2_I1_I8_pn3 I2_I1_bx3 XI2_I1_I8_I11_p1 VDD) gpdk090_pmos1v w=0.48u l=0.1u ad=0.1056p as=0.1632p pd=0.92u ps=1.64u
    I_MXI2_I1_I8_I11_MP4 (XI2_I1_I8_I11_p1 XI2_I1_I8_I11_An I2_I1_I8_pn3 VDD) gpdk090_pmos1v w=0.48u l=0.1u ad=0.1056p as=0.1056p pd=0.92u ps=0.92u
    I_MXI2_I1_I8_I11_MP2 (VDD A_3 XI2_I1_I8_I11_p1 VDD) gpdk090_pmos1v w=0.48u l=0.1u ad=0.1056p as=0.1056p pd=0.92u ps=0.92u
    I_MXI2_I1_I8_I11_MP3 (XI2_I1_I8_I11_p1 XI2_I1_I8_I11_Bn VDD VDD) gpdk090_pmos1v w=0.48u l=0.1u ad=0.1632p as=0.1056p pd=1.64u ps=0.92u
    I_MXI2_I1_I8_I11_MP0 (VDD A_3 XI2_I1_I8_I11_An VDD) gpdk090_pmos1v w=0.24u l=0.1u ad=0.0816p as=0.0816p pd=1.16u ps=1.16u
    I_MXI2_I1_I8_I12_MP1 (VDD I2_I1_bx4 XI2_I1_I8_I12_Bn VDD) gpdk090_pmos1v w=0.24u l=0.1u ad=0.0816p as=0.0816p pd=1.16u ps=1.16u
    I_MXI2_I1_I8_I12_MP5 (I2_I1_I8_pn4 I2_I1_bx4 XI2_I1_I8_I12_p1 VDD) gpdk090_pmos1v w=0.48u l=0.1u ad=0.1056p as=0.1632p pd=0.92u ps=1.64u
    I_MXI2_I1_I8_I12_MP4 (XI2_I1_I8_I12_p1 XI2_I1_I8_I12_An I2_I1_I8_pn4 VDD) gpdk090_pmos1v w=0.48u l=0.1u ad=0.1056p as=0.1056p pd=0.92u ps=0.92u
    I_MXI2_I1_I8_I12_MP2 (VDD A_4 XI2_I1_I8_I12_p1 VDD) gpdk090_pmos1v w=0.48u l=0.1u ad=0.1056p as=0.1056p pd=0.92u ps=0.92u
    I_MXI2_I1_I8_I12_MP3 (XI2_I1_I8_I12_p1 XI2_I1_I8_I12_Bn VDD VDD) gpdk090_pmos1v w=0.48u l=0.1u ad=0.1632p as=0.1056p pd=1.64u ps=0.92u
    I_MXI2_I1_I8_I12_MP0 (VDD A_4 XI2_I1_I8_I12_An VDD) gpdk090_pmos1v w=0.24u l=0.1u ad=0.0816p as=0.0816p pd=1.16u ps=1.16u
    I_MXI1_I132_I15_MP1 (VDD I1_b7_7 XI1_I132_I15_Bn VDD) gpdk090_pmos1v w=0.24u l=0.1u ad=0.0816p as=0.0816p pd=1.16u ps=1.16u
    I_MXI1_I132_I15_MP5 (I1_I132_pn7 I1_b7_7 XI1_I132_I15_p1 VDD) gpdk090_pmos1v w=0.48u l=0.1u ad=0.1056p as=0.1632p pd=0.92u ps=1.64u
    I_MXI1_I132_I15_MP4 (XI1_I132_I15_p1 XI1_I132_I15_An I1_I132_pn7 VDD) gpdk090_pmos1v w=0.48u l=0.1u ad=0.1056p as=0.1056p pd=0.92u ps=0.92u
    I_MXI1_I132_I15_MP2 (VDD I1_p6_6 XI1_I132_I15_p1 VDD) gpdk090_pmos1v w=0.48u l=0.1u ad=0.1056p as=0.1056p pd=0.92u ps=0.92u
    I_MXI1_I132_I15_MP3 (XI1_I132_I15_p1 XI1_I132_I15_Bn VDD VDD) gpdk090_pmos1v w=0.48u l=0.1u ad=0.1632p as=0.1056p pd=1.64u ps=0.92u
    I_MXI1_I132_I15_MP0 (VDD I1_p6_6 XI1_I132_I15_An VDD) gpdk090_pmos1v w=0.24u l=0.1u ad=0.0816p as=0.0816p pd=1.16u ps=1.16u
    I_MXI1_I132_I14_MP1 (VDD I1_b7_6 XI1_I132_I14_Bn VDD) gpdk090_pmos1v w=0.24u l=0.1u ad=0.0816p as=0.0816p pd=1.16u ps=1.16u
    I_MXI1_I132_I14_MP5 (I1_I132_pn6 I1_b7_6 XI1_I132_I14_p1 VDD) gpdk090_pmos1v w=0.48u l=0.1u ad=0.1056p as=0.1632p pd=0.92u ps=1.64u
    I_MXI1_I132_I14_MP4 (XI1_I132_I14_p1 XI1_I132_I14_An I1_I132_pn6 VDD) gpdk090_pmos1v w=0.48u l=0.1u ad=0.1056p as=0.1056p pd=0.92u ps=0.92u
    I_MXI1_I132_I14_MP2 (VDD I1_p6_5 XI1_I132_I14_p1 VDD) gpdk090_pmos1v w=0.48u l=0.1u ad=0.1056p as=0.1056p pd=0.92u ps=0.92u
    I_MXI1_I132_I14_MP3 (XI1_I132_I14_p1 XI1_I132_I14_Bn VDD VDD) gpdk090_pmos1v w=0.48u l=0.1u ad=0.1632p as=0.1056p pd=1.64u ps=0.92u
    I_MXI1_I132_I14_MP0 (VDD I1_p6_5 XI1_I132_I14_An VDD) gpdk090_pmos1v w=0.24u l=0.1u ad=0.0816p as=0.0816p pd=1.16u ps=1.16u
    I_MXI1_I132_I12_MP1 (VDD I1_b7_4 XI1_I132_I12_Bn VDD) gpdk090_pmos1v w=0.24u l=0.1u ad=0.0816p as=0.0816p pd=1.16u ps=1.16u
    I_MXI1_I132_I12_MP5 (I1_I132_pn4 I1_b7_4 XI1_I132_I12_p1 VDD) gpdk090_pmos1v w=0.48u l=0.1u ad=0.1056p as=0.1632p pd=0.92u ps=1.64u
    I_MXI1_I132_I12_MP4 (XI1_I132_I12_p1 XI1_I132_I12_An I1_I132_pn4 VDD) gpdk090_pmos1v w=0.48u l=0.1u ad=0.1056p as=0.1056p pd=0.92u ps=0.92u
    I_MXI1_I132_I12_MP2 (VDD I1_p6_3 XI1_I132_I12_p1 VDD) gpdk090_pmos1v w=0.48u l=0.1u ad=0.1056p as=0.1056p pd=0.92u ps=0.92u
    I_MXI1_I132_I12_MP3 (XI1_I132_I12_p1 XI1_I132_I12_Bn VDD VDD) gpdk090_pmos1v w=0.48u l=0.1u ad=0.1632p as=0.1056p pd=1.64u ps=0.92u
    I_MXI1_I132_I12_MP0 (VDD I1_p6_3 XI1_I132_I12_An VDD) gpdk090_pmos1v w=0.24u l=0.1u ad=0.0816p as=0.0816p pd=1.16u ps=1.16u
    I_MXI1_I132_I11_MP1 (VDD I1_b7_3 XI1_I132_I11_Bn VDD) gpdk090_pmos1v w=0.24u l=0.1u ad=0.0816p as=0.0816p pd=1.16u ps=1.16u
    I_MXI1_I132_I11_MP5 (I1_I132_pn3 I1_b7_3 XI1_I132_I11_p1 VDD) gpdk090_pmos1v w=0.48u l=0.1u ad=0.1056p as=0.1632p pd=0.92u ps=1.64u
    I_MXI1_I132_I11_MP4 (XI1_I132_I11_p1 XI1_I132_I11_An I1_I132_pn3 VDD) gpdk090_pmos1v w=0.48u l=0.1u ad=0.1056p as=0.1056p pd=0.92u ps=0.92u
    I_MXI1_I132_I11_MP2 (VDD I1_p6_2 XI1_I132_I11_p1 VDD) gpdk090_pmos1v w=0.48u l=0.1u ad=0.1056p as=0.1056p pd=0.92u ps=0.92u
    I_MXI1_I132_I11_MP3 (XI1_I132_I11_p1 XI1_I132_I11_Bn VDD VDD) gpdk090_pmos1v w=0.48u l=0.1u ad=0.1632p as=0.1056p pd=1.64u ps=0.92u
    I_MXI1_I132_I11_MP0 (VDD I1_p6_2 XI1_I132_I11_An VDD) gpdk090_pmos1v w=0.24u l=0.1u ad=0.0816p as=0.0816p pd=1.16u ps=1.16u
    I_MXI1_I132_I10_MP1 (VDD I1_b7_2 XI1_I132_I10_Bn VDD) gpdk090_pmos1v w=0.24u l=0.1u ad=0.0816p as=0.0816p pd=1.16u ps=1.16u
    I_MXI1_I132_I10_MP5 (I1_I132_pn2 I1_b7_2 XI1_I132_I10_p1 VDD) gpdk090_pmos1v w=0.48u l=0.1u ad=0.1056p as=0.1632p pd=0.92u ps=1.64u
    I_MXI1_I132_I10_MP4 (XI1_I132_I10_p1 XI1_I132_I10_An I1_I132_pn2 VDD) gpdk090_pmos1v w=0.48u l=0.1u ad=0.1056p as=0.1056p pd=0.92u ps=0.92u
    I_MXI1_I132_I10_MP2 (VDD I1_p6_1 XI1_I132_I10_p1 VDD) gpdk090_pmos1v w=0.48u l=0.1u ad=0.1056p as=0.1056p pd=0.92u ps=0.92u
    I_MXI1_I132_I10_MP3 (XI1_I132_I10_p1 XI1_I132_I10_Bn VDD VDD) gpdk090_pmos1v w=0.48u l=0.1u ad=0.1632p as=0.1056p pd=1.64u ps=0.92u
    I_MXI1_I132_I10_MP0 (VDD I1_p6_1 XI1_I132_I10_An VDD) gpdk090_pmos1v w=0.24u l=0.1u ad=0.0816p as=0.0816p pd=1.16u ps=1.16u
    I_MXI1_I36_MP1 (VDD I1_nbkn6 XI1_I36_Bn VDD) gpdk090_pmos1v w=0.24u l=0.1u ad=0.0816p as=0.0816p pd=1.16u ps=1.16u
    I_MXI1_I36_MP5 (I1_dd6 I1_nbkn6 XI1_I36_p1 VDD) gpdk090_pmos1v w=0.48u l=0.1u ad=0.1056p as=0.1632p pd=0.92u ps=1.64u
    I_MXI1_I36_MP4 (XI1_I36_p1 XI1_I36_An I1_dd6 VDD) gpdk090_pmos1v w=0.48u l=0.1u ad=0.1056p as=0.1056p pd=0.92u ps=0.92u
    I_MXI1_I36_MP2 (VDD B_6 XI1_I36_p1 VDD) gpdk090_pmos1v w=0.48u l=0.1u ad=0.1056p as=0.1056p pd=0.92u ps=0.92u
    I_MXI1_I36_MP3 (XI1_I36_p1 XI1_I36_Bn VDD VDD) gpdk090_pmos1v w=0.48u l=0.1u ad=0.1632p as=0.1056p pd=1.64u ps=0.92u
    I_MXI1_I36_MP0 (VDD B_6 XI1_I36_An VDD) gpdk090_pmos1v w=0.24u l=0.1u ad=0.0816p as=0.0816p pd=1.16u ps=1.16u
    I_MXI2_I1_I8_I42_MP1 (VDD I2_I1_I8_G4_0 XI2_I1_I8_I42_Bn VDD) gpdk090_pmos1v w=0.24u l=0.1u ad=0.0816p as=0.0816p pd=1.16u ps=1.16u
    I_MXI2_I1_I8_I42_MP5 (I2_S_5 I2_I1_I8_G4_0 XI2_I1_I8_I42_p1 VDD) gpdk090_pmos1v w=0.48u l=0.1u ad=0.1056p as=0.1632p pd=0.92u ps=1.64u
    I_MXI2_I1_I8_I42_MP4 (XI2_I1_I8_I42_p1 XI2_I1_I8_I42_An I2_S_5 VDD) gpdk090_pmos1v w=0.48u l=0.1u ad=0.1056p as=0.1056p pd=0.92u ps=0.92u
    I_MXI2_I1_I8_I42_MP2 (VDD I2_I1_I8_pn5 XI2_I1_I8_I42_p1 VDD) gpdk090_pmos1v w=0.48u l=0.1u ad=0.1056p as=0.1056p pd=0.92u ps=0.92u
    I_MXI2_I1_I8_I42_MP3 (XI2_I1_I8_I42_p1 XI2_I1_I8_I42_Bn VDD VDD) gpdk090_pmos1v w=0.48u l=0.1u ad=0.1632p as=0.1056p pd=1.64u ps=0.92u
    I_MXI2_I1_I8_I42_MP0 (VDD I2_I1_I8_pn5 XI2_I1_I8_I42_An VDD) gpdk090_pmos1v w=0.24u l=0.1u ad=0.0816p as=0.0816p pd=1.16u ps=1.16u
    I_MXI1_I120_I44_MP1 (VDD I1_c6_7 XI1_I120_I44_Bn VDD) gpdk090_pmos1v w=0.24u l=0.1u ad=0.0816p as=0.0816p pd=1.16u ps=1.16u
    I_MXI1_I120_I44_MP5 (I1_p6_7 I1_c6_7 XI1_I120_I44_p1 VDD) gpdk090_pmos1v w=0.48u l=0.1u ad=0.1056p as=0.1632p pd=0.92u ps=1.64u
    I_MXI1_I120_I44_MP4 (XI1_I120_I44_p1 XI1_I120_I44_An I1_p6_7 VDD) gpdk090_pmos1v w=0.48u l=0.1u ad=0.1056p as=0.1056p pd=0.92u ps=0.92u
    I_MXI1_I120_I44_MP2 (VDD I1_I120_pn7 XI1_I120_I44_p1 VDD) gpdk090_pmos1v w=0.48u l=0.1u ad=0.1056p as=0.1056p pd=0.92u ps=0.92u
    I_MXI1_I120_I44_MP3 (XI1_I120_I44_p1 XI1_I120_I44_Bn VDD VDD) gpdk090_pmos1v w=0.48u l=0.1u ad=0.1632p as=0.1056p pd=1.64u ps=0.92u
    I_MXI1_I120_I44_MP0 (VDD I1_I120_pn7 XI1_I120_I44_An VDD) gpdk090_pmos1v w=0.24u l=0.1u ad=0.0816p as=0.0816p pd=1.16u ps=1.16u
    I_MXI1_I120_I42_MP1 (VDD I1_I120_G4_0 XI1_I120_I42_Bn VDD) gpdk090_pmos1v w=0.24u l=0.1u ad=0.0816p as=0.0816p pd=1.16u ps=1.16u
    I_MXI1_I120_I42_MP5 (I1_p6_5 I1_I120_G4_0 XI1_I120_I42_p1 VDD) gpdk090_pmos1v w=0.48u l=0.1u ad=0.1056p as=0.1632p pd=0.92u ps=1.64u
    I_MXI1_I120_I42_MP4 (XI1_I120_I42_p1 XI1_I120_I42_An I1_p6_5 VDD) gpdk090_pmos1v w=0.48u l=0.1u ad=0.1056p as=0.1056p pd=0.92u ps=0.92u
    I_MXI1_I120_I42_MP2 (VDD I1_I120_pn5 XI1_I120_I42_p1 VDD) gpdk090_pmos1v w=0.48u l=0.1u ad=0.1056p as=0.1056p pd=0.92u ps=0.92u
    I_MXI1_I120_I42_MP3 (XI1_I120_I42_p1 XI1_I120_I42_Bn VDD VDD) gpdk090_pmos1v w=0.48u l=0.1u ad=0.1632p as=0.1056p pd=1.64u ps=0.92u
    I_MXI1_I120_I42_MP0 (VDD I1_I120_pn5 XI1_I120_I42_An VDD) gpdk090_pmos1v w=0.24u l=0.1u ad=0.0816p as=0.0816p pd=1.16u ps=1.16u
    I_MXI1_I132_I13_MP1 (VDD I1_b7_5 XI1_I132_I13_Bn VDD) gpdk090_pmos1v w=0.24u l=0.1u ad=0.0816p as=0.0816p pd=1.16u ps=1.16u
    I_MXI1_I132_I13_MP5 (I1_I132_pn5 I1_b7_5 XI1_I132_I13_p1 VDD) gpdk090_pmos1v w=0.48u l=0.1u ad=0.1056p as=0.1632p pd=0.92u ps=1.64u
    I_MXI1_I132_I13_MP4 (XI1_I132_I13_p1 XI1_I132_I13_An I1_I132_pn5 VDD) gpdk090_pmos1v w=0.48u l=0.1u ad=0.1056p as=0.1056p pd=0.92u ps=0.92u
    I_MXI1_I132_I13_MP2 (VDD I1_p6_4 XI1_I132_I13_p1 VDD) gpdk090_pmos1v w=0.48u l=0.1u ad=0.1056p as=0.1056p pd=0.92u ps=0.92u
    I_MXI1_I132_I13_MP3 (XI1_I132_I13_p1 XI1_I132_I13_Bn VDD VDD) gpdk090_pmos1v w=0.48u l=0.1u ad=0.1632p as=0.1056p pd=1.64u ps=0.92u
    I_MXI1_I132_I13_MP0 (VDD I1_p6_4 XI1_I132_I13_An VDD) gpdk090_pmos1v w=0.24u l=0.1u ad=0.0816p as=0.0816p pd=1.16u ps=1.16u
    I_MXI1_I120_I39_MP1 (VDD I1_I120_G1_0 XI1_I120_I39_Bn VDD) gpdk090_pmos1v w=0.24u l=0.1u ad=0.0816p as=0.0816p pd=1.16u ps=1.16u
    I_MXI1_I120_I39_MP5 (I1_p6_2 I1_I120_G1_0 XI1_I120_I39_p1 VDD) gpdk090_pmos1v w=0.48u l=0.1u ad=0.1056p as=0.1632p pd=0.92u ps=1.64u
    I_MXI1_I120_I39_MP4 (XI1_I120_I39_p1 XI1_I120_I39_An I1_p6_2 VDD) gpdk090_pmos1v w=0.48u l=0.1u ad=0.1056p as=0.1056p pd=0.92u ps=0.92u
    I_MXI1_I120_I39_MP2 (VDD I1_I120_pn2 XI1_I120_I39_p1 VDD) gpdk090_pmos1v w=0.48u l=0.1u ad=0.1056p as=0.1056p pd=0.92u ps=0.92u
    I_MXI1_I120_I39_MP3 (XI1_I120_I39_p1 XI1_I120_I39_Bn VDD VDD) gpdk090_pmos1v w=0.48u l=0.1u ad=0.1632p as=0.1056p pd=1.64u ps=0.92u
    I_MXI1_I120_I39_MP0 (VDD I1_I120_pn2 XI1_I120_I39_An VDD) gpdk090_pmos1v w=0.24u l=0.1u ad=0.0816p as=0.0816p pd=1.16u ps=1.16u
    I_MXI1_I120_I37_MP1 (VDD I1_qu2 XI1_I120_I37_Bn VDD) gpdk090_pmos1v w=0.24u l=0.1u ad=0.0816p as=0.0816p pd=1.16u ps=1.16u
    I_MXI1_I120_I37_MP5 (I1_p6_0 I1_qu2 XI1_I120_I37_p1 VDD) gpdk090_pmos1v w=0.48u l=0.1u ad=0.1056p as=0.1632p pd=0.92u ps=1.64u
    I_MXI1_I120_I37_MP4 (XI1_I120_I37_p1 XI1_I120_I37_An I1_p6_0 VDD) gpdk090_pmos1v w=0.48u l=0.1u ad=0.1056p as=0.1056p pd=0.92u ps=0.92u
    I_MXI1_I120_I37_MP2 (VDD I1_I120_pn0 XI1_I120_I37_p1 VDD) gpdk090_pmos1v w=0.48u l=0.1u ad=0.1056p as=0.1056p pd=0.92u ps=0.92u
    I_MXI1_I120_I37_MP3 (XI1_I120_I37_p1 XI1_I120_I37_Bn VDD VDD) gpdk090_pmos1v w=0.48u l=0.1u ad=0.1632p as=0.1056p pd=1.64u ps=0.92u
    I_MXI1_I120_I37_MP0 (VDD I1_I120_pn0 XI1_I120_I37_An VDD) gpdk090_pmos1v w=0.24u l=0.1u ad=0.0816p as=0.0816p pd=1.16u ps=1.16u
    I_MXI1_I33_MP1 (VDD I1_nbkn5 XI1_I33_Bn VDD) gpdk090_pmos1v w=0.24u l=0.1u ad=0.0816p as=0.0816p pd=1.16u ps=1.16u
    I_MXI1_I33_MP5 (I1_dd5 I1_nbkn5 XI1_I33_p1 VDD) gpdk090_pmos1v w=0.48u l=0.1u ad=0.1056p as=0.1632p pd=0.92u ps=1.64u
    I_MXI1_I33_MP4 (XI1_I33_p1 XI1_I33_An I1_dd5 VDD) gpdk090_pmos1v w=0.48u l=0.1u ad=0.1056p as=0.1056p pd=0.92u ps=0.92u
    I_MXI1_I33_MP2 (VDD B_5 XI1_I33_p1 VDD) gpdk090_pmos1v w=0.48u l=0.1u ad=0.1056p as=0.1056p pd=0.92u ps=0.92u
    I_MXI1_I33_MP3 (XI1_I33_p1 XI1_I33_Bn VDD VDD) gpdk090_pmos1v w=0.48u l=0.1u ad=0.1632p as=0.1056p pd=1.64u ps=0.92u
    I_MXI1_I33_MP0 (VDD B_5 XI1_I33_An VDD) gpdk090_pmos1v w=0.24u l=0.1u ad=0.0816p as=0.0816p pd=1.16u ps=1.16u
    I_MXI2_I1_I8_I9_MP1 (VDD I2_I1_bx1 XI2_I1_I8_I9_Bn VDD) gpdk090_pmos1v w=0.24u l=0.1u ad=0.0816p as=0.0816p pd=1.16u ps=1.16u
    I_MXI2_I1_I8_I9_MP5 (I2_I1_I8_pn1 I2_I1_bx1 XI2_I1_I8_I9_p1 VDD) gpdk090_pmos1v w=0.48u l=0.1u ad=0.1056p as=0.1632p pd=0.92u ps=1.64u
    I_MXI2_I1_I8_I9_MP4 (XI2_I1_I8_I9_p1 XI2_I1_I8_I9_An I2_I1_I8_pn1 VDD) gpdk090_pmos1v w=0.48u l=0.1u ad=0.1056p as=0.1056p pd=0.92u ps=0.92u
    I_MXI2_I1_I8_I9_MP2 (VDD A_1 XI2_I1_I8_I9_p1 VDD) gpdk090_pmos1v w=0.48u l=0.1u ad=0.1056p as=0.1056p pd=0.92u ps=0.92u
    I_MXI2_I1_I8_I9_MP3 (XI2_I1_I8_I9_p1 XI2_I1_I8_I9_Bn VDD VDD) gpdk090_pmos1v w=0.48u l=0.1u ad=0.1632p as=0.1056p pd=1.64u ps=0.92u
    I_MXI2_I1_I8_I9_MP0 (VDD A_1 XI2_I1_I8_I9_An VDD) gpdk090_pmos1v w=0.24u l=0.1u ad=0.0816p as=0.0816p pd=1.16u ps=1.16u
    I_MXI2_I1_I8_I10_MP1 (VDD I2_I1_bx2 XI2_I1_I8_I10_Bn VDD) gpdk090_pmos1v w=0.24u l=0.1u ad=0.0816p as=0.0816p pd=1.16u ps=1.16u
    I_MXI2_I1_I8_I10_MP5 (I2_I1_I8_pn2 I2_I1_bx2 XI2_I1_I8_I10_p1 VDD) gpdk090_pmos1v w=0.48u l=0.1u ad=0.1056p as=0.1632p pd=0.92u ps=1.64u
    I_MXI2_I1_I8_I10_MP4 (XI2_I1_I8_I10_p1 XI2_I1_I8_I10_An I2_I1_I8_pn2 VDD) gpdk090_pmos1v w=0.48u l=0.1u ad=0.1056p as=0.1056p pd=0.92u ps=0.92u
    I_MXI2_I1_I8_I10_MP2 (VDD A_2 XI2_I1_I8_I10_p1 VDD) gpdk090_pmos1v w=0.48u l=0.1u ad=0.1056p as=0.1056p pd=0.92u ps=0.92u
    I_MXI2_I1_I8_I10_MP3 (XI2_I1_I8_I10_p1 XI2_I1_I8_I10_Bn VDD VDD) gpdk090_pmos1v w=0.48u l=0.1u ad=0.1632p as=0.1056p pd=1.64u ps=0.92u
    I_MXI2_I1_I8_I10_MP0 (VDD A_2 XI2_I1_I8_I10_An VDD) gpdk090_pmos1v w=0.24u l=0.1u ad=0.0816p as=0.0816p pd=1.16u ps=1.16u
    I_MXI1_I120_I43_MP1 (VDD I1_I120_G5_0 XI1_I120_I43_Bn VDD) gpdk090_pmos1v w=0.24u l=0.1u ad=0.0816p as=0.0816p pd=1.16u ps=1.16u
    I_MXI1_I120_I43_MP5 (I1_p6_6 I1_I120_G5_0 XI1_I120_I43_p1 VDD) gpdk090_pmos1v w=0.48u l=0.1u ad=0.1056p as=0.1632p pd=0.92u ps=1.64u
    I_MXI1_I120_I43_MP4 (XI1_I120_I43_p1 XI1_I120_I43_An I1_p6_6 VDD) gpdk090_pmos1v w=0.48u l=0.1u ad=0.1056p as=0.1056p pd=0.92u ps=0.92u
    I_MXI1_I120_I43_MP2 (VDD I1_I120_pn6 XI1_I120_I43_p1 VDD) gpdk090_pmos1v w=0.48u l=0.1u ad=0.1056p as=0.1056p pd=0.92u ps=0.92u
    I_MXI1_I120_I43_MP3 (XI1_I120_I43_p1 XI1_I120_I43_Bn VDD VDD) gpdk090_pmos1v w=0.48u l=0.1u ad=0.1632p as=0.1056p pd=1.64u ps=0.92u
    I_MXI1_I120_I43_MP0 (VDD I1_I120_pn6 XI1_I120_I43_An VDD) gpdk090_pmos1v w=0.24u l=0.1u ad=0.0816p as=0.0816p pd=1.16u ps=1.16u
    I_MXI1_I120_I38_MP1 (VDD I1_I120_G0_0 XI1_I120_I38_Bn VDD) gpdk090_pmos1v w=0.24u l=0.1u ad=0.0816p as=0.0816p pd=1.16u ps=1.16u
    I_MXI1_I120_I38_MP5 (I1_p6_1 I1_I120_G0_0 XI1_I120_I38_p1 VDD) gpdk090_pmos1v w=0.48u l=0.1u ad=0.1056p as=0.1632p pd=0.92u ps=1.64u
    I_MXI1_I120_I38_MP4 (XI1_I120_I38_p1 XI1_I120_I38_An I1_p6_1 VDD) gpdk090_pmos1v w=0.48u l=0.1u ad=0.1056p as=0.1056p pd=0.92u ps=0.92u
    I_MXI1_I120_I38_MP2 (VDD I1_I120_pn1 XI1_I120_I38_p1 VDD) gpdk090_pmos1v w=0.48u l=0.1u ad=0.1056p as=0.1056p pd=0.92u ps=0.92u
    I_MXI1_I120_I38_MP3 (XI1_I120_I38_p1 XI1_I120_I38_Bn VDD VDD) gpdk090_pmos1v w=0.48u l=0.1u ad=0.1632p as=0.1056p pd=1.64u ps=0.92u
    I_MXI1_I120_I38_MP0 (VDD I1_I120_pn1 XI1_I120_I38_An VDD) gpdk090_pmos1v w=0.24u l=0.1u ad=0.0816p as=0.0816p pd=1.16u ps=1.16u
    I_MXI1_I120_I9_MP1 (VDD I1_b6_1 XI1_I120_I9_Bn VDD) gpdk090_pmos1v w=0.24u l=0.1u ad=0.0816p as=0.0816p pd=1.16u ps=1.16u
    I_MXI1_I120_I9_MP5 (I1_I120_pn1 I1_b6_1 XI1_I120_I9_p1 VDD) gpdk090_pmos1v w=0.48u l=0.1u ad=0.1056p as=0.1632p pd=0.92u ps=1.64u
    I_MXI1_I120_I9_MP4 (XI1_I120_I9_p1 XI1_I120_I9_An I1_I120_pn1 VDD) gpdk090_pmos1v w=0.48u l=0.1u ad=0.1056p as=0.1056p pd=0.92u ps=0.92u
    I_MXI1_I120_I9_MP2 (VDD I1_p5_0 XI1_I120_I9_p1 VDD) gpdk090_pmos1v w=0.48u l=0.1u ad=0.1056p as=0.1056p pd=0.92u ps=0.92u
    I_MXI1_I120_I9_MP3 (XI1_I120_I9_p1 XI1_I120_I9_Bn VDD VDD) gpdk090_pmos1v w=0.48u l=0.1u ad=0.1632p as=0.1056p pd=1.64u ps=0.92u
    I_MXI1_I120_I9_MP0 (VDD I1_p5_0 XI1_I120_I9_An VDD) gpdk090_pmos1v w=0.24u l=0.1u ad=0.0816p as=0.0816p pd=1.16u ps=1.16u
    I_MXI1_I155_MP1 (VDD I1_nqkn1 XI1_I155_Bn VDD) gpdk090_pmos1v w=0.24u l=0.1u ad=0.0816p as=0.0816p pd=1.16u ps=1.16u
    I_MXI1_I155_MP5 (DIVQ_1 I1_nqkn1 XI1_I155_p1 VDD) gpdk090_pmos1v w=0.48u l=0.1u ad=0.1056p as=0.1632p pd=0.92u ps=1.64u
    I_MXI1_I155_MP4 (XI1_I155_p1 XI1_I155_An DIVQ_1 VDD) gpdk090_pmos1v w=0.48u l=0.1u ad=0.1056p as=0.1056p pd=0.92u ps=0.92u
    I_MXI1_I155_MP2 (VDD I1_qu1 XI1_I155_p1 VDD) gpdk090_pmos1v w=0.48u l=0.1u ad=0.1056p as=0.1056p pd=0.92u ps=0.92u
    I_MXI1_I155_MP3 (XI1_I155_p1 XI1_I155_Bn VDD VDD) gpdk090_pmos1v w=0.48u l=0.1u ad=0.1632p as=0.1056p pd=1.64u ps=0.92u
    I_MXI1_I155_MP0 (VDD I1_qu1 XI1_I155_An VDD) gpdk090_pmos1v w=0.24u l=0.1u ad=0.0816p as=0.0816p pd=1.16u ps=1.16u
    I_MXI1_I158_MP1 (VDD I1_nqkn2 XI1_I158_Bn VDD) gpdk090_pmos1v w=0.24u l=0.1u ad=0.0816p as=0.0816p pd=1.16u ps=1.16u
    I_MXI1_I158_MP5 (DIVQ_2 I1_nqkn2 XI1_I158_p1 VDD) gpdk090_pmos1v w=0.48u l=0.1u ad=0.1056p as=0.1632p pd=0.92u ps=1.64u
    I_MXI1_I158_MP4 (XI1_I158_p1 XI1_I158_An DIVQ_2 VDD) gpdk090_pmos1v w=0.48u l=0.1u ad=0.1056p as=0.1056p pd=0.92u ps=0.92u
    I_MXI1_I158_MP2 (VDD I1_qu2 XI1_I158_p1 VDD) gpdk090_pmos1v w=0.48u l=0.1u ad=0.1056p as=0.1056p pd=0.92u ps=0.92u
    I_MXI1_I158_MP3 (XI1_I158_p1 XI1_I158_Bn VDD VDD) gpdk090_pmos1v w=0.48u l=0.1u ad=0.1632p as=0.1056p pd=1.64u ps=0.92u
    I_MXI1_I158_MP0 (VDD I1_qu2 XI1_I158_An VDD) gpdk090_pmos1v w=0.24u l=0.1u ad=0.0816p as=0.0816p pd=1.16u ps=1.16u
    I_MXI2_I1_I8_I38_MP1 (VDD I2_I1_I8_G0_0 XI2_I1_I8_I38_Bn VDD) gpdk090_pmos1v w=0.24u l=0.1u ad=0.0816p as=0.0816p pd=1.16u ps=1.16u
    I_MXI2_I1_I8_I38_MP5 (I2_S_1 I2_I1_I8_G0_0 XI2_I1_I8_I38_p1 VDD) gpdk090_pmos1v w=0.48u l=0.1u ad=0.1056p as=0.1632p pd=0.92u ps=1.64u
    I_MXI2_I1_I8_I38_MP4 (XI2_I1_I8_I38_p1 XI2_I1_I8_I38_An I2_S_1 VDD) gpdk090_pmos1v w=0.48u l=0.1u ad=0.1056p as=0.1056p pd=0.92u ps=0.92u
    I_MXI2_I1_I8_I38_MP2 (VDD I2_I1_I8_pn1 XI2_I1_I8_I38_p1 VDD) gpdk090_pmos1v w=0.48u l=0.1u ad=0.1056p as=0.1056p pd=0.92u ps=0.92u
    I_MXI2_I1_I8_I38_MP3 (XI2_I1_I8_I38_p1 XI2_I1_I8_I38_Bn VDD VDD) gpdk090_pmos1v w=0.48u l=0.1u ad=0.1632p as=0.1056p pd=1.64u ps=0.92u
    I_MXI2_I1_I8_I38_MP0 (VDD I2_I1_I8_pn1 XI2_I1_I8_I38_An VDD) gpdk090_pmos1v w=0.24u l=0.1u ad=0.0816p as=0.0816p pd=1.16u ps=1.16u
    I_MXI2_I1_I8_I8_MP1 (VDD I2_I1_bx0 XI2_I1_I8_I8_Bn VDD) gpdk090_pmos1v w=0.24u l=0.1u ad=0.0816p as=0.0816p pd=1.16u ps=1.16u
    I_MXI2_I1_I8_I8_MP5 (I2_I1_I8_pn0 I2_I1_bx0 XI2_I1_I8_I8_p1 VDD) gpdk090_pmos1v w=0.48u l=0.1u ad=0.1056p as=0.1632p pd=0.92u ps=1.64u
    I_MXI2_I1_I8_I8_MP4 (XI2_I1_I8_I8_p1 XI2_I1_I8_I8_An I2_I1_I8_pn0 VDD) gpdk090_pmos1v w=0.48u l=0.1u ad=0.1056p as=0.1056p pd=0.92u ps=0.92u
    I_MXI2_I1_I8_I8_MP2 (VDD A_0 XI2_I1_I8_I8_p1 VDD) gpdk090_pmos1v w=0.48u l=0.1u ad=0.1056p as=0.1056p pd=0.92u ps=0.92u
    I_MXI2_I1_I8_I8_MP3 (XI2_I1_I8_I8_p1 XI2_I1_I8_I8_Bn VDD VDD) gpdk090_pmos1v w=0.48u l=0.1u ad=0.1632p as=0.1056p pd=1.64u ps=0.92u
    I_MXI2_I1_I8_I8_MP0 (VDD A_0 XI2_I1_I8_I8_An VDD) gpdk090_pmos1v w=0.24u l=0.1u ad=0.0816p as=0.0816p pd=1.16u ps=1.16u
    I_MXI2_I1_I8_I37_MP1 (VDD OP_0 XI2_I1_I8_I37_Bn VDD) gpdk090_pmos1v w=0.24u l=0.1u ad=0.0816p as=0.0816p pd=1.16u ps=1.16u
    I_MXI2_I1_I8_I37_MP5 (I2_S_0 OP_0 XI2_I1_I8_I37_p1 VDD) gpdk090_pmos1v w=0.48u l=0.1u ad=0.1056p as=0.1632p pd=0.92u ps=1.64u
    I_MXI2_I1_I8_I37_MP4 (XI2_I1_I8_I37_p1 XI2_I1_I8_I37_An I2_S_0 VDD) gpdk090_pmos1v w=0.48u l=0.1u ad=0.1056p as=0.1056p pd=0.92u ps=0.92u
    I_MXI2_I1_I8_I37_MP2 (VDD I2_I1_I8_pn0 XI2_I1_I8_I37_p1 VDD) gpdk090_pmos1v w=0.48u l=0.1u ad=0.1056p as=0.1056p pd=0.92u ps=0.92u
    I_MXI2_I1_I8_I37_MP3 (XI2_I1_I8_I37_p1 XI2_I1_I8_I37_Bn VDD VDD) gpdk090_pmos1v w=0.48u l=0.1u ad=0.1632p as=0.1056p pd=1.64u ps=0.92u
    I_MXI2_I1_I8_I37_MP0 (VDD I2_I1_I8_pn0 XI2_I1_I8_I37_An VDD) gpdk090_pmos1v w=0.24u l=0.1u ad=0.0816p as=0.0816p pd=1.16u ps=1.16u
    I_MXI2_I1_I8_I39_MP1 (VDD I2_I1_I8_G1_0 XI2_I1_I8_I39_Bn VDD) gpdk090_pmos1v w=0.24u l=0.1u ad=0.0816p as=0.0816p pd=1.16u ps=1.16u
    I_MXI2_I1_I8_I39_MP5 (I2_S_2 I2_I1_I8_G1_0 XI2_I1_I8_I39_p1 VDD) gpdk090_pmos1v w=0.48u l=0.1u ad=0.1056p as=0.1632p pd=0.92u ps=1.64u
    I_MXI2_I1_I8_I39_MP4 (XI2_I1_I8_I39_p1 XI2_I1_I8_I39_An I2_S_2 VDD) gpdk090_pmos1v w=0.48u l=0.1u ad=0.1056p as=0.1056p pd=0.92u ps=0.92u
    I_MXI2_I1_I8_I39_MP2 (VDD I2_I1_I8_pn2 XI2_I1_I8_I39_p1 VDD) gpdk090_pmos1v w=0.48u l=0.1u ad=0.1056p as=0.1056p pd=0.92u ps=0.92u
    I_MXI2_I1_I8_I39_MP3 (XI2_I1_I8_I39_p1 XI2_I1_I8_I39_Bn VDD VDD) gpdk090_pmos1v w=0.48u l=0.1u ad=0.1632p as=0.1056p pd=1.64u ps=0.92u
    I_MXI2_I1_I8_I39_MP0 (VDD I2_I1_I8_pn2 XI2_I1_I8_I39_An VDD) gpdk090_pmos1v w=0.24u l=0.1u ad=0.0816p as=0.0816p pd=1.16u ps=1.16u
    I_MXI1_I120_I10_MP1 (VDD I1_b6_2 XI1_I120_I10_Bn VDD) gpdk090_pmos1v w=0.24u l=0.1u ad=0.0816p as=0.0816p pd=1.16u ps=1.16u
    I_MXI1_I120_I10_MP5 (I1_I120_pn2 I1_b6_2 XI1_I120_I10_p1 VDD) gpdk090_pmos1v w=0.48u l=0.1u ad=0.1056p as=0.1632p pd=0.92u ps=1.64u
    I_MXI1_I120_I10_MP4 (XI1_I120_I10_p1 XI1_I120_I10_An I1_I120_pn2 VDD) gpdk090_pmos1v w=0.48u l=0.1u ad=0.1056p as=0.1056p pd=0.92u ps=0.92u
    I_MXI1_I120_I10_MP2 (VDD I1_p5_1 XI1_I120_I10_p1 VDD) gpdk090_pmos1v w=0.48u l=0.1u ad=0.1056p as=0.1056p pd=0.92u ps=0.92u
    I_MXI1_I120_I10_MP3 (XI1_I120_I10_p1 XI1_I120_I10_Bn VDD VDD) gpdk090_pmos1v w=0.48u l=0.1u ad=0.1632p as=0.1056p pd=1.64u ps=0.92u
    I_MXI1_I120_I10_MP0 (VDD I1_p5_1 XI1_I120_I10_An VDD) gpdk090_pmos1v w=0.24u l=0.1u ad=0.0816p as=0.0816p pd=1.16u ps=1.16u
    I_MXI1_I120_I8_MP1 (VDD I1_b6_0 XI1_I120_I8_Bn VDD) gpdk090_pmos1v w=0.24u l=0.1u ad=0.0816p as=0.0816p pd=1.16u ps=1.16u
    I_MXI1_I120_I8_MP5 (I1_I120_pn0 I1_b6_0 XI1_I120_I8_p1 VDD) gpdk090_pmos1v w=0.48u l=0.1u ad=0.1056p as=0.1632p pd=0.92u ps=1.64u
    I_MXI1_I120_I8_MP4 (XI1_I120_I8_p1 XI1_I120_I8_An I1_I120_pn0 VDD) gpdk090_pmos1v w=0.48u l=0.1u ad=0.1056p as=0.1056p pd=0.92u ps=0.92u
    I_MXI1_I120_I8_MP2 (VDD I1_aa1 XI1_I120_I8_p1 VDD) gpdk090_pmos1v w=0.48u l=0.1u ad=0.1056p as=0.1056p pd=0.92u ps=0.92u
    I_MXI1_I120_I8_MP3 (XI1_I120_I8_p1 XI1_I120_I8_Bn VDD VDD) gpdk090_pmos1v w=0.48u l=0.1u ad=0.1632p as=0.1056p pd=1.64u ps=0.92u
    I_MXI1_I120_I8_MP0 (VDD I1_aa1 XI1_I120_I8_An VDD) gpdk090_pmos1v w=0.24u l=0.1u ad=0.0816p as=0.0816p pd=1.16u ps=1.16u
    I_MXI1_I1_MP1 (VDD I1_nakn1 XI1_I1_Bn VDD) gpdk090_pmos1v w=0.24u l=0.1u ad=0.0816p as=0.0816p pd=1.16u ps=1.16u
    I_MXI1_I1_MP5 (I1_aa1 I1_nakn1 XI1_I1_p1 VDD) gpdk090_pmos1v w=0.48u l=0.1u ad=0.1056p as=0.1632p pd=0.92u ps=1.64u
    I_MXI1_I1_MP4 (XI1_I1_p1 XI1_I1_An I1_aa1 VDD) gpdk090_pmos1v w=0.48u l=0.1u ad=0.1056p as=0.1056p pd=0.92u ps=0.92u
    I_MXI1_I1_MP2 (VDD A_1 XI1_I1_p1 VDD) gpdk090_pmos1v w=0.48u l=0.1u ad=0.1056p as=0.1056p pd=0.92u ps=0.92u
    I_MXI1_I1_MP3 (XI1_I1_p1 XI1_I1_Bn VDD VDD) gpdk090_pmos1v w=0.48u l=0.1u ad=0.1632p as=0.1056p pd=1.64u ps=0.92u
    I_MXI1_I1_MP0 (VDD A_1 XI1_I1_An VDD) gpdk090_pmos1v w=0.24u l=0.1u ad=0.0816p as=0.0816p pd=1.16u ps=1.16u
    I_MXI1_I27_MP1 (VDD I1_nbkn3 XI1_I27_Bn VDD) gpdk090_pmos1v w=0.24u l=0.1u ad=0.0816p as=0.0816p pd=1.16u ps=1.16u
    I_MXI1_I27_MP5 (I1_dd3 I1_nbkn3 XI1_I27_p1 VDD) gpdk090_pmos1v w=0.48u l=0.1u ad=0.1056p as=0.1632p pd=0.92u ps=1.64u
    I_MXI1_I27_MP4 (XI1_I27_p1 XI1_I27_An I1_dd3 VDD) gpdk090_pmos1v w=0.48u l=0.1u ad=0.1056p as=0.1056p pd=0.92u ps=0.92u
    I_MXI1_I27_MP2 (VDD B_3 XI1_I27_p1 VDD) gpdk090_pmos1v w=0.48u l=0.1u ad=0.1056p as=0.1056p pd=0.92u ps=0.92u
    I_MXI1_I27_MP3 (XI1_I27_p1 XI1_I27_Bn VDD VDD) gpdk090_pmos1v w=0.48u l=0.1u ad=0.1632p as=0.1056p pd=1.64u ps=0.92u
    I_MXI1_I27_MP0 (VDD B_3 XI1_I27_An VDD) gpdk090_pmos1v w=0.24u l=0.1u ad=0.0816p as=0.0816p pd=1.16u ps=1.16u
    I_MXI1_I30_MP1 (VDD I1_nbkn4 XI1_I30_Bn VDD) gpdk090_pmos1v w=0.24u l=0.1u ad=0.0816p as=0.0816p pd=1.16u ps=1.16u
    I_MXI1_I30_MP5 (I1_dd4 I1_nbkn4 XI1_I30_p1 VDD) gpdk090_pmos1v w=0.48u l=0.1u ad=0.1056p as=0.1632p pd=0.92u ps=1.64u
    I_MXI1_I30_MP4 (XI1_I30_p1 XI1_I30_An I1_dd4 VDD) gpdk090_pmos1v w=0.48u l=0.1u ad=0.1056p as=0.1056p pd=0.92u ps=0.92u
    I_MXI1_I30_MP2 (VDD B_4 XI1_I30_p1 VDD) gpdk090_pmos1v w=0.48u l=0.1u ad=0.1056p as=0.1056p pd=0.92u ps=0.92u
    I_MXI1_I30_MP3 (XI1_I30_p1 XI1_I30_Bn VDD VDD) gpdk090_pmos1v w=0.48u l=0.1u ad=0.1632p as=0.1056p pd=1.64u ps=0.92u
    I_MXI1_I30_MP0 (VDD B_4 XI1_I30_An VDD) gpdk090_pmos1v w=0.24u l=0.1u ad=0.0816p as=0.0816p pd=1.16u ps=1.16u
    I_MXI1_I120_I15_MP1 (VDD I1_b6_7 XI1_I120_I15_Bn VDD) gpdk090_pmos1v w=0.24u l=0.1u ad=0.0816p as=0.0816p pd=1.16u ps=1.16u
    I_MXI1_I120_I15_MP5 (I1_I120_pn7 I1_b6_7 XI1_I120_I15_p1 VDD) gpdk090_pmos1v w=0.48u l=0.1u ad=0.1056p as=0.1632p pd=0.92u ps=1.64u
    I_MXI1_I120_I15_MP4 (XI1_I120_I15_p1 XI1_I120_I15_An I1_I120_pn7 VDD) gpdk090_pmos1v w=0.48u l=0.1u ad=0.1056p as=0.1056p pd=0.92u ps=0.92u
    I_MXI1_I120_I15_MP2 (VDD I1_p5_6 XI1_I120_I15_p1 VDD) gpdk090_pmos1v w=0.48u l=0.1u ad=0.1056p as=0.1056p pd=0.92u ps=0.92u
    I_MXI1_I120_I15_MP3 (XI1_I120_I15_p1 XI1_I120_I15_Bn VDD VDD) gpdk090_pmos1v w=0.48u l=0.1u ad=0.1632p as=0.1056p pd=1.64u ps=0.92u
    I_MXI1_I120_I15_MP0 (VDD I1_p5_6 XI1_I120_I15_An VDD) gpdk090_pmos1v w=0.24u l=0.1u ad=0.0816p as=0.0816p pd=1.16u ps=1.16u
    I_MXI1_I120_I13_MP1 (VDD I1_b6_5 XI1_I120_I13_Bn VDD) gpdk090_pmos1v w=0.24u l=0.1u ad=0.0816p as=0.0816p pd=1.16u ps=1.16u
    I_MXI1_I120_I13_MP5 (I1_I120_pn5 I1_b6_5 XI1_I120_I13_p1 VDD) gpdk090_pmos1v w=0.48u l=0.1u ad=0.1056p as=0.1632p pd=0.92u ps=1.64u
    I_MXI1_I120_I13_MP4 (XI1_I120_I13_p1 XI1_I120_I13_An I1_I120_pn5 VDD) gpdk090_pmos1v w=0.48u l=0.1u ad=0.1056p as=0.1056p pd=0.92u ps=0.92u
    I_MXI1_I120_I13_MP2 (VDD I1_p5_4 XI1_I120_I13_p1 VDD) gpdk090_pmos1v w=0.48u l=0.1u ad=0.1056p as=0.1056p pd=0.92u ps=0.92u
    I_MXI1_I120_I13_MP3 (XI1_I120_I13_p1 XI1_I120_I13_Bn VDD VDD) gpdk090_pmos1v w=0.48u l=0.1u ad=0.1632p as=0.1056p pd=1.64u ps=0.92u
    I_MXI1_I120_I13_MP0 (VDD I1_p5_4 XI1_I120_I13_An VDD) gpdk090_pmos1v w=0.24u l=0.1u ad=0.0816p as=0.0816p pd=1.16u ps=1.16u
    I_MXI1_I120_I12_MP1 (VDD I1_b6_4 XI1_I120_I12_Bn VDD) gpdk090_pmos1v w=0.24u l=0.1u ad=0.0816p as=0.0816p pd=1.16u ps=1.16u
    I_MXI1_I120_I12_MP5 (I1_I120_pn4 I1_b6_4 XI1_I120_I12_p1 VDD) gpdk090_pmos1v w=0.48u l=0.1u ad=0.1056p as=0.1632p pd=0.92u ps=1.64u
    I_MXI1_I120_I12_MP4 (XI1_I120_I12_p1 XI1_I120_I12_An I1_I120_pn4 VDD) gpdk090_pmos1v w=0.48u l=0.1u ad=0.1056p as=0.1056p pd=0.92u ps=0.92u
    I_MXI1_I120_I12_MP2 (VDD I1_p5_3 XI1_I120_I12_p1 VDD) gpdk090_pmos1v w=0.48u l=0.1u ad=0.1056p as=0.1056p pd=0.92u ps=0.92u
    I_MXI1_I120_I12_MP3 (XI1_I120_I12_p1 XI1_I120_I12_Bn VDD VDD) gpdk090_pmos1v w=0.48u l=0.1u ad=0.1632p as=0.1056p pd=1.64u ps=0.92u
    I_MXI1_I120_I12_MP0 (VDD I1_p5_3 XI1_I120_I12_An VDD) gpdk090_pmos1v w=0.24u l=0.1u ad=0.0816p as=0.0816p pd=1.16u ps=1.16u
    I_MXI1_I120_I11_MP1 (VDD I1_b6_3 XI1_I120_I11_Bn VDD) gpdk090_pmos1v w=0.24u l=0.1u ad=0.0816p as=0.0816p pd=1.16u ps=1.16u
    I_MXI1_I120_I11_MP5 (I1_I120_pn3 I1_b6_3 XI1_I120_I11_p1 VDD) gpdk090_pmos1v w=0.48u l=0.1u ad=0.1056p as=0.1632p pd=0.92u ps=1.64u
    I_MXI1_I120_I11_MP4 (XI1_I120_I11_p1 XI1_I120_I11_An I1_I120_pn3 VDD) gpdk090_pmos1v w=0.48u l=0.1u ad=0.1056p as=0.1056p pd=0.92u ps=0.92u
    I_MXI1_I120_I11_MP2 (VDD I1_p5_2 XI1_I120_I11_p1 VDD) gpdk090_pmos1v w=0.48u l=0.1u ad=0.1056p as=0.1056p pd=0.92u ps=0.92u
    I_MXI1_I120_I11_MP3 (XI1_I120_I11_p1 XI1_I120_I11_Bn VDD VDD) gpdk090_pmos1v w=0.48u l=0.1u ad=0.1632p as=0.1056p pd=1.64u ps=0.92u
    I_MXI1_I120_I11_MP0 (VDD I1_p5_2 XI1_I120_I11_An VDD) gpdk090_pmos1v w=0.24u l=0.1u ad=0.0816p as=0.0816p pd=1.16u ps=1.16u
    I_MXI1_I108_I38_MP1 (VDD I1_I108_G0_0 XI1_I108_I38_Bn VDD) gpdk090_pmos1v w=0.24u l=0.1u ad=0.0816p as=0.0816p pd=1.16u ps=1.16u
    I_MXI1_I108_I38_MP5 (I1_p5_1 I1_I108_G0_0 XI1_I108_I38_p1 VDD) gpdk090_pmos1v w=0.48u l=0.1u ad=0.1056p as=0.1632p pd=0.92u ps=1.64u
    I_MXI1_I108_I38_MP4 (XI1_I108_I38_p1 XI1_I108_I38_An I1_p5_1 VDD) gpdk090_pmos1v w=0.48u l=0.1u ad=0.1056p as=0.1056p pd=0.92u ps=0.92u
    I_MXI1_I108_I38_MP2 (VDD I1_I108_pn1 XI1_I108_I38_p1 VDD) gpdk090_pmos1v w=0.48u l=0.1u ad=0.1056p as=0.1056p pd=0.92u ps=0.92u
    I_MXI1_I108_I38_MP3 (XI1_I108_I38_p1 XI1_I108_I38_Bn VDD VDD) gpdk090_pmos1v w=0.48u l=0.1u ad=0.1632p as=0.1056p pd=1.64u ps=0.92u
    I_MXI1_I108_I38_MP0 (VDD I1_I108_pn1 XI1_I108_I38_An VDD) gpdk090_pmos1v w=0.24u l=0.1u ad=0.0816p as=0.0816p pd=1.16u ps=1.16u
    I_MXI1_I108_I37_MP1 (VDD I1_qu3 XI1_I108_I37_Bn VDD) gpdk090_pmos1v w=0.24u l=0.1u ad=0.0816p as=0.0816p pd=1.16u ps=1.16u
    I_MXI1_I108_I37_MP5 (I1_p5_0 I1_qu3 XI1_I108_I37_p1 VDD) gpdk090_pmos1v w=0.48u l=0.1u ad=0.1056p as=0.1632p pd=0.92u ps=1.64u
    I_MXI1_I108_I37_MP4 (XI1_I108_I37_p1 XI1_I108_I37_An I1_p5_0 VDD) gpdk090_pmos1v w=0.48u l=0.1u ad=0.1056p as=0.1056p pd=0.92u ps=0.92u
    I_MXI1_I108_I37_MP2 (VDD I1_I108_pn0 XI1_I108_I37_p1 VDD) gpdk090_pmos1v w=0.48u l=0.1u ad=0.1056p as=0.1056p pd=0.92u ps=0.92u
    I_MXI1_I108_I37_MP3 (XI1_I108_I37_p1 XI1_I108_I37_Bn VDD VDD) gpdk090_pmos1v w=0.48u l=0.1u ad=0.1632p as=0.1056p pd=1.64u ps=0.92u
    I_MXI1_I108_I37_MP0 (VDD I1_I108_pn0 XI1_I108_I37_An VDD) gpdk090_pmos1v w=0.24u l=0.1u ad=0.0816p as=0.0816p pd=1.16u ps=1.16u
    I_MXI1_I108_I8_MP1 (VDD I1_b5_0 XI1_I108_I8_Bn VDD) gpdk090_pmos1v w=0.24u l=0.1u ad=0.0816p as=0.0816p pd=1.16u ps=1.16u
    I_MXI1_I108_I8_MP5 (I1_I108_pn0 I1_b5_0 XI1_I108_I8_p1 VDD) gpdk090_pmos1v w=0.48u l=0.1u ad=0.1056p as=0.1632p pd=0.92u ps=1.64u
    I_MXI1_I108_I8_MP4 (XI1_I108_I8_p1 XI1_I108_I8_An I1_I108_pn0 VDD) gpdk090_pmos1v w=0.48u l=0.1u ad=0.1056p as=0.1056p pd=0.92u ps=0.92u
    I_MXI1_I108_I8_MP2 (VDD I1_aa2 XI1_I108_I8_p1 VDD) gpdk090_pmos1v w=0.48u l=0.1u ad=0.1056p as=0.1056p pd=0.92u ps=0.92u
    I_MXI1_I108_I8_MP3 (XI1_I108_I8_p1 XI1_I108_I8_Bn VDD VDD) gpdk090_pmos1v w=0.48u l=0.1u ad=0.1632p as=0.1056p pd=1.64u ps=0.92u
    I_MXI1_I108_I8_MP0 (VDD I1_aa2 XI1_I108_I8_An VDD) gpdk090_pmos1v w=0.24u l=0.1u ad=0.0816p as=0.0816p pd=1.16u ps=1.16u
    I_MXI1_I164_MP1 (VDD I1_nqkn4 XI1_I164_Bn VDD) gpdk090_pmos1v w=0.24u l=0.1u ad=0.0816p as=0.0816p pd=1.16u ps=1.16u
    I_MXI1_I164_MP5 (DIVQ_4 I1_nqkn4 XI1_I164_p1 VDD) gpdk090_pmos1v w=0.48u l=0.1u ad=0.1056p as=0.1632p pd=0.92u ps=1.64u
    I_MXI1_I164_MP4 (XI1_I164_p1 XI1_I164_An DIVQ_4 VDD) gpdk090_pmos1v w=0.48u l=0.1u ad=0.1056p as=0.1056p pd=0.92u ps=0.92u
    I_MXI1_I164_MP2 (VDD I1_qu4 XI1_I164_p1 VDD) gpdk090_pmos1v w=0.48u l=0.1u ad=0.1056p as=0.1056p pd=0.92u ps=0.92u
    I_MXI1_I164_MP3 (XI1_I164_p1 XI1_I164_Bn VDD VDD) gpdk090_pmos1v w=0.48u l=0.1u ad=0.1632p as=0.1056p pd=1.64u ps=0.92u
    I_MXI1_I164_MP0 (VDD I1_qu4 XI1_I164_An VDD) gpdk090_pmos1v w=0.24u l=0.1u ad=0.0816p as=0.0816p pd=1.16u ps=1.16u
    I_MXI1_I161_MP1 (VDD I1_nqkn3 XI1_I161_Bn VDD) gpdk090_pmos1v w=0.24u l=0.1u ad=0.0816p as=0.0816p pd=1.16u ps=1.16u
    I_MXI1_I161_MP5 (DIVQ_3 I1_nqkn3 XI1_I161_p1 VDD) gpdk090_pmos1v w=0.48u l=0.1u ad=0.1056p as=0.1632p pd=0.92u ps=1.64u
    I_MXI1_I161_MP4 (XI1_I161_p1 XI1_I161_An DIVQ_3 VDD) gpdk090_pmos1v w=0.48u l=0.1u ad=0.1056p as=0.1056p pd=0.92u ps=0.92u
    I_MXI1_I161_MP2 (VDD I1_qu3 XI1_I161_p1 VDD) gpdk090_pmos1v w=0.48u l=0.1u ad=0.1056p as=0.1056p pd=0.92u ps=0.92u
    I_MXI1_I161_MP3 (XI1_I161_p1 XI1_I161_Bn VDD VDD) gpdk090_pmos1v w=0.48u l=0.1u ad=0.1632p as=0.1056p pd=1.64u ps=0.92u
    I_MXI1_I161_MP0 (VDD I1_qu3 XI1_I161_An VDD) gpdk090_pmos1v w=0.24u l=0.1u ad=0.0816p as=0.0816p pd=1.16u ps=1.16u
    I_MXI1_I4_MP1 (VDD I1_nakn2 XI1_I4_Bn VDD) gpdk090_pmos1v w=0.24u l=0.1u ad=0.0816p as=0.0816p pd=1.16u ps=1.16u
    I_MXI1_I4_MP5 (I1_aa2 I1_nakn2 XI1_I4_p1 VDD) gpdk090_pmos1v w=0.48u l=0.1u ad=0.1056p as=0.1632p pd=0.92u ps=1.64u
    I_MXI1_I4_MP4 (XI1_I4_p1 XI1_I4_An I1_aa2 VDD) gpdk090_pmos1v w=0.48u l=0.1u ad=0.1056p as=0.1056p pd=0.92u ps=0.92u
    I_MXI1_I4_MP2 (VDD A_2 XI1_I4_p1 VDD) gpdk090_pmos1v w=0.48u l=0.1u ad=0.1056p as=0.1056p pd=0.92u ps=0.92u
    I_MXI1_I4_MP3 (XI1_I4_p1 XI1_I4_Bn VDD VDD) gpdk090_pmos1v w=0.48u l=0.1u ad=0.1632p as=0.1056p pd=1.64u ps=0.92u
    I_MXI1_I4_MP0 (VDD A_2 XI1_I4_An VDD) gpdk090_pmos1v w=0.24u l=0.1u ad=0.0816p as=0.0816p pd=1.16u ps=1.16u
    I_MXI1_I7_MP1 (VDD I1_nakn3 XI1_I7_Bn VDD) gpdk090_pmos1v w=0.24u l=0.1u ad=0.0816p as=0.0816p pd=1.16u ps=1.16u
    I_MXI1_I7_MP5 (I1_aa3 I1_nakn3 XI1_I7_p1 VDD) gpdk090_pmos1v w=0.48u l=0.1u ad=0.1056p as=0.1632p pd=0.92u ps=1.64u
    I_MXI1_I7_MP4 (XI1_I7_p1 XI1_I7_An I1_aa3 VDD) gpdk090_pmos1v w=0.48u l=0.1u ad=0.1056p as=0.1056p pd=0.92u ps=0.92u
    I_MXI1_I7_MP2 (VDD A_3 XI1_I7_p1 VDD) gpdk090_pmos1v w=0.48u l=0.1u ad=0.1056p as=0.1056p pd=0.92u ps=0.92u
    I_MXI1_I7_MP3 (XI1_I7_p1 XI1_I7_Bn VDD VDD) gpdk090_pmos1v w=0.48u l=0.1u ad=0.1632p as=0.1056p pd=1.64u ps=0.92u
    I_MXI1_I7_MP0 (VDD A_3 XI1_I7_An VDD) gpdk090_pmos1v w=0.24u l=0.1u ad=0.0816p as=0.0816p pd=1.16u ps=1.16u
    I_MXI1_I10_MP1 (VDD I1_nakn4 XI1_I10_Bn VDD) gpdk090_pmos1v w=0.24u l=0.1u ad=0.0816p as=0.0816p pd=1.16u ps=1.16u
    I_MXI1_I10_MP5 (I1_aa4 I1_nakn4 XI1_I10_p1 VDD) gpdk090_pmos1v w=0.48u l=0.1u ad=0.1056p as=0.1632p pd=0.92u ps=1.64u
    I_MXI1_I10_MP4 (XI1_I10_p1 XI1_I10_An I1_aa4 VDD) gpdk090_pmos1v w=0.48u l=0.1u ad=0.1056p as=0.1056p pd=0.92u ps=0.92u
    I_MXI1_I10_MP2 (VDD A_4 XI1_I10_p1 VDD) gpdk090_pmos1v w=0.48u l=0.1u ad=0.1056p as=0.1056p pd=0.92u ps=0.92u
    I_MXI1_I10_MP3 (XI1_I10_p1 XI1_I10_Bn VDD VDD) gpdk090_pmos1v w=0.48u l=0.1u ad=0.1632p as=0.1056p pd=1.64u ps=0.92u
    I_MXI1_I10_MP0 (VDD A_4 XI1_I10_An VDD) gpdk090_pmos1v w=0.24u l=0.1u ad=0.0816p as=0.0816p pd=1.16u ps=1.16u
    I_MXI1_I173_MP1 (VDD I1_nqkn7 XI1_I173_Bn VDD) gpdk090_pmos1v w=0.24u l=0.1u ad=0.0816p as=0.0816p pd=1.16u ps=1.16u
    I_MXI1_I173_MP5 (DIVQ_7 I1_nqkn7 XI1_I173_p1 VDD) gpdk090_pmos1v w=0.48u l=0.1u ad=0.1056p as=0.1632p pd=0.92u ps=1.64u
    I_MXI1_I173_MP4 (XI1_I173_p1 XI1_I173_An DIVQ_7 VDD) gpdk090_pmos1v w=0.48u l=0.1u ad=0.1056p as=0.1056p pd=0.92u ps=0.92u
    I_MXI1_I173_MP2 (VDD I1_qu7 XI1_I173_p1 VDD) gpdk090_pmos1v w=0.48u l=0.1u ad=0.1056p as=0.1056p pd=0.92u ps=0.92u
    I_MXI1_I173_MP3 (XI1_I173_p1 XI1_I173_Bn VDD VDD) gpdk090_pmos1v w=0.48u l=0.1u ad=0.1632p as=0.1056p pd=1.64u ps=0.92u
    I_MXI1_I173_MP0 (VDD I1_qu7 XI1_I173_An VDD) gpdk090_pmos1v w=0.24u l=0.1u ad=0.0816p as=0.0816p pd=1.16u ps=1.16u
    I_MXI1_I21_MP1 (VDD I1_nbkn1 XI1_I21_Bn VDD) gpdk090_pmos1v w=0.24u l=0.1u ad=0.0816p as=0.0816p pd=1.16u ps=1.16u
    I_MXI1_I21_MP5 (I1_dd1 I1_nbkn1 XI1_I21_p1 VDD) gpdk090_pmos1v w=0.48u l=0.1u ad=0.1056p as=0.1632p pd=0.92u ps=1.64u
    I_MXI1_I21_MP4 (XI1_I21_p1 XI1_I21_An I1_dd1 VDD) gpdk090_pmos1v w=0.48u l=0.1u ad=0.1056p as=0.1056p pd=0.92u ps=0.92u
    I_MXI1_I21_MP2 (VDD B_1 XI1_I21_p1 VDD) gpdk090_pmos1v w=0.48u l=0.1u ad=0.1056p as=0.1056p pd=0.92u ps=0.92u
    I_MXI1_I21_MP3 (XI1_I21_p1 XI1_I21_Bn VDD VDD) gpdk090_pmos1v w=0.48u l=0.1u ad=0.1632p as=0.1056p pd=1.64u ps=0.92u
    I_MXI1_I21_MP0 (VDD B_1 XI1_I21_An VDD) gpdk090_pmos1v w=0.24u l=0.1u ad=0.0816p as=0.0816p pd=1.16u ps=1.16u
    I_MXI1_I24_MP1 (VDD I1_nbkn2 XI1_I24_Bn VDD) gpdk090_pmos1v w=0.24u l=0.1u ad=0.0816p as=0.0816p pd=1.16u ps=1.16u
    I_MXI1_I24_MP5 (I1_dd2 I1_nbkn2 XI1_I24_p1 VDD) gpdk090_pmos1v w=0.48u l=0.1u ad=0.1056p as=0.1632p pd=0.92u ps=1.64u
    I_MXI1_I24_MP4 (XI1_I24_p1 XI1_I24_An I1_dd2 VDD) gpdk090_pmos1v w=0.48u l=0.1u ad=0.1056p as=0.1056p pd=0.92u ps=0.92u
    I_MXI1_I24_MP2 (VDD B_2 XI1_I24_p1 VDD) gpdk090_pmos1v w=0.48u l=0.1u ad=0.1056p as=0.1056p pd=0.92u ps=0.92u
    I_MXI1_I24_MP3 (XI1_I24_p1 XI1_I24_Bn VDD VDD) gpdk090_pmos1v w=0.48u l=0.1u ad=0.1632p as=0.1056p pd=1.64u ps=0.92u
    I_MXI1_I24_MP0 (VDD B_2 XI1_I24_An VDD) gpdk090_pmos1v w=0.24u l=0.1u ad=0.0816p as=0.0816p pd=1.16u ps=1.16u
    I_MXI1_I120_I14_MP1 (VDD I1_b6_6 XI1_I120_I14_Bn VDD) gpdk090_pmos1v w=0.24u l=0.1u ad=0.0816p as=0.0816p pd=1.16u ps=1.16u
    I_MXI1_I120_I14_MP5 (I1_I120_pn6 I1_b6_6 XI1_I120_I14_p1 VDD) gpdk090_pmos1v w=0.48u l=0.1u ad=0.1056p as=0.1632p pd=0.92u ps=1.64u
    I_MXI1_I120_I14_MP4 (XI1_I120_I14_p1 XI1_I120_I14_An I1_I120_pn6 VDD) gpdk090_pmos1v w=0.48u l=0.1u ad=0.1056p as=0.1056p pd=0.92u ps=0.92u
    I_MXI1_I120_I14_MP2 (VDD I1_p5_5 XI1_I120_I14_p1 VDD) gpdk090_pmos1v w=0.48u l=0.1u ad=0.1056p as=0.1056p pd=0.92u ps=0.92u
    I_MXI1_I120_I14_MP3 (XI1_I120_I14_p1 XI1_I120_I14_Bn VDD VDD) gpdk090_pmos1v w=0.48u l=0.1u ad=0.1632p as=0.1056p pd=1.64u ps=0.92u
    I_MXI1_I120_I14_MP0 (VDD I1_p5_5 XI1_I120_I14_An VDD) gpdk090_pmos1v w=0.24u l=0.1u ad=0.0816p as=0.0816p pd=1.16u ps=1.16u
    I_MXI1_I108_I39_MP1 (VDD I1_I108_G1_0 XI1_I108_I39_Bn VDD) gpdk090_pmos1v w=0.24u l=0.1u ad=0.0816p as=0.0816p pd=1.16u ps=1.16u
    I_MXI1_I108_I39_MP5 (I1_p5_2 I1_I108_G1_0 XI1_I108_I39_p1 VDD) gpdk090_pmos1v w=0.48u l=0.1u ad=0.1056p as=0.1632p pd=0.92u ps=1.64u
    I_MXI1_I108_I39_MP4 (XI1_I108_I39_p1 XI1_I108_I39_An I1_p5_2 VDD) gpdk090_pmos1v w=0.48u l=0.1u ad=0.1056p as=0.1056p pd=0.92u ps=0.92u
    I_MXI1_I108_I39_MP2 (VDD I1_I108_pn2 XI1_I108_I39_p1 VDD) gpdk090_pmos1v w=0.48u l=0.1u ad=0.1056p as=0.1056p pd=0.92u ps=0.92u
    I_MXI1_I108_I39_MP3 (XI1_I108_I39_p1 XI1_I108_I39_Bn VDD VDD) gpdk090_pmos1v w=0.48u l=0.1u ad=0.1632p as=0.1056p pd=1.64u ps=0.92u
    I_MXI1_I108_I39_MP0 (VDD I1_I108_pn2 XI1_I108_I39_An VDD) gpdk090_pmos1v w=0.24u l=0.1u ad=0.0816p as=0.0816p pd=1.16u ps=1.16u
    I_MXI1_I108_I9_MP1 (VDD I1_b5_1 XI1_I108_I9_Bn VDD) gpdk090_pmos1v w=0.24u l=0.1u ad=0.0816p as=0.0816p pd=1.16u ps=1.16u
    I_MXI1_I108_I9_MP5 (I1_I108_pn1 I1_b5_1 XI1_I108_I9_p1 VDD) gpdk090_pmos1v w=0.48u l=0.1u ad=0.1056p as=0.1632p pd=0.92u ps=1.64u
    I_MXI1_I108_I9_MP4 (XI1_I108_I9_p1 XI1_I108_I9_An I1_I108_pn1 VDD) gpdk090_pmos1v w=0.48u l=0.1u ad=0.1056p as=0.1056p pd=0.92u ps=0.92u
    I_MXI1_I108_I9_MP2 (VDD I1_p4_0 XI1_I108_I9_p1 VDD) gpdk090_pmos1v w=0.48u l=0.1u ad=0.1056p as=0.1056p pd=0.92u ps=0.92u
    I_MXI1_I108_I9_MP3 (XI1_I108_I9_p1 XI1_I108_I9_Bn VDD VDD) gpdk090_pmos1v w=0.48u l=0.1u ad=0.1632p as=0.1056p pd=1.64u ps=0.92u
    I_MXI1_I108_I9_MP0 (VDD I1_p4_0 XI1_I108_I9_An VDD) gpdk090_pmos1v w=0.24u l=0.1u ad=0.0816p as=0.0816p pd=1.16u ps=1.16u
    I_MXI1_I96_I37_MP1 (VDD I1_qu4 XI1_I96_I37_Bn VDD) gpdk090_pmos1v w=0.24u l=0.1u ad=0.0816p as=0.0816p pd=1.16u ps=1.16u
    I_MXI1_I96_I37_MP5 (I1_p4_0 I1_qu4 XI1_I96_I37_p1 VDD) gpdk090_pmos1v w=0.48u l=0.1u ad=0.1056p as=0.1632p pd=0.92u ps=1.64u
    I_MXI1_I96_I37_MP4 (XI1_I96_I37_p1 XI1_I96_I37_An I1_p4_0 VDD) gpdk090_pmos1v w=0.48u l=0.1u ad=0.1056p as=0.1056p pd=0.92u ps=0.92u
    I_MXI1_I96_I37_MP2 (VDD I1_I96_pn0 XI1_I96_I37_p1 VDD) gpdk090_pmos1v w=0.48u l=0.1u ad=0.1056p as=0.1056p pd=0.92u ps=0.92u
    I_MXI1_I96_I37_MP3 (XI1_I96_I37_p1 XI1_I96_I37_Bn VDD VDD) gpdk090_pmos1v w=0.48u l=0.1u ad=0.1632p as=0.1056p pd=1.64u ps=0.92u
    I_MXI1_I96_I37_MP0 (VDD I1_I96_pn0 XI1_I96_I37_An VDD) gpdk090_pmos1v w=0.24u l=0.1u ad=0.0816p as=0.0816p pd=1.16u ps=1.16u
    I_MXI1_I96_I8_MP1 (VDD I1_b4_0 XI1_I96_I8_Bn VDD) gpdk090_pmos1v w=0.24u l=0.1u ad=0.0816p as=0.0816p pd=1.16u ps=1.16u
    I_MXI1_I96_I8_MP5 (I1_I96_pn0 I1_b4_0 XI1_I96_I8_p1 VDD) gpdk090_pmos1v w=0.48u l=0.1u ad=0.1056p as=0.1632p pd=0.92u ps=1.64u
    I_MXI1_I96_I8_MP4 (XI1_I96_I8_p1 XI1_I96_I8_An I1_I96_pn0 VDD) gpdk090_pmos1v w=0.48u l=0.1u ad=0.1056p as=0.1056p pd=0.92u ps=0.92u
    I_MXI1_I96_I8_MP2 (VDD I1_aa3 XI1_I96_I8_p1 VDD) gpdk090_pmos1v w=0.48u l=0.1u ad=0.1056p as=0.1056p pd=0.92u ps=0.92u
    I_MXI1_I96_I8_MP3 (XI1_I96_I8_p1 XI1_I96_I8_Bn VDD VDD) gpdk090_pmos1v w=0.48u l=0.1u ad=0.1632p as=0.1056p pd=1.64u ps=0.92u
    I_MXI1_I96_I8_MP0 (VDD I1_aa3 XI1_I96_I8_An VDD) gpdk090_pmos1v w=0.24u l=0.1u ad=0.0816p as=0.0816p pd=1.16u ps=1.16u
    I_MXI1_I167_MP1 (VDD I1_nqkn5 XI1_I167_Bn VDD) gpdk090_pmos1v w=0.24u l=0.1u ad=0.0816p as=0.0816p pd=1.16u ps=1.16u
    I_MXI1_I167_MP5 (DIVQ_5 I1_nqkn5 XI1_I167_p1 VDD) gpdk090_pmos1v w=0.48u l=0.1u ad=0.1056p as=0.1632p pd=0.92u ps=1.64u
    I_MXI1_I167_MP4 (XI1_I167_p1 XI1_I167_An DIVQ_5 VDD) gpdk090_pmos1v w=0.48u l=0.1u ad=0.1056p as=0.1056p pd=0.92u ps=0.92u
    I_MXI1_I167_MP2 (VDD I1_qu5 XI1_I167_p1 VDD) gpdk090_pmos1v w=0.48u l=0.1u ad=0.1056p as=0.1056p pd=0.92u ps=0.92u
    I_MXI1_I167_MP3 (XI1_I167_p1 XI1_I167_Bn VDD VDD) gpdk090_pmos1v w=0.48u l=0.1u ad=0.1632p as=0.1056p pd=1.64u ps=0.92u
    I_MXI1_I167_MP0 (VDD I1_qu5 XI1_I167_An VDD) gpdk090_pmos1v w=0.24u l=0.1u ad=0.0816p as=0.0816p pd=1.16u ps=1.16u
    I_MXI1_I84_I8_MP1 (VDD I1_b3_0 XI1_I84_I8_Bn VDD) gpdk090_pmos1v w=0.24u l=0.1u ad=0.0816p as=0.0816p pd=1.16u ps=1.16u
    I_MXI1_I84_I8_MP5 (I1_I84_pn0 I1_b3_0 XI1_I84_I8_p1 VDD) gpdk090_pmos1v w=0.48u l=0.1u ad=0.1056p as=0.1632p pd=0.92u ps=1.64u
    I_MXI1_I84_I8_MP4 (XI1_I84_I8_p1 XI1_I84_I8_An I1_I84_pn0 VDD) gpdk090_pmos1v w=0.48u l=0.1u ad=0.1056p as=0.1056p pd=0.92u ps=0.92u
    I_MXI1_I84_I8_MP2 (VDD I1_aa4 XI1_I84_I8_p1 VDD) gpdk090_pmos1v w=0.48u l=0.1u ad=0.1056p as=0.1056p pd=0.92u ps=0.92u
    I_MXI1_I84_I8_MP3 (XI1_I84_I8_p1 XI1_I84_I8_Bn VDD VDD) gpdk090_pmos1v w=0.48u l=0.1u ad=0.1632p as=0.1056p pd=1.64u ps=0.92u
    I_MXI1_I84_I8_MP0 (VDD I1_aa4 XI1_I84_I8_An VDD) gpdk090_pmos1v w=0.24u l=0.1u ad=0.0816p as=0.0816p pd=1.16u ps=1.16u
    I_MXI1_I170_MP1 (VDD I1_nqkn6 XI1_I170_Bn VDD) gpdk090_pmos1v w=0.24u l=0.1u ad=0.0816p as=0.0816p pd=1.16u ps=1.16u
    I_MXI1_I170_MP5 (DIVQ_6 I1_nqkn6 XI1_I170_p1 VDD) gpdk090_pmos1v w=0.48u l=0.1u ad=0.1056p as=0.1632p pd=0.92u ps=1.64u
    I_MXI1_I170_MP4 (XI1_I170_p1 XI1_I170_An DIVQ_6 VDD) gpdk090_pmos1v w=0.48u l=0.1u ad=0.1056p as=0.1056p pd=0.92u ps=0.92u
    I_MXI1_I170_MP2 (VDD I1_qu6 XI1_I170_p1 VDD) gpdk090_pmos1v w=0.48u l=0.1u ad=0.1056p as=0.1056p pd=0.92u ps=0.92u
    I_MXI1_I170_MP3 (XI1_I170_p1 XI1_I170_Bn VDD VDD) gpdk090_pmos1v w=0.48u l=0.1u ad=0.1632p as=0.1056p pd=1.64u ps=0.92u
    I_MXI1_I170_MP0 (VDD I1_qu6 XI1_I170_An VDD) gpdk090_pmos1v w=0.24u l=0.1u ad=0.0816p as=0.0816p pd=1.16u ps=1.16u
    I_MXI1_I13_MP1 (VDD I1_nakn5 XI1_I13_Bn VDD) gpdk090_pmos1v w=0.24u l=0.1u ad=0.0816p as=0.0816p pd=1.16u ps=1.16u
    I_MXI1_I13_MP5 (I1_aa5 I1_nakn5 XI1_I13_p1 VDD) gpdk090_pmos1v w=0.48u l=0.1u ad=0.1056p as=0.1632p pd=0.92u ps=1.64u
    I_MXI1_I13_MP4 (XI1_I13_p1 XI1_I13_An I1_aa5 VDD) gpdk090_pmos1v w=0.48u l=0.1u ad=0.1056p as=0.1056p pd=0.92u ps=0.92u
    I_MXI1_I13_MP2 (VDD A_5 XI1_I13_p1 VDD) gpdk090_pmos1v w=0.48u l=0.1u ad=0.1056p as=0.1056p pd=0.92u ps=0.92u
    I_MXI1_I13_MP3 (XI1_I13_p1 XI1_I13_Bn VDD VDD) gpdk090_pmos1v w=0.48u l=0.1u ad=0.1632p as=0.1056p pd=1.64u ps=0.92u
    I_MXI1_I13_MP0 (VDD A_5 XI1_I13_An VDD) gpdk090_pmos1v w=0.24u l=0.1u ad=0.0816p as=0.0816p pd=1.16u ps=1.16u
    I_MXI1_I16_MP1 (VDD I1_nakn6 XI1_I16_Bn VDD) gpdk090_pmos1v w=0.24u l=0.1u ad=0.0816p as=0.0816p pd=1.16u ps=1.16u
    I_MXI1_I16_MP5 (I1_aa6 I1_nakn6 XI1_I16_p1 VDD) gpdk090_pmos1v w=0.48u l=0.1u ad=0.1056p as=0.1632p pd=0.92u ps=1.64u
    I_MXI1_I16_MP4 (XI1_I16_p1 XI1_I16_An I1_aa6 VDD) gpdk090_pmos1v w=0.48u l=0.1u ad=0.1056p as=0.1056p pd=0.92u ps=0.92u
    I_MXI1_I16_MP2 (VDD A_6 XI1_I16_p1 VDD) gpdk090_pmos1v w=0.48u l=0.1u ad=0.1056p as=0.1056p pd=0.92u ps=0.92u
    I_MXI1_I16_MP3 (XI1_I16_p1 XI1_I16_Bn VDD VDD) gpdk090_pmos1v w=0.48u l=0.1u ad=0.1632p as=0.1056p pd=1.64u ps=0.92u
    I_MXI1_I16_MP0 (VDD A_6 XI1_I16_An VDD) gpdk090_pmos1v w=0.24u l=0.1u ad=0.0816p as=0.0816p pd=1.16u ps=1.16u
    I_MXI1_I19_MP1 (VDD I1_nakn7 XI1_I19_Bn VDD) gpdk090_pmos1v w=0.24u l=0.1u ad=0.0816p as=0.0816p pd=1.16u ps=1.16u
    I_MXI1_I19_MP5 (I1_aa7 I1_nakn7 XI1_I19_p1 VDD) gpdk090_pmos1v w=0.48u l=0.1u ad=0.1056p as=0.1632p pd=0.92u ps=1.64u
    I_MXI1_I19_MP4 (XI1_I19_p1 XI1_I19_An I1_aa7 VDD) gpdk090_pmos1v w=0.48u l=0.1u ad=0.1056p as=0.1056p pd=0.92u ps=0.92u
    I_MXI1_I19_MP2 (VDD A_7 XI1_I19_p1 VDD) gpdk090_pmos1v w=0.48u l=0.1u ad=0.1056p as=0.1056p pd=0.92u ps=0.92u
    I_MXI1_I19_MP3 (XI1_I19_p1 XI1_I19_Bn VDD VDD) gpdk090_pmos1v w=0.48u l=0.1u ad=0.1632p as=0.1056p pd=1.64u ps=0.92u
    I_MXI1_I19_MP0 (VDD A_7 XI1_I19_An VDD) gpdk090_pmos1v w=0.24u l=0.1u ad=0.0816p as=0.0816p pd=1.16u ps=1.16u
    I_MXI1_I48_I8_MP1 (VDD I1_b0_0 XI1_I48_I8_Bn VDD) gpdk090_pmos1v w=0.24u l=0.1u ad=0.0816p as=0.0816p pd=1.16u ps=1.16u
    I_MXI1_I48_I8_MP5 (I1_I48_pn0 I1_b0_0 XI1_I48_I8_p1 VDD) gpdk090_pmos1v w=0.48u l=0.1u ad=0.1056p as=0.1632p pd=0.92u ps=1.64u
    I_MXI1_I48_I8_MP4 (XI1_I48_I8_p1 XI1_I48_I8_An I1_I48_pn0 VDD) gpdk090_pmos1v w=0.48u l=0.1u ad=0.1056p as=0.1056p pd=0.92u ps=0.92u
    I_MXI1_I48_I8_MP2 (VDD I1_aa7 XI1_I48_I8_p1 VDD) gpdk090_pmos1v w=0.48u l=0.1u ad=0.1056p as=0.1056p pd=0.92u ps=0.92u
    I_MXI1_I48_I8_MP3 (XI1_I48_I8_p1 XI1_I48_I8_Bn VDD VDD) gpdk090_pmos1v w=0.48u l=0.1u ad=0.1632p as=0.1056p pd=1.64u ps=0.92u
    I_MXI1_I48_I8_MP0 (VDD I1_aa7 XI1_I48_I8_An VDD) gpdk090_pmos1v w=0.24u l=0.1u ad=0.0816p as=0.0816p pd=1.16u ps=1.16u
    I_MXI1_I108_I44_MP1 (VDD I1_c5_7 XI1_I108_I44_Bn VDD) gpdk090_pmos1v w=0.24u l=0.1u ad=0.0816p as=0.0816p pd=1.16u ps=1.16u
    I_MXI1_I108_I44_MP5 (I1_p5_7 I1_c5_7 XI1_I108_I44_p1 VDD) gpdk090_pmos1v w=0.48u l=0.1u ad=0.1056p as=0.1632p pd=0.92u ps=1.64u
    I_MXI1_I108_I44_MP4 (XI1_I108_I44_p1 XI1_I108_I44_An I1_p5_7 VDD) gpdk090_pmos1v w=0.48u l=0.1u ad=0.1056p as=0.1056p pd=0.92u ps=0.92u
    I_MXI1_I108_I44_MP2 (VDD I1_I108_pn7 XI1_I108_I44_p1 VDD) gpdk090_pmos1v w=0.48u l=0.1u ad=0.1056p as=0.1056p pd=0.92u ps=0.92u
    I_MXI1_I108_I44_MP3 (XI1_I108_I44_p1 XI1_I108_I44_Bn VDD VDD) gpdk090_pmos1v w=0.48u l=0.1u ad=0.1632p as=0.1056p pd=1.64u ps=0.92u
    I_MXI1_I108_I44_MP0 (VDD I1_I108_pn7 XI1_I108_I44_An VDD) gpdk090_pmos1v w=0.24u l=0.1u ad=0.0816p as=0.0816p pd=1.16u ps=1.16u
    I_MXI1_I108_I42_MP1 (VDD I1_I108_G4_0 XI1_I108_I42_Bn VDD) gpdk090_pmos1v w=0.24u l=0.1u ad=0.0816p as=0.0816p pd=1.16u ps=1.16u
    I_MXI1_I108_I42_MP5 (I1_p5_5 I1_I108_G4_0 XI1_I108_I42_p1 VDD) gpdk090_pmos1v w=0.48u l=0.1u ad=0.1056p as=0.1632p pd=0.92u ps=1.64u
    I_MXI1_I108_I42_MP4 (XI1_I108_I42_p1 XI1_I108_I42_An I1_p5_5 VDD) gpdk090_pmos1v w=0.48u l=0.1u ad=0.1056p as=0.1056p pd=0.92u ps=0.92u
    I_MXI1_I108_I42_MP2 (VDD I1_I108_pn5 XI1_I108_I42_p1 VDD) gpdk090_pmos1v w=0.48u l=0.1u ad=0.1056p as=0.1056p pd=0.92u ps=0.92u
    I_MXI1_I108_I42_MP3 (XI1_I108_I42_p1 XI1_I108_I42_Bn VDD VDD) gpdk090_pmos1v w=0.48u l=0.1u ad=0.1632p as=0.1056p pd=1.64u ps=0.92u
    I_MXI1_I108_I42_MP0 (VDD I1_I108_pn5 XI1_I108_I42_An VDD) gpdk090_pmos1v w=0.24u l=0.1u ad=0.0816p as=0.0816p pd=1.16u ps=1.16u
    I_MXI1_I108_I10_MP1 (VDD I1_b5_2 XI1_I108_I10_Bn VDD) gpdk090_pmos1v w=0.24u l=0.1u ad=0.0816p as=0.0816p pd=1.16u ps=1.16u
    I_MXI1_I108_I10_MP5 (I1_I108_pn2 I1_b5_2 XI1_I108_I10_p1 VDD) gpdk090_pmos1v w=0.48u l=0.1u ad=0.1056p as=0.1632p pd=0.92u ps=1.64u
    I_MXI1_I108_I10_MP4 (XI1_I108_I10_p1 XI1_I108_I10_An I1_I108_pn2 VDD) gpdk090_pmos1v w=0.48u l=0.1u ad=0.1056p as=0.1056p pd=0.92u ps=0.92u
    I_MXI1_I108_I10_MP2 (VDD I1_p4_1 XI1_I108_I10_p1 VDD) gpdk090_pmos1v w=0.48u l=0.1u ad=0.1056p as=0.1056p pd=0.92u ps=0.92u
    I_MXI1_I108_I10_MP3 (XI1_I108_I10_p1 XI1_I108_I10_Bn VDD VDD) gpdk090_pmos1v w=0.48u l=0.1u ad=0.1632p as=0.1056p pd=1.64u ps=0.92u
    I_MXI1_I108_I10_MP0 (VDD I1_p4_1 XI1_I108_I10_An VDD) gpdk090_pmos1v w=0.24u l=0.1u ad=0.0816p as=0.0816p pd=1.16u ps=1.16u
    I_MXI1_I96_I9_MP1 (VDD I1_b4_1 XI1_I96_I9_Bn VDD) gpdk090_pmos1v w=0.24u l=0.1u ad=0.0816p as=0.0816p pd=1.16u ps=1.16u
    I_MXI1_I96_I9_MP5 (I1_I96_pn1 I1_b4_1 XI1_I96_I9_p1 VDD) gpdk090_pmos1v w=0.48u l=0.1u ad=0.1056p as=0.1632p pd=0.92u ps=1.64u
    I_MXI1_I96_I9_MP4 (XI1_I96_I9_p1 XI1_I96_I9_An I1_I96_pn1 VDD) gpdk090_pmos1v w=0.48u l=0.1u ad=0.1056p as=0.1056p pd=0.92u ps=0.92u
    I_MXI1_I96_I9_MP2 (VDD I1_p3_0 XI1_I96_I9_p1 VDD) gpdk090_pmos1v w=0.48u l=0.1u ad=0.1056p as=0.1056p pd=0.92u ps=0.92u
    I_MXI1_I96_I9_MP3 (XI1_I96_I9_p1 XI1_I96_I9_Bn VDD VDD) gpdk090_pmos1v w=0.48u l=0.1u ad=0.1632p as=0.1056p pd=1.64u ps=0.92u
    I_MXI1_I96_I9_MP0 (VDD I1_p3_0 XI1_I96_I9_An VDD) gpdk090_pmos1v w=0.24u l=0.1u ad=0.0816p as=0.0816p pd=1.16u ps=1.16u
    I_MXI1_I84_I37_MP1 (VDD I1_qu5 XI1_I84_I37_Bn VDD) gpdk090_pmos1v w=0.24u l=0.1u ad=0.0816p as=0.0816p pd=1.16u ps=1.16u
    I_MXI1_I84_I37_MP5 (I1_p3_0 I1_qu5 XI1_I84_I37_p1 VDD) gpdk090_pmos1v w=0.48u l=0.1u ad=0.1056p as=0.1632p pd=0.92u ps=1.64u
    I_MXI1_I84_I37_MP4 (XI1_I84_I37_p1 XI1_I84_I37_An I1_p3_0 VDD) gpdk090_pmos1v w=0.48u l=0.1u ad=0.1056p as=0.1056p pd=0.92u ps=0.92u
    I_MXI1_I84_I37_MP2 (VDD I1_I84_pn0 XI1_I84_I37_p1 VDD) gpdk090_pmos1v w=0.48u l=0.1u ad=0.1056p as=0.1056p pd=0.92u ps=0.92u
    I_MXI1_I84_I37_MP3 (XI1_I84_I37_p1 XI1_I84_I37_Bn VDD VDD) gpdk090_pmos1v w=0.48u l=0.1u ad=0.1632p as=0.1056p pd=1.64u ps=0.92u
    I_MXI1_I84_I37_MP0 (VDD I1_I84_pn0 XI1_I84_I37_An VDD) gpdk090_pmos1v w=0.24u l=0.1u ad=0.0816p as=0.0816p pd=1.16u ps=1.16u
    I_MXI1_I84_I9_MP1 (VDD I1_b3_1 XI1_I84_I9_Bn VDD) gpdk090_pmos1v w=0.24u l=0.1u ad=0.0816p as=0.0816p pd=1.16u ps=1.16u
    I_MXI1_I84_I9_MP5 (I1_I84_pn1 I1_b3_1 XI1_I84_I9_p1 VDD) gpdk090_pmos1v w=0.48u l=0.1u ad=0.1056p as=0.1632p pd=0.92u ps=1.64u
    I_MXI1_I84_I9_MP4 (XI1_I84_I9_p1 XI1_I84_I9_An I1_I84_pn1 VDD) gpdk090_pmos1v w=0.48u l=0.1u ad=0.1056p as=0.1056p pd=0.92u ps=0.92u
    I_MXI1_I84_I9_MP2 (VDD I1_p2_0 XI1_I84_I9_p1 VDD) gpdk090_pmos1v w=0.48u l=0.1u ad=0.1056p as=0.1056p pd=0.92u ps=0.92u
    I_MXI1_I84_I9_MP3 (XI1_I84_I9_p1 XI1_I84_I9_Bn VDD VDD) gpdk090_pmos1v w=0.48u l=0.1u ad=0.1632p as=0.1056p pd=1.64u ps=0.92u
    I_MXI1_I84_I9_MP0 (VDD I1_p2_0 XI1_I84_I9_An VDD) gpdk090_pmos1v w=0.24u l=0.1u ad=0.0816p as=0.0816p pd=1.16u ps=1.16u
    I_MXI1_I72_I37_MP1 (VDD I1_qu6 XI1_I72_I37_Bn VDD) gpdk090_pmos1v w=0.24u l=0.1u ad=0.0816p as=0.0816p pd=1.16u ps=1.16u
    I_MXI1_I72_I37_MP5 (I1_p2_0 I1_qu6 XI1_I72_I37_p1 VDD) gpdk090_pmos1v w=0.48u l=0.1u ad=0.1056p as=0.1632p pd=0.92u ps=1.64u
    I_MXI1_I72_I37_MP4 (XI1_I72_I37_p1 XI1_I72_I37_An I1_p2_0 VDD) gpdk090_pmos1v w=0.48u l=0.1u ad=0.1056p as=0.1056p pd=0.92u ps=0.92u
    I_MXI1_I72_I37_MP2 (VDD I1_I72_pn0 XI1_I72_I37_p1 VDD) gpdk090_pmos1v w=0.48u l=0.1u ad=0.1056p as=0.1056p pd=0.92u ps=0.92u
    I_MXI1_I72_I37_MP3 (XI1_I72_I37_p1 XI1_I72_I37_Bn VDD VDD) gpdk090_pmos1v w=0.48u l=0.1u ad=0.1632p as=0.1056p pd=1.64u ps=0.92u
    I_MXI1_I72_I37_MP0 (VDD I1_I72_pn0 XI1_I72_I37_An VDD) gpdk090_pmos1v w=0.24u l=0.1u ad=0.0816p as=0.0816p pd=1.16u ps=1.16u
    I_MXI1_I72_I8_MP1 (VDD I1_b2_0 XI1_I72_I8_Bn VDD) gpdk090_pmos1v w=0.24u l=0.1u ad=0.0816p as=0.0816p pd=1.16u ps=1.16u
    I_MXI1_I72_I8_MP5 (I1_I72_pn0 I1_b2_0 XI1_I72_I8_p1 VDD) gpdk090_pmos1v w=0.48u l=0.1u ad=0.1056p as=0.1632p pd=0.92u ps=1.64u
    I_MXI1_I72_I8_MP4 (XI1_I72_I8_p1 XI1_I72_I8_An I1_I72_pn0 VDD) gpdk090_pmos1v w=0.48u l=0.1u ad=0.1056p as=0.1056p pd=0.92u ps=0.92u
    I_MXI1_I72_I8_MP2 (VDD I1_aa5 XI1_I72_I8_p1 VDD) gpdk090_pmos1v w=0.48u l=0.1u ad=0.1056p as=0.1056p pd=0.92u ps=0.92u
    I_MXI1_I72_I8_MP3 (XI1_I72_I8_p1 XI1_I72_I8_Bn VDD VDD) gpdk090_pmos1v w=0.48u l=0.1u ad=0.1632p as=0.1056p pd=1.64u ps=0.92u
    I_MXI1_I72_I8_MP0 (VDD I1_aa5 XI1_I72_I8_An VDD) gpdk090_pmos1v w=0.24u l=0.1u ad=0.0816p as=0.0816p pd=1.16u ps=1.16u
    I_MXI1_I60_I8_MP1 (VDD I1_b1_0 XI1_I60_I8_Bn VDD) gpdk090_pmos1v w=0.24u l=0.1u ad=0.0816p as=0.0816p pd=1.16u ps=1.16u
    I_MXI1_I60_I8_MP5 (I1_I60_pn0 I1_b1_0 XI1_I60_I8_p1 VDD) gpdk090_pmos1v w=0.48u l=0.1u ad=0.1056p as=0.1632p pd=0.92u ps=1.64u
    I_MXI1_I60_I8_MP4 (XI1_I60_I8_p1 XI1_I60_I8_An I1_I60_pn0 VDD) gpdk090_pmos1v w=0.48u l=0.1u ad=0.1056p as=0.1056p pd=0.92u ps=0.92u
    I_MXI1_I60_I8_MP2 (VDD I1_aa6 XI1_I60_I8_p1 VDD) gpdk090_pmos1v w=0.48u l=0.1u ad=0.1056p as=0.1056p pd=0.92u ps=0.92u
    I_MXI1_I60_I8_MP3 (XI1_I60_I8_p1 XI1_I60_I8_Bn VDD VDD) gpdk090_pmos1v w=0.48u l=0.1u ad=0.1632p as=0.1056p pd=1.64u ps=0.92u
    I_MXI1_I60_I8_MP0 (VDD I1_aa6 XI1_I60_I8_An VDD) gpdk090_pmos1v w=0.24u l=0.1u ad=0.0816p as=0.0816p pd=1.16u ps=1.16u
    I_MXI1_I48_I37_MP1 (VDD VDD XI1_I48_I37_Bn VDD) gpdk090_pmos1v w=0.24u l=0.1u ad=0.0816p as=0.0816p pd=1.16u ps=1.16u
    I_MXI1_I48_I37_MP5 (I1_p0_0 VDD XI1_I48_I37_p1 VDD) gpdk090_pmos1v w=0.48u l=0.1u ad=0.1056p as=0.1632p pd=0.92u ps=1.64u
    I_MXI1_I48_I37_MP4 (XI1_I48_I37_p1 XI1_I48_I37_An I1_p0_0 VDD) gpdk090_pmos1v w=0.48u l=0.1u ad=0.1056p as=0.1056p pd=0.92u ps=0.92u
    I_MXI1_I48_I37_MP2 (VDD I1_I48_pn0 XI1_I48_I37_p1 VDD) gpdk090_pmos1v w=0.48u l=0.1u ad=0.1056p as=0.1056p pd=0.92u ps=0.92u
    I_MXI1_I48_I37_MP3 (XI1_I48_I37_p1 XI1_I48_I37_Bn VDD VDD) gpdk090_pmos1v w=0.48u l=0.1u ad=0.1632p as=0.1056p pd=1.64u ps=0.92u
    I_MXI1_I48_I37_MP0 (VDD I1_I48_pn0 XI1_I48_I37_An VDD) gpdk090_pmos1v w=0.24u l=0.1u ad=0.0816p as=0.0816p pd=1.16u ps=1.16u
    I_MXI1_I60_I37_MP1 (VDD I1_qu7 XI1_I60_I37_Bn VDD) gpdk090_pmos1v w=0.24u l=0.1u ad=0.0816p as=0.0816p pd=1.16u ps=1.16u
    I_MXI1_I60_I37_MP5 (I1_p1_0 I1_qu7 XI1_I60_I37_p1 VDD) gpdk090_pmos1v w=0.48u l=0.1u ad=0.1056p as=0.1632p pd=0.92u ps=1.64u
    I_MXI1_I60_I37_MP4 (XI1_I60_I37_p1 XI1_I60_I37_An I1_p1_0 VDD) gpdk090_pmos1v w=0.48u l=0.1u ad=0.1056p as=0.1056p pd=0.92u ps=0.92u
    I_MXI1_I60_I37_MP2 (VDD I1_I60_pn0 XI1_I60_I37_p1 VDD) gpdk090_pmos1v w=0.48u l=0.1u ad=0.1056p as=0.1056p pd=0.92u ps=0.92u
    I_MXI1_I60_I37_MP3 (XI1_I60_I37_p1 XI1_I60_I37_Bn VDD VDD) gpdk090_pmos1v w=0.48u l=0.1u ad=0.1632p as=0.1056p pd=1.64u ps=0.92u
    I_MXI1_I60_I37_MP0 (VDD I1_I60_pn0 XI1_I60_I37_An VDD) gpdk090_pmos1v w=0.24u l=0.1u ad=0.0816p as=0.0816p pd=1.16u ps=1.16u
    I_MXI1_I48_I10_MP1 (VDD I1_b0_2 XI1_I48_I10_Bn VDD) gpdk090_pmos1v w=0.24u l=0.1u ad=0.0816p as=0.0816p pd=1.16u ps=1.16u
    I_MXI1_I48_I10_MP5 (I1_I48_pn2 I1_b0_2 XI1_I48_I10_p1 VDD) gpdk090_pmos1v w=0.48u l=0.1u ad=0.1056p as=0.1632p pd=0.92u ps=1.64u
    I_MXI1_I48_I10_MP4 (XI1_I48_I10_p1 XI1_I48_I10_An I1_I48_pn2 VDD) gpdk090_pmos1v w=0.48u l=0.1u ad=0.1056p as=0.1056p pd=0.92u ps=0.92u
    I_MXI1_I48_I10_MP2 (VDD VSS XI1_I48_I10_p1 VDD) gpdk090_pmos1v w=0.48u l=0.1u ad=0.1056p as=0.1056p pd=0.92u ps=0.92u
    I_MXI1_I48_I10_MP3 (XI1_I48_I10_p1 XI1_I48_I10_Bn VDD VDD) gpdk090_pmos1v w=0.48u l=0.1u ad=0.1632p as=0.1056p pd=1.64u ps=0.92u
    I_MXI1_I48_I10_MP0 (VDD VSS XI1_I48_I10_An VDD) gpdk090_pmos1v w=0.24u l=0.1u ad=0.0816p as=0.0816p pd=1.16u ps=1.16u
    I_MXI1_I108_I43_MP1 (VDD I1_I108_G5_0 XI1_I108_I43_Bn VDD) gpdk090_pmos1v w=0.24u l=0.1u ad=0.0816p as=0.0816p pd=1.16u ps=1.16u
    I_MXI1_I108_I43_MP5 (I1_p5_6 I1_I108_G5_0 XI1_I108_I43_p1 VDD) gpdk090_pmos1v w=0.48u l=0.1u ad=0.1056p as=0.1632p pd=0.92u ps=1.64u
    I_MXI1_I108_I43_MP4 (XI1_I108_I43_p1 XI1_I108_I43_An I1_p5_6 VDD) gpdk090_pmos1v w=0.48u l=0.1u ad=0.1056p as=0.1056p pd=0.92u ps=0.92u
    I_MXI1_I108_I43_MP2 (VDD I1_I108_pn6 XI1_I108_I43_p1 VDD) gpdk090_pmos1v w=0.48u l=0.1u ad=0.1056p as=0.1056p pd=0.92u ps=0.92u
    I_MXI1_I108_I43_MP3 (XI1_I108_I43_p1 XI1_I108_I43_Bn VDD VDD) gpdk090_pmos1v w=0.48u l=0.1u ad=0.1632p as=0.1056p pd=1.64u ps=0.92u
    I_MXI1_I108_I43_MP0 (VDD I1_I108_pn6 XI1_I108_I43_An VDD) gpdk090_pmos1v w=0.24u l=0.1u ad=0.0816p as=0.0816p pd=1.16u ps=1.16u
    I_MXI1_I96_I38_MP1 (VDD I1_I96_G0_0 XI1_I96_I38_Bn VDD) gpdk090_pmos1v w=0.24u l=0.1u ad=0.0816p as=0.0816p pd=1.16u ps=1.16u
    I_MXI1_I96_I38_MP5 (I1_p4_1 I1_I96_G0_0 XI1_I96_I38_p1 VDD) gpdk090_pmos1v w=0.48u l=0.1u ad=0.1056p as=0.1632p pd=0.92u ps=1.64u
    I_MXI1_I96_I38_MP4 (XI1_I96_I38_p1 XI1_I96_I38_An I1_p4_1 VDD) gpdk090_pmos1v w=0.48u l=0.1u ad=0.1056p as=0.1056p pd=0.92u ps=0.92u
    I_MXI1_I96_I38_MP2 (VDD I1_I96_pn1 XI1_I96_I38_p1 VDD) gpdk090_pmos1v w=0.48u l=0.1u ad=0.1056p as=0.1056p pd=0.92u ps=0.92u
    I_MXI1_I96_I38_MP3 (XI1_I96_I38_p1 XI1_I96_I38_Bn VDD VDD) gpdk090_pmos1v w=0.48u l=0.1u ad=0.1632p as=0.1056p pd=1.64u ps=0.92u
    I_MXI1_I96_I38_MP0 (VDD I1_I96_pn1 XI1_I96_I38_An VDD) gpdk090_pmos1v w=0.24u l=0.1u ad=0.0816p as=0.0816p pd=1.16u ps=1.16u
    I_MXI1_I108_I11_MP1 (VDD I1_b5_3 XI1_I108_I11_Bn VDD) gpdk090_pmos1v w=0.24u l=0.1u ad=0.0816p as=0.0816p pd=1.16u ps=1.16u
    I_MXI1_I108_I11_MP5 (I1_I108_pn3 I1_b5_3 XI1_I108_I11_p1 VDD) gpdk090_pmos1v w=0.48u l=0.1u ad=0.1056p as=0.1632p pd=0.92u ps=1.64u
    I_MXI1_I108_I11_MP4 (XI1_I108_I11_p1 XI1_I108_I11_An I1_I108_pn3 VDD) gpdk090_pmos1v w=0.48u l=0.1u ad=0.1056p as=0.1056p pd=0.92u ps=0.92u
    I_MXI1_I108_I11_MP2 (VDD I1_p4_2 XI1_I108_I11_p1 VDD) gpdk090_pmos1v w=0.48u l=0.1u ad=0.1056p as=0.1056p pd=0.92u ps=0.92u
    I_MXI1_I108_I11_MP3 (XI1_I108_I11_p1 XI1_I108_I11_Bn VDD VDD) gpdk090_pmos1v w=0.48u l=0.1u ad=0.1632p as=0.1056p pd=1.64u ps=0.92u
    I_MXI1_I108_I11_MP0 (VDD I1_p4_2 XI1_I108_I11_An VDD) gpdk090_pmos1v w=0.24u l=0.1u ad=0.0816p as=0.0816p pd=1.16u ps=1.16u
    I_MXI1_I96_I10_MP1 (VDD I1_b4_2 XI1_I96_I10_Bn VDD) gpdk090_pmos1v w=0.24u l=0.1u ad=0.0816p as=0.0816p pd=1.16u ps=1.16u
    I_MXI1_I96_I10_MP5 (I1_I96_pn2 I1_b4_2 XI1_I96_I10_p1 VDD) gpdk090_pmos1v w=0.48u l=0.1u ad=0.1056p as=0.1632p pd=0.92u ps=1.64u
    I_MXI1_I96_I10_MP4 (XI1_I96_I10_p1 XI1_I96_I10_An I1_I96_pn2 VDD) gpdk090_pmos1v w=0.48u l=0.1u ad=0.1056p as=0.1056p pd=0.92u ps=0.92u
    I_MXI1_I96_I10_MP2 (VDD I1_p3_1 XI1_I96_I10_p1 VDD) gpdk090_pmos1v w=0.48u l=0.1u ad=0.1056p as=0.1056p pd=0.92u ps=0.92u
    I_MXI1_I96_I10_MP3 (XI1_I96_I10_p1 XI1_I96_I10_Bn VDD VDD) gpdk090_pmos1v w=0.48u l=0.1u ad=0.1632p as=0.1056p pd=1.64u ps=0.92u
    I_MXI1_I96_I10_MP0 (VDD I1_p3_1 XI1_I96_I10_An VDD) gpdk090_pmos1v w=0.24u l=0.1u ad=0.0816p as=0.0816p pd=1.16u ps=1.16u
    I_MXI1_I84_I38_MP1 (VDD I1_I84_G0_0 XI1_I84_I38_Bn VDD) gpdk090_pmos1v w=0.24u l=0.1u ad=0.0816p as=0.0816p pd=1.16u ps=1.16u
    I_MXI1_I84_I38_MP5 (I1_p3_1 I1_I84_G0_0 XI1_I84_I38_p1 VDD) gpdk090_pmos1v w=0.48u l=0.1u ad=0.1056p as=0.1632p pd=0.92u ps=1.64u
    I_MXI1_I84_I38_MP4 (XI1_I84_I38_p1 XI1_I84_I38_An I1_p3_1 VDD) gpdk090_pmos1v w=0.48u l=0.1u ad=0.1056p as=0.1056p pd=0.92u ps=0.92u
    I_MXI1_I84_I38_MP2 (VDD I1_I84_pn1 XI1_I84_I38_p1 VDD) gpdk090_pmos1v w=0.48u l=0.1u ad=0.1056p as=0.1056p pd=0.92u ps=0.92u
    I_MXI1_I84_I38_MP3 (XI1_I84_I38_p1 XI1_I84_I38_Bn VDD VDD) gpdk090_pmos1v w=0.48u l=0.1u ad=0.1632p as=0.1056p pd=1.64u ps=0.92u
    I_MXI1_I84_I38_MP0 (VDD I1_I84_pn1 XI1_I84_I38_An VDD) gpdk090_pmos1v w=0.24u l=0.1u ad=0.0816p as=0.0816p pd=1.16u ps=1.16u
    I_MXI1_I84_I10_MP1 (VDD I1_b3_2 XI1_I84_I10_Bn VDD) gpdk090_pmos1v w=0.24u l=0.1u ad=0.0816p as=0.0816p pd=1.16u ps=1.16u
    I_MXI1_I84_I10_MP5 (I1_I84_pn2 I1_b3_2 XI1_I84_I10_p1 VDD) gpdk090_pmos1v w=0.48u l=0.1u ad=0.1056p as=0.1632p pd=0.92u ps=1.64u
    I_MXI1_I84_I10_MP4 (XI1_I84_I10_p1 XI1_I84_I10_An I1_I84_pn2 VDD) gpdk090_pmos1v w=0.48u l=0.1u ad=0.1056p as=0.1056p pd=0.92u ps=0.92u
    I_MXI1_I84_I10_MP2 (VDD I1_p2_1 XI1_I84_I10_p1 VDD) gpdk090_pmos1v w=0.48u l=0.1u ad=0.1056p as=0.1056p pd=0.92u ps=0.92u
    I_MXI1_I84_I10_MP3 (XI1_I84_I10_p1 XI1_I84_I10_Bn VDD VDD) gpdk090_pmos1v w=0.48u l=0.1u ad=0.1632p as=0.1056p pd=1.64u ps=0.92u
    I_MXI1_I84_I10_MP0 (VDD I1_p2_1 XI1_I84_I10_An VDD) gpdk090_pmos1v w=0.24u l=0.1u ad=0.0816p as=0.0816p pd=1.16u ps=1.16u
    I_MXI1_I72_I38_MP1 (VDD I1_I72_G0_0 XI1_I72_I38_Bn VDD) gpdk090_pmos1v w=0.24u l=0.1u ad=0.0816p as=0.0816p pd=1.16u ps=1.16u
    I_MXI1_I72_I38_MP5 (I1_p2_1 I1_I72_G0_0 XI1_I72_I38_p1 VDD) gpdk090_pmos1v w=0.48u l=0.1u ad=0.1056p as=0.1632p pd=0.92u ps=1.64u
    I_MXI1_I72_I38_MP4 (XI1_I72_I38_p1 XI1_I72_I38_An I1_p2_1 VDD) gpdk090_pmos1v w=0.48u l=0.1u ad=0.1056p as=0.1056p pd=0.92u ps=0.92u
    I_MXI1_I72_I38_MP2 (VDD I1_I72_pn1 XI1_I72_I38_p1 VDD) gpdk090_pmos1v w=0.48u l=0.1u ad=0.1056p as=0.1056p pd=0.92u ps=0.92u
    I_MXI1_I72_I38_MP3 (XI1_I72_I38_p1 XI1_I72_I38_Bn VDD VDD) gpdk090_pmos1v w=0.48u l=0.1u ad=0.1632p as=0.1056p pd=1.64u ps=0.92u
    I_MXI1_I72_I38_MP0 (VDD I1_I72_pn1 XI1_I72_I38_An VDD) gpdk090_pmos1v w=0.24u l=0.1u ad=0.0816p as=0.0816p pd=1.16u ps=1.16u
    I_MXI1_I72_I9_MP1 (VDD I1_b2_1 XI1_I72_I9_Bn VDD) gpdk090_pmos1v w=0.24u l=0.1u ad=0.0816p as=0.0816p pd=1.16u ps=1.16u
    I_MXI1_I72_I9_MP5 (I1_I72_pn1 I1_b2_1 XI1_I72_I9_p1 VDD) gpdk090_pmos1v w=0.48u l=0.1u ad=0.1056p as=0.1632p pd=0.92u ps=1.64u
    I_MXI1_I72_I9_MP4 (XI1_I72_I9_p1 XI1_I72_I9_An I1_I72_pn1 VDD) gpdk090_pmos1v w=0.48u l=0.1u ad=0.1056p as=0.1056p pd=0.92u ps=0.92u
    I_MXI1_I72_I9_MP2 (VDD I1_p1_0 XI1_I72_I9_p1 VDD) gpdk090_pmos1v w=0.48u l=0.1u ad=0.1056p as=0.1056p pd=0.92u ps=0.92u
    I_MXI1_I72_I9_MP3 (XI1_I72_I9_p1 XI1_I72_I9_Bn VDD VDD) gpdk090_pmos1v w=0.48u l=0.1u ad=0.1632p as=0.1056p pd=1.64u ps=0.92u
    I_MXI1_I72_I9_MP0 (VDD I1_p1_0 XI1_I72_I9_An VDD) gpdk090_pmos1v w=0.24u l=0.1u ad=0.0816p as=0.0816p pd=1.16u ps=1.16u
    I_MXI1_I72_I10_MP1 (VDD I1_b2_2 XI1_I72_I10_Bn VDD) gpdk090_pmos1v w=0.24u l=0.1u ad=0.0816p as=0.0816p pd=1.16u ps=1.16u
    I_MXI1_I72_I10_MP5 (I1_I72_pn2 I1_b2_2 XI1_I72_I10_p1 VDD) gpdk090_pmos1v w=0.48u l=0.1u ad=0.1056p as=0.1632p pd=0.92u ps=1.64u
    I_MXI1_I72_I10_MP4 (XI1_I72_I10_p1 XI1_I72_I10_An I1_I72_pn2 VDD) gpdk090_pmos1v w=0.48u l=0.1u ad=0.1056p as=0.1056p pd=0.92u ps=0.92u
    I_MXI1_I72_I10_MP2 (VDD I1_p1_1 XI1_I72_I10_p1 VDD) gpdk090_pmos1v w=0.48u l=0.1u ad=0.1056p as=0.1056p pd=0.92u ps=0.92u
    I_MXI1_I72_I10_MP3 (XI1_I72_I10_p1 XI1_I72_I10_Bn VDD VDD) gpdk090_pmos1v w=0.48u l=0.1u ad=0.1632p as=0.1056p pd=1.64u ps=0.92u
    I_MXI1_I72_I10_MP0 (VDD I1_p1_1 XI1_I72_I10_An VDD) gpdk090_pmos1v w=0.24u l=0.1u ad=0.0816p as=0.0816p pd=1.16u ps=1.16u
    I_MXI1_I60_I38_MP1 (VDD I1_I60_G0_0 XI1_I60_I38_Bn VDD) gpdk090_pmos1v w=0.24u l=0.1u ad=0.0816p as=0.0816p pd=1.16u ps=1.16u
    I_MXI1_I60_I38_MP5 (I1_p1_1 I1_I60_G0_0 XI1_I60_I38_p1 VDD) gpdk090_pmos1v w=0.48u l=0.1u ad=0.1056p as=0.1632p pd=0.92u ps=1.64u
    I_MXI1_I60_I38_MP4 (XI1_I60_I38_p1 XI1_I60_I38_An I1_p1_1 VDD) gpdk090_pmos1v w=0.48u l=0.1u ad=0.1056p as=0.1056p pd=0.92u ps=0.92u
    I_MXI1_I60_I38_MP2 (VDD I1_I60_pn1 XI1_I60_I38_p1 VDD) gpdk090_pmos1v w=0.48u l=0.1u ad=0.1056p as=0.1056p pd=0.92u ps=0.92u
    I_MXI1_I60_I38_MP3 (XI1_I60_I38_p1 XI1_I60_I38_Bn VDD VDD) gpdk090_pmos1v w=0.48u l=0.1u ad=0.1632p as=0.1056p pd=1.64u ps=0.92u
    I_MXI1_I60_I38_MP0 (VDD I1_I60_pn1 XI1_I60_I38_An VDD) gpdk090_pmos1v w=0.24u l=0.1u ad=0.0816p as=0.0816p pd=1.16u ps=1.16u
    I_MXI1_I60_I9_MP1 (VDD I1_b1_1 XI1_I60_I9_Bn VDD) gpdk090_pmos1v w=0.24u l=0.1u ad=0.0816p as=0.0816p pd=1.16u ps=1.16u
    I_MXI1_I60_I9_MP5 (I1_I60_pn1 I1_b1_1 XI1_I60_I9_p1 VDD) gpdk090_pmos1v w=0.48u l=0.1u ad=0.1056p as=0.1632p pd=0.92u ps=1.64u
    I_MXI1_I60_I9_MP4 (XI1_I60_I9_p1 XI1_I60_I9_An I1_I60_pn1 VDD) gpdk090_pmos1v w=0.48u l=0.1u ad=0.1056p as=0.1056p pd=0.92u ps=0.92u
    I_MXI1_I60_I9_MP2 (VDD I1_p0_0 XI1_I60_I9_p1 VDD) gpdk090_pmos1v w=0.48u l=0.1u ad=0.1056p as=0.1056p pd=0.92u ps=0.92u
    I_MXI1_I60_I9_MP3 (XI1_I60_I9_p1 XI1_I60_I9_Bn VDD VDD) gpdk090_pmos1v w=0.48u l=0.1u ad=0.1632p as=0.1056p pd=1.64u ps=0.92u
    I_MXI1_I60_I9_MP0 (VDD I1_p0_0 XI1_I60_I9_An VDD) gpdk090_pmos1v w=0.24u l=0.1u ad=0.0816p as=0.0816p pd=1.16u ps=1.16u
    I_MXI1_I48_I38_MP1 (VDD I1_I48_G0_0 XI1_I48_I38_Bn VDD) gpdk090_pmos1v w=0.24u l=0.1u ad=0.0816p as=0.0816p pd=1.16u ps=1.16u
    I_MXI1_I48_I38_MP5 (I1_p0_1 I1_I48_G0_0 XI1_I48_I38_p1 VDD) gpdk090_pmos1v w=0.48u l=0.1u ad=0.1056p as=0.1632p pd=0.92u ps=1.64u
    I_MXI1_I48_I38_MP4 (XI1_I48_I38_p1 XI1_I48_I38_An I1_p0_1 VDD) gpdk090_pmos1v w=0.48u l=0.1u ad=0.1056p as=0.1056p pd=0.92u ps=0.92u
    I_MXI1_I48_I38_MP2 (VDD I1_I48_pn1 XI1_I48_I38_p1 VDD) gpdk090_pmos1v w=0.48u l=0.1u ad=0.1056p as=0.1056p pd=0.92u ps=0.92u
    I_MXI1_I48_I38_MP3 (XI1_I48_I38_p1 XI1_I48_I38_Bn VDD VDD) gpdk090_pmos1v w=0.48u l=0.1u ad=0.1632p as=0.1056p pd=1.64u ps=0.92u
    I_MXI1_I48_I38_MP0 (VDD I1_I48_pn1 XI1_I48_I38_An VDD) gpdk090_pmos1v w=0.24u l=0.1u ad=0.0816p as=0.0816p pd=1.16u ps=1.16u
    I_MXI1_I60_I10_MP1 (VDD I1_b1_2 XI1_I60_I10_Bn VDD) gpdk090_pmos1v w=0.24u l=0.1u ad=0.0816p as=0.0816p pd=1.16u ps=1.16u
    I_MXI1_I60_I10_MP5 (I1_I60_pn2 I1_b1_2 XI1_I60_I10_p1 VDD) gpdk090_pmos1v w=0.48u l=0.1u ad=0.1056p as=0.1632p pd=0.92u ps=1.64u
    I_MXI1_I60_I10_MP4 (XI1_I60_I10_p1 XI1_I60_I10_An I1_I60_pn2 VDD) gpdk090_pmos1v w=0.48u l=0.1u ad=0.1056p as=0.1056p pd=0.92u ps=0.92u
    I_MXI1_I60_I10_MP2 (VDD I1_p0_1 XI1_I60_I10_p1 VDD) gpdk090_pmos1v w=0.48u l=0.1u ad=0.1056p as=0.1056p pd=0.92u ps=0.92u
    I_MXI1_I60_I10_MP3 (XI1_I60_I10_p1 XI1_I60_I10_Bn VDD VDD) gpdk090_pmos1v w=0.48u l=0.1u ad=0.1632p as=0.1056p pd=1.64u ps=0.92u
    I_MXI1_I60_I10_MP0 (VDD I1_p0_1 XI1_I60_I10_An VDD) gpdk090_pmos1v w=0.24u l=0.1u ad=0.0816p as=0.0816p pd=1.16u ps=1.16u
    I_MXI1_I48_I9_MP1 (VDD I1_b0_1 XI1_I48_I9_Bn VDD) gpdk090_pmos1v w=0.24u l=0.1u ad=0.0816p as=0.0816p pd=1.16u ps=1.16u
    I_MXI1_I48_I9_MP5 (I1_I48_pn1 I1_b0_1 XI1_I48_I9_p1 VDD) gpdk090_pmos1v w=0.48u l=0.1u ad=0.1056p as=0.1632p pd=0.92u ps=1.64u
    I_MXI1_I48_I9_MP4 (XI1_I48_I9_p1 XI1_I48_I9_An I1_I48_pn1 VDD) gpdk090_pmos1v w=0.48u l=0.1u ad=0.1056p as=0.1056p pd=0.92u ps=0.92u
    I_MXI1_I48_I9_MP2 (VDD VSS XI1_I48_I9_p1 VDD) gpdk090_pmos1v w=0.48u l=0.1u ad=0.1056p as=0.1056p pd=0.92u ps=0.92u
    I_MXI1_I48_I9_MP3 (XI1_I48_I9_p1 XI1_I48_I9_Bn VDD VDD) gpdk090_pmos1v w=0.48u l=0.1u ad=0.1632p as=0.1056p pd=1.64u ps=0.92u
    I_MXI1_I48_I9_MP0 (VDD VSS XI1_I48_I9_An VDD) gpdk090_pmos1v w=0.24u l=0.1u ad=0.0816p as=0.0816p pd=1.16u ps=1.16u
    I_MXI1_I48_I11_MP1 (VDD I1_b0_3 XI1_I48_I11_Bn VDD) gpdk090_pmos1v w=0.24u l=0.1u ad=0.0816p as=0.0816p pd=1.16u ps=1.16u
    I_MXI1_I48_I11_MP5 (I1_I48_pn3 I1_b0_3 XI1_I48_I11_p1 VDD) gpdk090_pmos1v w=0.48u l=0.1u ad=0.1056p as=0.1632p pd=0.92u ps=1.64u
    I_MXI1_I48_I11_MP4 (XI1_I48_I11_p1 XI1_I48_I11_An I1_I48_pn3 VDD) gpdk090_pmos1v w=0.48u l=0.1u ad=0.1056p as=0.1056p pd=0.92u ps=0.92u
    I_MXI1_I48_I11_MP2 (VDD VSS XI1_I48_I11_p1 VDD) gpdk090_pmos1v w=0.48u l=0.1u ad=0.1056p as=0.1056p pd=0.92u ps=0.92u
    I_MXI1_I48_I11_MP3 (XI1_I48_I11_p1 XI1_I48_I11_Bn VDD VDD) gpdk090_pmos1v w=0.48u l=0.1u ad=0.1632p as=0.1056p pd=1.64u ps=0.92u
    I_MXI1_I48_I11_MP0 (VDD VSS XI1_I48_I11_An VDD) gpdk090_pmos1v w=0.24u l=0.1u ad=0.0816p as=0.0816p pd=1.16u ps=1.16u
    I_MXI1_I108_I12_MP1 (VDD I1_b5_4 XI1_I108_I12_Bn VDD) gpdk090_pmos1v w=0.24u l=0.1u ad=0.0816p as=0.0816p pd=1.16u ps=1.16u
    I_MXI1_I108_I12_MP5 (I1_I108_pn4 I1_b5_4 XI1_I108_I12_p1 VDD) gpdk090_pmos1v w=0.48u l=0.1u ad=0.1056p as=0.1632p pd=0.92u ps=1.64u
    I_MXI1_I108_I12_MP4 (XI1_I108_I12_p1 XI1_I108_I12_An I1_I108_pn4 VDD) gpdk090_pmos1v w=0.48u l=0.1u ad=0.1056p as=0.1056p pd=0.92u ps=0.92u
    I_MXI1_I108_I12_MP2 (VDD I1_p4_3 XI1_I108_I12_p1 VDD) gpdk090_pmos1v w=0.48u l=0.1u ad=0.1056p as=0.1056p pd=0.92u ps=0.92u
    I_MXI1_I108_I12_MP3 (XI1_I108_I12_p1 XI1_I108_I12_Bn VDD VDD) gpdk090_pmos1v w=0.48u l=0.1u ad=0.1632p as=0.1056p pd=1.64u ps=0.92u
    I_MXI1_I108_I12_MP0 (VDD I1_p4_3 XI1_I108_I12_An VDD) gpdk090_pmos1v w=0.24u l=0.1u ad=0.0816p as=0.0816p pd=1.16u ps=1.16u
    I_MXI1_I96_I39_MP1 (VDD I1_I96_G1_0 XI1_I96_I39_Bn VDD) gpdk090_pmos1v w=0.24u l=0.1u ad=0.0816p as=0.0816p pd=1.16u ps=1.16u
    I_MXI1_I96_I39_MP5 (I1_p4_2 I1_I96_G1_0 XI1_I96_I39_p1 VDD) gpdk090_pmos1v w=0.48u l=0.1u ad=0.1056p as=0.1632p pd=0.92u ps=1.64u
    I_MXI1_I96_I39_MP4 (XI1_I96_I39_p1 XI1_I96_I39_An I1_p4_2 VDD) gpdk090_pmos1v w=0.48u l=0.1u ad=0.1056p as=0.1056p pd=0.92u ps=0.92u
    I_MXI1_I96_I39_MP2 (VDD I1_I96_pn2 XI1_I96_I39_p1 VDD) gpdk090_pmos1v w=0.48u l=0.1u ad=0.1056p as=0.1056p pd=0.92u ps=0.92u
    I_MXI1_I96_I39_MP3 (XI1_I96_I39_p1 XI1_I96_I39_Bn VDD VDD) gpdk090_pmos1v w=0.48u l=0.1u ad=0.1632p as=0.1056p pd=1.64u ps=0.92u
    I_MXI1_I96_I39_MP0 (VDD I1_I96_pn2 XI1_I96_I39_An VDD) gpdk090_pmos1v w=0.24u l=0.1u ad=0.0816p as=0.0816p pd=1.16u ps=1.16u
    I_MXI1_I96_I11_MP1 (VDD I1_b4_3 XI1_I96_I11_Bn VDD) gpdk090_pmos1v w=0.24u l=0.1u ad=0.0816p as=0.0816p pd=1.16u ps=1.16u
    I_MXI1_I96_I11_MP5 (I1_I96_pn3 I1_b4_3 XI1_I96_I11_p1 VDD) gpdk090_pmos1v w=0.48u l=0.1u ad=0.1056p as=0.1632p pd=0.92u ps=1.64u
    I_MXI1_I96_I11_MP4 (XI1_I96_I11_p1 XI1_I96_I11_An I1_I96_pn3 VDD) gpdk090_pmos1v w=0.48u l=0.1u ad=0.1056p as=0.1056p pd=0.92u ps=0.92u
    I_MXI1_I96_I11_MP2 (VDD I1_p3_2 XI1_I96_I11_p1 VDD) gpdk090_pmos1v w=0.48u l=0.1u ad=0.1056p as=0.1056p pd=0.92u ps=0.92u
    I_MXI1_I96_I11_MP3 (XI1_I96_I11_p1 XI1_I96_I11_Bn VDD VDD) gpdk090_pmos1v w=0.48u l=0.1u ad=0.1632p as=0.1056p pd=1.64u ps=0.92u
    I_MXI1_I96_I11_MP0 (VDD I1_p3_2 XI1_I96_I11_An VDD) gpdk090_pmos1v w=0.24u l=0.1u ad=0.0816p as=0.0816p pd=1.16u ps=1.16u
    I_MXI1_I84_I39_MP1 (VDD I1_I84_G1_0 XI1_I84_I39_Bn VDD) gpdk090_pmos1v w=0.24u l=0.1u ad=0.0816p as=0.0816p pd=1.16u ps=1.16u
    I_MXI1_I84_I39_MP5 (I1_p3_2 I1_I84_G1_0 XI1_I84_I39_p1 VDD) gpdk090_pmos1v w=0.48u l=0.1u ad=0.1056p as=0.1632p pd=0.92u ps=1.64u
    I_MXI1_I84_I39_MP4 (XI1_I84_I39_p1 XI1_I84_I39_An I1_p3_2 VDD) gpdk090_pmos1v w=0.48u l=0.1u ad=0.1056p as=0.1056p pd=0.92u ps=0.92u
    I_MXI1_I84_I39_MP2 (VDD I1_I84_pn2 XI1_I84_I39_p1 VDD) gpdk090_pmos1v w=0.48u l=0.1u ad=0.1056p as=0.1056p pd=0.92u ps=0.92u
    I_MXI1_I84_I39_MP3 (XI1_I84_I39_p1 XI1_I84_I39_Bn VDD VDD) gpdk090_pmos1v w=0.48u l=0.1u ad=0.1632p as=0.1056p pd=1.64u ps=0.92u
    I_MXI1_I84_I39_MP0 (VDD I1_I84_pn2 XI1_I84_I39_An VDD) gpdk090_pmos1v w=0.24u l=0.1u ad=0.0816p as=0.0816p pd=1.16u ps=1.16u
    I_MXI1_I84_I11_MP1 (VDD I1_b3_3 XI1_I84_I11_Bn VDD) gpdk090_pmos1v w=0.24u l=0.1u ad=0.0816p as=0.0816p pd=1.16u ps=1.16u
    I_MXI1_I84_I11_MP5 (I1_I84_pn3 I1_b3_3 XI1_I84_I11_p1 VDD) gpdk090_pmos1v w=0.48u l=0.1u ad=0.1056p as=0.1632p pd=0.92u ps=1.64u
    I_MXI1_I84_I11_MP4 (XI1_I84_I11_p1 XI1_I84_I11_An I1_I84_pn3 VDD) gpdk090_pmos1v w=0.48u l=0.1u ad=0.1056p as=0.1056p pd=0.92u ps=0.92u
    I_MXI1_I84_I11_MP2 (VDD I1_p2_2 XI1_I84_I11_p1 VDD) gpdk090_pmos1v w=0.48u l=0.1u ad=0.1056p as=0.1056p pd=0.92u ps=0.92u
    I_MXI1_I84_I11_MP3 (XI1_I84_I11_p1 XI1_I84_I11_Bn VDD VDD) gpdk090_pmos1v w=0.48u l=0.1u ad=0.1632p as=0.1056p pd=1.64u ps=0.92u
    I_MXI1_I84_I11_MP0 (VDD I1_p2_2 XI1_I84_I11_An VDD) gpdk090_pmos1v w=0.24u l=0.1u ad=0.0816p as=0.0816p pd=1.16u ps=1.16u
    I_MXI1_I72_I39_MP1 (VDD I1_I72_G1_0 XI1_I72_I39_Bn VDD) gpdk090_pmos1v w=0.24u l=0.1u ad=0.0816p as=0.0816p pd=1.16u ps=1.16u
    I_MXI1_I72_I39_MP5 (I1_p2_2 I1_I72_G1_0 XI1_I72_I39_p1 VDD) gpdk090_pmos1v w=0.48u l=0.1u ad=0.1056p as=0.1632p pd=0.92u ps=1.64u
    I_MXI1_I72_I39_MP4 (XI1_I72_I39_p1 XI1_I72_I39_An I1_p2_2 VDD) gpdk090_pmos1v w=0.48u l=0.1u ad=0.1056p as=0.1056p pd=0.92u ps=0.92u
    I_MXI1_I72_I39_MP2 (VDD I1_I72_pn2 XI1_I72_I39_p1 VDD) gpdk090_pmos1v w=0.48u l=0.1u ad=0.1056p as=0.1056p pd=0.92u ps=0.92u
    I_MXI1_I72_I39_MP3 (XI1_I72_I39_p1 XI1_I72_I39_Bn VDD VDD) gpdk090_pmos1v w=0.48u l=0.1u ad=0.1632p as=0.1056p pd=1.64u ps=0.92u
    I_MXI1_I72_I39_MP0 (VDD I1_I72_pn2 XI1_I72_I39_An VDD) gpdk090_pmos1v w=0.24u l=0.1u ad=0.0816p as=0.0816p pd=1.16u ps=1.16u
    I_MXI1_I72_I11_MP1 (VDD I1_b2_3 XI1_I72_I11_Bn VDD) gpdk090_pmos1v w=0.24u l=0.1u ad=0.0816p as=0.0816p pd=1.16u ps=1.16u
    I_MXI1_I72_I11_MP5 (I1_I72_pn3 I1_b2_3 XI1_I72_I11_p1 VDD) gpdk090_pmos1v w=0.48u l=0.1u ad=0.1056p as=0.1632p pd=0.92u ps=1.64u
    I_MXI1_I72_I11_MP4 (XI1_I72_I11_p1 XI1_I72_I11_An I1_I72_pn3 VDD) gpdk090_pmos1v w=0.48u l=0.1u ad=0.1056p as=0.1056p pd=0.92u ps=0.92u
    I_MXI1_I72_I11_MP2 (VDD I1_p1_2 XI1_I72_I11_p1 VDD) gpdk090_pmos1v w=0.48u l=0.1u ad=0.1056p as=0.1056p pd=0.92u ps=0.92u
    I_MXI1_I72_I11_MP3 (XI1_I72_I11_p1 XI1_I72_I11_Bn VDD VDD) gpdk090_pmos1v w=0.48u l=0.1u ad=0.1632p as=0.1056p pd=1.64u ps=0.92u
    I_MXI1_I72_I11_MP0 (VDD I1_p1_2 XI1_I72_I11_An VDD) gpdk090_pmos1v w=0.24u l=0.1u ad=0.0816p as=0.0816p pd=1.16u ps=1.16u
    I_MXI1_I60_I39_MP1 (VDD I1_I60_G1_0 XI1_I60_I39_Bn VDD) gpdk090_pmos1v w=0.24u l=0.1u ad=0.0816p as=0.0816p pd=1.16u ps=1.16u
    I_MXI1_I60_I39_MP5 (I1_p1_2 I1_I60_G1_0 XI1_I60_I39_p1 VDD) gpdk090_pmos1v w=0.48u l=0.1u ad=0.1056p as=0.1632p pd=0.92u ps=1.64u
    I_MXI1_I60_I39_MP4 (XI1_I60_I39_p1 XI1_I60_I39_An I1_p1_2 VDD) gpdk090_pmos1v w=0.48u l=0.1u ad=0.1056p as=0.1056p pd=0.92u ps=0.92u
    I_MXI1_I60_I39_MP2 (VDD I1_I60_pn2 XI1_I60_I39_p1 VDD) gpdk090_pmos1v w=0.48u l=0.1u ad=0.1056p as=0.1056p pd=0.92u ps=0.92u
    I_MXI1_I60_I39_MP3 (XI1_I60_I39_p1 XI1_I60_I39_Bn VDD VDD) gpdk090_pmos1v w=0.48u l=0.1u ad=0.1632p as=0.1056p pd=1.64u ps=0.92u
    I_MXI1_I60_I39_MP0 (VDD I1_I60_pn2 XI1_I60_I39_An VDD) gpdk090_pmos1v w=0.24u l=0.1u ad=0.0816p as=0.0816p pd=1.16u ps=1.16u
    I_MXI1_I60_I11_MP1 (VDD I1_b1_3 XI1_I60_I11_Bn VDD) gpdk090_pmos1v w=0.24u l=0.1u ad=0.0816p as=0.0816p pd=1.16u ps=1.16u
    I_MXI1_I60_I11_MP5 (I1_I60_pn3 I1_b1_3 XI1_I60_I11_p1 VDD) gpdk090_pmos1v w=0.48u l=0.1u ad=0.1056p as=0.1632p pd=0.92u ps=1.64u
    I_MXI1_I60_I11_MP4 (XI1_I60_I11_p1 XI1_I60_I11_An I1_I60_pn3 VDD) gpdk090_pmos1v w=0.48u l=0.1u ad=0.1056p as=0.1056p pd=0.92u ps=0.92u
    I_MXI1_I60_I11_MP2 (VDD I1_p0_2 XI1_I60_I11_p1 VDD) gpdk090_pmos1v w=0.48u l=0.1u ad=0.1056p as=0.1056p pd=0.92u ps=0.92u
    I_MXI1_I60_I11_MP3 (XI1_I60_I11_p1 XI1_I60_I11_Bn VDD VDD) gpdk090_pmos1v w=0.48u l=0.1u ad=0.1632p as=0.1056p pd=1.64u ps=0.92u
    I_MXI1_I60_I11_MP0 (VDD I1_p0_2 XI1_I60_I11_An VDD) gpdk090_pmos1v w=0.24u l=0.1u ad=0.0816p as=0.0816p pd=1.16u ps=1.16u
    I_MXI1_I48_I39_MP1 (VDD I1_I48_G1_0 XI1_I48_I39_Bn VDD) gpdk090_pmos1v w=0.24u l=0.1u ad=0.0816p as=0.0816p pd=1.16u ps=1.16u
    I_MXI1_I48_I39_MP5 (I1_p0_2 I1_I48_G1_0 XI1_I48_I39_p1 VDD) gpdk090_pmos1v w=0.48u l=0.1u ad=0.1056p as=0.1632p pd=0.92u ps=1.64u
    I_MXI1_I48_I39_MP4 (XI1_I48_I39_p1 XI1_I48_I39_An I1_p0_2 VDD) gpdk090_pmos1v w=0.48u l=0.1u ad=0.1056p as=0.1056p pd=0.92u ps=0.92u
    I_MXI1_I48_I39_MP2 (VDD I1_I48_pn2 XI1_I48_I39_p1 VDD) gpdk090_pmos1v w=0.48u l=0.1u ad=0.1056p as=0.1056p pd=0.92u ps=0.92u
    I_MXI1_I48_I39_MP3 (XI1_I48_I39_p1 XI1_I48_I39_Bn VDD VDD) gpdk090_pmos1v w=0.48u l=0.1u ad=0.1632p as=0.1056p pd=1.64u ps=0.92u
    I_MXI1_I48_I39_MP0 (VDD I1_I48_pn2 XI1_I48_I39_An VDD) gpdk090_pmos1v w=0.24u l=0.1u ad=0.0816p as=0.0816p pd=1.16u ps=1.16u
    I_MXI1_I48_I12_MP1 (VDD I1_b0_4 XI1_I48_I12_Bn VDD) gpdk090_pmos1v w=0.24u l=0.1u ad=0.0816p as=0.0816p pd=1.16u ps=1.16u
    I_MXI1_I48_I12_MP5 (I1_I48_pn4 I1_b0_4 XI1_I48_I12_p1 VDD) gpdk090_pmos1v w=0.48u l=0.1u ad=0.1056p as=0.1632p pd=0.92u ps=1.64u
    I_MXI1_I48_I12_MP4 (XI1_I48_I12_p1 XI1_I48_I12_An I1_I48_pn4 VDD) gpdk090_pmos1v w=0.48u l=0.1u ad=0.1056p as=0.1056p pd=0.92u ps=0.92u
    I_MXI1_I48_I12_MP2 (VDD VSS XI1_I48_I12_p1 VDD) gpdk090_pmos1v w=0.48u l=0.1u ad=0.1056p as=0.1056p pd=0.92u ps=0.92u
    I_MXI1_I48_I12_MP3 (XI1_I48_I12_p1 XI1_I48_I12_Bn VDD VDD) gpdk090_pmos1v w=0.48u l=0.1u ad=0.1632p as=0.1056p pd=1.64u ps=0.92u
    I_MXI1_I48_I12_MP0 (VDD VSS XI1_I48_I12_An VDD) gpdk090_pmos1v w=0.24u l=0.1u ad=0.0816p as=0.0816p pd=1.16u ps=1.16u
    I_MXI1_I108_I13_MP1 (VDD I1_b5_5 XI1_I108_I13_Bn VDD) gpdk090_pmos1v w=0.24u l=0.1u ad=0.0816p as=0.0816p pd=1.16u ps=1.16u
    I_MXI1_I108_I13_MP5 (I1_I108_pn5 I1_b5_5 XI1_I108_I13_p1 VDD) gpdk090_pmos1v w=0.48u l=0.1u ad=0.1056p as=0.1632p pd=0.92u ps=1.64u
    I_MXI1_I108_I13_MP4 (XI1_I108_I13_p1 XI1_I108_I13_An I1_I108_pn5 VDD) gpdk090_pmos1v w=0.48u l=0.1u ad=0.1056p as=0.1056p pd=0.92u ps=0.92u
    I_MXI1_I108_I13_MP2 (VDD I1_p4_4 XI1_I108_I13_p1 VDD) gpdk090_pmos1v w=0.48u l=0.1u ad=0.1056p as=0.1056p pd=0.92u ps=0.92u
    I_MXI1_I108_I13_MP3 (XI1_I108_I13_p1 XI1_I108_I13_Bn VDD VDD) gpdk090_pmos1v w=0.48u l=0.1u ad=0.1632p as=0.1056p pd=1.64u ps=0.92u
    I_MXI1_I108_I13_MP0 (VDD I1_p4_4 XI1_I108_I13_An VDD) gpdk090_pmos1v w=0.24u l=0.1u ad=0.0816p as=0.0816p pd=1.16u ps=1.16u
    I_MXI1_I96_I12_MP1 (VDD I1_b4_4 XI1_I96_I12_Bn VDD) gpdk090_pmos1v w=0.24u l=0.1u ad=0.0816p as=0.0816p pd=1.16u ps=1.16u
    I_MXI1_I96_I12_MP5 (I1_I96_pn4 I1_b4_4 XI1_I96_I12_p1 VDD) gpdk090_pmos1v w=0.48u l=0.1u ad=0.1056p as=0.1632p pd=0.92u ps=1.64u
    I_MXI1_I96_I12_MP4 (XI1_I96_I12_p1 XI1_I96_I12_An I1_I96_pn4 VDD) gpdk090_pmos1v w=0.48u l=0.1u ad=0.1056p as=0.1056p pd=0.92u ps=0.92u
    I_MXI1_I96_I12_MP2 (VDD I1_p3_3 XI1_I96_I12_p1 VDD) gpdk090_pmos1v w=0.48u l=0.1u ad=0.1056p as=0.1056p pd=0.92u ps=0.92u
    I_MXI1_I96_I12_MP3 (XI1_I96_I12_p1 XI1_I96_I12_Bn VDD VDD) gpdk090_pmos1v w=0.48u l=0.1u ad=0.1632p as=0.1056p pd=1.64u ps=0.92u
    I_MXI1_I96_I12_MP0 (VDD I1_p3_3 XI1_I96_I12_An VDD) gpdk090_pmos1v w=0.24u l=0.1u ad=0.0816p as=0.0816p pd=1.16u ps=1.16u
    I_MXI1_I84_I12_MP1 (VDD I1_b3_4 XI1_I84_I12_Bn VDD) gpdk090_pmos1v w=0.24u l=0.1u ad=0.0816p as=0.0816p pd=1.16u ps=1.16u
    I_MXI1_I84_I12_MP5 (I1_I84_pn4 I1_b3_4 XI1_I84_I12_p1 VDD) gpdk090_pmos1v w=0.48u l=0.1u ad=0.1056p as=0.1632p pd=0.92u ps=1.64u
    I_MXI1_I84_I12_MP4 (XI1_I84_I12_p1 XI1_I84_I12_An I1_I84_pn4 VDD) gpdk090_pmos1v w=0.48u l=0.1u ad=0.1056p as=0.1056p pd=0.92u ps=0.92u
    I_MXI1_I84_I12_MP2 (VDD I1_p2_3 XI1_I84_I12_p1 VDD) gpdk090_pmos1v w=0.48u l=0.1u ad=0.1056p as=0.1056p pd=0.92u ps=0.92u
    I_MXI1_I84_I12_MP3 (XI1_I84_I12_p1 XI1_I84_I12_Bn VDD VDD) gpdk090_pmos1v w=0.48u l=0.1u ad=0.1632p as=0.1056p pd=1.64u ps=0.92u
    I_MXI1_I84_I12_MP0 (VDD I1_p2_3 XI1_I84_I12_An VDD) gpdk090_pmos1v w=0.24u l=0.1u ad=0.0816p as=0.0816p pd=1.16u ps=1.16u
    I_MXI1_I72_I12_MP1 (VDD I1_b2_4 XI1_I72_I12_Bn VDD) gpdk090_pmos1v w=0.24u l=0.1u ad=0.0816p as=0.0816p pd=1.16u ps=1.16u
    I_MXI1_I72_I12_MP5 (I1_I72_pn4 I1_b2_4 XI1_I72_I12_p1 VDD) gpdk090_pmos1v w=0.48u l=0.1u ad=0.1056p as=0.1632p pd=0.92u ps=1.64u
    I_MXI1_I72_I12_MP4 (XI1_I72_I12_p1 XI1_I72_I12_An I1_I72_pn4 VDD) gpdk090_pmos1v w=0.48u l=0.1u ad=0.1056p as=0.1056p pd=0.92u ps=0.92u
    I_MXI1_I72_I12_MP2 (VDD I1_p1_3 XI1_I72_I12_p1 VDD) gpdk090_pmos1v w=0.48u l=0.1u ad=0.1056p as=0.1056p pd=0.92u ps=0.92u
    I_MXI1_I72_I12_MP3 (XI1_I72_I12_p1 XI1_I72_I12_Bn VDD VDD) gpdk090_pmos1v w=0.48u l=0.1u ad=0.1632p as=0.1056p pd=1.64u ps=0.92u
    I_MXI1_I72_I12_MP0 (VDD I1_p1_3 XI1_I72_I12_An VDD) gpdk090_pmos1v w=0.24u l=0.1u ad=0.0816p as=0.0816p pd=1.16u ps=1.16u
    I_MXI1_I60_I12_MP1 (VDD I1_b1_4 XI1_I60_I12_Bn VDD) gpdk090_pmos1v w=0.24u l=0.1u ad=0.0816p as=0.0816p pd=1.16u ps=1.16u
    I_MXI1_I60_I12_MP5 (I1_I60_pn4 I1_b1_4 XI1_I60_I12_p1 VDD) gpdk090_pmos1v w=0.48u l=0.1u ad=0.1056p as=0.1632p pd=0.92u ps=1.64u
    I_MXI1_I60_I12_MP4 (XI1_I60_I12_p1 XI1_I60_I12_An I1_I60_pn4 VDD) gpdk090_pmos1v w=0.48u l=0.1u ad=0.1056p as=0.1056p pd=0.92u ps=0.92u
    I_MXI1_I60_I12_MP2 (VDD I1_p0_3 XI1_I60_I12_p1 VDD) gpdk090_pmos1v w=0.48u l=0.1u ad=0.1056p as=0.1056p pd=0.92u ps=0.92u
    I_MXI1_I60_I12_MP3 (XI1_I60_I12_p1 XI1_I60_I12_Bn VDD VDD) gpdk090_pmos1v w=0.48u l=0.1u ad=0.1632p as=0.1056p pd=1.64u ps=0.92u
    I_MXI1_I60_I12_MP0 (VDD I1_p0_3 XI1_I60_I12_An VDD) gpdk090_pmos1v w=0.24u l=0.1u ad=0.0816p as=0.0816p pd=1.16u ps=1.16u
    I_MXI1_I48_I42_MP1 (VDD I1_I48_G4_0 XI1_I48_I42_Bn VDD) gpdk090_pmos1v w=0.24u l=0.1u ad=0.0816p as=0.0816p pd=1.16u ps=1.16u
    I_MXI1_I48_I42_MP5 (I1_p0_5 I1_I48_G4_0 XI1_I48_I42_p1 VDD) gpdk090_pmos1v w=0.48u l=0.1u ad=0.1056p as=0.1632p pd=0.92u ps=1.64u
    I_MXI1_I48_I42_MP4 (XI1_I48_I42_p1 XI1_I48_I42_An I1_p0_5 VDD) gpdk090_pmos1v w=0.48u l=0.1u ad=0.1056p as=0.1056p pd=0.92u ps=0.92u
    I_MXI1_I48_I42_MP2 (VDD I1_I48_pn5 XI1_I48_I42_p1 VDD) gpdk090_pmos1v w=0.48u l=0.1u ad=0.1056p as=0.1056p pd=0.92u ps=0.92u
    I_MXI1_I48_I42_MP3 (XI1_I48_I42_p1 XI1_I48_I42_Bn VDD VDD) gpdk090_pmos1v w=0.48u l=0.1u ad=0.1632p as=0.1056p pd=1.64u ps=0.92u
    I_MXI1_I48_I42_MP0 (VDD I1_I48_pn5 XI1_I48_I42_An VDD) gpdk090_pmos1v w=0.24u l=0.1u ad=0.0816p as=0.0816p pd=1.16u ps=1.16u
    I_MXI1_I108_I14_MP1 (VDD I1_b5_6 XI1_I108_I14_Bn VDD) gpdk090_pmos1v w=0.24u l=0.1u ad=0.0816p as=0.0816p pd=1.16u ps=1.16u
    I_MXI1_I108_I14_MP5 (I1_I108_pn6 I1_b5_6 XI1_I108_I14_p1 VDD) gpdk090_pmos1v w=0.48u l=0.1u ad=0.1056p as=0.1632p pd=0.92u ps=1.64u
    I_MXI1_I108_I14_MP4 (XI1_I108_I14_p1 XI1_I108_I14_An I1_I108_pn6 VDD) gpdk090_pmos1v w=0.48u l=0.1u ad=0.1056p as=0.1056p pd=0.92u ps=0.92u
    I_MXI1_I108_I14_MP2 (VDD I1_p4_5 XI1_I108_I14_p1 VDD) gpdk090_pmos1v w=0.48u l=0.1u ad=0.1056p as=0.1056p pd=0.92u ps=0.92u
    I_MXI1_I108_I14_MP3 (XI1_I108_I14_p1 XI1_I108_I14_Bn VDD VDD) gpdk090_pmos1v w=0.48u l=0.1u ad=0.1632p as=0.1056p pd=1.64u ps=0.92u
    I_MXI1_I108_I14_MP0 (VDD I1_p4_5 XI1_I108_I14_An VDD) gpdk090_pmos1v w=0.24u l=0.1u ad=0.0816p as=0.0816p pd=1.16u ps=1.16u
    I_MXI1_I96_I42_MP1 (VDD I1_I96_G4_0 XI1_I96_I42_Bn VDD) gpdk090_pmos1v w=0.24u l=0.1u ad=0.0816p as=0.0816p pd=1.16u ps=1.16u
    I_MXI1_I96_I42_MP5 (I1_p4_5 I1_I96_G4_0 XI1_I96_I42_p1 VDD) gpdk090_pmos1v w=0.48u l=0.1u ad=0.1056p as=0.1632p pd=0.92u ps=1.64u
    I_MXI1_I96_I42_MP4 (XI1_I96_I42_p1 XI1_I96_I42_An I1_p4_5 VDD) gpdk090_pmos1v w=0.48u l=0.1u ad=0.1056p as=0.1056p pd=0.92u ps=0.92u
    I_MXI1_I96_I42_MP2 (VDD I1_I96_pn5 XI1_I96_I42_p1 VDD) gpdk090_pmos1v w=0.48u l=0.1u ad=0.1056p as=0.1056p pd=0.92u ps=0.92u
    I_MXI1_I96_I42_MP3 (XI1_I96_I42_p1 XI1_I96_I42_Bn VDD VDD) gpdk090_pmos1v w=0.48u l=0.1u ad=0.1632p as=0.1056p pd=1.64u ps=0.92u
    I_MXI1_I96_I42_MP0 (VDD I1_I96_pn5 XI1_I96_I42_An VDD) gpdk090_pmos1v w=0.24u l=0.1u ad=0.0816p as=0.0816p pd=1.16u ps=1.16u
    I_MXI1_I96_I13_MP1 (VDD I1_b4_5 XI1_I96_I13_Bn VDD) gpdk090_pmos1v w=0.24u l=0.1u ad=0.0816p as=0.0816p pd=1.16u ps=1.16u
    I_MXI1_I96_I13_MP5 (I1_I96_pn5 I1_b4_5 XI1_I96_I13_p1 VDD) gpdk090_pmos1v w=0.48u l=0.1u ad=0.1056p as=0.1632p pd=0.92u ps=1.64u
    I_MXI1_I96_I13_MP4 (XI1_I96_I13_p1 XI1_I96_I13_An I1_I96_pn5 VDD) gpdk090_pmos1v w=0.48u l=0.1u ad=0.1056p as=0.1056p pd=0.92u ps=0.92u
    I_MXI1_I96_I13_MP2 (VDD I1_p3_4 XI1_I96_I13_p1 VDD) gpdk090_pmos1v w=0.48u l=0.1u ad=0.1056p as=0.1056p pd=0.92u ps=0.92u
    I_MXI1_I96_I13_MP3 (XI1_I96_I13_p1 XI1_I96_I13_Bn VDD VDD) gpdk090_pmos1v w=0.48u l=0.1u ad=0.1632p as=0.1056p pd=1.64u ps=0.92u
    I_MXI1_I96_I13_MP0 (VDD I1_p3_4 XI1_I96_I13_An VDD) gpdk090_pmos1v w=0.24u l=0.1u ad=0.0816p as=0.0816p pd=1.16u ps=1.16u
    I_MXI1_I84_I42_MP1 (VDD I1_I84_G4_0 XI1_I84_I42_Bn VDD) gpdk090_pmos1v w=0.24u l=0.1u ad=0.0816p as=0.0816p pd=1.16u ps=1.16u
    I_MXI1_I84_I42_MP5 (I1_p3_5 I1_I84_G4_0 XI1_I84_I42_p1 VDD) gpdk090_pmos1v w=0.48u l=0.1u ad=0.1056p as=0.1632p pd=0.92u ps=1.64u
    I_MXI1_I84_I42_MP4 (XI1_I84_I42_p1 XI1_I84_I42_An I1_p3_5 VDD) gpdk090_pmos1v w=0.48u l=0.1u ad=0.1056p as=0.1056p pd=0.92u ps=0.92u
    I_MXI1_I84_I42_MP2 (VDD I1_I84_pn5 XI1_I84_I42_p1 VDD) gpdk090_pmos1v w=0.48u l=0.1u ad=0.1056p as=0.1056p pd=0.92u ps=0.92u
    I_MXI1_I84_I42_MP3 (XI1_I84_I42_p1 XI1_I84_I42_Bn VDD VDD) gpdk090_pmos1v w=0.48u l=0.1u ad=0.1632p as=0.1056p pd=1.64u ps=0.92u
    I_MXI1_I84_I42_MP0 (VDD I1_I84_pn5 XI1_I84_I42_An VDD) gpdk090_pmos1v w=0.24u l=0.1u ad=0.0816p as=0.0816p pd=1.16u ps=1.16u
    I_MXI1_I84_I13_MP1 (VDD I1_b3_5 XI1_I84_I13_Bn VDD) gpdk090_pmos1v w=0.24u l=0.1u ad=0.0816p as=0.0816p pd=1.16u ps=1.16u
    I_MXI1_I84_I13_MP5 (I1_I84_pn5 I1_b3_5 XI1_I84_I13_p1 VDD) gpdk090_pmos1v w=0.48u l=0.1u ad=0.1056p as=0.1632p pd=0.92u ps=1.64u
    I_MXI1_I84_I13_MP4 (XI1_I84_I13_p1 XI1_I84_I13_An I1_I84_pn5 VDD) gpdk090_pmos1v w=0.48u l=0.1u ad=0.1056p as=0.1056p pd=0.92u ps=0.92u
    I_MXI1_I84_I13_MP2 (VDD I1_p2_4 XI1_I84_I13_p1 VDD) gpdk090_pmos1v w=0.48u l=0.1u ad=0.1056p as=0.1056p pd=0.92u ps=0.92u
    I_MXI1_I84_I13_MP3 (XI1_I84_I13_p1 XI1_I84_I13_Bn VDD VDD) gpdk090_pmos1v w=0.48u l=0.1u ad=0.1632p as=0.1056p pd=1.64u ps=0.92u
    I_MXI1_I84_I13_MP0 (VDD I1_p2_4 XI1_I84_I13_An VDD) gpdk090_pmos1v w=0.24u l=0.1u ad=0.0816p as=0.0816p pd=1.16u ps=1.16u
    I_MXI1_I72_I42_MP1 (VDD I1_I72_G4_0 XI1_I72_I42_Bn VDD) gpdk090_pmos1v w=0.24u l=0.1u ad=0.0816p as=0.0816p pd=1.16u ps=1.16u
    I_MXI1_I72_I42_MP5 (I1_p2_5 I1_I72_G4_0 XI1_I72_I42_p1 VDD) gpdk090_pmos1v w=0.48u l=0.1u ad=0.1056p as=0.1632p pd=0.92u ps=1.64u
    I_MXI1_I72_I42_MP4 (XI1_I72_I42_p1 XI1_I72_I42_An I1_p2_5 VDD) gpdk090_pmos1v w=0.48u l=0.1u ad=0.1056p as=0.1056p pd=0.92u ps=0.92u
    I_MXI1_I72_I42_MP2 (VDD I1_I72_pn5 XI1_I72_I42_p1 VDD) gpdk090_pmos1v w=0.48u l=0.1u ad=0.1056p as=0.1056p pd=0.92u ps=0.92u
    I_MXI1_I72_I42_MP3 (XI1_I72_I42_p1 XI1_I72_I42_Bn VDD VDD) gpdk090_pmos1v w=0.48u l=0.1u ad=0.1632p as=0.1056p pd=1.64u ps=0.92u
    I_MXI1_I72_I42_MP0 (VDD I1_I72_pn5 XI1_I72_I42_An VDD) gpdk090_pmos1v w=0.24u l=0.1u ad=0.0816p as=0.0816p pd=1.16u ps=1.16u
    I_MXI1_I72_I13_MP1 (VDD I1_b2_5 XI1_I72_I13_Bn VDD) gpdk090_pmos1v w=0.24u l=0.1u ad=0.0816p as=0.0816p pd=1.16u ps=1.16u
    I_MXI1_I72_I13_MP5 (I1_I72_pn5 I1_b2_5 XI1_I72_I13_p1 VDD) gpdk090_pmos1v w=0.48u l=0.1u ad=0.1056p as=0.1632p pd=0.92u ps=1.64u
    I_MXI1_I72_I13_MP4 (XI1_I72_I13_p1 XI1_I72_I13_An I1_I72_pn5 VDD) gpdk090_pmos1v w=0.48u l=0.1u ad=0.1056p as=0.1056p pd=0.92u ps=0.92u
    I_MXI1_I72_I13_MP2 (VDD I1_p1_4 XI1_I72_I13_p1 VDD) gpdk090_pmos1v w=0.48u l=0.1u ad=0.1056p as=0.1056p pd=0.92u ps=0.92u
    I_MXI1_I72_I13_MP3 (XI1_I72_I13_p1 XI1_I72_I13_Bn VDD VDD) gpdk090_pmos1v w=0.48u l=0.1u ad=0.1632p as=0.1056p pd=1.64u ps=0.92u
    I_MXI1_I72_I13_MP0 (VDD I1_p1_4 XI1_I72_I13_An VDD) gpdk090_pmos1v w=0.24u l=0.1u ad=0.0816p as=0.0816p pd=1.16u ps=1.16u
    I_MXI1_I60_I42_MP1 (VDD I1_I60_G4_0 XI1_I60_I42_Bn VDD) gpdk090_pmos1v w=0.24u l=0.1u ad=0.0816p as=0.0816p pd=1.16u ps=1.16u
    I_MXI1_I60_I42_MP5 (I1_p1_5 I1_I60_G4_0 XI1_I60_I42_p1 VDD) gpdk090_pmos1v w=0.48u l=0.1u ad=0.1056p as=0.1632p pd=0.92u ps=1.64u
    I_MXI1_I60_I42_MP4 (XI1_I60_I42_p1 XI1_I60_I42_An I1_p1_5 VDD) gpdk090_pmos1v w=0.48u l=0.1u ad=0.1056p as=0.1056p pd=0.92u ps=0.92u
    I_MXI1_I60_I42_MP2 (VDD I1_I60_pn5 XI1_I60_I42_p1 VDD) gpdk090_pmos1v w=0.48u l=0.1u ad=0.1056p as=0.1056p pd=0.92u ps=0.92u
    I_MXI1_I60_I42_MP3 (XI1_I60_I42_p1 XI1_I60_I42_Bn VDD VDD) gpdk090_pmos1v w=0.48u l=0.1u ad=0.1632p as=0.1056p pd=1.64u ps=0.92u
    I_MXI1_I60_I42_MP0 (VDD I1_I60_pn5 XI1_I60_I42_An VDD) gpdk090_pmos1v w=0.24u l=0.1u ad=0.0816p as=0.0816p pd=1.16u ps=1.16u
    I_MXI1_I60_I13_MP1 (VDD I1_b1_5 XI1_I60_I13_Bn VDD) gpdk090_pmos1v w=0.24u l=0.1u ad=0.0816p as=0.0816p pd=1.16u ps=1.16u
    I_MXI1_I60_I13_MP5 (I1_I60_pn5 I1_b1_5 XI1_I60_I13_p1 VDD) gpdk090_pmos1v w=0.48u l=0.1u ad=0.1056p as=0.1632p pd=0.92u ps=1.64u
    I_MXI1_I60_I13_MP4 (XI1_I60_I13_p1 XI1_I60_I13_An I1_I60_pn5 VDD) gpdk090_pmos1v w=0.48u l=0.1u ad=0.1056p as=0.1056p pd=0.92u ps=0.92u
    I_MXI1_I60_I13_MP2 (VDD I1_p0_4 XI1_I60_I13_p1 VDD) gpdk090_pmos1v w=0.48u l=0.1u ad=0.1056p as=0.1056p pd=0.92u ps=0.92u
    I_MXI1_I60_I13_MP3 (XI1_I60_I13_p1 XI1_I60_I13_Bn VDD VDD) gpdk090_pmos1v w=0.48u l=0.1u ad=0.1632p as=0.1056p pd=1.64u ps=0.92u
    I_MXI1_I60_I13_MP0 (VDD I1_p0_4 XI1_I60_I13_An VDD) gpdk090_pmos1v w=0.24u l=0.1u ad=0.0816p as=0.0816p pd=1.16u ps=1.16u
    I_MXI1_I48_I13_MP1 (VDD I1_b0_5 XI1_I48_I13_Bn VDD) gpdk090_pmos1v w=0.24u l=0.1u ad=0.0816p as=0.0816p pd=1.16u ps=1.16u
    I_MXI1_I48_I13_MP5 (I1_I48_pn5 I1_b0_5 XI1_I48_I13_p1 VDD) gpdk090_pmos1v w=0.48u l=0.1u ad=0.1056p as=0.1632p pd=0.92u ps=1.64u
    I_MXI1_I48_I13_MP4 (XI1_I48_I13_p1 XI1_I48_I13_An I1_I48_pn5 VDD) gpdk090_pmos1v w=0.48u l=0.1u ad=0.1056p as=0.1056p pd=0.92u ps=0.92u
    I_MXI1_I48_I13_MP2 (VDD VSS XI1_I48_I13_p1 VDD) gpdk090_pmos1v w=0.48u l=0.1u ad=0.1056p as=0.1056p pd=0.92u ps=0.92u
    I_MXI1_I48_I13_MP3 (XI1_I48_I13_p1 XI1_I48_I13_Bn VDD VDD) gpdk090_pmos1v w=0.48u l=0.1u ad=0.1632p as=0.1056p pd=1.64u ps=0.92u
    I_MXI1_I48_I13_MP0 (VDD VSS XI1_I48_I13_An VDD) gpdk090_pmos1v w=0.24u l=0.1u ad=0.0816p as=0.0816p pd=1.16u ps=1.16u
    I_MXI1_I48_I14_MP1 (VDD I1_b0_6 XI1_I48_I14_Bn VDD) gpdk090_pmos1v w=0.24u l=0.1u ad=0.0816p as=0.0816p pd=1.16u ps=1.16u
    I_MXI1_I48_I14_MP5 (I1_I48_pn6 I1_b0_6 XI1_I48_I14_p1 VDD) gpdk090_pmos1v w=0.48u l=0.1u ad=0.1056p as=0.1632p pd=0.92u ps=1.64u
    I_MXI1_I48_I14_MP4 (XI1_I48_I14_p1 XI1_I48_I14_An I1_I48_pn6 VDD) gpdk090_pmos1v w=0.48u l=0.1u ad=0.1056p as=0.1056p pd=0.92u ps=0.92u
    I_MXI1_I48_I14_MP2 (VDD VSS XI1_I48_I14_p1 VDD) gpdk090_pmos1v w=0.48u l=0.1u ad=0.1056p as=0.1056p pd=0.92u ps=0.92u
    I_MXI1_I48_I14_MP3 (XI1_I48_I14_p1 XI1_I48_I14_Bn VDD VDD) gpdk090_pmos1v w=0.48u l=0.1u ad=0.1632p as=0.1056p pd=1.64u ps=0.92u
    I_MXI1_I48_I14_MP0 (VDD VSS XI1_I48_I14_An VDD) gpdk090_pmos1v w=0.24u l=0.1u ad=0.0816p as=0.0816p pd=1.16u ps=1.16u
    I_MXI1_I48_I43_MP1 (VDD I1_I48_G5_0 XI1_I48_I43_Bn VDD) gpdk090_pmos1v w=0.24u l=0.1u ad=0.0816p as=0.0816p pd=1.16u ps=1.16u
    I_MXI1_I48_I43_MP5 (I1_p0_6 I1_I48_G5_0 XI1_I48_I43_p1 VDD) gpdk090_pmos1v w=0.48u l=0.1u ad=0.1056p as=0.1632p pd=0.92u ps=1.64u
    I_MXI1_I48_I43_MP4 (XI1_I48_I43_p1 XI1_I48_I43_An I1_p0_6 VDD) gpdk090_pmos1v w=0.48u l=0.1u ad=0.1056p as=0.1056p pd=0.92u ps=0.92u
    I_MXI1_I48_I43_MP2 (VDD I1_I48_pn6 XI1_I48_I43_p1 VDD) gpdk090_pmos1v w=0.48u l=0.1u ad=0.1056p as=0.1056p pd=0.92u ps=0.92u
    I_MXI1_I48_I43_MP3 (XI1_I48_I43_p1 XI1_I48_I43_Bn VDD VDD) gpdk090_pmos1v w=0.48u l=0.1u ad=0.1632p as=0.1056p pd=1.64u ps=0.92u
    I_MXI1_I48_I43_MP0 (VDD I1_I48_pn6 XI1_I48_I43_An VDD) gpdk090_pmos1v w=0.24u l=0.1u ad=0.0816p as=0.0816p pd=1.16u ps=1.16u
    I_MXI1_I108_I15_MP1 (VDD I1_b5_7 XI1_I108_I15_Bn VDD) gpdk090_pmos1v w=0.24u l=0.1u ad=0.0816p as=0.0816p pd=1.16u ps=1.16u
    I_MXI1_I108_I15_MP5 (I1_I108_pn7 I1_b5_7 XI1_I108_I15_p1 VDD) gpdk090_pmos1v w=0.48u l=0.1u ad=0.1056p as=0.1632p pd=0.92u ps=1.64u
    I_MXI1_I108_I15_MP4 (XI1_I108_I15_p1 XI1_I108_I15_An I1_I108_pn7 VDD) gpdk090_pmos1v w=0.48u l=0.1u ad=0.1056p as=0.1056p pd=0.92u ps=0.92u
    I_MXI1_I108_I15_MP2 (VDD I1_p4_6 XI1_I108_I15_p1 VDD) gpdk090_pmos1v w=0.48u l=0.1u ad=0.1056p as=0.1056p pd=0.92u ps=0.92u
    I_MXI1_I108_I15_MP3 (XI1_I108_I15_p1 XI1_I108_I15_Bn VDD VDD) gpdk090_pmos1v w=0.48u l=0.1u ad=0.1632p as=0.1056p pd=1.64u ps=0.92u
    I_MXI1_I108_I15_MP0 (VDD I1_p4_6 XI1_I108_I15_An VDD) gpdk090_pmos1v w=0.24u l=0.1u ad=0.0816p as=0.0816p pd=1.16u ps=1.16u
    I_MXI1_I96_I43_MP1 (VDD I1_I96_G5_0 XI1_I96_I43_Bn VDD) gpdk090_pmos1v w=0.24u l=0.1u ad=0.0816p as=0.0816p pd=1.16u ps=1.16u
    I_MXI1_I96_I43_MP5 (I1_p4_6 I1_I96_G5_0 XI1_I96_I43_p1 VDD) gpdk090_pmos1v w=0.48u l=0.1u ad=0.1056p as=0.1632p pd=0.92u ps=1.64u
    I_MXI1_I96_I43_MP4 (XI1_I96_I43_p1 XI1_I96_I43_An I1_p4_6 VDD) gpdk090_pmos1v w=0.48u l=0.1u ad=0.1056p as=0.1056p pd=0.92u ps=0.92u
    I_MXI1_I96_I43_MP2 (VDD I1_I96_pn6 XI1_I96_I43_p1 VDD) gpdk090_pmos1v w=0.48u l=0.1u ad=0.1056p as=0.1056p pd=0.92u ps=0.92u
    I_MXI1_I96_I43_MP3 (XI1_I96_I43_p1 XI1_I96_I43_Bn VDD VDD) gpdk090_pmos1v w=0.48u l=0.1u ad=0.1632p as=0.1056p pd=1.64u ps=0.92u
    I_MXI1_I96_I43_MP0 (VDD I1_I96_pn6 XI1_I96_I43_An VDD) gpdk090_pmos1v w=0.24u l=0.1u ad=0.0816p as=0.0816p pd=1.16u ps=1.16u
    I_MXI1_I96_I44_MP1 (VDD I1_c4_7 XI1_I96_I44_Bn VDD) gpdk090_pmos1v w=0.24u l=0.1u ad=0.0816p as=0.0816p pd=1.16u ps=1.16u
    I_MXI1_I96_I44_MP5 (I1_p4_7 I1_c4_7 XI1_I96_I44_p1 VDD) gpdk090_pmos1v w=0.48u l=0.1u ad=0.1056p as=0.1632p pd=0.92u ps=1.64u
    I_MXI1_I96_I44_MP4 (XI1_I96_I44_p1 XI1_I96_I44_An I1_p4_7 VDD) gpdk090_pmos1v w=0.48u l=0.1u ad=0.1056p as=0.1056p pd=0.92u ps=0.92u
    I_MXI1_I96_I44_MP2 (VDD I1_I96_pn7 XI1_I96_I44_p1 VDD) gpdk090_pmos1v w=0.48u l=0.1u ad=0.1056p as=0.1056p pd=0.92u ps=0.92u
    I_MXI1_I96_I44_MP3 (XI1_I96_I44_p1 XI1_I96_I44_Bn VDD VDD) gpdk090_pmos1v w=0.48u l=0.1u ad=0.1632p as=0.1056p pd=1.64u ps=0.92u
    I_MXI1_I96_I44_MP0 (VDD I1_I96_pn7 XI1_I96_I44_An VDD) gpdk090_pmos1v w=0.24u l=0.1u ad=0.0816p as=0.0816p pd=1.16u ps=1.16u
    I_MXI1_I96_I14_MP1 (VDD I1_b4_6 XI1_I96_I14_Bn VDD) gpdk090_pmos1v w=0.24u l=0.1u ad=0.0816p as=0.0816p pd=1.16u ps=1.16u
    I_MXI1_I96_I14_MP5 (I1_I96_pn6 I1_b4_6 XI1_I96_I14_p1 VDD) gpdk090_pmos1v w=0.48u l=0.1u ad=0.1056p as=0.1632p pd=0.92u ps=1.64u
    I_MXI1_I96_I14_MP4 (XI1_I96_I14_p1 XI1_I96_I14_An I1_I96_pn6 VDD) gpdk090_pmos1v w=0.48u l=0.1u ad=0.1056p as=0.1056p pd=0.92u ps=0.92u
    I_MXI1_I96_I14_MP2 (VDD I1_p3_5 XI1_I96_I14_p1 VDD) gpdk090_pmos1v w=0.48u l=0.1u ad=0.1056p as=0.1056p pd=0.92u ps=0.92u
    I_MXI1_I96_I14_MP3 (XI1_I96_I14_p1 XI1_I96_I14_Bn VDD VDD) gpdk090_pmos1v w=0.48u l=0.1u ad=0.1632p as=0.1056p pd=1.64u ps=0.92u
    I_MXI1_I96_I14_MP0 (VDD I1_p3_5 XI1_I96_I14_An VDD) gpdk090_pmos1v w=0.24u l=0.1u ad=0.0816p as=0.0816p pd=1.16u ps=1.16u
    I_MXI1_I84_I43_MP1 (VDD I1_I84_G5_0 XI1_I84_I43_Bn VDD) gpdk090_pmos1v w=0.24u l=0.1u ad=0.0816p as=0.0816p pd=1.16u ps=1.16u
    I_MXI1_I84_I43_MP5 (I1_p3_6 I1_I84_G5_0 XI1_I84_I43_p1 VDD) gpdk090_pmos1v w=0.48u l=0.1u ad=0.1056p as=0.1632p pd=0.92u ps=1.64u
    I_MXI1_I84_I43_MP4 (XI1_I84_I43_p1 XI1_I84_I43_An I1_p3_6 VDD) gpdk090_pmos1v w=0.48u l=0.1u ad=0.1056p as=0.1056p pd=0.92u ps=0.92u
    I_MXI1_I84_I43_MP2 (VDD I1_I84_pn6 XI1_I84_I43_p1 VDD) gpdk090_pmos1v w=0.48u l=0.1u ad=0.1056p as=0.1056p pd=0.92u ps=0.92u
    I_MXI1_I84_I43_MP3 (XI1_I84_I43_p1 XI1_I84_I43_Bn VDD VDD) gpdk090_pmos1v w=0.48u l=0.1u ad=0.1632p as=0.1056p pd=1.64u ps=0.92u
    I_MXI1_I84_I43_MP0 (VDD I1_I84_pn6 XI1_I84_I43_An VDD) gpdk090_pmos1v w=0.24u l=0.1u ad=0.0816p as=0.0816p pd=1.16u ps=1.16u
    I_MXI1_I84_I14_MP1 (VDD I1_b3_6 XI1_I84_I14_Bn VDD) gpdk090_pmos1v w=0.24u l=0.1u ad=0.0816p as=0.0816p pd=1.16u ps=1.16u
    I_MXI1_I84_I14_MP5 (I1_I84_pn6 I1_b3_6 XI1_I84_I14_p1 VDD) gpdk090_pmos1v w=0.48u l=0.1u ad=0.1056p as=0.1632p pd=0.92u ps=1.64u
    I_MXI1_I84_I14_MP4 (XI1_I84_I14_p1 XI1_I84_I14_An I1_I84_pn6 VDD) gpdk090_pmos1v w=0.48u l=0.1u ad=0.1056p as=0.1056p pd=0.92u ps=0.92u
    I_MXI1_I84_I14_MP2 (VDD I1_p2_5 XI1_I84_I14_p1 VDD) gpdk090_pmos1v w=0.48u l=0.1u ad=0.1056p as=0.1056p pd=0.92u ps=0.92u
    I_MXI1_I84_I14_MP3 (XI1_I84_I14_p1 XI1_I84_I14_Bn VDD VDD) gpdk090_pmos1v w=0.48u l=0.1u ad=0.1632p as=0.1056p pd=1.64u ps=0.92u
    I_MXI1_I84_I14_MP0 (VDD I1_p2_5 XI1_I84_I14_An VDD) gpdk090_pmos1v w=0.24u l=0.1u ad=0.0816p as=0.0816p pd=1.16u ps=1.16u
    I_MXI1_I72_I44_MP1 (VDD I1_c2_7 XI1_I72_I44_Bn VDD) gpdk090_pmos1v w=0.24u l=0.1u ad=0.0816p as=0.0816p pd=1.16u ps=1.16u
    I_MXI1_I72_I44_MP5 (I1_p2_7 I1_c2_7 XI1_I72_I44_p1 VDD) gpdk090_pmos1v w=0.48u l=0.1u ad=0.1056p as=0.1632p pd=0.92u ps=1.64u
    I_MXI1_I72_I44_MP4 (XI1_I72_I44_p1 XI1_I72_I44_An I1_p2_7 VDD) gpdk090_pmos1v w=0.48u l=0.1u ad=0.1056p as=0.1056p pd=0.92u ps=0.92u
    I_MXI1_I72_I44_MP2 (VDD I1_I72_pn7 XI1_I72_I44_p1 VDD) gpdk090_pmos1v w=0.48u l=0.1u ad=0.1056p as=0.1056p pd=0.92u ps=0.92u
    I_MXI1_I72_I44_MP3 (XI1_I72_I44_p1 XI1_I72_I44_Bn VDD VDD) gpdk090_pmos1v w=0.48u l=0.1u ad=0.1632p as=0.1056p pd=1.64u ps=0.92u
    I_MXI1_I72_I44_MP0 (VDD I1_I72_pn7 XI1_I72_I44_An VDD) gpdk090_pmos1v w=0.24u l=0.1u ad=0.0816p as=0.0816p pd=1.16u ps=1.16u
    I_MXI1_I72_I14_MP1 (VDD I1_b2_6 XI1_I72_I14_Bn VDD) gpdk090_pmos1v w=0.24u l=0.1u ad=0.0816p as=0.0816p pd=1.16u ps=1.16u
    I_MXI1_I72_I14_MP5 (I1_I72_pn6 I1_b2_6 XI1_I72_I14_p1 VDD) gpdk090_pmos1v w=0.48u l=0.1u ad=0.1056p as=0.1632p pd=0.92u ps=1.64u
    I_MXI1_I72_I14_MP4 (XI1_I72_I14_p1 XI1_I72_I14_An I1_I72_pn6 VDD) gpdk090_pmos1v w=0.48u l=0.1u ad=0.1056p as=0.1056p pd=0.92u ps=0.92u
    I_MXI1_I72_I14_MP2 (VDD I1_p1_5 XI1_I72_I14_p1 VDD) gpdk090_pmos1v w=0.48u l=0.1u ad=0.1056p as=0.1056p pd=0.92u ps=0.92u
    I_MXI1_I72_I14_MP3 (XI1_I72_I14_p1 XI1_I72_I14_Bn VDD VDD) gpdk090_pmos1v w=0.48u l=0.1u ad=0.1632p as=0.1056p pd=1.64u ps=0.92u
    I_MXI1_I72_I14_MP0 (VDD I1_p1_5 XI1_I72_I14_An VDD) gpdk090_pmos1v w=0.24u l=0.1u ad=0.0816p as=0.0816p pd=1.16u ps=1.16u
    I_MXI1_I60_I43_MP1 (VDD I1_I60_G5_0 XI1_I60_I43_Bn VDD) gpdk090_pmos1v w=0.24u l=0.1u ad=0.0816p as=0.0816p pd=1.16u ps=1.16u
    I_MXI1_I60_I43_MP5 (I1_p1_6 I1_I60_G5_0 XI1_I60_I43_p1 VDD) gpdk090_pmos1v w=0.48u l=0.1u ad=0.1056p as=0.1632p pd=0.92u ps=1.64u
    I_MXI1_I60_I43_MP4 (XI1_I60_I43_p1 XI1_I60_I43_An I1_p1_6 VDD) gpdk090_pmos1v w=0.48u l=0.1u ad=0.1056p as=0.1056p pd=0.92u ps=0.92u
    I_MXI1_I60_I43_MP2 (VDD I1_I60_pn6 XI1_I60_I43_p1 VDD) gpdk090_pmos1v w=0.48u l=0.1u ad=0.1056p as=0.1056p pd=0.92u ps=0.92u
    I_MXI1_I60_I43_MP3 (XI1_I60_I43_p1 XI1_I60_I43_Bn VDD VDD) gpdk090_pmos1v w=0.48u l=0.1u ad=0.1632p as=0.1056p pd=1.64u ps=0.92u
    I_MXI1_I60_I43_MP0 (VDD I1_I60_pn6 XI1_I60_I43_An VDD) gpdk090_pmos1v w=0.24u l=0.1u ad=0.0816p as=0.0816p pd=1.16u ps=1.16u
    I_MXI1_I60_I14_MP1 (VDD I1_b1_6 XI1_I60_I14_Bn VDD) gpdk090_pmos1v w=0.24u l=0.1u ad=0.0816p as=0.0816p pd=1.16u ps=1.16u
    I_MXI1_I60_I14_MP5 (I1_I60_pn6 I1_b1_6 XI1_I60_I14_p1 VDD) gpdk090_pmos1v w=0.48u l=0.1u ad=0.1056p as=0.1632p pd=0.92u ps=1.64u
    I_MXI1_I60_I14_MP4 (XI1_I60_I14_p1 XI1_I60_I14_An I1_I60_pn6 VDD) gpdk090_pmos1v w=0.48u l=0.1u ad=0.1056p as=0.1056p pd=0.92u ps=0.92u
    I_MXI1_I60_I14_MP2 (VDD I1_p0_5 XI1_I60_I14_p1 VDD) gpdk090_pmos1v w=0.48u l=0.1u ad=0.1056p as=0.1056p pd=0.92u ps=0.92u
    I_MXI1_I60_I14_MP3 (XI1_I60_I14_p1 XI1_I60_I14_Bn VDD VDD) gpdk090_pmos1v w=0.48u l=0.1u ad=0.1632p as=0.1056p pd=1.64u ps=0.92u
    I_MXI1_I60_I14_MP0 (VDD I1_p0_5 XI1_I60_I14_An VDD) gpdk090_pmos1v w=0.24u l=0.1u ad=0.0816p as=0.0816p pd=1.16u ps=1.16u
    I_MXI1_I48_I44_MP1 (VDD I1_c0_7 XI1_I48_I44_Bn VDD) gpdk090_pmos1v w=0.24u l=0.1u ad=0.0816p as=0.0816p pd=1.16u ps=1.16u
    I_MXI1_I48_I44_MP5 (I1_p0_7 I1_c0_7 XI1_I48_I44_p1 VDD) gpdk090_pmos1v w=0.48u l=0.1u ad=0.1056p as=0.1632p pd=0.92u ps=1.64u
    I_MXI1_I48_I44_MP4 (XI1_I48_I44_p1 XI1_I48_I44_An I1_p0_7 VDD) gpdk090_pmos1v w=0.48u l=0.1u ad=0.1056p as=0.1056p pd=0.92u ps=0.92u
    I_MXI1_I48_I44_MP2 (VDD I1_I48_pn7 XI1_I48_I44_p1 VDD) gpdk090_pmos1v w=0.48u l=0.1u ad=0.1056p as=0.1056p pd=0.92u ps=0.92u
    I_MXI1_I48_I44_MP3 (XI1_I48_I44_p1 XI1_I48_I44_Bn VDD VDD) gpdk090_pmos1v w=0.48u l=0.1u ad=0.1632p as=0.1056p pd=1.64u ps=0.92u
    I_MXI1_I48_I44_MP0 (VDD I1_I48_pn7 XI1_I48_I44_An VDD) gpdk090_pmos1v w=0.24u l=0.1u ad=0.0816p as=0.0816p pd=1.16u ps=1.16u
    I_MXI1_I96_I15_MP1 (VDD I1_b4_7 XI1_I96_I15_Bn VDD) gpdk090_pmos1v w=0.24u l=0.1u ad=0.0816p as=0.0816p pd=1.16u ps=1.16u
    I_MXI1_I96_I15_MP5 (I1_I96_pn7 I1_b4_7 XI1_I96_I15_p1 VDD) gpdk090_pmos1v w=0.48u l=0.1u ad=0.1056p as=0.1632p pd=0.92u ps=1.64u
    I_MXI1_I96_I15_MP4 (XI1_I96_I15_p1 XI1_I96_I15_An I1_I96_pn7 VDD) gpdk090_pmos1v w=0.48u l=0.1u ad=0.1056p as=0.1056p pd=0.92u ps=0.92u
    I_MXI1_I96_I15_MP2 (VDD I1_p3_6 XI1_I96_I15_p1 VDD) gpdk090_pmos1v w=0.48u l=0.1u ad=0.1056p as=0.1056p pd=0.92u ps=0.92u
    I_MXI1_I96_I15_MP3 (XI1_I96_I15_p1 XI1_I96_I15_Bn VDD VDD) gpdk090_pmos1v w=0.48u l=0.1u ad=0.1632p as=0.1056p pd=1.64u ps=0.92u
    I_MXI1_I96_I15_MP0 (VDD I1_p3_6 XI1_I96_I15_An VDD) gpdk090_pmos1v w=0.24u l=0.1u ad=0.0816p as=0.0816p pd=1.16u ps=1.16u
    I_MXI1_I84_I44_MP1 (VDD I1_c3_7 XI1_I84_I44_Bn VDD) gpdk090_pmos1v w=0.24u l=0.1u ad=0.0816p as=0.0816p pd=1.16u ps=1.16u
    I_MXI1_I84_I44_MP5 (I1_p3_7 I1_c3_7 XI1_I84_I44_p1 VDD) gpdk090_pmos1v w=0.48u l=0.1u ad=0.1056p as=0.1632p pd=0.92u ps=1.64u
    I_MXI1_I84_I44_MP4 (XI1_I84_I44_p1 XI1_I84_I44_An I1_p3_7 VDD) gpdk090_pmos1v w=0.48u l=0.1u ad=0.1056p as=0.1056p pd=0.92u ps=0.92u
    I_MXI1_I84_I44_MP2 (VDD I1_I84_pn7 XI1_I84_I44_p1 VDD) gpdk090_pmos1v w=0.48u l=0.1u ad=0.1056p as=0.1056p pd=0.92u ps=0.92u
    I_MXI1_I84_I44_MP3 (XI1_I84_I44_p1 XI1_I84_I44_Bn VDD VDD) gpdk090_pmos1v w=0.48u l=0.1u ad=0.1632p as=0.1056p pd=1.64u ps=0.92u
    I_MXI1_I84_I44_MP0 (VDD I1_I84_pn7 XI1_I84_I44_An VDD) gpdk090_pmos1v w=0.24u l=0.1u ad=0.0816p as=0.0816p pd=1.16u ps=1.16u
    I_MXI1_I84_I15_MP1 (VDD I1_b3_7 XI1_I84_I15_Bn VDD) gpdk090_pmos1v w=0.24u l=0.1u ad=0.0816p as=0.0816p pd=1.16u ps=1.16u
    I_MXI1_I84_I15_MP5 (I1_I84_pn7 I1_b3_7 XI1_I84_I15_p1 VDD) gpdk090_pmos1v w=0.48u l=0.1u ad=0.1056p as=0.1632p pd=0.92u ps=1.64u
    I_MXI1_I84_I15_MP4 (XI1_I84_I15_p1 XI1_I84_I15_An I1_I84_pn7 VDD) gpdk090_pmos1v w=0.48u l=0.1u ad=0.1056p as=0.1056p pd=0.92u ps=0.92u
    I_MXI1_I84_I15_MP2 (VDD I1_p2_6 XI1_I84_I15_p1 VDD) gpdk090_pmos1v w=0.48u l=0.1u ad=0.1056p as=0.1056p pd=0.92u ps=0.92u
    I_MXI1_I84_I15_MP3 (XI1_I84_I15_p1 XI1_I84_I15_Bn VDD VDD) gpdk090_pmos1v w=0.48u l=0.1u ad=0.1632p as=0.1056p pd=1.64u ps=0.92u
    I_MXI1_I84_I15_MP0 (VDD I1_p2_6 XI1_I84_I15_An VDD) gpdk090_pmos1v w=0.24u l=0.1u ad=0.0816p as=0.0816p pd=1.16u ps=1.16u
    I_MXI1_I72_I43_MP1 (VDD I1_I72_G5_0 XI1_I72_I43_Bn VDD) gpdk090_pmos1v w=0.24u l=0.1u ad=0.0816p as=0.0816p pd=1.16u ps=1.16u
    I_MXI1_I72_I43_MP5 (I1_p2_6 I1_I72_G5_0 XI1_I72_I43_p1 VDD) gpdk090_pmos1v w=0.48u l=0.1u ad=0.1056p as=0.1632p pd=0.92u ps=1.64u
    I_MXI1_I72_I43_MP4 (XI1_I72_I43_p1 XI1_I72_I43_An I1_p2_6 VDD) gpdk090_pmos1v w=0.48u l=0.1u ad=0.1056p as=0.1056p pd=0.92u ps=0.92u
    I_MXI1_I72_I43_MP2 (VDD I1_I72_pn6 XI1_I72_I43_p1 VDD) gpdk090_pmos1v w=0.48u l=0.1u ad=0.1056p as=0.1056p pd=0.92u ps=0.92u
    I_MXI1_I72_I43_MP3 (XI1_I72_I43_p1 XI1_I72_I43_Bn VDD VDD) gpdk090_pmos1v w=0.48u l=0.1u ad=0.1632p as=0.1056p pd=1.64u ps=0.92u
    I_MXI1_I72_I43_MP0 (VDD I1_I72_pn6 XI1_I72_I43_An VDD) gpdk090_pmos1v w=0.24u l=0.1u ad=0.0816p as=0.0816p pd=1.16u ps=1.16u
    I_MXI1_I72_I15_MP1 (VDD I1_b2_7 XI1_I72_I15_Bn VDD) gpdk090_pmos1v w=0.24u l=0.1u ad=0.0816p as=0.0816p pd=1.16u ps=1.16u
    I_MXI1_I72_I15_MP5 (I1_I72_pn7 I1_b2_7 XI1_I72_I15_p1 VDD) gpdk090_pmos1v w=0.48u l=0.1u ad=0.1056p as=0.1632p pd=0.92u ps=1.64u
    I_MXI1_I72_I15_MP4 (XI1_I72_I15_p1 XI1_I72_I15_An I1_I72_pn7 VDD) gpdk090_pmos1v w=0.48u l=0.1u ad=0.1056p as=0.1056p pd=0.92u ps=0.92u
    I_MXI1_I72_I15_MP2 (VDD I1_p1_6 XI1_I72_I15_p1 VDD) gpdk090_pmos1v w=0.48u l=0.1u ad=0.1056p as=0.1056p pd=0.92u ps=0.92u
    I_MXI1_I72_I15_MP3 (XI1_I72_I15_p1 XI1_I72_I15_Bn VDD VDD) gpdk090_pmos1v w=0.48u l=0.1u ad=0.1632p as=0.1056p pd=1.64u ps=0.92u
    I_MXI1_I72_I15_MP0 (VDD I1_p1_6 XI1_I72_I15_An VDD) gpdk090_pmos1v w=0.24u l=0.1u ad=0.0816p as=0.0816p pd=1.16u ps=1.16u
    I_MXI1_I60_I44_MP1 (VDD I1_c1_7 XI1_I60_I44_Bn VDD) gpdk090_pmos1v w=0.24u l=0.1u ad=0.0816p as=0.0816p pd=1.16u ps=1.16u
    I_MXI1_I60_I44_MP5 (I1_p1_7 I1_c1_7 XI1_I60_I44_p1 VDD) gpdk090_pmos1v w=0.48u l=0.1u ad=0.1056p as=0.1632p pd=0.92u ps=1.64u
    I_MXI1_I60_I44_MP4 (XI1_I60_I44_p1 XI1_I60_I44_An I1_p1_7 VDD) gpdk090_pmos1v w=0.48u l=0.1u ad=0.1056p as=0.1056p pd=0.92u ps=0.92u
    I_MXI1_I60_I44_MP2 (VDD I1_I60_pn7 XI1_I60_I44_p1 VDD) gpdk090_pmos1v w=0.48u l=0.1u ad=0.1056p as=0.1056p pd=0.92u ps=0.92u
    I_MXI1_I60_I44_MP3 (XI1_I60_I44_p1 XI1_I60_I44_Bn VDD VDD) gpdk090_pmos1v w=0.48u l=0.1u ad=0.1632p as=0.1056p pd=1.64u ps=0.92u
    I_MXI1_I60_I44_MP0 (VDD I1_I60_pn7 XI1_I60_I44_An VDD) gpdk090_pmos1v w=0.24u l=0.1u ad=0.0816p as=0.0816p pd=1.16u ps=1.16u
    I_MXI1_I60_I15_MP1 (VDD I1_b1_7 XI1_I60_I15_Bn VDD) gpdk090_pmos1v w=0.24u l=0.1u ad=0.0816p as=0.0816p pd=1.16u ps=1.16u
    I_MXI1_I60_I15_MP5 (I1_I60_pn7 I1_b1_7 XI1_I60_I15_p1 VDD) gpdk090_pmos1v w=0.48u l=0.1u ad=0.1056p as=0.1632p pd=0.92u ps=1.64u
    I_MXI1_I60_I15_MP4 (XI1_I60_I15_p1 XI1_I60_I15_An I1_I60_pn7 VDD) gpdk090_pmos1v w=0.48u l=0.1u ad=0.1056p as=0.1056p pd=0.92u ps=0.92u
    I_MXI1_I60_I15_MP2 (VDD I1_p0_6 XI1_I60_I15_p1 VDD) gpdk090_pmos1v w=0.48u l=0.1u ad=0.1056p as=0.1056p pd=0.92u ps=0.92u
    I_MXI1_I60_I15_MP3 (XI1_I60_I15_p1 XI1_I60_I15_Bn VDD VDD) gpdk090_pmos1v w=0.48u l=0.1u ad=0.1632p as=0.1056p pd=1.64u ps=0.92u
    I_MXI1_I60_I15_MP0 (VDD I1_p0_6 XI1_I60_I15_An VDD) gpdk090_pmos1v w=0.24u l=0.1u ad=0.0816p as=0.0816p pd=1.16u ps=1.16u
    I_MXI1_I48_I15_MP1 (VDD I1_b0_7 XI1_I48_I15_Bn VDD) gpdk090_pmos1v w=0.24u l=0.1u ad=0.0816p as=0.0816p pd=1.16u ps=1.16u
    I_MXI1_I48_I15_MP5 (I1_I48_pn7 I1_b0_7 XI1_I48_I15_p1 VDD) gpdk090_pmos1v w=0.48u l=0.1u ad=0.1056p as=0.1632p pd=0.92u ps=1.64u
    I_MXI1_I48_I15_MP4 (XI1_I48_I15_p1 XI1_I48_I15_An I1_I48_pn7 VDD) gpdk090_pmos1v w=0.48u l=0.1u ad=0.1056p as=0.1056p pd=0.92u ps=0.92u
    I_MXI1_I48_I15_MP2 (VDD VSS XI1_I48_I15_p1 VDD) gpdk090_pmos1v w=0.48u l=0.1u ad=0.1056p as=0.1056p pd=0.92u ps=0.92u
    I_MXI1_I48_I15_MP3 (XI1_I48_I15_p1 XI1_I48_I15_Bn VDD VDD) gpdk090_pmos1v w=0.48u l=0.1u ad=0.1632p as=0.1056p pd=1.64u ps=0.92u
    I_MXI1_I48_I15_MP0 (VDD VSS XI1_I48_I15_An VDD) gpdk090_pmos1v w=0.24u l=0.1u ad=0.0816p as=0.0816p pd=1.16u ps=1.16u
    I_MXI1_I123_MP2 (I1_qu1 I1_p6_8 VDD VDD) gpdk090_pmos1v w=0.48u l=0.1u ad=0.1056p as=0.1632p pd=0.92u ps=1.64u
    I_MXI1_I123_MP2_1 (VDD I1_p6_8 I1_qu1 VDD) gpdk090_pmos1v w=0.48u l=0.1u ad=0.1632p as=0.1056p pd=1.64u ps=0.92u
    I_MXI1_I111_MP2 (I1_qu2 I1_p5_8 VDD VDD) gpdk090_pmos1v w=0.48u l=0.1u ad=0.1056p as=0.1632p pd=0.92u ps=1.64u
    I_MXI1_I111_MP2_1 (VDD I1_p5_8 I1_qu2 VDD) gpdk090_pmos1v w=0.48u l=0.1u ad=0.1632p as=0.1056p pd=1.64u ps=0.92u
    I_MXI1_I99_MP2 (I1_qu3 I1_p4_8 VDD VDD) gpdk090_pmos1v w=0.48u l=0.1u ad=0.1056p as=0.1632p pd=0.92u ps=1.64u
    I_MXI1_I99_MP2_1 (VDD I1_p4_8 I1_qu3 VDD) gpdk090_pmos1v w=0.48u l=0.1u ad=0.1632p as=0.1056p pd=1.64u ps=0.92u
    I_MXI1_I51_MP2 (I1_qu7 I1_p0_8 VDD VDD) gpdk090_pmos1v w=0.48u l=0.1u ad=0.1056p as=0.1632p pd=0.92u ps=1.64u
    I_MXI1_I51_MP2_1 (VDD I1_p0_8 I1_qu7 VDD) gpdk090_pmos1v w=0.48u l=0.1u ad=0.1632p as=0.1056p pd=1.64u ps=0.92u
    I_MXI1_I87_MP2 (I1_qu4 I1_p3_8 VDD VDD) gpdk090_pmos1v w=0.48u l=0.1u ad=0.1056p as=0.1632p pd=0.92u ps=1.64u
    I_MXI1_I87_MP2_1 (VDD I1_p3_8 I1_qu4 VDD) gpdk090_pmos1v w=0.48u l=0.1u ad=0.1632p as=0.1056p pd=1.64u ps=0.92u
    I_MXI1_I75_MP2 (I1_qu5 I1_p2_8 VDD VDD) gpdk090_pmos1v w=0.48u l=0.1u ad=0.1056p as=0.1632p pd=0.92u ps=1.64u
    I_MXI1_I75_MP2_1 (VDD I1_p2_8 I1_qu5 VDD) gpdk090_pmos1v w=0.48u l=0.1u ad=0.1632p as=0.1056p pd=1.64u ps=0.92u
    I_MXI1_I63_MP2 (I1_qu6 I1_p1_8 VDD VDD) gpdk090_pmos1v w=0.48u l=0.1u ad=0.1056p as=0.1632p pd=0.92u ps=1.64u
    I_MXI1_I63_MP2_1 (VDD I1_p1_8 I1_qu6 VDD) gpdk090_pmos1v w=0.48u l=0.1u ad=0.1632p as=0.1056p pd=1.64u ps=0.92u
    I_MXI0_I68_MP9 (XI0_I68_xp1 I0_ha13_1 VDD VDD) gpdk090_pmos1v w=0.48u l=0.1u ad=0.1056p as=0.1632p pd=0.92u ps=1.64u
    I_MXI0_I68_MP11 (I0_ha25_0 XI0_I68_xan XI0_I68_xp1 VDD) gpdk090_pmos1v w=0.48u l=0.1u ad=0.1056p as=0.1056p pd=0.92u ps=0.92u
    I_MXI0_I68_MP12 (XI0_I68_xp1 XI0_I68_xbn I0_ha25_0 VDD) gpdk090_pmos1v w=0.48u l=0.1u ad=0.1056p as=0.1056p pd=0.92u ps=0.92u
    I_MXI0_I68_MP10 (VDD I0_sn3 XI0_I68_xp1 VDD) gpdk090_pmos1v w=0.48u l=0.1u ad=0.1632p as=0.1056p pd=1.64u ps=0.92u
    I_MXI0_I68_MP2 (VDD I0_ha13_1 XI0_I68_xan VDD) gpdk090_pmos1v w=0.24u l=0.1u ad=0.0528p as=0.0816p pd=0.68u ps=1.16u
    I_MXI0_I68_MP16 (XI0_I68_con I0_sn3 VDD VDD) gpdk090_pmos1v w=0.24u l=0.1u ad=0.0528p as=0.0528p pd=0.68u ps=0.68u
    I_MXI0_I68_MP15 (VDD I0_ha13_1 XI0_I68_con VDD) gpdk090_pmos1v w=0.24u l=0.1u ad=0.0816p as=0.0528p pd=1.16u ps=0.68u
    I_MXI0_I68_MP18 (VDD XI0_I68_con I0_ha25_1 VDD) gpdk090_pmos1v w=0.24u l=0.1u ad=0.0816p as=0.0816p pd=1.16u ps=1.16u
    I_MXI0_I68_MP4 (XI0_I68_xbn I0_sn3 VDD VDD) gpdk090_pmos1v w=0.24u l=0.1u ad=0.0816p as=0.0816p pd=1.16u ps=1.16u
    I_MXI0_I65_MP9 (XI0_I65_xp1 I0_cm10_1 VDD VDD) gpdk090_pmos1v w=0.48u l=0.1u ad=0.1056p as=0.1632p pd=0.92u ps=1.64u
    I_MXI0_I65_MP11 (I0_ha22_0 XI0_I65_xan XI0_I65_xp1 VDD) gpdk090_pmos1v w=0.48u l=0.1u ad=0.1056p as=0.1056p pd=0.92u ps=0.92u
    I_MXI0_I65_MP12 (XI0_I65_xp1 XI0_I65_xbn I0_ha22_0 VDD) gpdk090_pmos1v w=0.48u l=0.1u ad=0.1056p as=0.1056p pd=0.92u ps=0.92u
    I_MXI0_I65_MP10 (VDD I0_cm11_0 XI0_I65_xp1 VDD) gpdk090_pmos1v w=0.48u l=0.1u ad=0.1632p as=0.1056p pd=1.64u ps=0.92u
    I_MXI0_I65_MP2 (VDD I0_cm10_1 XI0_I65_xan VDD) gpdk090_pmos1v w=0.24u l=0.1u ad=0.0528p as=0.0816p pd=0.68u ps=1.16u
    I_MXI0_I65_MP16 (XI0_I65_con I0_cm11_0 VDD VDD) gpdk090_pmos1v w=0.24u l=0.1u ad=0.0528p as=0.0528p pd=0.68u ps=0.68u
    I_MXI0_I65_MP15 (VDD I0_cm10_1 XI0_I65_con VDD) gpdk090_pmos1v w=0.24u l=0.1u ad=0.0816p as=0.0528p pd=1.16u ps=0.68u
    I_MXI0_I65_MP18 (VDD XI0_I65_con I0_ha22_1 VDD) gpdk090_pmos1v w=0.24u l=0.1u ad=0.0816p as=0.0816p pd=1.16u ps=1.16u
    I_MXI0_I65_MP4 (XI0_I65_xbn I0_cm11_0 VDD VDD) gpdk090_pmos1v w=0.24u l=0.1u ad=0.0816p as=0.0816p pd=1.16u ps=1.16u
    I_MXI0_I66_MP9 (XI0_I66_xp1 I0_cm11_1 VDD VDD) gpdk090_pmos1v w=0.48u l=0.1u ad=0.1056p as=0.1632p pd=0.92u ps=1.64u
    I_MXI0_I66_MP11 (I0_ha23_0 XI0_I66_xan XI0_I66_xp1 VDD) gpdk090_pmos1v w=0.48u l=0.1u ad=0.1056p as=0.1056p pd=0.92u ps=0.92u
    I_MXI0_I66_MP12 (XI0_I66_xp1 XI0_I66_xbn I0_ha23_0 VDD) gpdk090_pmos1v w=0.48u l=0.1u ad=0.1056p as=0.1056p pd=0.92u ps=0.92u
    I_MXI0_I66_MP10 (VDD I0_fa12_0 XI0_I66_xp1 VDD) gpdk090_pmos1v w=0.48u l=0.1u ad=0.1632p as=0.1056p pd=1.64u ps=0.92u
    I_MXI0_I66_MP2 (VDD I0_cm11_1 XI0_I66_xan VDD) gpdk090_pmos1v w=0.24u l=0.1u ad=0.0528p as=0.0816p pd=0.68u ps=1.16u
    I_MXI0_I66_MP16 (XI0_I66_con I0_fa12_0 VDD VDD) gpdk090_pmos1v w=0.24u l=0.1u ad=0.0528p as=0.0528p pd=0.68u ps=0.68u
    I_MXI0_I66_MP15 (VDD I0_cm11_1 XI0_I66_con VDD) gpdk090_pmos1v w=0.24u l=0.1u ad=0.0816p as=0.0528p pd=1.16u ps=0.68u
    I_MXI0_I66_MP18 (VDD XI0_I66_con I0_ha23_1 VDD) gpdk090_pmos1v w=0.24u l=0.1u ad=0.0816p as=0.0816p pd=1.16u ps=1.16u
    I_MXI0_I66_MP4 (XI0_I66_xbn I0_fa12_0 VDD VDD) gpdk090_pmos1v w=0.24u l=0.1u ad=0.0816p as=0.0816p pd=1.16u ps=1.16u
    I_MXI0_I67_MP9 (XI0_I67_xp1 I0_fa12_1 VDD VDD) gpdk090_pmos1v w=0.48u l=0.1u ad=0.1056p as=0.1632p pd=0.92u ps=1.64u
    I_MXI0_I67_MP11 (I0_ha24_0 XI0_I67_xan XI0_I67_xp1 VDD) gpdk090_pmos1v w=0.48u l=0.1u ad=0.1056p as=0.1056p pd=0.92u ps=0.92u
    I_MXI0_I67_MP12 (XI0_I67_xp1 XI0_I67_xbn I0_ha24_0 VDD) gpdk090_pmos1v w=0.48u l=0.1u ad=0.1056p as=0.1056p pd=0.92u ps=0.92u
    I_MXI0_I67_MP10 (VDD I0_ha13_0 XI0_I67_xp1 VDD) gpdk090_pmos1v w=0.48u l=0.1u ad=0.1632p as=0.1056p pd=1.64u ps=0.92u
    I_MXI0_I67_MP2 (VDD I0_fa12_1 XI0_I67_xan VDD) gpdk090_pmos1v w=0.24u l=0.1u ad=0.0528p as=0.0816p pd=0.68u ps=1.16u
    I_MXI0_I67_MP16 (XI0_I67_con I0_ha13_0 VDD VDD) gpdk090_pmos1v w=0.24u l=0.1u ad=0.0528p as=0.0528p pd=0.68u ps=0.68u
    I_MXI0_I67_MP15 (VDD I0_fa12_1 XI0_I67_con VDD) gpdk090_pmos1v w=0.24u l=0.1u ad=0.0816p as=0.0528p pd=1.16u ps=0.68u
    I_MXI0_I67_MP18 (VDD XI0_I67_con I0_ha24_1 VDD) gpdk090_pmos1v w=0.24u l=0.1u ad=0.0816p as=0.0816p pd=1.16u ps=1.16u
    I_MXI0_I67_MP4 (XI0_I67_xbn I0_ha13_0 VDD VDD) gpdk090_pmos1v w=0.24u l=0.1u ad=0.0816p as=0.0816p pd=1.16u ps=1.16u
    I_MXI0_I56_MP9 (XI0_I56_xp1 VDD VDD VDD) gpdk090_pmos1v w=0.48u l=0.1u ad=0.1056p as=0.1632p pd=0.92u ps=1.64u
    I_MXI0_I56_MP11 (I0_ha13_0 XI0_I56_xan XI0_I56_xp1 VDD) gpdk090_pmos1v w=0.48u l=0.1u ad=0.1056p as=0.1056p pd=0.92u ps=0.92u
    I_MXI0_I56_MP12 (XI0_I56_xp1 XI0_I56_xbn I0_ha13_0 VDD) gpdk090_pmos1v w=0.48u l=0.1u ad=0.1056p as=0.1056p pd=0.92u ps=0.92u
    I_MXI0_I56_MP10 (VDD I0_pp3_8 XI0_I56_xp1 VDD) gpdk090_pmos1v w=0.48u l=0.1u ad=0.1632p as=0.1056p pd=1.64u ps=0.92u
    I_MXI0_I56_MP2 (VDD VDD XI0_I56_xan VDD) gpdk090_pmos1v w=0.24u l=0.1u ad=0.0528p as=0.0816p pd=0.68u ps=1.16u
    I_MXI0_I56_MP16 (XI0_I56_con I0_pp3_8 VDD VDD) gpdk090_pmos1v w=0.24u l=0.1u ad=0.0528p as=0.0528p pd=0.68u ps=0.68u
    I_MXI0_I56_MP15 (VDD VDD XI0_I56_con VDD) gpdk090_pmos1v w=0.24u l=0.1u ad=0.0816p as=0.0528p pd=1.16u ps=0.68u
    I_MXI0_I56_MP18 (VDD XI0_I56_con I0_ha13_1 VDD) gpdk090_pmos1v w=0.24u l=0.1u ad=0.0816p as=0.0816p pd=1.16u ps=1.16u
    I_MXI0_I56_MP4 (XI0_I56_xbn I0_pp3_8 VDD VDD) gpdk090_pmos1v w=0.24u l=0.1u ad=0.0816p as=0.0816p pd=1.16u ps=1.16u
    I_MXI0_I64_MP9 (XI0_I64_xp1 I0_cm9_1 VDD VDD) gpdk090_pmos1v w=0.48u l=0.1u ad=0.1056p as=0.1632p pd=0.92u ps=1.64u
    I_MXI0_I64_MP11 (I0_ha21_0 XI0_I64_xan XI0_I64_xp1 VDD) gpdk090_pmos1v w=0.48u l=0.1u ad=0.1056p as=0.1056p pd=0.92u ps=0.92u
    I_MXI0_I64_MP12 (XI0_I64_xp1 XI0_I64_xbn I0_ha21_0 VDD) gpdk090_pmos1v w=0.48u l=0.1u ad=0.1056p as=0.1056p pd=0.92u ps=0.92u
    I_MXI0_I64_MP10 (VDD I0_cm10_0 XI0_I64_xp1 VDD) gpdk090_pmos1v w=0.48u l=0.1u ad=0.1632p as=0.1056p pd=1.64u ps=0.92u
    I_MXI0_I64_MP2 (VDD I0_cm9_1 XI0_I64_xan VDD) gpdk090_pmos1v w=0.24u l=0.1u ad=0.0528p as=0.0816p pd=0.68u ps=1.16u
    I_MXI0_I64_MP16 (XI0_I64_con I0_cm10_0 VDD VDD) gpdk090_pmos1v w=0.24u l=0.1u ad=0.0528p as=0.0528p pd=0.68u ps=0.68u
    I_MXI0_I64_MP15 (VDD I0_cm9_1 XI0_I64_con VDD) gpdk090_pmos1v w=0.24u l=0.1u ad=0.0816p as=0.0528p pd=1.16u ps=0.68u
    I_MXI0_I64_MP18 (VDD XI0_I64_con I0_ha21_1 VDD) gpdk090_pmos1v w=0.24u l=0.1u ad=0.0816p as=0.0816p pd=1.16u ps=1.16u
    I_MXI0_I64_MP4 (XI0_I64_xbn I0_cm10_0 VDD VDD) gpdk090_pmos1v w=0.24u l=0.1u ad=0.0816p as=0.0816p pd=1.16u ps=1.16u
    I_MXI0_I63_MP9 (XI0_I63_xp1 I0_cm8_1 VDD VDD) gpdk090_pmos1v w=0.48u l=0.1u ad=0.1056p as=0.1632p pd=0.92u ps=1.64u
    I_MXI0_I63_MP11 (I0_ha20_0 XI0_I63_xan XI0_I63_xp1 VDD) gpdk090_pmos1v w=0.48u l=0.1u ad=0.1056p as=0.1056p pd=0.92u ps=0.92u
    I_MXI0_I63_MP12 (XI0_I63_xp1 XI0_I63_xbn I0_ha20_0 VDD) gpdk090_pmos1v w=0.48u l=0.1u ad=0.1056p as=0.1056p pd=0.92u ps=0.92u
    I_MXI0_I63_MP10 (VDD I0_cm9_0 XI0_I63_xp1 VDD) gpdk090_pmos1v w=0.48u l=0.1u ad=0.1632p as=0.1056p pd=1.64u ps=0.92u
    I_MXI0_I63_MP2 (VDD I0_cm8_1 XI0_I63_xan VDD) gpdk090_pmos1v w=0.24u l=0.1u ad=0.0528p as=0.0816p pd=0.68u ps=1.16u
    I_MXI0_I63_MP16 (XI0_I63_con I0_cm9_0 VDD VDD) gpdk090_pmos1v w=0.24u l=0.1u ad=0.0528p as=0.0528p pd=0.68u ps=0.68u
    I_MXI0_I63_MP15 (VDD I0_cm8_1 XI0_I63_con VDD) gpdk090_pmos1v w=0.24u l=0.1u ad=0.0816p as=0.0528p pd=1.16u ps=0.68u
    I_MXI0_I63_MP18 (VDD XI0_I63_con I0_ha20_1 VDD) gpdk090_pmos1v w=0.24u l=0.1u ad=0.0816p as=0.0816p pd=1.16u ps=1.16u
    I_MXI0_I63_MP4 (XI0_I63_xbn I0_cm9_0 VDD VDD) gpdk090_pmos1v w=0.24u l=0.1u ad=0.0816p as=0.0816p pd=1.16u ps=1.16u
    I_MXI0_I62_MP9 (XI0_I62_xp1 I0_cm7_1 VDD VDD) gpdk090_pmos1v w=0.48u l=0.1u ad=0.1056p as=0.1632p pd=0.92u ps=1.64u
    I_MXI0_I62_MP11 (I0_ha19_0 XI0_I62_xan XI0_I62_xp1 VDD) gpdk090_pmos1v w=0.48u l=0.1u ad=0.1056p as=0.1056p pd=0.92u ps=0.92u
    I_MXI0_I62_MP12 (XI0_I62_xp1 XI0_I62_xbn I0_ha19_0 VDD) gpdk090_pmos1v w=0.48u l=0.1u ad=0.1056p as=0.1056p pd=0.92u ps=0.92u
    I_MXI0_I62_MP10 (VDD I0_cm8_0 XI0_I62_xp1 VDD) gpdk090_pmos1v w=0.48u l=0.1u ad=0.1632p as=0.1056p pd=1.64u ps=0.92u
    I_MXI0_I62_MP2 (VDD I0_cm7_1 XI0_I62_xan VDD) gpdk090_pmos1v w=0.24u l=0.1u ad=0.0528p as=0.0816p pd=0.68u ps=1.16u
    I_MXI0_I62_MP16 (XI0_I62_con I0_cm8_0 VDD VDD) gpdk090_pmos1v w=0.24u l=0.1u ad=0.0528p as=0.0528p pd=0.68u ps=0.68u
    I_MXI0_I62_MP15 (VDD I0_cm7_1 XI0_I62_con VDD) gpdk090_pmos1v w=0.24u l=0.1u ad=0.0816p as=0.0528p pd=1.16u ps=0.68u
    I_MXI0_I62_MP18 (VDD XI0_I62_con I0_ha19_1 VDD) gpdk090_pmos1v w=0.24u l=0.1u ad=0.0816p as=0.0816p pd=1.16u ps=1.16u
    I_MXI0_I62_MP4 (XI0_I62_xbn I0_cm8_0 VDD VDD) gpdk090_pmos1v w=0.24u l=0.1u ad=0.0816p as=0.0816p pd=1.16u ps=1.16u
    I_MXI0_I61_MP9 (XI0_I61_xp1 I0_cm6_1 VDD VDD) gpdk090_pmos1v w=0.48u l=0.1u ad=0.1056p as=0.1632p pd=0.92u ps=1.64u
    I_MXI0_I61_MP11 (I0_ha18_0 XI0_I61_xan XI0_I61_xp1 VDD) gpdk090_pmos1v w=0.48u l=0.1u ad=0.1056p as=0.1056p pd=0.92u ps=0.92u
    I_MXI0_I61_MP12 (XI0_I61_xp1 XI0_I61_xbn I0_ha18_0 VDD) gpdk090_pmos1v w=0.48u l=0.1u ad=0.1056p as=0.1056p pd=0.92u ps=0.92u
    I_MXI0_I61_MP10 (VDD I0_cm7_0 XI0_I61_xp1 VDD) gpdk090_pmos1v w=0.48u l=0.1u ad=0.1632p as=0.1056p pd=1.64u ps=0.92u
    I_MXI0_I61_MP2 (VDD I0_cm6_1 XI0_I61_xan VDD) gpdk090_pmos1v w=0.24u l=0.1u ad=0.0528p as=0.0816p pd=0.68u ps=1.16u
    I_MXI0_I61_MP16 (XI0_I61_con I0_cm7_0 VDD VDD) gpdk090_pmos1v w=0.24u l=0.1u ad=0.0528p as=0.0528p pd=0.68u ps=0.68u
    I_MXI0_I61_MP15 (VDD I0_cm6_1 XI0_I61_con VDD) gpdk090_pmos1v w=0.24u l=0.1u ad=0.0816p as=0.0528p pd=1.16u ps=0.68u
    I_MXI0_I61_MP18 (VDD XI0_I61_con I0_ha18_1 VDD) gpdk090_pmos1v w=0.24u l=0.1u ad=0.0816p as=0.0816p pd=1.16u ps=1.16u
    I_MXI0_I61_MP4 (XI0_I61_xbn I0_cm7_0 VDD VDD) gpdk090_pmos1v w=0.24u l=0.1u ad=0.0816p as=0.0816p pd=1.16u ps=1.16u
    I_MXI0_I59_MP9 (XI0_I59_xp1 I0_fa4_1 VDD VDD) gpdk090_pmos1v w=0.48u l=0.1u ad=0.1056p as=0.1632p pd=0.92u ps=1.64u
    I_MXI0_I59_MP11 (I0_ha16_0 XI0_I59_xan XI0_I59_xp1 VDD) gpdk090_pmos1v w=0.48u l=0.1u ad=0.1056p as=0.1056p pd=0.92u ps=0.92u
    I_MXI0_I59_MP12 (XI0_I59_xp1 XI0_I59_xbn I0_ha16_0 VDD) gpdk090_pmos1v w=0.48u l=0.1u ad=0.1056p as=0.1056p pd=0.92u ps=0.92u
    I_MXI0_I59_MP10 (VDD I0_cm5_0 XI0_I59_xp1 VDD) gpdk090_pmos1v w=0.48u l=0.1u ad=0.1632p as=0.1056p pd=1.64u ps=0.92u
    I_MXI0_I59_MP2 (VDD I0_fa4_1 XI0_I59_xan VDD) gpdk090_pmos1v w=0.24u l=0.1u ad=0.0528p as=0.0816p pd=0.68u ps=1.16u
    I_MXI0_I59_MP16 (XI0_I59_con I0_cm5_0 VDD VDD) gpdk090_pmos1v w=0.24u l=0.1u ad=0.0528p as=0.0528p pd=0.68u ps=0.68u
    I_MXI0_I59_MP15 (VDD I0_fa4_1 XI0_I59_con VDD) gpdk090_pmos1v w=0.24u l=0.1u ad=0.0816p as=0.0528p pd=1.16u ps=0.68u
    I_MXI0_I59_MP18 (VDD XI0_I59_con I0_ha16_1 VDD) gpdk090_pmos1v w=0.24u l=0.1u ad=0.0816p as=0.0816p pd=1.16u ps=1.16u
    I_MXI0_I59_MP4 (XI0_I59_xbn I0_cm5_0 VDD VDD) gpdk090_pmos1v w=0.24u l=0.1u ad=0.0816p as=0.0816p pd=1.16u ps=1.16u
    I_MXI0_I60_MP9 (XI0_I60_xp1 I0_cm5_1 VDD VDD) gpdk090_pmos1v w=0.48u l=0.1u ad=0.1056p as=0.1632p pd=0.92u ps=1.64u
    I_MXI0_I60_MP11 (I0_ha17_0 XI0_I60_xan XI0_I60_xp1 VDD) gpdk090_pmos1v w=0.48u l=0.1u ad=0.1056p as=0.1056p pd=0.92u ps=0.92u
    I_MXI0_I60_MP12 (XI0_I60_xp1 XI0_I60_xbn I0_ha17_0 VDD) gpdk090_pmos1v w=0.48u l=0.1u ad=0.1056p as=0.1056p pd=0.92u ps=0.92u
    I_MXI0_I60_MP10 (VDD I0_cm6_0 XI0_I60_xp1 VDD) gpdk090_pmos1v w=0.48u l=0.1u ad=0.1632p as=0.1056p pd=1.64u ps=0.92u
    I_MXI0_I60_MP2 (VDD I0_cm5_1 XI0_I60_xan VDD) gpdk090_pmos1v w=0.24u l=0.1u ad=0.0528p as=0.0816p pd=0.68u ps=1.16u
    I_MXI0_I60_MP16 (XI0_I60_con I0_cm6_0 VDD VDD) gpdk090_pmos1v w=0.24u l=0.1u ad=0.0528p as=0.0528p pd=0.68u ps=0.68u
    I_MXI0_I60_MP15 (VDD I0_cm5_1 XI0_I60_con VDD) gpdk090_pmos1v w=0.24u l=0.1u ad=0.0816p as=0.0528p pd=1.16u ps=0.68u
    I_MXI0_I60_MP18 (VDD XI0_I60_con I0_ha17_1 VDD) gpdk090_pmos1v w=0.24u l=0.1u ad=0.0816p as=0.0816p pd=1.16u ps=1.16u
    I_MXI0_I60_MP4 (XI0_I60_xbn I0_cm6_0 VDD VDD) gpdk090_pmos1v w=0.24u l=0.1u ad=0.0816p as=0.0816p pd=1.16u ps=1.16u
    I_MXI0_I58_MP9 (XI0_I58_xp1 I0_fa3_1 VDD VDD) gpdk090_pmos1v w=0.48u l=0.1u ad=0.1056p as=0.1632p pd=0.92u ps=1.64u
    I_MXI0_I58_MP11 (I0_ha15_0 XI0_I58_xan XI0_I58_xp1 VDD) gpdk090_pmos1v w=0.48u l=0.1u ad=0.1056p as=0.1056p pd=0.92u ps=0.92u
    I_MXI0_I58_MP12 (XI0_I58_xp1 XI0_I58_xbn I0_ha15_0 VDD) gpdk090_pmos1v w=0.48u l=0.1u ad=0.1056p as=0.1056p pd=0.92u ps=0.92u
    I_MXI0_I58_MP10 (VDD I0_fa4_0 XI0_I58_xp1 VDD) gpdk090_pmos1v w=0.48u l=0.1u ad=0.1632p as=0.1056p pd=1.64u ps=0.92u
    I_MXI0_I58_MP2 (VDD I0_fa3_1 XI0_I58_xan VDD) gpdk090_pmos1v w=0.24u l=0.1u ad=0.0528p as=0.0816p pd=0.68u ps=1.16u
    I_MXI0_I58_MP16 (XI0_I58_con I0_fa4_0 VDD VDD) gpdk090_pmos1v w=0.24u l=0.1u ad=0.0528p as=0.0528p pd=0.68u ps=0.68u
    I_MXI0_I58_MP15 (VDD I0_fa3_1 XI0_I58_con VDD) gpdk090_pmos1v w=0.24u l=0.1u ad=0.0816p as=0.0528p pd=1.16u ps=0.68u
    I_MXI0_I58_MP18 (VDD XI0_I58_con I0_ha15_1 VDD) gpdk090_pmos1v w=0.24u l=0.1u ad=0.0816p as=0.0816p pd=1.16u ps=1.16u
    I_MXI0_I58_MP4 (XI0_I58_xbn I0_fa4_0 VDD VDD) gpdk090_pmos1v w=0.24u l=0.1u ad=0.0816p as=0.0816p pd=1.16u ps=1.16u
    I_MXI0_I73_MP9 (XI0_I73_xp1 I0_fa14_0 VDD VDD) gpdk090_pmos1v w=0.48u l=0.1u ad=0.1056p as=0.1632p pd=0.92u ps=1.64u
    I_MXI0_I73_MP11 (MULP_4 XI0_I73_xan XI0_I73_xp1 VDD) gpdk090_pmos1v w=0.48u l=0.1u ad=0.1056p as=0.1056p pd=0.92u ps=0.92u
    I_MXI0_I73_MP12 (XI0_I73_xp1 XI0_I73_xbn MULP_4 VDD) gpdk090_pmos1v w=0.48u l=0.1u ad=0.1056p as=0.1056p pd=0.92u ps=0.92u
    I_MXI0_I73_MP10 (VDD I0_rc4 XI0_I73_xp1 VDD) gpdk090_pmos1v w=0.48u l=0.1u ad=0.1632p as=0.1056p pd=1.64u ps=0.92u
    I_MXI0_I73_MP2 (VDD I0_fa14_0 XI0_I73_xan VDD) gpdk090_pmos1v w=0.24u l=0.1u ad=0.0528p as=0.0816p pd=0.68u ps=1.16u
    I_MXI0_I73_MP16 (XI0_I73_con I0_rc4 VDD VDD) gpdk090_pmos1v w=0.24u l=0.1u ad=0.0528p as=0.0528p pd=0.68u ps=0.68u
    I_MXI0_I73_MP15 (VDD I0_fa14_0 XI0_I73_con VDD) gpdk090_pmos1v w=0.24u l=0.1u ad=0.0816p as=0.0528p pd=1.16u ps=0.68u
    I_MXI0_I73_MP18 (VDD XI0_I73_con I0_rc5 VDD) gpdk090_pmos1v w=0.24u l=0.1u ad=0.0816p as=0.0816p pd=1.16u ps=1.16u
    I_MXI0_I73_MP4 (XI0_I73_xbn I0_rc4 VDD VDD) gpdk090_pmos1v w=0.24u l=0.1u ad=0.0816p as=0.0816p pd=1.16u ps=1.16u
    I_MXI0_I45_MP9 (XI0_I45_xp1 I0_pp0_3 VDD VDD) gpdk090_pmos1v w=0.48u l=0.1u ad=0.1056p as=0.1632p pd=0.92u ps=1.64u
    I_MXI0_I45_MP11 (I0_ha2_0 XI0_I45_xan XI0_I45_xp1 VDD) gpdk090_pmos1v w=0.48u l=0.1u ad=0.1056p as=0.1056p pd=0.92u ps=0.92u
    I_MXI0_I45_MP12 (XI0_I45_xp1 XI0_I45_xbn I0_ha2_0 VDD) gpdk090_pmos1v w=0.48u l=0.1u ad=0.1056p as=0.1056p pd=0.92u ps=0.92u
    I_MXI0_I45_MP10 (VDD I0_pp1_1 XI0_I45_xp1 VDD) gpdk090_pmos1v w=0.48u l=0.1u ad=0.1632p as=0.1056p pd=1.64u ps=0.92u
    I_MXI0_I45_MP2 (VDD I0_pp0_3 XI0_I45_xan VDD) gpdk090_pmos1v w=0.24u l=0.1u ad=0.0528p as=0.0816p pd=0.68u ps=1.16u
    I_MXI0_I45_MP16 (XI0_I45_con I0_pp1_1 VDD VDD) gpdk090_pmos1v w=0.24u l=0.1u ad=0.0528p as=0.0528p pd=0.68u ps=0.68u
    I_MXI0_I45_MP15 (VDD I0_pp0_3 XI0_I45_con VDD) gpdk090_pmos1v w=0.24u l=0.1u ad=0.0816p as=0.0528p pd=1.16u ps=0.68u
    I_MXI0_I45_MP18 (VDD XI0_I45_con I0_ha2_1 VDD) gpdk090_pmos1v w=0.24u l=0.1u ad=0.0816p as=0.0816p pd=1.16u ps=1.16u
    I_MXI0_I45_MP4 (XI0_I45_xbn I0_pp1_1 VDD VDD) gpdk090_pmos1v w=0.24u l=0.1u ad=0.0816p as=0.0816p pd=1.16u ps=1.16u
    I_MXI0_I70_MP9 (XI0_I70_xp1 I0_pp0_1 VDD VDD) gpdk090_pmos1v w=0.48u l=0.1u ad=0.1056p as=0.1632p pd=0.92u ps=1.64u
    I_MXI0_I70_MP11 (MULP_1 XI0_I70_xan XI0_I70_xp1 VDD) gpdk090_pmos1v w=0.48u l=0.1u ad=0.1056p as=0.1056p pd=0.92u ps=0.92u
    I_MXI0_I70_MP12 (XI0_I70_xp1 XI0_I70_xbn MULP_1 VDD) gpdk090_pmos1v w=0.48u l=0.1u ad=0.1056p as=0.1056p pd=0.92u ps=0.92u
    I_MXI0_I70_MP10 (VDD I0_rc1 XI0_I70_xp1 VDD) gpdk090_pmos1v w=0.48u l=0.1u ad=0.1632p as=0.1056p pd=1.64u ps=0.92u
    I_MXI0_I70_MP2 (VDD I0_pp0_1 XI0_I70_xan VDD) gpdk090_pmos1v w=0.24u l=0.1u ad=0.0528p as=0.0816p pd=0.68u ps=1.16u
    I_MXI0_I70_MP16 (XI0_I70_con I0_rc1 VDD VDD) gpdk090_pmos1v w=0.24u l=0.1u ad=0.0528p as=0.0528p pd=0.68u ps=0.68u
    I_MXI0_I70_MP15 (VDD I0_pp0_1 XI0_I70_con VDD) gpdk090_pmos1v w=0.24u l=0.1u ad=0.0816p as=0.0528p pd=1.16u ps=0.68u
    I_MXI0_I70_MP18 (VDD XI0_I70_con I0_rc2 VDD) gpdk090_pmos1v w=0.24u l=0.1u ad=0.0816p as=0.0816p pd=1.16u ps=1.16u
    I_MXI0_I70_MP4 (XI0_I70_xbn I0_rc1 VDD VDD) gpdk090_pmos1v w=0.24u l=0.1u ad=0.0816p as=0.0816p pd=1.16u ps=1.16u
    I_MXI0_I69_MP9 (XI0_I69_xp1 I0_pp0_0 VDD VDD) gpdk090_pmos1v w=0.48u l=0.1u ad=0.1056p as=0.1632p pd=0.92u ps=1.64u
    I_MXI0_I69_MP11 (MULP_0 XI0_I69_xan XI0_I69_xp1 VDD) gpdk090_pmos1v w=0.48u l=0.1u ad=0.1056p as=0.1056p pd=0.92u ps=0.92u
    I_MXI0_I69_MP12 (XI0_I69_xp1 XI0_I69_xbn MULP_0 VDD) gpdk090_pmos1v w=0.48u l=0.1u ad=0.1056p as=0.1056p pd=0.92u ps=0.92u
    I_MXI0_I69_MP10 (VDD B_1 XI0_I69_xp1 VDD) gpdk090_pmos1v w=0.48u l=0.1u ad=0.1632p as=0.1056p pd=1.64u ps=0.92u
    I_MXI0_I69_MP2 (VDD I0_pp0_0 XI0_I69_xan VDD) gpdk090_pmos1v w=0.24u l=0.1u ad=0.0528p as=0.0816p pd=0.68u ps=1.16u
    I_MXI0_I69_MP16 (XI0_I69_con B_1 VDD VDD) gpdk090_pmos1v w=0.24u l=0.1u ad=0.0528p as=0.0528p pd=0.68u ps=0.68u
    I_MXI0_I69_MP15 (VDD I0_pp0_0 XI0_I69_con VDD) gpdk090_pmos1v w=0.24u l=0.1u ad=0.0816p as=0.0528p pd=1.16u ps=0.68u
    I_MXI0_I69_MP18 (VDD XI0_I69_con I0_rc1 VDD) gpdk090_pmos1v w=0.24u l=0.1u ad=0.0816p as=0.0816p pd=1.16u ps=1.16u
    I_MXI0_I69_MP4 (XI0_I69_xbn B_1 VDD VDD) gpdk090_pmos1v w=0.24u l=0.1u ad=0.0816p as=0.0816p pd=1.16u ps=1.16u
    I_MXI0_I71_MP9 (XI0_I71_xp1 I0_fa1_0 VDD VDD) gpdk090_pmos1v w=0.48u l=0.1u ad=0.1056p as=0.1632p pd=0.92u ps=1.64u
    I_MXI0_I71_MP11 (MULP_2 XI0_I71_xan XI0_I71_xp1 VDD) gpdk090_pmos1v w=0.48u l=0.1u ad=0.1056p as=0.1056p pd=0.92u ps=0.92u
    I_MXI0_I71_MP12 (XI0_I71_xp1 XI0_I71_xbn MULP_2 VDD) gpdk090_pmos1v w=0.48u l=0.1u ad=0.1056p as=0.1056p pd=0.92u ps=0.92u
    I_MXI0_I71_MP10 (VDD I0_rc2 XI0_I71_xp1 VDD) gpdk090_pmos1v w=0.48u l=0.1u ad=0.1632p as=0.1056p pd=1.64u ps=0.92u
    I_MXI0_I71_MP2 (VDD I0_fa1_0 XI0_I71_xan VDD) gpdk090_pmos1v w=0.24u l=0.1u ad=0.0528p as=0.0816p pd=0.68u ps=1.16u
    I_MXI0_I71_MP16 (XI0_I71_con I0_rc2 VDD VDD) gpdk090_pmos1v w=0.24u l=0.1u ad=0.0528p as=0.0528p pd=0.68u ps=0.68u
    I_MXI0_I71_MP15 (VDD I0_fa1_0 XI0_I71_con VDD) gpdk090_pmos1v w=0.24u l=0.1u ad=0.0816p as=0.0528p pd=1.16u ps=0.68u
    I_MXI0_I71_MP18 (VDD XI0_I71_con I0_rc3 VDD) gpdk090_pmos1v w=0.24u l=0.1u ad=0.0816p as=0.0816p pd=1.16u ps=1.16u
    I_MXI0_I71_MP4 (XI0_I71_xbn I0_rc2 VDD VDD) gpdk090_pmos1v w=0.24u l=0.1u ad=0.0816p as=0.0816p pd=1.16u ps=1.16u
    I_MXI0_I77_I31_XG_MP2 (XI0_I77_I31_XG_p1 I0_I77_G7_6 I0_I77_G7_4n VDD) gpdk090_pmos1v w=0.48u l=0.1u ad=0.1056p as=0.1632p pd=0.92u ps=1.64u
    I_MXI0_I77_I31_XG_MP0 (VDD I0_I77_P7_6 XI0_I77_I31_XG_p1 VDD) gpdk090_pmos1v w=0.48u l=0.1u ad=0.1056p as=0.1056p pd=0.92u ps=0.92u
    I_MXI0_I77_I31_XG_MP1 (XI0_I77_I31_XG_p1 I0_I77_G5_4 VDD VDD) gpdk090_pmos1v w=0.48u l=0.1u ad=0.1632p as=0.1056p pd=1.64u ps=0.92u
    I_MXI1_I189_MP2 (XI1_I189_p1 I1_nrk5 I1_nrkn6 VDD) gpdk090_pmos1v w=0.48u l=0.1u ad=0.1056p as=0.1632p pd=0.92u ps=1.64u
    I_MXI1_I189_MP0 (VDD A_7 XI1_I189_p1 VDD) gpdk090_pmos1v w=0.48u l=0.1u ad=0.1056p as=0.1056p pd=0.92u ps=0.92u
    I_MXI1_I189_MP1 (XI1_I189_p1 I1_ru5 VDD VDD) gpdk090_pmos1v w=0.48u l=0.1u ad=0.1632p as=0.1056p pd=1.64u ps=0.92u
    I_MXI1_I192_MP2 (XI1_I192_p1 I1_nrk6 I1_nrkn7 VDD) gpdk090_pmos1v w=0.48u l=0.1u ad=0.1056p as=0.1632p pd=0.92u ps=1.64u
    I_MXI1_I192_MP0 (VDD A_7 XI1_I192_p1 VDD) gpdk090_pmos1v w=0.48u l=0.1u ad=0.1056p as=0.1056p pd=0.92u ps=0.92u
    I_MXI1_I192_MP1 (XI1_I192_p1 I1_ru6 VDD VDD) gpdk090_pmos1v w=0.48u l=0.1u ad=0.1632p as=0.1056p pd=1.64u ps=0.92u
    I_MXI0_I77_I30_XG_MP2 (XI0_I77_I30_XG_p1 I0_I77_G6_5 I0_I77_G6_3n VDD) gpdk090_pmos1v w=0.48u l=0.1u ad=0.1056p as=0.1632p pd=0.92u ps=1.64u
    I_MXI0_I77_I30_XG_MP0 (VDD I0_I77_P6_5 XI0_I77_I30_XG_p1 VDD) gpdk090_pmos1v w=0.48u l=0.1u ad=0.1056p as=0.1056p pd=0.92u ps=0.92u
    I_MXI0_I77_I30_XG_MP1 (XI0_I77_I30_XG_p1 I0_I77_G4_3 VDD VDD) gpdk090_pmos1v w=0.48u l=0.1u ad=0.1632p as=0.1056p pd=1.64u ps=0.92u
    I_MXI0_I77_I27_XG_MP2 (XI0_I77_I27_XG_p1 I0_I77_G3_2 I0_I77_G3_0n VDD) gpdk090_pmos1v w=0.48u l=0.1u ad=0.1056p as=0.1632p pd=0.92u ps=1.64u
    I_MXI0_I77_I27_XG_MP0 (VDD I0_I77_P3_2 XI0_I77_I27_XG_p1 VDD) gpdk090_pmos1v w=0.48u l=0.1u ad=0.1056p as=0.1056p pd=0.92u ps=0.92u
    I_MXI0_I77_I27_XG_MP1 (XI0_I77_I27_XG_p1 I0_I77_G1_0 VDD VDD) gpdk090_pmos1v w=0.48u l=0.1u ad=0.1632p as=0.1056p pd=1.64u ps=0.92u
    I_MXI0_I77_I29_XG_MP2 (XI0_I77_I29_XG_p1 I0_I77_G5_4 I0_I77_G5_2n VDD) gpdk090_pmos1v w=0.48u l=0.1u ad=0.1056p as=0.1632p pd=0.92u ps=1.64u
    I_MXI0_I77_I29_XG_MP0 (VDD I0_I77_P5_4 XI0_I77_I29_XG_p1 VDD) gpdk090_pmos1v w=0.48u l=0.1u ad=0.1056p as=0.1056p pd=0.92u ps=0.92u
    I_MXI0_I77_I29_XG_MP1 (XI0_I77_I29_XG_p1 I0_I77_G3_2 VDD VDD) gpdk090_pmos1v w=0.48u l=0.1u ad=0.1632p as=0.1056p pd=1.64u ps=0.92u
    I_MXI1_I152_I29_XG_MP2 (XI1_I152_I29_XG_p1 I1_I152_G5_4 I1_I152_G5_2n VDD) gpdk090_pmos1v w=0.48u l=0.1u ad=0.1056p as=0.1632p pd=0.92u ps=1.64u
    I_MXI1_I152_I29_XG_MP0 (VDD I1_I152_P5_4 XI1_I152_I29_XG_p1 VDD) gpdk090_pmos1v w=0.48u l=0.1u ad=0.1056p as=0.1056p pd=0.92u ps=0.92u
    I_MXI1_I152_I29_XG_MP1 (XI1_I152_I29_XG_p1 I1_I152_G3_2 VDD VDD) gpdk090_pmos1v w=0.48u l=0.1u ad=0.1632p as=0.1056p pd=1.64u ps=0.92u
    I_MXI1_I186_MP2 (XI1_I186_p1 I1_nrk4 I1_nrkn5 VDD) gpdk090_pmos1v w=0.48u l=0.1u ad=0.1056p as=0.1632p pd=0.92u ps=1.64u
    I_MXI1_I186_MP0 (VDD A_7 XI1_I186_p1 VDD) gpdk090_pmos1v w=0.48u l=0.1u ad=0.1056p as=0.1056p pd=0.92u ps=0.92u
    I_MXI1_I186_MP1 (XI1_I186_p1 I1_ru4 VDD VDD) gpdk090_pmos1v w=0.48u l=0.1u ad=0.1632p as=0.1056p pd=1.64u ps=0.92u
    I_MXI1_I183_MP2 (XI1_I183_p1 I1_nrk3 I1_nrkn4 VDD) gpdk090_pmos1v w=0.48u l=0.1u ad=0.1056p as=0.1632p pd=0.92u ps=1.64u
    I_MXI1_I183_MP0 (VDD A_7 XI1_I183_p1 VDD) gpdk090_pmos1v w=0.48u l=0.1u ad=0.1056p as=0.1056p pd=0.92u ps=0.92u
    I_MXI1_I183_MP1 (XI1_I183_p1 I1_ru3 VDD VDD) gpdk090_pmos1v w=0.48u l=0.1u ad=0.1632p as=0.1056p pd=1.64u ps=0.92u
    I_MXI0_I77_I28_XG_MP2 (XI0_I77_I28_XG_p1 I0_I77_G4_3 I0_I77_G4_1n VDD) gpdk090_pmos1v w=0.48u l=0.1u ad=0.1056p as=0.1632p pd=0.92u ps=1.64u
    I_MXI0_I77_I28_XG_MP0 (VDD I0_I77_P4_3 XI0_I77_I28_XG_p1 VDD) gpdk090_pmos1v w=0.48u l=0.1u ad=0.1056p as=0.1056p pd=0.92u ps=0.92u
    I_MXI0_I77_I28_XG_MP1 (XI0_I77_I28_XG_p1 I0_I77_G2_1 VDD VDD) gpdk090_pmos1v w=0.48u l=0.1u ad=0.1632p as=0.1056p pd=1.64u ps=0.92u
    I_MXI1_I152_I31_XG_MP2 (XI1_I152_I31_XG_p1 I1_I152_G7_6 I1_I152_G7_4n VDD) gpdk090_pmos1v w=0.48u l=0.1u ad=0.1056p as=0.1632p pd=0.92u ps=1.64u
    I_MXI1_I152_I31_XG_MP0 (VDD I1_I152_P7_6 XI1_I152_I31_XG_p1 VDD) gpdk090_pmos1v w=0.48u l=0.1u ad=0.1056p as=0.1056p pd=0.92u ps=0.92u
    I_MXI1_I152_I31_XG_MP1 (XI1_I152_I31_XG_p1 I1_I152_G5_4 VDD VDD) gpdk090_pmos1v w=0.48u l=0.1u ad=0.1632p as=0.1056p pd=1.64u ps=0.92u
    I_MXI1_I152_I27_XG_MP2 (XI1_I152_I27_XG_p1 I1_I152_G3_2 I1_I152_G3_0n VDD) gpdk090_pmos1v w=0.48u l=0.1u ad=0.1056p as=0.1632p pd=0.92u ps=1.64u
    I_MXI1_I152_I27_XG_MP0 (VDD I1_I152_P3_2 XI1_I152_I27_XG_p1 VDD) gpdk090_pmos1v w=0.48u l=0.1u ad=0.1056p as=0.1056p pd=0.92u ps=0.92u
    I_MXI1_I152_I27_XG_MP1 (XI1_I152_I27_XG_p1 I1_I152_G1_0 VDD VDD) gpdk090_pmos1v w=0.48u l=0.1u ad=0.1632p as=0.1056p pd=1.64u ps=0.92u
    I_MXI1_I180_MP2 (XI1_I180_p1 I1_nrk2 I1_nrkn3 VDD) gpdk090_pmos1v w=0.48u l=0.1u ad=0.1056p as=0.1632p pd=0.92u ps=1.64u
    I_MXI1_I180_MP0 (VDD A_7 XI1_I180_p1 VDD) gpdk090_pmos1v w=0.48u l=0.1u ad=0.1056p as=0.1056p pd=0.92u ps=0.92u
    I_MXI1_I180_MP1 (XI1_I180_p1 I1_ru2 VDD VDD) gpdk090_pmos1v w=0.48u l=0.1u ad=0.1632p as=0.1056p pd=1.64u ps=0.92u
    I_MXI0_I77_I26_XG_MP2 (XI0_I77_I26_XG_p1 I0_I77_G2_1 I0_I77_G2_0n VDD) gpdk090_pmos1v w=0.48u l=0.1u ad=0.1056p as=0.1632p pd=0.92u ps=1.64u
    I_MXI0_I77_I26_XG_MP0 (VDD I0_I77_P2_1 XI0_I77_I26_XG_p1 VDD) gpdk090_pmos1v w=0.48u l=0.1u ad=0.1056p as=0.1056p pd=0.92u ps=0.92u
    I_MXI0_I77_I26_XG_MP1 (XI0_I77_I26_XG_p1 I0_I77_G0_0 VDD VDD) gpdk090_pmos1v w=0.48u l=0.1u ad=0.1632p as=0.1056p pd=1.64u ps=0.92u
    I_MXI1_I152_I30_XG_MP2 (XI1_I152_I30_XG_p1 I1_I152_G6_5 I1_I152_G6_3n VDD) gpdk090_pmos1v w=0.48u l=0.1u ad=0.1056p as=0.1632p pd=0.92u ps=1.64u
    I_MXI1_I152_I30_XG_MP0 (VDD I1_I152_P6_5 XI1_I152_I30_XG_p1 VDD) gpdk090_pmos1v w=0.48u l=0.1u ad=0.1056p as=0.1056p pd=0.92u ps=0.92u
    I_MXI1_I152_I30_XG_MP1 (XI1_I152_I30_XG_p1 I1_I152_G4_3 VDD VDD) gpdk090_pmos1v w=0.48u l=0.1u ad=0.1632p as=0.1056p pd=1.64u ps=0.92u
    I_MXI1_I152_I28_XG_MP2 (XI1_I152_I28_XG_p1 I1_I152_G4_3 I1_I152_G4_1n VDD) gpdk090_pmos1v w=0.48u l=0.1u ad=0.1056p as=0.1632p pd=0.92u ps=1.64u
    I_MXI1_I152_I28_XG_MP0 (VDD I1_I152_P4_3 XI1_I152_I28_XG_p1 VDD) gpdk090_pmos1v w=0.48u l=0.1u ad=0.1056p as=0.1056p pd=0.92u ps=0.92u
    I_MXI1_I152_I28_XG_MP1 (XI1_I152_I28_XG_p1 I1_I152_G2_1 VDD VDD) gpdk090_pmos1v w=0.48u l=0.1u ad=0.1632p as=0.1056p pd=1.64u ps=0.92u
    I_MXI1_I152_I26_XG_MP2 (XI1_I152_I26_XG_p1 I1_I152_G2_1 I1_I152_G2_0n VDD) gpdk090_pmos1v w=0.48u l=0.1u ad=0.1056p as=0.1632p pd=0.92u ps=1.64u
    I_MXI1_I152_I26_XG_MP0 (VDD I1_I152_P2_1 XI1_I152_I26_XG_p1 VDD) gpdk090_pmos1v w=0.48u l=0.1u ad=0.1056p as=0.1056p pd=0.92u ps=0.92u
    I_MXI1_I152_I26_XG_MP1 (XI1_I152_I26_XG_p1 I1_I152_G0_0 VDD VDD) gpdk090_pmos1v w=0.48u l=0.1u ad=0.1632p as=0.1056p pd=1.64u ps=0.92u
    I_MXI1_I177_MP2 (XI1_I177_p1 I1_nrk1 I1_nrkn2 VDD) gpdk090_pmos1v w=0.48u l=0.1u ad=0.1056p as=0.1632p pd=0.92u ps=1.64u
    I_MXI1_I177_MP0 (VDD A_7 XI1_I177_p1 VDD) gpdk090_pmos1v w=0.48u l=0.1u ad=0.1056p as=0.1056p pd=0.92u ps=0.92u
    I_MXI1_I177_MP1 (XI1_I177_p1 I1_ru1 VDD VDD) gpdk090_pmos1v w=0.48u l=0.1u ad=0.1632p as=0.1056p pd=1.64u ps=0.92u
    I_MXI2_I3_I94_MP2 (XI2_I3_I94_p1 I2_I3_o7_2 I2_I3_q7_2 VDD) gpdk090_pmos1v w=0.48u l=0.1u ad=0.1056p as=0.1632p pd=0.92u ps=1.64u
    I_MXI2_I3_I94_MP0 (VDD I2_SEL_AS XI2_I3_I94_p1 VDD) gpdk090_pmos1v w=0.48u l=0.1u ad=0.1056p as=0.1056p pd=0.92u ps=0.92u
    I_MXI2_I3_I94_MP1 (XI2_I3_I94_p1 I2_S_7 VDD VDD) gpdk090_pmos1v w=0.48u l=0.1u ad=0.1632p as=0.1056p pd=1.64u ps=0.92u
    I_MXI1_I132_I29_XG_MP2 (XI1_I132_I29_XG_p1 I1_I132_G5_4 I1_I132_G5_2n VDD) gpdk090_pmos1v w=0.48u l=0.1u ad=0.1056p as=0.1632p pd=0.92u ps=1.64u
    I_MXI1_I132_I29_XG_MP0 (VDD I1_I132_P5_4 XI1_I132_I29_XG_p1 VDD) gpdk090_pmos1v w=0.48u l=0.1u ad=0.1056p as=0.1056p pd=0.92u ps=0.92u
    I_MXI1_I132_I29_XG_MP1 (XI1_I132_I29_XG_p1 I1_I132_G3_2 VDD VDD) gpdk090_pmos1v w=0.48u l=0.1u ad=0.1632p as=0.1056p pd=1.64u ps=0.92u
    I_MXI1_I132_I27_XG_MP2 (XI1_I132_I27_XG_p1 I1_I132_G3_2 I1_I132_G3_0n VDD) gpdk090_pmos1v w=0.48u l=0.1u ad=0.1056p as=0.1632p pd=0.92u ps=1.64u
    I_MXI1_I132_I27_XG_MP0 (VDD I1_I132_P3_2 XI1_I132_I27_XG_p1 VDD) gpdk090_pmos1v w=0.48u l=0.1u ad=0.1056p as=0.1056p pd=0.92u ps=0.92u
    I_MXI1_I132_I27_XG_MP1 (XI1_I132_I27_XG_p1 I1_I132_G1_0 VDD VDD) gpdk090_pmos1v w=0.48u l=0.1u ad=0.1632p as=0.1056p pd=1.64u ps=0.92u
    I_MXI2_I3_I82_MP2 (XI2_I3_I82_p1 I2_I3_o6_2 I2_I3_q6_2 VDD) gpdk090_pmos1v w=0.48u l=0.1u ad=0.1056p as=0.1632p pd=0.92u ps=1.64u
    I_MXI2_I3_I82_MP0 (VDD I2_SEL_AS XI2_I3_I82_p1 VDD) gpdk090_pmos1v w=0.48u l=0.1u ad=0.1056p as=0.1056p pd=0.92u ps=0.92u
    I_MXI2_I3_I82_MP1 (XI2_I3_I82_p1 I2_S_6 VDD VDD) gpdk090_pmos1v w=0.48u l=0.1u ad=0.1632p as=0.1056p pd=1.64u ps=0.92u
    I_MXI2_I1_I8_I31_XG_MP2 (XI2_I1_I8_I31_XG_p1 I2_I1_I8_G7_6 I2_I1_I8_G7_4n VDD) gpdk090_pmos1v w=0.48u l=0.1u ad=0.1056p as=0.1632p pd=0.92u ps=1.64u
    I_MXI2_I1_I8_I31_XG_MP0 (VDD I2_I1_I8_P7_6 XI2_I1_I8_I31_XG_p1 VDD) gpdk090_pmos1v w=0.48u l=0.1u ad=0.1056p as=0.1056p pd=0.92u ps=0.92u
    I_MXI2_I1_I8_I31_XG_MP1 (XI2_I1_I8_I31_XG_p1 I2_I1_I8_G5_4 VDD VDD) gpdk090_pmos1v w=0.48u l=0.1u ad=0.1632p as=0.1056p pd=1.64u ps=0.92u
    I_MXI2_I1_I8_I29_XG_MP2 (XI2_I1_I8_I29_XG_p1 I2_I1_I8_G5_4 I2_I1_I8_G5_2n VDD) gpdk090_pmos1v w=0.48u l=0.1u ad=0.1056p as=0.1632p pd=0.92u ps=1.64u
    I_MXI2_I1_I8_I29_XG_MP0 (VDD I2_I1_I8_P5_4 XI2_I1_I8_I29_XG_p1 VDD) gpdk090_pmos1v w=0.48u l=0.1u ad=0.1056p as=0.1056p pd=0.92u ps=0.92u
    I_MXI2_I1_I8_I29_XG_MP1 (XI2_I1_I8_I29_XG_p1 I2_I1_I8_G3_2 VDD VDD) gpdk090_pmos1v w=0.48u l=0.1u ad=0.1632p as=0.1056p pd=1.64u ps=0.92u
    I_MXI2_I1_I8_I30_XG_MP2 (XI2_I1_I8_I30_XG_p1 I2_I1_I8_G6_5 I2_I1_I8_G6_3n VDD) gpdk090_pmos1v w=0.48u l=0.1u ad=0.1056p as=0.1632p pd=0.92u ps=1.64u
    I_MXI2_I1_I8_I30_XG_MP0 (VDD I2_I1_I8_P6_5 XI2_I1_I8_I30_XG_p1 VDD) gpdk090_pmos1v w=0.48u l=0.1u ad=0.1056p as=0.1056p pd=0.92u ps=0.92u
    I_MXI2_I1_I8_I30_XG_MP1 (XI2_I1_I8_I30_XG_p1 I2_I1_I8_G4_3 VDD VDD) gpdk090_pmos1v w=0.48u l=0.1u ad=0.1632p as=0.1056p pd=1.64u ps=0.92u
    I_MXI1_I132_I31_XG_MP2 (XI1_I132_I31_XG_p1 I1_I132_G7_6 I1_I132_G7_4n VDD) gpdk090_pmos1v w=0.48u l=0.1u ad=0.1056p as=0.1632p pd=0.92u ps=1.64u
    I_MXI1_I132_I31_XG_MP0 (VDD I1_I132_P7_6 XI1_I132_I31_XG_p1 VDD) gpdk090_pmos1v w=0.48u l=0.1u ad=0.1056p as=0.1056p pd=0.92u ps=0.92u
    I_MXI1_I132_I31_XG_MP1 (XI1_I132_I31_XG_p1 I1_I132_G5_4 VDD VDD) gpdk090_pmos1v w=0.48u l=0.1u ad=0.1632p as=0.1056p pd=1.64u ps=0.92u
    I_MXI1_I132_I28_XG_MP2 (XI1_I132_I28_XG_p1 I1_I132_G4_3 I1_I132_G4_1n VDD) gpdk090_pmos1v w=0.48u l=0.1u ad=0.1056p as=0.1632p pd=0.92u ps=1.64u
    I_MXI1_I132_I28_XG_MP0 (VDD I1_I132_P4_3 XI1_I132_I28_XG_p1 VDD) gpdk090_pmos1v w=0.48u l=0.1u ad=0.1056p as=0.1056p pd=0.92u ps=0.92u
    I_MXI1_I132_I28_XG_MP1 (XI1_I132_I28_XG_p1 I1_I132_G2_1 VDD VDD) gpdk090_pmos1v w=0.48u l=0.1u ad=0.1632p as=0.1056p pd=1.64u ps=0.92u
    I_MXI1_I132_I26_XG_MP2 (XI1_I132_I26_XG_p1 I1_I132_G2_1 I1_I132_G2_0n VDD) gpdk090_pmos1v w=0.48u l=0.1u ad=0.1056p as=0.1632p pd=0.92u ps=1.64u
    I_MXI1_I132_I26_XG_MP0 (VDD I1_I132_P2_1 XI1_I132_I26_XG_p1 VDD) gpdk090_pmos1v w=0.48u l=0.1u ad=0.1056p as=0.1056p pd=0.92u ps=0.92u
    I_MXI1_I132_I26_XG_MP1 (XI1_I132_I26_XG_p1 I1_I132_G0_0 VDD VDD) gpdk090_pmos1v w=0.48u l=0.1u ad=0.1632p as=0.1056p pd=1.64u ps=0.92u
    I_MXI1_I38_MP2 (XI1_I38_p1 I1_nbk6 I1_nbkn7 VDD) gpdk090_pmos1v w=0.48u l=0.1u ad=0.1056p as=0.1632p pd=0.92u ps=1.64u
    I_MXI1_I38_MP0 (VDD B_7 XI1_I38_p1 VDD) gpdk090_pmos1v w=0.48u l=0.1u ad=0.1056p as=0.1056p pd=0.92u ps=0.92u
    I_MXI1_I38_MP1 (XI1_I38_p1 B_6 VDD VDD) gpdk090_pmos1v w=0.48u l=0.1u ad=0.1632p as=0.1056p pd=1.64u ps=0.92u
    I_MXI2_I1_I8_I27_XG_MP2 (XI2_I1_I8_I27_XG_p1 I2_I1_I8_G3_2 I2_I1_I8_G3_0n VDD) gpdk090_pmos1v w=0.48u l=0.1u ad=0.1056p as=0.1632p pd=0.92u ps=1.64u
    I_MXI2_I1_I8_I27_XG_MP0 (VDD I2_I1_I8_P3_2 XI2_I1_I8_I27_XG_p1 VDD) gpdk090_pmos1v w=0.48u l=0.1u ad=0.1056p as=0.1056p pd=0.92u ps=0.92u
    I_MXI2_I1_I8_I27_XG_MP1 (XI2_I1_I8_I27_XG_p1 I2_I1_I8_G1_0 VDD VDD) gpdk090_pmos1v w=0.48u l=0.1u ad=0.1632p as=0.1056p pd=1.64u ps=0.92u
    I_MXI1_I132_I30_XG_MP2 (XI1_I132_I30_XG_p1 I1_I132_G6_5 I1_I132_G6_3n VDD) gpdk090_pmos1v w=0.48u l=0.1u ad=0.1056p as=0.1632p pd=0.92u ps=1.64u
    I_MXI1_I132_I30_XG_MP0 (VDD I1_I132_P6_5 XI1_I132_I30_XG_p1 VDD) gpdk090_pmos1v w=0.48u l=0.1u ad=0.1056p as=0.1056p pd=0.92u ps=0.92u
    I_MXI1_I132_I30_XG_MP1 (XI1_I132_I30_XG_p1 I1_I132_G4_3 VDD VDD) gpdk090_pmos1v w=0.48u l=0.1u ad=0.1632p as=0.1056p pd=1.64u ps=0.92u
    I_MXI1_I35_MP2 (XI1_I35_p1 I1_nbk5 I1_nbkn6 VDD) gpdk090_pmos1v w=0.48u l=0.1u ad=0.1056p as=0.1632p pd=0.92u ps=1.64u
    I_MXI1_I35_MP0 (VDD B_7 XI1_I35_p1 VDD) gpdk090_pmos1v w=0.48u l=0.1u ad=0.1056p as=0.1056p pd=0.92u ps=0.92u
    I_MXI1_I35_MP1 (XI1_I35_p1 B_5 VDD VDD) gpdk090_pmos1v w=0.48u l=0.1u ad=0.1632p as=0.1056p pd=1.64u ps=0.92u
    I_MXI2_I3_I70_MP2 (XI2_I3_I70_p1 I2_I3_o5_2 I2_I3_q5_2 VDD) gpdk090_pmos1v w=0.48u l=0.1u ad=0.1056p as=0.1632p pd=0.92u ps=1.64u
    I_MXI2_I3_I70_MP0 (VDD I2_SEL_AS XI2_I3_I70_p1 VDD) gpdk090_pmos1v w=0.48u l=0.1u ad=0.1056p as=0.1056p pd=0.92u ps=0.92u
    I_MXI2_I3_I70_MP1 (XI2_I3_I70_p1 I2_S_5 VDD VDD) gpdk090_pmos1v w=0.48u l=0.1u ad=0.1632p as=0.1056p pd=1.64u ps=0.92u
    I_MXI2_I1_I8_I28_XG_MP2 (XI2_I1_I8_I28_XG_p1 I2_I1_I8_G4_3 I2_I1_I8_G4_1n VDD) gpdk090_pmos1v w=0.48u l=0.1u ad=0.1056p as=0.1632p pd=0.92u ps=1.64u
    I_MXI2_I1_I8_I28_XG_MP0 (VDD I2_I1_I8_P4_3 XI2_I1_I8_I28_XG_p1 VDD) gpdk090_pmos1v w=0.48u l=0.1u ad=0.1056p as=0.1056p pd=0.92u ps=0.92u
    I_MXI2_I1_I8_I28_XG_MP1 (XI2_I1_I8_I28_XG_p1 I2_I1_I8_G2_1 VDD VDD) gpdk090_pmos1v w=0.48u l=0.1u ad=0.1632p as=0.1056p pd=1.64u ps=0.92u
    I_MXI1_I157_MP2 (XI1_I157_p1 I1_nqk1 I1_nqkn2 VDD) gpdk090_pmos1v w=0.48u l=0.1u ad=0.1056p as=0.1632p pd=0.92u ps=1.64u
    I_MXI1_I157_MP0 (VDD I1_sq XI1_I157_p1 VDD) gpdk090_pmos1v w=0.48u l=0.1u ad=0.1056p as=0.1056p pd=0.92u ps=0.92u
    I_MXI1_I157_MP1 (XI1_I157_p1 I1_qu1 VDD VDD) gpdk090_pmos1v w=0.48u l=0.1u ad=0.1632p as=0.1056p pd=1.64u ps=0.92u
    I_MXI2_I3_I58_MP2 (XI2_I3_I58_p1 I2_I3_o4_2 I2_I3_q4_2 VDD) gpdk090_pmos1v w=0.48u l=0.1u ad=0.1056p as=0.1632p pd=0.92u ps=1.64u
    I_MXI2_I3_I58_MP0 (VDD I2_SEL_AS XI2_I3_I58_p1 VDD) gpdk090_pmos1v w=0.48u l=0.1u ad=0.1056p as=0.1056p pd=0.92u ps=0.92u
    I_MXI2_I3_I58_MP1 (XI2_I3_I58_p1 I2_S_4 VDD VDD) gpdk090_pmos1v w=0.48u l=0.1u ad=0.1632p as=0.1056p pd=1.64u ps=0.92u
    I_MXI2_I1_I8_I26_XG_MP2 (XI2_I1_I8_I26_XG_p1 I2_I1_I8_G2_1 I2_I1_I8_G2_0n VDD) gpdk090_pmos1v w=0.48u l=0.1u ad=0.1056p as=0.1632p pd=0.92u ps=1.64u
    I_MXI2_I1_I8_I26_XG_MP0 (VDD I2_I1_I8_P2_1 XI2_I1_I8_I26_XG_p1 VDD) gpdk090_pmos1v w=0.48u l=0.1u ad=0.1056p as=0.1056p pd=0.92u ps=0.92u
    I_MXI2_I1_I8_I26_XG_MP1 (XI2_I1_I8_I26_XG_p1 I2_I1_I8_G0_0 VDD VDD) gpdk090_pmos1v w=0.48u l=0.1u ad=0.1632p as=0.1056p pd=1.64u ps=0.92u
    I_MXI1_I120_I26_XG_MP2 (XI1_I120_I26_XG_p1 I1_I120_G2_1 I1_I120_G2_0n VDD) gpdk090_pmos1v w=0.48u l=0.1u ad=0.1056p as=0.1632p pd=0.92u ps=1.64u
    I_MXI1_I120_I26_XG_MP0 (VDD I1_I120_P2_1 XI1_I120_I26_XG_p1 VDD) gpdk090_pmos1v w=0.48u l=0.1u ad=0.1056p as=0.1056p pd=0.92u ps=0.92u
    I_MXI1_I120_I26_XG_MP1 (XI1_I120_I26_XG_p1 I1_I120_G0_0 VDD VDD) gpdk090_pmos1v w=0.48u l=0.1u ad=0.1632p as=0.1056p pd=1.64u ps=0.92u
    I_MXI1_I32_MP2 (XI1_I32_p1 I1_nbk4 I1_nbkn5 VDD) gpdk090_pmos1v w=0.48u l=0.1u ad=0.1056p as=0.1632p pd=0.92u ps=1.64u
    I_MXI1_I32_MP0 (VDD B_7 XI1_I32_p1 VDD) gpdk090_pmos1v w=0.48u l=0.1u ad=0.1056p as=0.1056p pd=0.92u ps=0.92u
    I_MXI1_I32_MP1 (XI1_I32_p1 B_4 VDD VDD) gpdk090_pmos1v w=0.48u l=0.1u ad=0.1632p as=0.1056p pd=1.64u ps=0.92u
    I_MXI2_I3_I22_MP2 (XI2_I3_I22_p1 I2_I3_o1_2 I2_I3_q1_2 VDD) gpdk090_pmos1v w=0.48u l=0.1u ad=0.1056p as=0.1632p pd=0.92u ps=1.64u
    I_MXI2_I3_I22_MP0 (VDD I2_SEL_AS XI2_I3_I22_p1 VDD) gpdk090_pmos1v w=0.48u l=0.1u ad=0.1056p as=0.1056p pd=0.92u ps=0.92u
    I_MXI2_I3_I22_MP1 (XI2_I3_I22_p1 I2_S_1 VDD VDD) gpdk090_pmos1v w=0.48u l=0.1u ad=0.1632p as=0.1056p pd=1.64u ps=0.92u
    I_MXI2_I3_I46_MP2 (XI2_I3_I46_p1 I2_I3_o3_2 I2_I3_q3_2 VDD) gpdk090_pmos1v w=0.48u l=0.1u ad=0.1056p as=0.1632p pd=0.92u ps=1.64u
    I_MXI2_I3_I46_MP0 (VDD I2_SEL_AS XI2_I3_I46_p1 VDD) gpdk090_pmos1v w=0.48u l=0.1u ad=0.1056p as=0.1056p pd=0.92u ps=0.92u
    I_MXI2_I3_I46_MP1 (XI2_I3_I46_p1 I2_S_3 VDD VDD) gpdk090_pmos1v w=0.48u l=0.1u ad=0.1632p as=0.1056p pd=1.64u ps=0.92u
    I_MXI2_I3_I34_MP2 (XI2_I3_I34_p1 I2_I3_o2_2 I2_I3_q2_2 VDD) gpdk090_pmos1v w=0.48u l=0.1u ad=0.1056p as=0.1632p pd=0.92u ps=1.64u
    I_MXI2_I3_I34_MP0 (VDD I2_SEL_AS XI2_I3_I34_p1 VDD) gpdk090_pmos1v w=0.48u l=0.1u ad=0.1056p as=0.1056p pd=0.92u ps=0.92u
    I_MXI2_I3_I34_MP1 (XI2_I3_I34_p1 I2_S_2 VDD VDD) gpdk090_pmos1v w=0.48u l=0.1u ad=0.1632p as=0.1056p pd=1.64u ps=0.92u
    I_MXI1_I120_I31_XG_MP2 (XI1_I120_I31_XG_p1 I1_I120_G7_6 I1_I120_G7_4n VDD) gpdk090_pmos1v w=0.48u l=0.1u ad=0.1056p as=0.1632p pd=0.92u ps=1.64u
    I_MXI1_I120_I31_XG_MP0 (VDD I1_I120_P7_6 XI1_I120_I31_XG_p1 VDD) gpdk090_pmos1v w=0.48u l=0.1u ad=0.1056p as=0.1056p pd=0.92u ps=0.92u
    I_MXI1_I120_I31_XG_MP1 (XI1_I120_I31_XG_p1 I1_I120_G5_4 VDD VDD) gpdk090_pmos1v w=0.48u l=0.1u ad=0.1632p as=0.1056p pd=1.64u ps=0.92u
    I_MXI1_I120_I29_XG_MP2 (XI1_I120_I29_XG_p1 I1_I120_G5_4 I1_I120_G5_2n VDD) gpdk090_pmos1v w=0.48u l=0.1u ad=0.1056p as=0.1632p pd=0.92u ps=1.64u
    I_MXI1_I120_I29_XG_MP0 (VDD I1_I120_P5_4 XI1_I120_I29_XG_p1 VDD) gpdk090_pmos1v w=0.48u l=0.1u ad=0.1056p as=0.1056p pd=0.92u ps=0.92u
    I_MXI1_I120_I29_XG_MP1 (XI1_I120_I29_XG_p1 I1_I120_G3_2 VDD VDD) gpdk090_pmos1v w=0.48u l=0.1u ad=0.1632p as=0.1056p pd=1.64u ps=0.92u
    I_MXI1_I120_I27_XG_MP2 (XI1_I120_I27_XG_p1 I1_I120_G3_2 I1_I120_G3_0n VDD) gpdk090_pmos1v w=0.48u l=0.1u ad=0.1056p as=0.1632p pd=0.92u ps=1.64u
    I_MXI1_I120_I27_XG_MP0 (VDD I1_I120_P3_2 XI1_I120_I27_XG_p1 VDD) gpdk090_pmos1v w=0.48u l=0.1u ad=0.1056p as=0.1056p pd=0.92u ps=0.92u
    I_MXI1_I120_I27_XG_MP1 (XI1_I120_I27_XG_p1 I1_I120_G1_0 VDD VDD) gpdk090_pmos1v w=0.48u l=0.1u ad=0.1632p as=0.1056p pd=1.64u ps=0.92u
    I_MXI1_I120_I30_XG_MP2 (XI1_I120_I30_XG_p1 I1_I120_G6_5 I1_I120_G6_3n VDD) gpdk090_pmos1v w=0.48u l=0.1u ad=0.1056p as=0.1632p pd=0.92u ps=1.64u
    I_MXI1_I120_I30_XG_MP0 (VDD I1_I120_P6_5 XI1_I120_I30_XG_p1 VDD) gpdk090_pmos1v w=0.48u l=0.1u ad=0.1056p as=0.1056p pd=0.92u ps=0.92u
    I_MXI1_I120_I30_XG_MP1 (XI1_I120_I30_XG_p1 I1_I120_G4_3 VDD VDD) gpdk090_pmos1v w=0.48u l=0.1u ad=0.1632p as=0.1056p pd=1.64u ps=0.92u
    I_MXI1_I120_I28_XG_MP2 (XI1_I120_I28_XG_p1 I1_I120_G4_3 I1_I120_G4_1n VDD) gpdk090_pmos1v w=0.48u l=0.1u ad=0.1056p as=0.1632p pd=0.92u ps=1.64u
    I_MXI1_I120_I28_XG_MP0 (VDD I1_I120_P4_3 XI1_I120_I28_XG_p1 VDD) gpdk090_pmos1v w=0.48u l=0.1u ad=0.1056p as=0.1056p pd=0.92u ps=0.92u
    I_MXI1_I120_I28_XG_MP1 (XI1_I120_I28_XG_p1 I1_I120_G2_1 VDD VDD) gpdk090_pmos1v w=0.48u l=0.1u ad=0.1632p as=0.1056p pd=1.64u ps=0.92u
    I_MXI1_I160_MP2 (XI1_I160_p1 I1_nqk2 I1_nqkn3 VDD) gpdk090_pmos1v w=0.48u l=0.1u ad=0.1056p as=0.1632p pd=0.92u ps=1.64u
    I_MXI1_I160_MP0 (VDD I1_sq XI1_I160_p1 VDD) gpdk090_pmos1v w=0.48u l=0.1u ad=0.1056p as=0.1056p pd=0.92u ps=0.92u
    I_MXI1_I160_MP1 (XI1_I160_p1 I1_qu2 VDD VDD) gpdk090_pmos1v w=0.48u l=0.1u ad=0.1632p as=0.1056p pd=1.64u ps=0.92u
    I_MXI1_I29_MP2 (XI1_I29_p1 I1_nbk3 I1_nbkn4 VDD) gpdk090_pmos1v w=0.48u l=0.1u ad=0.1056p as=0.1632p pd=0.92u ps=1.64u
    I_MXI1_I29_MP0 (VDD B_7 XI1_I29_p1 VDD) gpdk090_pmos1v w=0.48u l=0.1u ad=0.1056p as=0.1056p pd=0.92u ps=0.92u
    I_MXI1_I29_MP1 (XI1_I29_p1 B_3 VDD VDD) gpdk090_pmos1v w=0.48u l=0.1u ad=0.1632p as=0.1056p pd=1.64u ps=0.92u
    I_MXI2_I3_I10_MP2 (XI2_I3_I10_p1 I2_I3_o0_2 I2_I3_q0_2 VDD) gpdk090_pmos1v w=0.48u l=0.1u ad=0.1056p as=0.1632p pd=0.92u ps=1.64u
    I_MXI2_I3_I10_MP0 (VDD I2_SEL_AS XI2_I3_I10_p1 VDD) gpdk090_pmos1v w=0.48u l=0.1u ad=0.1056p as=0.1056p pd=0.92u ps=0.92u
    I_MXI2_I3_I10_MP1 (XI2_I3_I10_p1 I2_S_0 VDD VDD) gpdk090_pmos1v w=0.48u l=0.1u ad=0.1632p as=0.1056p pd=1.64u ps=0.92u
    I_MXI1_I163_MP2 (XI1_I163_p1 I1_nqk3 I1_nqkn4 VDD) gpdk090_pmos1v w=0.48u l=0.1u ad=0.1056p as=0.1632p pd=0.92u ps=1.64u
    I_MXI1_I163_MP0 (VDD I1_sq XI1_I163_p1 VDD) gpdk090_pmos1v w=0.48u l=0.1u ad=0.1056p as=0.1056p pd=0.92u ps=0.92u
    I_MXI1_I163_MP1 (XI1_I163_p1 I1_qu3 VDD VDD) gpdk090_pmos1v w=0.48u l=0.1u ad=0.1632p as=0.1056p pd=1.64u ps=0.92u
    I_MXI1_I3_MP2 (XI1_I3_p1 I1_nak1 I1_nakn2 VDD) gpdk090_pmos1v w=0.48u l=0.1u ad=0.1056p as=0.1632p pd=0.92u ps=1.64u
    I_MXI1_I3_MP0 (VDD A_7 XI1_I3_p1 VDD) gpdk090_pmos1v w=0.48u l=0.1u ad=0.1056p as=0.1056p pd=0.92u ps=0.92u
    I_MXI1_I3_MP1 (XI1_I3_p1 A_1 VDD VDD) gpdk090_pmos1v w=0.48u l=0.1u ad=0.1632p as=0.1056p pd=1.64u ps=0.92u
    I_MXI1_I6_MP2 (XI1_I6_p1 I1_nak2 I1_nakn3 VDD) gpdk090_pmos1v w=0.48u l=0.1u ad=0.1056p as=0.1632p pd=0.92u ps=1.64u
    I_MXI1_I6_MP0 (VDD A_7 XI1_I6_p1 VDD) gpdk090_pmos1v w=0.48u l=0.1u ad=0.1056p as=0.1056p pd=0.92u ps=0.92u
    I_MXI1_I6_MP1 (XI1_I6_p1 A_2 VDD VDD) gpdk090_pmos1v w=0.48u l=0.1u ad=0.1632p as=0.1056p pd=1.64u ps=0.92u
    I_MXI1_I9_MP2 (XI1_I9_p1 I1_nak3 I1_nakn4 VDD) gpdk090_pmos1v w=0.48u l=0.1u ad=0.1056p as=0.1632p pd=0.92u ps=1.64u
    I_MXI1_I9_MP0 (VDD A_7 XI1_I9_p1 VDD) gpdk090_pmos1v w=0.48u l=0.1u ad=0.1056p as=0.1056p pd=0.92u ps=0.92u
    I_MXI1_I9_MP1 (XI1_I9_p1 A_3 VDD VDD) gpdk090_pmos1v w=0.48u l=0.1u ad=0.1632p as=0.1056p pd=1.64u ps=0.92u
    I_MXI1_I12_MP2 (XI1_I12_p1 I1_nak4 I1_nakn5 VDD) gpdk090_pmos1v w=0.48u l=0.1u ad=0.1056p as=0.1632p pd=0.92u ps=1.64u
    I_MXI1_I12_MP0 (VDD A_7 XI1_I12_p1 VDD) gpdk090_pmos1v w=0.48u l=0.1u ad=0.1056p as=0.1056p pd=0.92u ps=0.92u
    I_MXI1_I12_MP1 (XI1_I12_p1 A_4 VDD VDD) gpdk090_pmos1v w=0.48u l=0.1u ad=0.1632p as=0.1056p pd=1.64u ps=0.92u
    I_MXI1_I15_MP2 (XI1_I15_p1 I1_nak5 I1_nakn6 VDD) gpdk090_pmos1v w=0.48u l=0.1u ad=0.1056p as=0.1632p pd=0.92u ps=1.64u
    I_MXI1_I15_MP0 (VDD A_7 XI1_I15_p1 VDD) gpdk090_pmos1v w=0.48u l=0.1u ad=0.1056p as=0.1056p pd=0.92u ps=0.92u
    I_MXI1_I15_MP1 (XI1_I15_p1 A_5 VDD VDD) gpdk090_pmos1v w=0.48u l=0.1u ad=0.1632p as=0.1056p pd=1.64u ps=0.92u
    I_MXI1_I23_MP2 (XI1_I23_p1 I1_nbk1 I1_nbkn2 VDD) gpdk090_pmos1v w=0.48u l=0.1u ad=0.1056p as=0.1632p pd=0.92u ps=1.64u
    I_MXI1_I23_MP0 (VDD B_7 XI1_I23_p1 VDD) gpdk090_pmos1v w=0.48u l=0.1u ad=0.1056p as=0.1056p pd=0.92u ps=0.92u
    I_MXI1_I23_MP1 (XI1_I23_p1 B_1 VDD VDD) gpdk090_pmos1v w=0.48u l=0.1u ad=0.1632p as=0.1056p pd=1.64u ps=0.92u
    I_MXI1_I26_MP2 (XI1_I26_p1 I1_nbk2 I1_nbkn3 VDD) gpdk090_pmos1v w=0.48u l=0.1u ad=0.1056p as=0.1632p pd=0.92u ps=1.64u
    I_MXI1_I26_MP0 (VDD B_7 XI1_I26_p1 VDD) gpdk090_pmos1v w=0.48u l=0.1u ad=0.1056p as=0.1056p pd=0.92u ps=0.92u
    I_MXI1_I26_MP1 (XI1_I26_p1 B_2 VDD VDD) gpdk090_pmos1v w=0.48u l=0.1u ad=0.1632p as=0.1056p pd=1.64u ps=0.92u
    I_MXI1_I166_MP2 (XI1_I166_p1 I1_nqk4 I1_nqkn5 VDD) gpdk090_pmos1v w=0.48u l=0.1u ad=0.1056p as=0.1632p pd=0.92u ps=1.64u
    I_MXI1_I166_MP0 (VDD I1_sq XI1_I166_p1 VDD) gpdk090_pmos1v w=0.48u l=0.1u ad=0.1056p as=0.1056p pd=0.92u ps=0.92u
    I_MXI1_I166_MP1 (XI1_I166_p1 I1_qu4 VDD VDD) gpdk090_pmos1v w=0.48u l=0.1u ad=0.1632p as=0.1056p pd=1.64u ps=0.92u
    I_MXI1_I169_MP2 (XI1_I169_p1 I1_nqk5 I1_nqkn6 VDD) gpdk090_pmos1v w=0.48u l=0.1u ad=0.1056p as=0.1632p pd=0.92u ps=1.64u
    I_MXI1_I169_MP0 (VDD I1_sq XI1_I169_p1 VDD) gpdk090_pmos1v w=0.48u l=0.1u ad=0.1056p as=0.1056p pd=0.92u ps=0.92u
    I_MXI1_I169_MP1 (XI1_I169_p1 I1_qu5 VDD VDD) gpdk090_pmos1v w=0.48u l=0.1u ad=0.1632p as=0.1056p pd=1.64u ps=0.92u
    I_MXI1_I172_MP2 (XI1_I172_p1 I1_nqk6 I1_nqkn7 VDD) gpdk090_pmos1v w=0.48u l=0.1u ad=0.1056p as=0.1632p pd=0.92u ps=1.64u
    I_MXI1_I172_MP0 (VDD I1_sq XI1_I172_p1 VDD) gpdk090_pmos1v w=0.48u l=0.1u ad=0.1056p as=0.1056p pd=0.92u ps=0.92u
    I_MXI1_I172_MP1 (XI1_I172_p1 I1_qu6 VDD VDD) gpdk090_pmos1v w=0.48u l=0.1u ad=0.1632p as=0.1056p pd=1.64u ps=0.92u
    I_MXI1_I18_MP2 (XI1_I18_p1 I1_nak6 I1_nakn7 VDD) gpdk090_pmos1v w=0.48u l=0.1u ad=0.1056p as=0.1632p pd=0.92u ps=1.64u
    I_MXI1_I18_MP0 (VDD A_7 XI1_I18_p1 VDD) gpdk090_pmos1v w=0.48u l=0.1u ad=0.1056p as=0.1056p pd=0.92u ps=0.92u
    I_MXI1_I18_MP1 (XI1_I18_p1 A_6 VDD VDD) gpdk090_pmos1v w=0.48u l=0.1u ad=0.1632p as=0.1056p pd=1.64u ps=0.92u
    I_MXI1_I108_I28_XG_MP2 (XI1_I108_I28_XG_p1 I1_I108_G4_3 I1_I108_G4_1n VDD) gpdk090_pmos1v w=0.48u l=0.1u ad=0.1056p as=0.1632p pd=0.92u ps=1.64u
    I_MXI1_I108_I28_XG_MP0 (VDD I1_I108_P4_3 XI1_I108_I28_XG_p1 VDD) gpdk090_pmos1v w=0.48u l=0.1u ad=0.1056p as=0.1056p pd=0.92u ps=0.92u
    I_MXI1_I108_I28_XG_MP1 (XI1_I108_I28_XG_p1 I1_I108_G2_1 VDD VDD) gpdk090_pmos1v w=0.48u l=0.1u ad=0.1632p as=0.1056p pd=1.64u ps=0.92u
    I_MXI1_I108_I26_XG_MP2 (XI1_I108_I26_XG_p1 I1_I108_G2_1 I1_I108_G2_0n VDD) gpdk090_pmos1v w=0.48u l=0.1u ad=0.1056p as=0.1632p pd=0.92u ps=1.64u
    I_MXI1_I108_I26_XG_MP0 (VDD I1_I108_P2_1 XI1_I108_I26_XG_p1 VDD) gpdk090_pmos1v w=0.48u l=0.1u ad=0.1056p as=0.1056p pd=0.92u ps=0.92u
    I_MXI1_I108_I26_XG_MP1 (XI1_I108_I26_XG_p1 I1_I108_G0_0 VDD VDD) gpdk090_pmos1v w=0.48u l=0.1u ad=0.1632p as=0.1056p pd=1.64u ps=0.92u
    I_MXI1_I108_I27_XG_MP2 (XI1_I108_I27_XG_p1 I1_I108_G3_2 I1_I108_G3_0n VDD) gpdk090_pmos1v w=0.48u l=0.1u ad=0.1056p as=0.1632p pd=0.92u ps=1.64u
    I_MXI1_I108_I27_XG_MP0 (VDD I1_I108_P3_2 XI1_I108_I27_XG_p1 VDD) gpdk090_pmos1v w=0.48u l=0.1u ad=0.1056p as=0.1056p pd=0.92u ps=0.92u
    I_MXI1_I108_I27_XG_MP1 (XI1_I108_I27_XG_p1 I1_I108_G1_0 VDD VDD) gpdk090_pmos1v w=0.48u l=0.1u ad=0.1632p as=0.1056p pd=1.64u ps=0.92u
    I_MXI1_I108_I30_XG_MP2 (XI1_I108_I30_XG_p1 I1_I108_G6_5 I1_I108_G6_3n VDD) gpdk090_pmos1v w=0.48u l=0.1u ad=0.1056p as=0.1632p pd=0.92u ps=1.64u
    I_MXI1_I108_I30_XG_MP0 (VDD I1_I108_P6_5 XI1_I108_I30_XG_p1 VDD) gpdk090_pmos1v w=0.48u l=0.1u ad=0.1056p as=0.1056p pd=0.92u ps=0.92u
    I_MXI1_I108_I30_XG_MP1 (XI1_I108_I30_XG_p1 I1_I108_G4_3 VDD VDD) gpdk090_pmos1v w=0.48u l=0.1u ad=0.1632p as=0.1056p pd=1.64u ps=0.92u
    I_MXI1_I48_I26_XG_MP2 (XI1_I48_I26_XG_p1 I1_I48_G2_1 I1_I48_G2_0n VDD) gpdk090_pmos1v w=0.48u l=0.1u ad=0.1056p as=0.1632p pd=0.92u ps=1.64u
    I_MXI1_I48_I26_XG_MP0 (VDD I1_I48_P2_1 XI1_I48_I26_XG_p1 VDD) gpdk090_pmos1v w=0.48u l=0.1u ad=0.1056p as=0.1056p pd=0.92u ps=0.92u
    I_MXI1_I48_I26_XG_MP1 (XI1_I48_I26_XG_p1 I1_I48_G0_0 VDD VDD) gpdk090_pmos1v w=0.48u l=0.1u ad=0.1632p as=0.1056p pd=1.64u ps=0.92u
    I_MXI1_I108_I29_XG_MP2 (XI1_I108_I29_XG_p1 I1_I108_G5_4 I1_I108_G5_2n VDD) gpdk090_pmos1v w=0.48u l=0.1u ad=0.1056p as=0.1632p pd=0.92u ps=1.64u
    I_MXI1_I108_I29_XG_MP0 (VDD I1_I108_P5_4 XI1_I108_I29_XG_p1 VDD) gpdk090_pmos1v w=0.48u l=0.1u ad=0.1056p as=0.1056p pd=0.92u ps=0.92u
    I_MXI1_I108_I29_XG_MP1 (XI1_I108_I29_XG_p1 I1_I108_G3_2 VDD VDD) gpdk090_pmos1v w=0.48u l=0.1u ad=0.1632p as=0.1056p pd=1.64u ps=0.92u
    I_MXI1_I96_I26_XG_MP2 (XI1_I96_I26_XG_p1 I1_I96_G2_1 I1_I96_G2_0n VDD) gpdk090_pmos1v w=0.48u l=0.1u ad=0.1056p as=0.1632p pd=0.92u ps=1.64u
    I_MXI1_I96_I26_XG_MP0 (VDD I1_I96_P2_1 XI1_I96_I26_XG_p1 VDD) gpdk090_pmos1v w=0.48u l=0.1u ad=0.1056p as=0.1056p pd=0.92u ps=0.92u
    I_MXI1_I96_I26_XG_MP1 (XI1_I96_I26_XG_p1 I1_I96_G0_0 VDD VDD) gpdk090_pmos1v w=0.48u l=0.1u ad=0.1632p as=0.1056p pd=1.64u ps=0.92u
    I_MXI1_I84_I26_XG_MP2 (XI1_I84_I26_XG_p1 I1_I84_G2_1 I1_I84_G2_0n VDD) gpdk090_pmos1v w=0.48u l=0.1u ad=0.1056p as=0.1632p pd=0.92u ps=1.64u
    I_MXI1_I84_I26_XG_MP0 (VDD I1_I84_P2_1 XI1_I84_I26_XG_p1 VDD) gpdk090_pmos1v w=0.48u l=0.1u ad=0.1056p as=0.1056p pd=0.92u ps=0.92u
    I_MXI1_I84_I26_XG_MP1 (XI1_I84_I26_XG_p1 I1_I84_G0_0 VDD VDD) gpdk090_pmos1v w=0.48u l=0.1u ad=0.1632p as=0.1056p pd=1.64u ps=0.92u
    I_MXI1_I84_I28_XG_MP2 (XI1_I84_I28_XG_p1 I1_I84_G4_3 I1_I84_G4_1n VDD) gpdk090_pmos1v w=0.48u l=0.1u ad=0.1056p as=0.1632p pd=0.92u ps=1.64u
    I_MXI1_I84_I28_XG_MP0 (VDD I1_I84_P4_3 XI1_I84_I28_XG_p1 VDD) gpdk090_pmos1v w=0.48u l=0.1u ad=0.1056p as=0.1056p pd=0.92u ps=0.92u
    I_MXI1_I84_I28_XG_MP1 (XI1_I84_I28_XG_p1 I1_I84_G2_1 VDD VDD) gpdk090_pmos1v w=0.48u l=0.1u ad=0.1632p as=0.1056p pd=1.64u ps=0.92u
    I_MXI1_I72_I26_XG_MP2 (XI1_I72_I26_XG_p1 I1_I72_G2_1 I1_I72_G2_0n VDD) gpdk090_pmos1v w=0.48u l=0.1u ad=0.1056p as=0.1632p pd=0.92u ps=1.64u
    I_MXI1_I72_I26_XG_MP0 (VDD I1_I72_P2_1 XI1_I72_I26_XG_p1 VDD) gpdk090_pmos1v w=0.48u l=0.1u ad=0.1056p as=0.1056p pd=0.92u ps=0.92u
    I_MXI1_I72_I26_XG_MP1 (XI1_I72_I26_XG_p1 I1_I72_G0_0 VDD VDD) gpdk090_pmos1v w=0.48u l=0.1u ad=0.1632p as=0.1056p pd=1.64u ps=0.92u
    I_MXI1_I72_I28_XG_MP2 (XI1_I72_I28_XG_p1 I1_I72_G4_3 I1_I72_G4_1n VDD) gpdk090_pmos1v w=0.48u l=0.1u ad=0.1056p as=0.1632p pd=0.92u ps=1.64u
    I_MXI1_I72_I28_XG_MP0 (VDD I1_I72_P4_3 XI1_I72_I28_XG_p1 VDD) gpdk090_pmos1v w=0.48u l=0.1u ad=0.1056p as=0.1056p pd=0.92u ps=0.92u
    I_MXI1_I72_I28_XG_MP1 (XI1_I72_I28_XG_p1 I1_I72_G2_1 VDD VDD) gpdk090_pmos1v w=0.48u l=0.1u ad=0.1632p as=0.1056p pd=1.64u ps=0.92u
    I_MXI1_I60_I26_XG_MP2 (XI1_I60_I26_XG_p1 I1_I60_G2_1 I1_I60_G2_0n VDD) gpdk090_pmos1v w=0.48u l=0.1u ad=0.1056p as=0.1632p pd=0.92u ps=1.64u
    I_MXI1_I60_I26_XG_MP0 (VDD I1_I60_P2_1 XI1_I60_I26_XG_p1 VDD) gpdk090_pmos1v w=0.48u l=0.1u ad=0.1056p as=0.1056p pd=0.92u ps=0.92u
    I_MXI1_I60_I26_XG_MP1 (XI1_I60_I26_XG_p1 I1_I60_G0_0 VDD VDD) gpdk090_pmos1v w=0.48u l=0.1u ad=0.1632p as=0.1056p pd=1.64u ps=0.92u
    I_MXI1_I48_I28_XG_MP2 (XI1_I48_I28_XG_p1 I1_I48_G4_3 I1_I48_G4_1n VDD) gpdk090_pmos1v w=0.48u l=0.1u ad=0.1056p as=0.1632p pd=0.92u ps=1.64u
    I_MXI1_I48_I28_XG_MP0 (VDD I1_I48_P4_3 XI1_I48_I28_XG_p1 VDD) gpdk090_pmos1v w=0.48u l=0.1u ad=0.1056p as=0.1056p pd=0.92u ps=0.92u
    I_MXI1_I48_I28_XG_MP1 (XI1_I48_I28_XG_p1 I1_I48_G2_1 VDD VDD) gpdk090_pmos1v w=0.48u l=0.1u ad=0.1632p as=0.1056p pd=1.64u ps=0.92u
    I_MXI1_I48_I27_XG_MP2 (XI1_I48_I27_XG_p1 I1_I48_G3_2 I1_I48_G3_0n VDD) gpdk090_pmos1v w=0.48u l=0.1u ad=0.1056p as=0.1632p pd=0.92u ps=1.64u
    I_MXI1_I48_I27_XG_MP0 (VDD I1_I48_P3_2 XI1_I48_I27_XG_p1 VDD) gpdk090_pmos1v w=0.48u l=0.1u ad=0.1056p as=0.1056p pd=0.92u ps=0.92u
    I_MXI1_I48_I27_XG_MP1 (XI1_I48_I27_XG_p1 I1_I48_G1_0 VDD VDD) gpdk090_pmos1v w=0.48u l=0.1u ad=0.1632p as=0.1056p pd=1.64u ps=0.92u
    I_MXI1_I108_I31_XG_MP2 (XI1_I108_I31_XG_p1 I1_I108_G7_6 I1_I108_G7_4n VDD) gpdk090_pmos1v w=0.48u l=0.1u ad=0.1056p as=0.1632p pd=0.92u ps=1.64u
    I_MXI1_I108_I31_XG_MP0 (VDD I1_I108_P7_6 XI1_I108_I31_XG_p1 VDD) gpdk090_pmos1v w=0.48u l=0.1u ad=0.1056p as=0.1056p pd=0.92u ps=0.92u
    I_MXI1_I108_I31_XG_MP1 (XI1_I108_I31_XG_p1 I1_I108_G5_4 VDD VDD) gpdk090_pmos1v w=0.48u l=0.1u ad=0.1632p as=0.1056p pd=1.64u ps=0.92u
    I_MXI1_I96_I28_XG_MP2 (XI1_I96_I28_XG_p1 I1_I96_G4_3 I1_I96_G4_1n VDD) gpdk090_pmos1v w=0.48u l=0.1u ad=0.1056p as=0.1632p pd=0.92u ps=1.64u
    I_MXI1_I96_I28_XG_MP0 (VDD I1_I96_P4_3 XI1_I96_I28_XG_p1 VDD) gpdk090_pmos1v w=0.48u l=0.1u ad=0.1056p as=0.1056p pd=0.92u ps=0.92u
    I_MXI1_I96_I28_XG_MP1 (XI1_I96_I28_XG_p1 I1_I96_G2_1 VDD VDD) gpdk090_pmos1v w=0.48u l=0.1u ad=0.1632p as=0.1056p pd=1.64u ps=0.92u
    I_MXI1_I84_I27_XG_MP2 (XI1_I84_I27_XG_p1 I1_I84_G3_2 I1_I84_G3_0n VDD) gpdk090_pmos1v w=0.48u l=0.1u ad=0.1056p as=0.1632p pd=0.92u ps=1.64u
    I_MXI1_I84_I27_XG_MP0 (VDD I1_I84_P3_2 XI1_I84_I27_XG_p1 VDD) gpdk090_pmos1v w=0.48u l=0.1u ad=0.1056p as=0.1056p pd=0.92u ps=0.92u
    I_MXI1_I84_I27_XG_MP1 (XI1_I84_I27_XG_p1 I1_I84_G1_0 VDD VDD) gpdk090_pmos1v w=0.48u l=0.1u ad=0.1632p as=0.1056p pd=1.64u ps=0.92u
    I_MXI1_I72_I30_XG_MP2 (XI1_I72_I30_XG_p1 I1_I72_G6_5 I1_I72_G6_3n VDD) gpdk090_pmos1v w=0.48u l=0.1u ad=0.1056p as=0.1632p pd=0.92u ps=1.64u
    I_MXI1_I72_I30_XG_MP0 (VDD I1_I72_P6_5 XI1_I72_I30_XG_p1 VDD) gpdk090_pmos1v w=0.48u l=0.1u ad=0.1056p as=0.1056p pd=0.92u ps=0.92u
    I_MXI1_I72_I30_XG_MP1 (XI1_I72_I30_XG_p1 I1_I72_G4_3 VDD VDD) gpdk090_pmos1v w=0.48u l=0.1u ad=0.1632p as=0.1056p pd=1.64u ps=0.92u
    I_MXI1_I60_I28_XG_MP2 (XI1_I60_I28_XG_p1 I1_I60_G4_3 I1_I60_G4_1n VDD) gpdk090_pmos1v w=0.48u l=0.1u ad=0.1056p as=0.1632p pd=0.92u ps=1.64u
    I_MXI1_I60_I28_XG_MP0 (VDD I1_I60_P4_3 XI1_I60_I28_XG_p1 VDD) gpdk090_pmos1v w=0.48u l=0.1u ad=0.1056p as=0.1056p pd=0.92u ps=0.92u
    I_MXI1_I60_I28_XG_MP1 (XI1_I60_I28_XG_p1 I1_I60_G2_1 VDD VDD) gpdk090_pmos1v w=0.48u l=0.1u ad=0.1632p as=0.1056p pd=1.64u ps=0.92u
    I_MXI1_I60_I30_XG_MP2 (XI1_I60_I30_XG_p1 I1_I60_G6_5 I1_I60_G6_3n VDD) gpdk090_pmos1v w=0.48u l=0.1u ad=0.1056p as=0.1632p pd=0.92u ps=1.64u
    I_MXI1_I60_I30_XG_MP0 (VDD I1_I60_P6_5 XI1_I60_I30_XG_p1 VDD) gpdk090_pmos1v w=0.48u l=0.1u ad=0.1056p as=0.1056p pd=0.92u ps=0.92u
    I_MXI1_I60_I30_XG_MP1 (XI1_I60_I30_XG_p1 I1_I60_G4_3 VDD VDD) gpdk090_pmos1v w=0.48u l=0.1u ad=0.1632p as=0.1056p pd=1.64u ps=0.92u
    I_MXI1_I48_I30_XG_MP2 (XI1_I48_I30_XG_p1 I1_I48_G6_5 I1_I48_G6_3n VDD) gpdk090_pmos1v w=0.48u l=0.1u ad=0.1056p as=0.1632p pd=0.92u ps=1.64u
    I_MXI1_I48_I30_XG_MP0 (VDD I1_I48_P6_5 XI1_I48_I30_XG_p1 VDD) gpdk090_pmos1v w=0.48u l=0.1u ad=0.1056p as=0.1056p pd=0.92u ps=0.92u
    I_MXI1_I48_I30_XG_MP1 (XI1_I48_I30_XG_p1 I1_I48_G4_3 VDD VDD) gpdk090_pmos1v w=0.48u l=0.1u ad=0.1632p as=0.1056p pd=1.64u ps=0.92u
    I_MXI1_I48_I29_XG_MP2 (XI1_I48_I29_XG_p1 I1_I48_G5_4 I1_I48_G5_2n VDD) gpdk090_pmos1v w=0.48u l=0.1u ad=0.1056p as=0.1632p pd=0.92u ps=1.64u
    I_MXI1_I48_I29_XG_MP0 (VDD I1_I48_P5_4 XI1_I48_I29_XG_p1 VDD) gpdk090_pmos1v w=0.48u l=0.1u ad=0.1056p as=0.1056p pd=0.92u ps=0.92u
    I_MXI1_I48_I29_XG_MP1 (XI1_I48_I29_XG_p1 I1_I48_G3_2 VDD VDD) gpdk090_pmos1v w=0.48u l=0.1u ad=0.1632p as=0.1056p pd=1.64u ps=0.92u
    I_MXI1_I96_I27_XG_MP2 (XI1_I96_I27_XG_p1 I1_I96_G3_2 I1_I96_G3_0n VDD) gpdk090_pmos1v w=0.48u l=0.1u ad=0.1056p as=0.1632p pd=0.92u ps=1.64u
    I_MXI1_I96_I27_XG_MP0 (VDD I1_I96_P3_2 XI1_I96_I27_XG_p1 VDD) gpdk090_pmos1v w=0.48u l=0.1u ad=0.1056p as=0.1056p pd=0.92u ps=0.92u
    I_MXI1_I96_I27_XG_MP1 (XI1_I96_I27_XG_p1 I1_I96_G1_0 VDD VDD) gpdk090_pmos1v w=0.48u l=0.1u ad=0.1632p as=0.1056p pd=1.64u ps=0.92u
    I_MXI1_I96_I30_XG_MP2 (XI1_I96_I30_XG_p1 I1_I96_G6_5 I1_I96_G6_3n VDD) gpdk090_pmos1v w=0.48u l=0.1u ad=0.1056p as=0.1632p pd=0.92u ps=1.64u
    I_MXI1_I96_I30_XG_MP0 (VDD I1_I96_P6_5 XI1_I96_I30_XG_p1 VDD) gpdk090_pmos1v w=0.48u l=0.1u ad=0.1056p as=0.1056p pd=0.92u ps=0.92u
    I_MXI1_I96_I30_XG_MP1 (XI1_I96_I30_XG_p1 I1_I96_G4_3 VDD VDD) gpdk090_pmos1v w=0.48u l=0.1u ad=0.1632p as=0.1056p pd=1.64u ps=0.92u
    I_MXI1_I84_I29_XG_MP2 (XI1_I84_I29_XG_p1 I1_I84_G5_4 I1_I84_G5_2n VDD) gpdk090_pmos1v w=0.48u l=0.1u ad=0.1056p as=0.1632p pd=0.92u ps=1.64u
    I_MXI1_I84_I29_XG_MP0 (VDD I1_I84_P5_4 XI1_I84_I29_XG_p1 VDD) gpdk090_pmos1v w=0.48u l=0.1u ad=0.1056p as=0.1056p pd=0.92u ps=0.92u
    I_MXI1_I84_I29_XG_MP1 (XI1_I84_I29_XG_p1 I1_I84_G3_2 VDD VDD) gpdk090_pmos1v w=0.48u l=0.1u ad=0.1632p as=0.1056p pd=1.64u ps=0.92u
    I_MXI1_I84_I30_XG_MP2 (XI1_I84_I30_XG_p1 I1_I84_G6_5 I1_I84_G6_3n VDD) gpdk090_pmos1v w=0.48u l=0.1u ad=0.1056p as=0.1632p pd=0.92u ps=1.64u
    I_MXI1_I84_I30_XG_MP0 (VDD I1_I84_P6_5 XI1_I84_I30_XG_p1 VDD) gpdk090_pmos1v w=0.48u l=0.1u ad=0.1056p as=0.1056p pd=0.92u ps=0.92u
    I_MXI1_I84_I30_XG_MP1 (XI1_I84_I30_XG_p1 I1_I84_G4_3 VDD VDD) gpdk090_pmos1v w=0.48u l=0.1u ad=0.1632p as=0.1056p pd=1.64u ps=0.92u
    I_MXI1_I72_I27_XG_MP2 (XI1_I72_I27_XG_p1 I1_I72_G3_2 I1_I72_G3_0n VDD) gpdk090_pmos1v w=0.48u l=0.1u ad=0.1056p as=0.1632p pd=0.92u ps=1.64u
    I_MXI1_I72_I27_XG_MP0 (VDD I1_I72_P3_2 XI1_I72_I27_XG_p1 VDD) gpdk090_pmos1v w=0.48u l=0.1u ad=0.1056p as=0.1056p pd=0.92u ps=0.92u
    I_MXI1_I72_I27_XG_MP1 (XI1_I72_I27_XG_p1 I1_I72_G1_0 VDD VDD) gpdk090_pmos1v w=0.48u l=0.1u ad=0.1632p as=0.1056p pd=1.64u ps=0.92u
    I_MXI1_I60_I27_XG_MP2 (XI1_I60_I27_XG_p1 I1_I60_G3_2 I1_I60_G3_0n VDD) gpdk090_pmos1v w=0.48u l=0.1u ad=0.1056p as=0.1632p pd=0.92u ps=1.64u
    I_MXI1_I60_I27_XG_MP0 (VDD I1_I60_P3_2 XI1_I60_I27_XG_p1 VDD) gpdk090_pmos1v w=0.48u l=0.1u ad=0.1056p as=0.1056p pd=0.92u ps=0.92u
    I_MXI1_I60_I27_XG_MP1 (XI1_I60_I27_XG_p1 I1_I60_G1_0 VDD VDD) gpdk090_pmos1v w=0.48u l=0.1u ad=0.1632p as=0.1056p pd=1.64u ps=0.92u
    I_MXI1_I96_I29_XG_MP2 (XI1_I96_I29_XG_p1 I1_I96_G5_4 I1_I96_G5_2n VDD) gpdk090_pmos1v w=0.48u l=0.1u ad=0.1056p as=0.1632p pd=0.92u ps=1.64u
    I_MXI1_I96_I29_XG_MP0 (VDD I1_I96_P5_4 XI1_I96_I29_XG_p1 VDD) gpdk090_pmos1v w=0.48u l=0.1u ad=0.1056p as=0.1056p pd=0.92u ps=0.92u
    I_MXI1_I96_I29_XG_MP1 (XI1_I96_I29_XG_p1 I1_I96_G3_2 VDD VDD) gpdk090_pmos1v w=0.48u l=0.1u ad=0.1632p as=0.1056p pd=1.64u ps=0.92u
    I_MXI1_I84_I31_XG_MP2 (XI1_I84_I31_XG_p1 I1_I84_G7_6 I1_I84_G7_4n VDD) gpdk090_pmos1v w=0.48u l=0.1u ad=0.1056p as=0.1632p pd=0.92u ps=1.64u
    I_MXI1_I84_I31_XG_MP0 (VDD I1_I84_P7_6 XI1_I84_I31_XG_p1 VDD) gpdk090_pmos1v w=0.48u l=0.1u ad=0.1056p as=0.1056p pd=0.92u ps=0.92u
    I_MXI1_I84_I31_XG_MP1 (XI1_I84_I31_XG_p1 I1_I84_G5_4 VDD VDD) gpdk090_pmos1v w=0.48u l=0.1u ad=0.1632p as=0.1056p pd=1.64u ps=0.92u
    I_MXI1_I72_I29_XG_MP2 (XI1_I72_I29_XG_p1 I1_I72_G5_4 I1_I72_G5_2n VDD) gpdk090_pmos1v w=0.48u l=0.1u ad=0.1056p as=0.1632p pd=0.92u ps=1.64u
    I_MXI1_I72_I29_XG_MP0 (VDD I1_I72_P5_4 XI1_I72_I29_XG_p1 VDD) gpdk090_pmos1v w=0.48u l=0.1u ad=0.1056p as=0.1056p pd=0.92u ps=0.92u
    I_MXI1_I72_I29_XG_MP1 (XI1_I72_I29_XG_p1 I1_I72_G3_2 VDD VDD) gpdk090_pmos1v w=0.48u l=0.1u ad=0.1632p as=0.1056p pd=1.64u ps=0.92u
    I_MXI1_I60_I29_XG_MP2 (XI1_I60_I29_XG_p1 I1_I60_G5_4 I1_I60_G5_2n VDD) gpdk090_pmos1v w=0.48u l=0.1u ad=0.1056p as=0.1632p pd=0.92u ps=1.64u
    I_MXI1_I60_I29_XG_MP0 (VDD I1_I60_P5_4 XI1_I60_I29_XG_p1 VDD) gpdk090_pmos1v w=0.48u l=0.1u ad=0.1056p as=0.1056p pd=0.92u ps=0.92u
    I_MXI1_I60_I29_XG_MP1 (XI1_I60_I29_XG_p1 I1_I60_G3_2 VDD VDD) gpdk090_pmos1v w=0.48u l=0.1u ad=0.1632p as=0.1056p pd=1.64u ps=0.92u
    I_MXI1_I48_I31_XG_MP2 (XI1_I48_I31_XG_p1 I1_I48_G7_6 I1_I48_G7_4n VDD) gpdk090_pmos1v w=0.48u l=0.1u ad=0.1056p as=0.1632p pd=0.92u ps=1.64u
    I_MXI1_I48_I31_XG_MP0 (VDD I1_I48_P7_6 XI1_I48_I31_XG_p1 VDD) gpdk090_pmos1v w=0.48u l=0.1u ad=0.1056p as=0.1056p pd=0.92u ps=0.92u
    I_MXI1_I48_I31_XG_MP1 (XI1_I48_I31_XG_p1 I1_I48_G5_4 VDD VDD) gpdk090_pmos1v w=0.48u l=0.1u ad=0.1632p as=0.1056p pd=1.64u ps=0.92u
    I_MXI1_I96_I31_XG_MP2 (XI1_I96_I31_XG_p1 I1_I96_G7_6 I1_I96_G7_4n VDD) gpdk090_pmos1v w=0.48u l=0.1u ad=0.1056p as=0.1632p pd=0.92u ps=1.64u
    I_MXI1_I96_I31_XG_MP0 (VDD I1_I96_P7_6 XI1_I96_I31_XG_p1 VDD) gpdk090_pmos1v w=0.48u l=0.1u ad=0.1056p as=0.1056p pd=0.92u ps=0.92u
    I_MXI1_I96_I31_XG_MP1 (XI1_I96_I31_XG_p1 I1_I96_G5_4 VDD VDD) gpdk090_pmos1v w=0.48u l=0.1u ad=0.1632p as=0.1056p pd=1.64u ps=0.92u
    I_MXI1_I72_I31_XG_MP2 (XI1_I72_I31_XG_p1 I1_I72_G7_6 I1_I72_G7_4n VDD) gpdk090_pmos1v w=0.48u l=0.1u ad=0.1056p as=0.1632p pd=0.92u ps=1.64u
    I_MXI1_I72_I31_XG_MP0 (VDD I1_I72_P7_6 XI1_I72_I31_XG_p1 VDD) gpdk090_pmos1v w=0.48u l=0.1u ad=0.1056p as=0.1056p pd=0.92u ps=0.92u
    I_MXI1_I72_I31_XG_MP1 (XI1_I72_I31_XG_p1 I1_I72_G5_4 VDD VDD) gpdk090_pmos1v w=0.48u l=0.1u ad=0.1632p as=0.1056p pd=1.64u ps=0.92u
    I_MXI1_I60_I31_XG_MP2 (XI1_I60_I31_XG_p1 I1_I60_G7_6 I1_I60_G7_4n VDD) gpdk090_pmos1v w=0.48u l=0.1u ad=0.1056p as=0.1632p pd=0.92u ps=1.64u
    I_MXI1_I60_I31_XG_MP0 (VDD I1_I60_P7_6 XI1_I60_I31_XG_p1 VDD) gpdk090_pmos1v w=0.48u l=0.1u ad=0.1056p as=0.1056p pd=0.92u ps=0.92u
    I_MXI1_I60_I31_XG_MP1 (XI1_I60_I31_XG_p1 I1_I60_G5_4 VDD VDD) gpdk090_pmos1v w=0.48u l=0.1u ad=0.1632p as=0.1056p pd=1.64u ps=0.92u
    I_MXI0_I77_I36_XG_MP2 (VDD I0_I77_G7_4n I0_kc8 VDD) gpdk090_pmos1v w=0.24u l=0.1u ad=0.0936p as=0.0816p pd=0.92u ps=1.16u
    I_MXI0_I77_I36_XG_MP0 (XI0_I77_I36_XG_p1 I0_I77_P7_4n VDD VDD) gpdk090_pmos1v w=0.48u l=0.1u ad=0.1056p as=0.0936p pd=0.92u ps=0.92u
    I_MXI0_I77_I36_XG_MP1 (I0_kc8 I0_I77_G3_0n XI0_I77_I36_XG_p1 VDD) gpdk090_pmos1v w=0.48u l=0.1u ad=0.1632p as=0.1056p pd=1.64u ps=0.92u
    I_MXI0_I77_I25_XG_MP2 (VDD I0_I77_gn7 I0_I77_G7_6 VDD) gpdk090_pmos1v w=0.24u l=0.1u ad=0.0936p as=0.0816p pd=0.92u ps=1.16u
    I_MXI0_I77_I25_XG_MP0 (XI0_I77_I25_XG_p1 I0_I77_pn7 VDD VDD) gpdk090_pmos1v w=0.48u l=0.1u ad=0.1056p as=0.0936p pd=0.92u ps=0.92u
    I_MXI0_I77_I25_XG_MP1 (I0_I77_G7_6 I0_I77_gn6 XI0_I77_I25_XG_p1 VDD) gpdk090_pmos1v w=0.48u l=0.1u ad=0.1632p as=0.1056p pd=1.64u ps=0.92u
    I_MXI0_I77_I35_XG_MP2 (VDD I0_I77_G6_3n I0_kc7 VDD) gpdk090_pmos1v w=0.24u l=0.1u ad=0.0936p as=0.0816p pd=0.92u ps=1.16u
    I_MXI0_I77_I35_XG_MP0 (XI0_I77_I35_XG_p1 I0_I77_P6_3n VDD VDD) gpdk090_pmos1v w=0.48u l=0.1u ad=0.1056p as=0.0936p pd=0.92u ps=0.92u
    I_MXI0_I77_I35_XG_MP1 (I0_kc7 I0_I77_G2_0n XI0_I77_I35_XG_p1 VDD) gpdk090_pmos1v w=0.48u l=0.1u ad=0.1632p as=0.1056p pd=1.64u ps=0.92u
    I_MXI0_I77_I34_XG_MP2 (VDD I0_I77_G5_2n I0_I77_G5_0 VDD) gpdk090_pmos1v w=0.24u l=0.1u ad=0.0936p as=0.0816p pd=0.92u ps=1.16u
    I_MXI0_I77_I34_XG_MP0 (XI0_I77_I34_XG_p1 I0_I77_P5_2n VDD VDD) gpdk090_pmos1v w=0.48u l=0.1u ad=0.1056p as=0.0936p pd=0.92u ps=0.92u
    I_MXI0_I77_I34_XG_MP1 (I0_I77_G5_0 I0_I77_G1_0n XI0_I77_I34_XG_p1 VDD) gpdk090_pmos1v w=0.48u l=0.1u ad=0.1632p as=0.1056p pd=1.64u ps=0.92u
    I_MXI0_I77_I23_XG_MP2 (VDD I0_I77_gn5 I0_I77_G5_4 VDD) gpdk090_pmos1v w=0.24u l=0.1u ad=0.0936p as=0.0816p pd=0.92u ps=1.16u
    I_MXI0_I77_I23_XG_MP0 (XI0_I77_I23_XG_p1 I0_I77_pn5 VDD VDD) gpdk090_pmos1v w=0.48u l=0.1u ad=0.1056p as=0.0936p pd=0.92u ps=0.92u
    I_MXI0_I77_I23_XG_MP1 (I0_I77_G5_4 I0_I77_gn4 XI0_I77_I23_XG_p1 VDD) gpdk090_pmos1v w=0.48u l=0.1u ad=0.1632p as=0.1056p pd=1.64u ps=0.92u
    I_MXI0_I77_I24_XG_MP2 (VDD I0_I77_gn6 I0_I77_G6_5 VDD) gpdk090_pmos1v w=0.24u l=0.1u ad=0.0936p as=0.0816p pd=0.92u ps=1.16u
    I_MXI0_I77_I24_XG_MP0 (XI0_I77_I24_XG_p1 I0_I77_pn6 VDD VDD) gpdk090_pmos1v w=0.48u l=0.1u ad=0.1056p as=0.0936p pd=0.92u ps=0.92u
    I_MXI0_I77_I24_XG_MP1 (I0_I77_G6_5 I0_I77_gn5 XI0_I77_I24_XG_p1 VDD) gpdk090_pmos1v w=0.48u l=0.1u ad=0.1632p as=0.1056p pd=1.64u ps=0.92u
    I_MXI1_I152_I34_XG_MP2 (VDD I1_I152_G5_2n I1_I152_G5_0 VDD) gpdk090_pmos1v w=0.24u l=0.1u ad=0.0936p as=0.0816p pd=0.92u ps=1.16u
    I_MXI1_I152_I34_XG_MP0 (XI1_I152_I34_XG_p1 I1_I152_P5_2n VDD VDD) gpdk090_pmos1v w=0.48u l=0.1u ad=0.1056p as=0.0936p pd=0.92u ps=0.92u
    I_MXI1_I152_I34_XG_MP1 (I1_I152_G5_0 I1_I152_G1_0n XI1_I152_I34_XG_p1 VDD) gpdk090_pmos1v w=0.48u l=0.1u ad=0.1632p as=0.1056p pd=1.64u ps=0.92u
    I_MXI0_I77_I32_XG_MP2 (VDD I0_I77_G4_1n I0_I77_G4_0 VDD) gpdk090_pmos1v w=0.24u l=0.1u ad=0.0936p as=0.0816p pd=0.92u ps=1.16u
    I_MXI0_I77_I32_XG_MP0 (XI0_I77_I32_XG_p1 I0_I77_P4_1n VDD VDD) gpdk090_pmos1v w=0.48u l=0.1u ad=0.1056p as=0.0936p pd=0.92u ps=0.92u
    I_MXI0_I77_I32_XG_MP1 (I0_I77_G4_0 I0_I77_G0_0n XI0_I77_I32_XG_p1 VDD) gpdk090_pmos1v w=0.48u l=0.1u ad=0.1632p as=0.1056p pd=1.64u ps=0.92u
    I_MXI0_I77_I22_XG_MP2 (VDD I0_I77_gn4 I0_I77_G4_3 VDD) gpdk090_pmos1v w=0.24u l=0.1u ad=0.0936p as=0.0816p pd=0.92u ps=1.16u
    I_MXI0_I77_I22_XG_MP0 (XI0_I77_I22_XG_p1 I0_I77_pn4 VDD VDD) gpdk090_pmos1v w=0.48u l=0.1u ad=0.1056p as=0.0936p pd=0.92u ps=0.92u
    I_MXI0_I77_I22_XG_MP1 (I0_I77_G4_3 I0_I77_gn3 XI0_I77_I22_XG_p1 VDD) gpdk090_pmos1v w=0.48u l=0.1u ad=0.1632p as=0.1056p pd=1.64u ps=0.92u
    I_MXI0_I77_I21_XG_MP2 (VDD I0_I77_gn3 I0_I77_G3_2 VDD) gpdk090_pmos1v w=0.24u l=0.1u ad=0.0936p as=0.0816p pd=0.92u ps=1.16u
    I_MXI0_I77_I21_XG_MP0 (XI0_I77_I21_XG_p1 I0_I77_pn3 VDD VDD) gpdk090_pmos1v w=0.48u l=0.1u ad=0.1056p as=0.0936p pd=0.92u ps=0.92u
    I_MXI0_I77_I21_XG_MP1 (I0_I77_G3_2 I0_I77_gn2 XI0_I77_I21_XG_p1 VDD) gpdk090_pmos1v w=0.48u l=0.1u ad=0.1632p as=0.1056p pd=1.64u ps=0.92u
    I_MXI1_I152_I25_XG_MP2 (VDD I1_I152_gn7 I1_I152_G7_6 VDD) gpdk090_pmos1v w=0.24u l=0.1u ad=0.0936p as=0.0816p pd=0.92u ps=1.16u
    I_MXI1_I152_I25_XG_MP0 (XI1_I152_I25_XG_p1 I1_I152_pn7 VDD VDD) gpdk090_pmos1v w=0.48u l=0.1u ad=0.1056p as=0.0936p pd=0.92u ps=0.92u
    I_MXI1_I152_I25_XG_MP1 (I1_I152_G7_6 I1_I152_gn6 XI1_I152_I25_XG_p1 VDD) gpdk090_pmos1v w=0.48u l=0.1u ad=0.1632p as=0.1056p pd=1.64u ps=0.92u
    I_MXI1_I152_I36_XG_MP2 (VDD I1_I152_G7_4n I1_rc7 VDD) gpdk090_pmos1v w=0.24u l=0.1u ad=0.0936p as=0.0816p pd=0.92u ps=1.16u
    I_MXI1_I152_I36_XG_MP0 (XI1_I152_I36_XG_p1 I1_I152_P7_4n VDD VDD) gpdk090_pmos1v w=0.48u l=0.1u ad=0.1056p as=0.0936p pd=0.92u ps=0.92u
    I_MXI1_I152_I36_XG_MP1 (I1_rc7 I1_I152_G3_0n XI1_I152_I36_XG_p1 VDD) gpdk090_pmos1v w=0.48u l=0.1u ad=0.1632p as=0.1056p pd=1.64u ps=0.92u
    I_MXI1_I152_I35_XG_MP2 (VDD I1_I152_G6_3n I1_rc6 VDD) gpdk090_pmos1v w=0.24u l=0.1u ad=0.0936p as=0.0816p pd=0.92u ps=1.16u
    I_MXI1_I152_I35_XG_MP0 (XI1_I152_I35_XG_p1 I1_I152_P6_3n VDD VDD) gpdk090_pmos1v w=0.48u l=0.1u ad=0.1056p as=0.0936p pd=0.92u ps=0.92u
    I_MXI1_I152_I35_XG_MP1 (I1_rc6 I1_I152_G2_0n XI1_I152_I35_XG_p1 VDD) gpdk090_pmos1v w=0.48u l=0.1u ad=0.1632p as=0.1056p pd=1.64u ps=0.92u
    I_MXI0_I77_I19_XG_MP2 (VDD I0_I77_gn1 I0_I77_G1_0 VDD) gpdk090_pmos1v w=0.24u l=0.1u ad=0.0936p as=0.0816p pd=0.92u ps=1.16u
    I_MXI0_I77_I19_XG_MP0 (XI0_I77_I19_XG_p1 I0_I77_pn1 VDD VDD) gpdk090_pmos1v w=0.48u l=0.1u ad=0.1056p as=0.0936p pd=0.92u ps=0.92u
    I_MXI0_I77_I19_XG_MP1 (I0_I77_G1_0 I0_I77_G0_0n XI0_I77_I19_XG_p1 VDD) gpdk090_pmos1v w=0.48u l=0.1u ad=0.1632p as=0.1056p pd=1.64u ps=0.92u
    I_MXI0_I77_I20_XG_MP2 (VDD I0_I77_gn2 I0_I77_G2_1 VDD) gpdk090_pmos1v w=0.24u l=0.1u ad=0.0936p as=0.0816p pd=0.92u ps=1.16u
    I_MXI0_I77_I20_XG_MP0 (XI0_I77_I20_XG_p1 I0_I77_pn2 VDD VDD) gpdk090_pmos1v w=0.48u l=0.1u ad=0.1056p as=0.0936p pd=0.92u ps=0.92u
    I_MXI0_I77_I20_XG_MP1 (I0_I77_G2_1 I0_I77_gn1 XI0_I77_I20_XG_p1 VDD) gpdk090_pmos1v w=0.48u l=0.1u ad=0.1632p as=0.1056p pd=1.64u ps=0.92u
    I_MXI1_I152_I24_XG_MP2 (VDD I1_I152_gn6 I1_I152_G6_5 VDD) gpdk090_pmos1v w=0.24u l=0.1u ad=0.0936p as=0.0816p pd=0.92u ps=1.16u
    I_MXI1_I152_I24_XG_MP0 (XI1_I152_I24_XG_p1 I1_I152_pn6 VDD VDD) gpdk090_pmos1v w=0.48u l=0.1u ad=0.1056p as=0.0936p pd=0.92u ps=0.92u
    I_MXI1_I152_I24_XG_MP1 (I1_I152_G6_5 I1_I152_gn5 XI1_I152_I24_XG_p1 VDD) gpdk090_pmos1v w=0.48u l=0.1u ad=0.1632p as=0.1056p pd=1.64u ps=0.92u
    I_MXI1_I152_I23_XG_MP2 (VDD I1_I152_gn5 I1_I152_G5_4 VDD) gpdk090_pmos1v w=0.24u l=0.1u ad=0.0936p as=0.0816p pd=0.92u ps=1.16u
    I_MXI1_I152_I23_XG_MP0 (XI1_I152_I23_XG_p1 I1_I152_pn5 VDD VDD) gpdk090_pmos1v w=0.48u l=0.1u ad=0.1056p as=0.0936p pd=0.92u ps=0.92u
    I_MXI1_I152_I23_XG_MP1 (I1_I152_G5_4 I1_I152_gn4 XI1_I152_I23_XG_p1 VDD) gpdk090_pmos1v w=0.48u l=0.1u ad=0.1632p as=0.1056p pd=1.64u ps=0.92u
    I_MXI1_I152_I32_XG_MP2 (VDD I1_I152_G4_1n I1_I152_G4_0 VDD) gpdk090_pmos1v w=0.24u l=0.1u ad=0.0936p as=0.0816p pd=0.92u ps=1.16u
    I_MXI1_I152_I32_XG_MP0 (XI1_I152_I32_XG_p1 I1_I152_P4_1n VDD VDD) gpdk090_pmos1v w=0.48u l=0.1u ad=0.1056p as=0.0936p pd=0.92u ps=0.92u
    I_MXI1_I152_I32_XG_MP1 (I1_I152_G4_0 I1_I152_G0_0n XI1_I152_I32_XG_p1 VDD) gpdk090_pmos1v w=0.48u l=0.1u ad=0.1632p as=0.1056p pd=1.64u ps=0.92u
    I_MXI1_I152_I19_XG_MP2 (VDD I1_I152_gn1 I1_I152_G1_0 VDD) gpdk090_pmos1v w=0.24u l=0.1u ad=0.0936p as=0.0816p pd=0.92u ps=1.16u
    I_MXI1_I152_I19_XG_MP0 (XI1_I152_I19_XG_p1 I1_I152_pn1 VDD VDD) gpdk090_pmos1v w=0.48u l=0.1u ad=0.1056p as=0.0936p pd=0.92u ps=0.92u
    I_MXI1_I152_I19_XG_MP1 (I1_I152_G1_0 I1_I152_G0_0n XI1_I152_I19_XG_p1 VDD) gpdk090_pmos1v w=0.48u l=0.1u ad=0.1632p as=0.1056p pd=1.64u ps=0.92u
    I_MXI0_I77_I17_XG_MP2 (VDD I0_I77_gn0 I0_I77_G0_0 VDD) gpdk090_pmos1v w=0.24u l=0.1u ad=0.0936p as=0.0816p pd=0.92u ps=1.16u
    I_MXI0_I77_I17_XG_MP0 (XI0_I77_I17_XG_p1 I0_I77_pn0 VDD VDD) gpdk090_pmos1v w=0.48u l=0.1u ad=0.1056p as=0.0936p pd=0.92u ps=0.92u
    I_MXI0_I77_I17_XG_MP1 (I0_I77_G0_0 I0_I77_cinn XI0_I77_I17_XG_p1 VDD) gpdk090_pmos1v w=0.48u l=0.1u ad=0.1632p as=0.1056p pd=1.64u ps=0.92u
    I_MXI1_I152_I22_XG_MP2 (VDD I1_I152_gn4 I1_I152_G4_3 VDD) gpdk090_pmos1v w=0.24u l=0.1u ad=0.0936p as=0.0816p pd=0.92u ps=1.16u
    I_MXI1_I152_I22_XG_MP0 (XI1_I152_I22_XG_p1 I1_I152_pn4 VDD VDD) gpdk090_pmos1v w=0.48u l=0.1u ad=0.1056p as=0.0936p pd=0.92u ps=0.92u
    I_MXI1_I152_I22_XG_MP1 (I1_I152_G4_3 I1_I152_gn3 XI1_I152_I22_XG_p1 VDD) gpdk090_pmos1v w=0.48u l=0.1u ad=0.1632p as=0.1056p pd=1.64u ps=0.92u
    I_MXI1_I152_I21_XG_MP2 (VDD I1_I152_gn3 I1_I152_G3_2 VDD) gpdk090_pmos1v w=0.24u l=0.1u ad=0.0936p as=0.0816p pd=0.92u ps=1.16u
    I_MXI1_I152_I21_XG_MP0 (XI1_I152_I21_XG_p1 I1_I152_pn3 VDD VDD) gpdk090_pmos1v w=0.48u l=0.1u ad=0.1056p as=0.0936p pd=0.92u ps=0.92u
    I_MXI1_I152_I21_XG_MP1 (I1_I152_G3_2 I1_I152_gn2 XI1_I152_I21_XG_p1 VDD) gpdk090_pmos1v w=0.48u l=0.1u ad=0.1632p as=0.1056p pd=1.64u ps=0.92u
    I_MXI1_I152_I20_XG_MP2 (VDD I1_I152_gn2 I1_I152_G2_1 VDD) gpdk090_pmos1v w=0.24u l=0.1u ad=0.0936p as=0.0816p pd=0.92u ps=1.16u
    I_MXI1_I152_I20_XG_MP0 (XI1_I152_I20_XG_p1 I1_I152_pn2 VDD VDD) gpdk090_pmos1v w=0.48u l=0.1u ad=0.1056p as=0.0936p pd=0.92u ps=0.92u
    I_MXI1_I152_I20_XG_MP1 (I1_I152_G2_1 I1_I152_gn1 XI1_I152_I20_XG_p1 VDD) gpdk090_pmos1v w=0.48u l=0.1u ad=0.1632p as=0.1056p pd=1.64u ps=0.92u
    I_MXI2_I1_I8_I25_XG_MP2 (VDD I2_I1_I8_gn7 I2_I1_I8_G7_6 VDD) gpdk090_pmos1v w=0.24u l=0.1u ad=0.0936p as=0.0816p pd=0.92u ps=1.16u
    I_MXI2_I1_I8_I25_XG_MP0 (XI2_I1_I8_I25_XG_p1 I2_I1_I8_pn7 VDD VDD) gpdk090_pmos1v w=0.48u l=0.1u ad=0.1056p as=0.0936p pd=0.92u ps=0.92u
    I_MXI2_I1_I8_I25_XG_MP1 (I2_I1_I8_G7_6 I2_I1_I8_gn6 XI2_I1_I8_I25_XG_p1 VDD) gpdk090_pmos1v w=0.48u l=0.1u ad=0.1632p as=0.1056p pd=1.64u ps=0.92u
    I_MXI2_I1_I8_I24_XG_MP2 (VDD I2_I1_I8_gn6 I2_I1_I8_G6_5 VDD) gpdk090_pmos1v w=0.24u l=0.1u ad=0.0936p as=0.0816p pd=0.92u ps=1.16u
    I_MXI2_I1_I8_I24_XG_MP0 (XI2_I1_I8_I24_XG_p1 I2_I1_I8_pn6 VDD VDD) gpdk090_pmos1v w=0.48u l=0.1u ad=0.1056p as=0.0936p pd=0.92u ps=0.92u
    I_MXI2_I1_I8_I24_XG_MP1 (I2_I1_I8_G6_5 I2_I1_I8_gn5 XI2_I1_I8_I24_XG_p1 VDD) gpdk090_pmos1v w=0.48u l=0.1u ad=0.1632p as=0.1056p pd=1.64u ps=0.92u
    I_MXI1_I132_I36_XG_MP2 (VDD I1_I132_G7_4n I1_c7_8 VDD) gpdk090_pmos1v w=0.24u l=0.1u ad=0.0936p as=0.0816p pd=0.92u ps=1.16u
    I_MXI1_I132_I36_XG_MP0 (XI1_I132_I36_XG_p1 I1_I132_P7_4n VDD VDD) gpdk090_pmos1v w=0.48u l=0.1u ad=0.1056p as=0.0936p pd=0.92u ps=0.92u
    I_MXI1_I132_I36_XG_MP1 (I1_c7_8 I1_I132_G3_0n XI1_I132_I36_XG_p1 VDD) gpdk090_pmos1v w=0.48u l=0.1u ad=0.1632p as=0.1056p pd=1.64u ps=0.92u
    I_MXI1_I132_I34_XG_MP2 (VDD I1_I132_G5_2n I1_I132_G5_0 VDD) gpdk090_pmos1v w=0.24u l=0.1u ad=0.0936p as=0.0816p pd=0.92u ps=1.16u
    I_MXI1_I132_I34_XG_MP0 (XI1_I132_I34_XG_p1 I1_I132_P5_2n VDD VDD) gpdk090_pmos1v w=0.48u l=0.1u ad=0.1056p as=0.0936p pd=0.92u ps=0.92u
    I_MXI1_I132_I34_XG_MP1 (I1_I132_G5_0 I1_I132_G1_0n XI1_I132_I34_XG_p1 VDD) gpdk090_pmos1v w=0.48u l=0.1u ad=0.1632p as=0.1056p pd=1.64u ps=0.92u
    I_MXI1_I152_I17_XG_MP2 (VDD I1_I152_gn0 I1_I152_G0_0 VDD) gpdk090_pmos1v w=0.24u l=0.1u ad=0.0936p as=0.0816p pd=0.92u ps=1.16u
    I_MXI1_I152_I17_XG_MP0 (XI1_I152_I17_XG_p1 I1_I152_pn0 VDD VDD) gpdk090_pmos1v w=0.48u l=0.1u ad=0.1056p as=0.0936p pd=0.92u ps=0.92u
    I_MXI1_I152_I17_XG_MP1 (I1_I152_G0_0 I1_I152_cinn XI1_I152_I17_XG_p1 VDD) gpdk090_pmos1v w=0.48u l=0.1u ad=0.1632p as=0.1056p pd=1.64u ps=0.92u
    I_MXI2_I1_I8_I36_XG_MP2 (VDD I2_I1_I8_G7_4n I2_C8 VDD) gpdk090_pmos1v w=0.24u l=0.1u ad=0.0936p as=0.0816p pd=0.92u ps=1.16u
    I_MXI2_I1_I8_I36_XG_MP0 (XI2_I1_I8_I36_XG_p1 I2_I1_I8_P7_4n VDD VDD) gpdk090_pmos1v w=0.48u l=0.1u ad=0.1056p as=0.0936p pd=0.92u ps=0.92u
    I_MXI2_I1_I8_I36_XG_MP1 (I2_C8 I2_I1_I8_G3_0n XI2_I1_I8_I36_XG_p1 VDD) gpdk090_pmos1v w=0.48u l=0.1u ad=0.1632p as=0.1056p pd=1.64u ps=0.92u
    I_MXI2_I1_I8_I35_XG_MP2 (VDD I2_I1_I8_G6_3n I2_C7 VDD) gpdk090_pmos1v w=0.24u l=0.1u ad=0.0936p as=0.0816p pd=0.92u ps=1.16u
    I_MXI2_I1_I8_I35_XG_MP0 (XI2_I1_I8_I35_XG_p1 I2_I1_I8_P6_3n VDD VDD) gpdk090_pmos1v w=0.48u l=0.1u ad=0.1056p as=0.0936p pd=0.92u ps=0.92u
    I_MXI2_I1_I8_I35_XG_MP1 (I2_C7 I2_I1_I8_G2_0n XI2_I1_I8_I35_XG_p1 VDD) gpdk090_pmos1v w=0.48u l=0.1u ad=0.1632p as=0.1056p pd=1.64u ps=0.92u
    I_MXI2_I1_I8_I23_XG_MP2 (VDD I2_I1_I8_gn5 I2_I1_I8_G5_4 VDD) gpdk090_pmos1v w=0.24u l=0.1u ad=0.0936p as=0.0816p pd=0.92u ps=1.16u
    I_MXI2_I1_I8_I23_XG_MP0 (XI2_I1_I8_I23_XG_p1 I2_I1_I8_pn5 VDD VDD) gpdk090_pmos1v w=0.48u l=0.1u ad=0.1056p as=0.0936p pd=0.92u ps=0.92u
    I_MXI2_I1_I8_I23_XG_MP1 (I2_I1_I8_G5_4 I2_I1_I8_gn4 XI2_I1_I8_I23_XG_p1 VDD) gpdk090_pmos1v w=0.48u l=0.1u ad=0.1632p as=0.1056p pd=1.64u ps=0.92u
    I_MXI2_I1_I8_I22_XG_MP2 (VDD I2_I1_I8_gn4 I2_I1_I8_G4_3 VDD) gpdk090_pmos1v w=0.24u l=0.1u ad=0.0936p as=0.0816p pd=0.92u ps=1.16u
    I_MXI2_I1_I8_I22_XG_MP0 (XI2_I1_I8_I22_XG_p1 I2_I1_I8_pn4 VDD VDD) gpdk090_pmos1v w=0.48u l=0.1u ad=0.1056p as=0.0936p pd=0.92u ps=0.92u
    I_MXI2_I1_I8_I22_XG_MP1 (I2_I1_I8_G4_3 I2_I1_I8_gn3 XI2_I1_I8_I22_XG_p1 VDD) gpdk090_pmos1v w=0.48u l=0.1u ad=0.1632p as=0.1056p pd=1.64u ps=0.92u
    I_MXI1_I132_I35_XG_MP2 (VDD I1_I132_G6_3n I1_c7_7 VDD) gpdk090_pmos1v w=0.24u l=0.1u ad=0.0936p as=0.0816p pd=0.92u ps=1.16u
    I_MXI1_I132_I35_XG_MP0 (XI1_I132_I35_XG_p1 I1_I132_P6_3n VDD VDD) gpdk090_pmos1v w=0.48u l=0.1u ad=0.1056p as=0.0936p pd=0.92u ps=0.92u
    I_MXI1_I132_I35_XG_MP1 (I1_c7_7 I1_I132_G2_0n XI1_I132_I35_XG_p1 VDD) gpdk090_pmos1v w=0.48u l=0.1u ad=0.1632p as=0.1056p pd=1.64u ps=0.92u
    I_MXI1_I132_I32_XG_MP2 (VDD I1_I132_G4_1n I1_I132_G4_0 VDD) gpdk090_pmos1v w=0.24u l=0.1u ad=0.0936p as=0.0816p pd=0.92u ps=1.16u
    I_MXI1_I132_I32_XG_MP0 (XI1_I132_I32_XG_p1 I1_I132_P4_1n VDD VDD) gpdk090_pmos1v w=0.48u l=0.1u ad=0.1056p as=0.0936p pd=0.92u ps=0.92u
    I_MXI1_I132_I32_XG_MP1 (I1_I132_G4_0 I1_I132_G0_0n XI1_I132_I32_XG_p1 VDD) gpdk090_pmos1v w=0.48u l=0.1u ad=0.1632p as=0.1056p pd=1.64u ps=0.92u
    I_MXI1_I132_I19_XG_MP2 (VDD I1_I132_gn1 I1_I132_G1_0 VDD) gpdk090_pmos1v w=0.24u l=0.1u ad=0.0936p as=0.0816p pd=0.92u ps=1.16u
    I_MXI1_I132_I19_XG_MP0 (XI1_I132_I19_XG_p1 I1_I132_pn1 VDD VDD) gpdk090_pmos1v w=0.48u l=0.1u ad=0.1056p as=0.0936p pd=0.92u ps=0.92u
    I_MXI1_I132_I19_XG_MP1 (I1_I132_G1_0 I1_I132_G0_0n XI1_I132_I19_XG_p1 VDD) gpdk090_pmos1v w=0.48u l=0.1u ad=0.1632p as=0.1056p pd=1.64u ps=0.92u
    I_MXI2_I1_I8_I34_XG_MP2 (VDD I2_I1_I8_G5_2n I2_I1_I8_G5_0 VDD) gpdk090_pmos1v w=0.24u l=0.1u ad=0.0936p as=0.0816p pd=0.92u ps=1.16u
    I_MXI2_I1_I8_I34_XG_MP0 (XI2_I1_I8_I34_XG_p1 I2_I1_I8_P5_2n VDD VDD) gpdk090_pmos1v w=0.48u l=0.1u ad=0.1056p as=0.0936p pd=0.92u ps=0.92u
    I_MXI2_I1_I8_I34_XG_MP1 (I2_I1_I8_G5_0 I2_I1_I8_G1_0n XI2_I1_I8_I34_XG_p1 VDD) gpdk090_pmos1v w=0.48u l=0.1u ad=0.1632p as=0.1056p pd=1.64u ps=0.92u
    I_MXI2_I1_I8_I21_XG_MP2 (VDD I2_I1_I8_gn3 I2_I1_I8_G3_2 VDD) gpdk090_pmos1v w=0.24u l=0.1u ad=0.0936p as=0.0816p pd=0.92u ps=1.16u
    I_MXI2_I1_I8_I21_XG_MP0 (XI2_I1_I8_I21_XG_p1 I2_I1_I8_pn3 VDD VDD) gpdk090_pmos1v w=0.48u l=0.1u ad=0.1056p as=0.0936p pd=0.92u ps=0.92u
    I_MXI2_I1_I8_I21_XG_MP1 (I2_I1_I8_G3_2 I2_I1_I8_gn2 XI2_I1_I8_I21_XG_p1 VDD) gpdk090_pmos1v w=0.48u l=0.1u ad=0.1632p as=0.1056p pd=1.64u ps=0.92u
    I_MXI1_I132_I25_XG_MP2 (VDD I1_I132_gn7 I1_I132_G7_6 VDD) gpdk090_pmos1v w=0.24u l=0.1u ad=0.0936p as=0.0816p pd=0.92u ps=1.16u
    I_MXI1_I132_I25_XG_MP0 (XI1_I132_I25_XG_p1 I1_I132_pn7 VDD VDD) gpdk090_pmos1v w=0.48u l=0.1u ad=0.1056p as=0.0936p pd=0.92u ps=0.92u
    I_MXI1_I132_I25_XG_MP1 (I1_I132_G7_6 I1_I132_gn6 XI1_I132_I25_XG_p1 VDD) gpdk090_pmos1v w=0.48u l=0.1u ad=0.1632p as=0.1056p pd=1.64u ps=0.92u
    I_MXI1_I132_I24_XG_MP2 (VDD I1_I132_gn6 I1_I132_G6_5 VDD) gpdk090_pmos1v w=0.24u l=0.1u ad=0.0936p as=0.0816p pd=0.92u ps=1.16u
    I_MXI1_I132_I24_XG_MP0 (XI1_I132_I24_XG_p1 I1_I132_pn6 VDD VDD) gpdk090_pmos1v w=0.48u l=0.1u ad=0.1056p as=0.0936p pd=0.92u ps=0.92u
    I_MXI1_I132_I24_XG_MP1 (I1_I132_G6_5 I1_I132_gn5 XI1_I132_I24_XG_p1 VDD) gpdk090_pmos1v w=0.48u l=0.1u ad=0.1632p as=0.1056p pd=1.64u ps=0.92u
    I_MXI1_I132_I23_XG_MP2 (VDD I1_I132_gn5 I1_I132_G5_4 VDD) gpdk090_pmos1v w=0.24u l=0.1u ad=0.0936p as=0.0816p pd=0.92u ps=1.16u
    I_MXI1_I132_I23_XG_MP0 (XI1_I132_I23_XG_p1 I1_I132_pn5 VDD VDD) gpdk090_pmos1v w=0.48u l=0.1u ad=0.1056p as=0.0936p pd=0.92u ps=0.92u
    I_MXI1_I132_I23_XG_MP1 (I1_I132_G5_4 I1_I132_gn4 XI1_I132_I23_XG_p1 VDD) gpdk090_pmos1v w=0.48u l=0.1u ad=0.1632p as=0.1056p pd=1.64u ps=0.92u
    I_MXI1_I132_I22_XG_MP2 (VDD I1_I132_gn4 I1_I132_G4_3 VDD) gpdk090_pmos1v w=0.24u l=0.1u ad=0.0936p as=0.0816p pd=0.92u ps=1.16u
    I_MXI1_I132_I22_XG_MP0 (XI1_I132_I22_XG_p1 I1_I132_pn4 VDD VDD) gpdk090_pmos1v w=0.48u l=0.1u ad=0.1056p as=0.0936p pd=0.92u ps=0.92u
    I_MXI1_I132_I22_XG_MP1 (I1_I132_G4_3 I1_I132_gn3 XI1_I132_I22_XG_p1 VDD) gpdk090_pmos1v w=0.48u l=0.1u ad=0.1632p as=0.1056p pd=1.64u ps=0.92u
    I_MXI1_I132_I21_XG_MP2 (VDD I1_I132_gn3 I1_I132_G3_2 VDD) gpdk090_pmos1v w=0.24u l=0.1u ad=0.0936p as=0.0816p pd=0.92u ps=1.16u
    I_MXI1_I132_I21_XG_MP0 (XI1_I132_I21_XG_p1 I1_I132_pn3 VDD VDD) gpdk090_pmos1v w=0.48u l=0.1u ad=0.1056p as=0.0936p pd=0.92u ps=0.92u
    I_MXI1_I132_I21_XG_MP1 (I1_I132_G3_2 I1_I132_gn2 XI1_I132_I21_XG_p1 VDD) gpdk090_pmos1v w=0.48u l=0.1u ad=0.1632p as=0.1056p pd=1.64u ps=0.92u
    I_MXI1_I132_I20_XG_MP2 (VDD I1_I132_gn2 I1_I132_G2_1 VDD) gpdk090_pmos1v w=0.24u l=0.1u ad=0.0936p as=0.0816p pd=0.92u ps=1.16u
    I_MXI1_I132_I20_XG_MP0 (XI1_I132_I20_XG_p1 I1_I132_pn2 VDD VDD) gpdk090_pmos1v w=0.48u l=0.1u ad=0.1056p as=0.0936p pd=0.92u ps=0.92u
    I_MXI1_I132_I20_XG_MP1 (I1_I132_G2_1 I1_I132_gn1 XI1_I132_I20_XG_p1 VDD) gpdk090_pmos1v w=0.48u l=0.1u ad=0.1632p as=0.1056p pd=1.64u ps=0.92u
    I_MXI1_I132_I17_XG_MP2 (VDD I1_I132_gn0 I1_I132_G0_0 VDD) gpdk090_pmos1v w=0.24u l=0.1u ad=0.0936p as=0.0816p pd=0.92u ps=1.16u
    I_MXI1_I132_I17_XG_MP0 (XI1_I132_I17_XG_p1 I1_I132_pn0 VDD VDD) gpdk090_pmos1v w=0.48u l=0.1u ad=0.1056p as=0.0936p pd=0.92u ps=0.92u
    I_MXI1_I132_I17_XG_MP1 (I1_I132_G0_0 I1_I132_cinn XI1_I132_I17_XG_p1 VDD) gpdk090_pmos1v w=0.48u l=0.1u ad=0.1632p as=0.1056p pd=1.64u ps=0.92u
    I_MXI2_I1_I8_I32_XG_MP2 (VDD I2_I1_I8_G4_1n I2_I1_I8_G4_0 VDD) gpdk090_pmos1v w=0.24u l=0.1u ad=0.0936p as=0.0816p pd=0.92u ps=1.16u
    I_MXI2_I1_I8_I32_XG_MP0 (XI2_I1_I8_I32_XG_p1 I2_I1_I8_P4_1n VDD VDD) gpdk090_pmos1v w=0.48u l=0.1u ad=0.1056p as=0.0936p pd=0.92u ps=0.92u
    I_MXI2_I1_I8_I32_XG_MP1 (I2_I1_I8_G4_0 I2_I1_I8_G0_0n XI2_I1_I8_I32_XG_p1 VDD) gpdk090_pmos1v w=0.48u l=0.1u ad=0.1632p as=0.1056p pd=1.64u ps=0.92u
    I_MXI2_I1_I8_I17_XG_MP2 (VDD I2_I1_I8_gn0 I2_I1_I8_G0_0 VDD) gpdk090_pmos1v w=0.24u l=0.1u ad=0.0936p as=0.0816p pd=0.92u ps=1.16u
    I_MXI2_I1_I8_I17_XG_MP0 (XI2_I1_I8_I17_XG_p1 I2_I1_I8_pn0 VDD VDD) gpdk090_pmos1v w=0.48u l=0.1u ad=0.1056p as=0.0936p pd=0.92u ps=0.92u
    I_MXI2_I1_I8_I17_XG_MP1 (I2_I1_I8_G0_0 I2_I1_I8_cinn XI2_I1_I8_I17_XG_p1 VDD) gpdk090_pmos1v w=0.48u l=0.1u ad=0.1632p as=0.1056p pd=1.64u ps=0.92u
    I_MXI2_I1_I8_I19_XG_MP2 (VDD I2_I1_I8_gn1 I2_I1_I8_G1_0 VDD) gpdk090_pmos1v w=0.24u l=0.1u ad=0.0936p as=0.0816p pd=0.92u ps=1.16u
    I_MXI2_I1_I8_I19_XG_MP0 (XI2_I1_I8_I19_XG_p1 I2_I1_I8_pn1 VDD VDD) gpdk090_pmos1v w=0.48u l=0.1u ad=0.1056p as=0.0936p pd=0.92u ps=0.92u
    I_MXI2_I1_I8_I19_XG_MP1 (I2_I1_I8_G1_0 I2_I1_I8_G0_0n XI2_I1_I8_I19_XG_p1 VDD) gpdk090_pmos1v w=0.48u l=0.1u ad=0.1632p as=0.1056p pd=1.64u ps=0.92u
    I_MXI2_I1_I8_I20_XG_MP2 (VDD I2_I1_I8_gn2 I2_I1_I8_G2_1 VDD) gpdk090_pmos1v w=0.24u l=0.1u ad=0.0936p as=0.0816p pd=0.92u ps=1.16u
    I_MXI2_I1_I8_I20_XG_MP0 (XI2_I1_I8_I20_XG_p1 I2_I1_I8_pn2 VDD VDD) gpdk090_pmos1v w=0.48u l=0.1u ad=0.1056p as=0.0936p pd=0.92u ps=0.92u
    I_MXI2_I1_I8_I20_XG_MP1 (I2_I1_I8_G2_1 I2_I1_I8_gn1 XI2_I1_I8_I20_XG_p1 VDD) gpdk090_pmos1v w=0.48u l=0.1u ad=0.1632p as=0.1056p pd=1.64u ps=0.92u
    I_MXI1_I120_I34_XG_MP2 (VDD I1_I120_G5_2n I1_I120_G5_0 VDD) gpdk090_pmos1v w=0.24u l=0.1u ad=0.0936p as=0.0816p pd=0.92u ps=1.16u
    I_MXI1_I120_I34_XG_MP0 (XI1_I120_I34_XG_p1 I1_I120_P5_2n VDD VDD) gpdk090_pmos1v w=0.48u l=0.1u ad=0.1056p as=0.0936p pd=0.92u ps=0.92u
    I_MXI1_I120_I34_XG_MP1 (I1_I120_G5_0 I1_I120_G1_0n XI1_I120_I34_XG_p1 VDD) gpdk090_pmos1v w=0.48u l=0.1u ad=0.1632p as=0.1056p pd=1.64u ps=0.92u
    I_MXI1_I120_I35_XG_MP2 (VDD I1_I120_G6_3n I1_c6_7 VDD) gpdk090_pmos1v w=0.24u l=0.1u ad=0.0936p as=0.0816p pd=0.92u ps=1.16u
    I_MXI1_I120_I35_XG_MP0 (XI1_I120_I35_XG_p1 I1_I120_P6_3n VDD VDD) gpdk090_pmos1v w=0.48u l=0.1u ad=0.1056p as=0.0936p pd=0.92u ps=0.92u
    I_MXI1_I120_I35_XG_MP1 (I1_c6_7 I1_I120_G2_0n XI1_I120_I35_XG_p1 VDD) gpdk090_pmos1v w=0.48u l=0.1u ad=0.1632p as=0.1056p pd=1.64u ps=0.92u
    I_MXI1_I120_I32_XG_MP2 (VDD I1_I120_G4_1n I1_I120_G4_0 VDD) gpdk090_pmos1v w=0.24u l=0.1u ad=0.0936p as=0.0816p pd=0.92u ps=1.16u
    I_MXI1_I120_I32_XG_MP0 (XI1_I120_I32_XG_p1 I1_I120_P4_1n VDD VDD) gpdk090_pmos1v w=0.48u l=0.1u ad=0.1056p as=0.0936p pd=0.92u ps=0.92u
    I_MXI1_I120_I32_XG_MP1 (I1_I120_G4_0 I1_I120_G0_0n XI1_I120_I32_XG_p1 VDD) gpdk090_pmos1v w=0.48u l=0.1u ad=0.1632p as=0.1056p pd=1.64u ps=0.92u
    I_MXI1_I120_I19_XG_MP2 (VDD I1_I120_gn1 I1_I120_G1_0 VDD) gpdk090_pmos1v w=0.24u l=0.1u ad=0.0936p as=0.0816p pd=0.92u ps=1.16u
    I_MXI1_I120_I19_XG_MP0 (XI1_I120_I19_XG_p1 I1_I120_pn1 VDD VDD) gpdk090_pmos1v w=0.48u l=0.1u ad=0.1056p as=0.0936p pd=0.92u ps=0.92u
    I_MXI1_I120_I19_XG_MP1 (I1_I120_G1_0 I1_I120_G0_0n XI1_I120_I19_XG_p1 VDD) gpdk090_pmos1v w=0.48u l=0.1u ad=0.1632p as=0.1056p pd=1.64u ps=0.92u
    I_MXI1_I120_I17_XG_MP2 (VDD I1_I120_gn0 I1_I120_G0_0 VDD) gpdk090_pmos1v w=0.24u l=0.1u ad=0.0936p as=0.0816p pd=0.92u ps=1.16u
    I_MXI1_I120_I17_XG_MP0 (XI1_I120_I17_XG_p1 I1_I120_pn0 VDD VDD) gpdk090_pmos1v w=0.48u l=0.1u ad=0.1056p as=0.0936p pd=0.92u ps=0.92u
    I_MXI1_I120_I17_XG_MP1 (I1_I120_G0_0 I1_I120_cinn XI1_I120_I17_XG_p1 VDD) gpdk090_pmos1v w=0.48u l=0.1u ad=0.1632p as=0.1056p pd=1.64u ps=0.92u
    I_MXI1_I120_I36_XG_MP2 (VDD I1_I120_G7_4n I1_c6_8 VDD) gpdk090_pmos1v w=0.24u l=0.1u ad=0.0936p as=0.0816p pd=0.92u ps=1.16u
    I_MXI1_I120_I36_XG_MP0 (XI1_I120_I36_XG_p1 I1_I120_P7_4n VDD VDD) gpdk090_pmos1v w=0.48u l=0.1u ad=0.1056p as=0.0936p pd=0.92u ps=0.92u
    I_MXI1_I120_I36_XG_MP1 (I1_c6_8 I1_I120_G3_0n XI1_I120_I36_XG_p1 VDD) gpdk090_pmos1v w=0.48u l=0.1u ad=0.1632p as=0.1056p pd=1.64u ps=0.92u
    I_MXI1_I120_I22_XG_MP2 (VDD I1_I120_gn4 I1_I120_G4_3 VDD) gpdk090_pmos1v w=0.24u l=0.1u ad=0.0936p as=0.0816p pd=0.92u ps=1.16u
    I_MXI1_I120_I22_XG_MP0 (XI1_I120_I22_XG_p1 I1_I120_pn4 VDD VDD) gpdk090_pmos1v w=0.48u l=0.1u ad=0.1056p as=0.0936p pd=0.92u ps=0.92u
    I_MXI1_I120_I22_XG_MP1 (I1_I120_G4_3 I1_I120_gn3 XI1_I120_I22_XG_p1 VDD) gpdk090_pmos1v w=0.48u l=0.1u ad=0.1632p as=0.1056p pd=1.64u ps=0.92u
    I_MXI1_I120_I21_XG_MP2 (VDD I1_I120_gn3 I1_I120_G3_2 VDD) gpdk090_pmos1v w=0.24u l=0.1u ad=0.0936p as=0.0816p pd=0.92u ps=1.16u
    I_MXI1_I120_I21_XG_MP0 (XI1_I120_I21_XG_p1 I1_I120_pn3 VDD VDD) gpdk090_pmos1v w=0.48u l=0.1u ad=0.1056p as=0.0936p pd=0.92u ps=0.92u
    I_MXI1_I120_I21_XG_MP1 (I1_I120_G3_2 I1_I120_gn2 XI1_I120_I21_XG_p1 VDD) gpdk090_pmos1v w=0.48u l=0.1u ad=0.1632p as=0.1056p pd=1.64u ps=0.92u
    I_MXI1_I120_I20_XG_MP2 (VDD I1_I120_gn2 I1_I120_G2_1 VDD) gpdk090_pmos1v w=0.24u l=0.1u ad=0.0936p as=0.0816p pd=0.92u ps=1.16u
    I_MXI1_I120_I20_XG_MP0 (XI1_I120_I20_XG_p1 I1_I120_pn2 VDD VDD) gpdk090_pmos1v w=0.48u l=0.1u ad=0.1056p as=0.0936p pd=0.92u ps=0.92u
    I_MXI1_I120_I20_XG_MP1 (I1_I120_G2_1 I1_I120_gn1 XI1_I120_I20_XG_p1 VDD) gpdk090_pmos1v w=0.48u l=0.1u ad=0.1632p as=0.1056p pd=1.64u ps=0.92u
    I_MXI1_I120_I25_XG_MP2 (VDD I1_I120_gn7 I1_I120_G7_6 VDD) gpdk090_pmos1v w=0.24u l=0.1u ad=0.0936p as=0.0816p pd=0.92u ps=1.16u
    I_MXI1_I120_I25_XG_MP0 (XI1_I120_I25_XG_p1 I1_I120_pn7 VDD VDD) gpdk090_pmos1v w=0.48u l=0.1u ad=0.1056p as=0.0936p pd=0.92u ps=0.92u
    I_MXI1_I120_I25_XG_MP1 (I1_I120_G7_6 I1_I120_gn6 XI1_I120_I25_XG_p1 VDD) gpdk090_pmos1v w=0.48u l=0.1u ad=0.1632p as=0.1056p pd=1.64u ps=0.92u
    I_MXI1_I120_I24_XG_MP2 (VDD I1_I120_gn6 I1_I120_G6_5 VDD) gpdk090_pmos1v w=0.24u l=0.1u ad=0.0936p as=0.0816p pd=0.92u ps=1.16u
    I_MXI1_I120_I24_XG_MP0 (XI1_I120_I24_XG_p1 I1_I120_pn6 VDD VDD) gpdk090_pmos1v w=0.48u l=0.1u ad=0.1056p as=0.0936p pd=0.92u ps=0.92u
    I_MXI1_I120_I24_XG_MP1 (I1_I120_G6_5 I1_I120_gn5 XI1_I120_I24_XG_p1 VDD) gpdk090_pmos1v w=0.48u l=0.1u ad=0.1632p as=0.1056p pd=1.64u ps=0.92u
    I_MXI1_I120_I23_XG_MP2 (VDD I1_I120_gn5 I1_I120_G5_4 VDD) gpdk090_pmos1v w=0.24u l=0.1u ad=0.0936p as=0.0816p pd=0.92u ps=1.16u
    I_MXI1_I120_I23_XG_MP0 (XI1_I120_I23_XG_p1 I1_I120_pn5 VDD VDD) gpdk090_pmos1v w=0.48u l=0.1u ad=0.1056p as=0.0936p pd=0.92u ps=0.92u
    I_MXI1_I120_I23_XG_MP1 (I1_I120_G5_4 I1_I120_gn4 XI1_I120_I23_XG_p1 VDD) gpdk090_pmos1v w=0.48u l=0.1u ad=0.1632p as=0.1056p pd=1.64u ps=0.92u
    I_MXI1_I108_I17_XG_MP2 (VDD I1_I108_gn0 I1_I108_G0_0 VDD) gpdk090_pmos1v w=0.24u l=0.1u ad=0.0936p as=0.0816p pd=0.92u ps=1.16u
    I_MXI1_I108_I17_XG_MP0 (XI1_I108_I17_XG_p1 I1_I108_pn0 VDD VDD) gpdk090_pmos1v w=0.48u l=0.1u ad=0.1056p as=0.0936p pd=0.92u ps=0.92u
    I_MXI1_I108_I17_XG_MP1 (I1_I108_G0_0 I1_I108_cinn XI1_I108_I17_XG_p1 VDD) gpdk090_pmos1v w=0.48u l=0.1u ad=0.1632p as=0.1056p pd=1.64u ps=0.92u
    I_MXI1_I108_I19_XG_MP2 (VDD I1_I108_gn1 I1_I108_G1_0 VDD) gpdk090_pmos1v w=0.24u l=0.1u ad=0.0936p as=0.0816p pd=0.92u ps=1.16u
    I_MXI1_I108_I19_XG_MP0 (XI1_I108_I19_XG_p1 I1_I108_pn1 VDD VDD) gpdk090_pmos1v w=0.48u l=0.1u ad=0.1056p as=0.0936p pd=0.92u ps=0.92u
    I_MXI1_I108_I19_XG_MP1 (I1_I108_G1_0 I1_I108_G0_0n XI1_I108_I19_XG_p1 VDD) gpdk090_pmos1v w=0.48u l=0.1u ad=0.1632p as=0.1056p pd=1.64u ps=0.92u
    I_MXI1_I96_I17_XG_MP2 (VDD I1_I96_gn0 I1_I96_G0_0 VDD) gpdk090_pmos1v w=0.24u l=0.1u ad=0.0936p as=0.0816p pd=0.92u ps=1.16u
    I_MXI1_I96_I17_XG_MP0 (XI1_I96_I17_XG_p1 I1_I96_pn0 VDD VDD) gpdk090_pmos1v w=0.48u l=0.1u ad=0.1056p as=0.0936p pd=0.92u ps=0.92u
    I_MXI1_I96_I17_XG_MP1 (I1_I96_G0_0 I1_I96_cinn XI1_I96_I17_XG_p1 VDD) gpdk090_pmos1v w=0.48u l=0.1u ad=0.1632p as=0.1056p pd=1.64u ps=0.92u
    I_MXI1_I84_I17_XG_MP2 (VDD I1_I84_gn0 I1_I84_G0_0 VDD) gpdk090_pmos1v w=0.24u l=0.1u ad=0.0936p as=0.0816p pd=0.92u ps=1.16u
    I_MXI1_I84_I17_XG_MP0 (XI1_I84_I17_XG_p1 I1_I84_pn0 VDD VDD) gpdk090_pmos1v w=0.48u l=0.1u ad=0.1056p as=0.0936p pd=0.92u ps=0.92u
    I_MXI1_I84_I17_XG_MP1 (I1_I84_G0_0 I1_I84_cinn XI1_I84_I17_XG_p1 VDD) gpdk090_pmos1v w=0.48u l=0.1u ad=0.1632p as=0.1056p pd=1.64u ps=0.92u
    I_MXI1_I108_I32_XG_MP2 (VDD I1_I108_G4_1n I1_I108_G4_0 VDD) gpdk090_pmos1v w=0.24u l=0.1u ad=0.0936p as=0.0816p pd=0.92u ps=1.16u
    I_MXI1_I108_I32_XG_MP0 (XI1_I108_I32_XG_p1 I1_I108_P4_1n VDD VDD) gpdk090_pmos1v w=0.48u l=0.1u ad=0.1056p as=0.0936p pd=0.92u ps=0.92u
    I_MXI1_I108_I32_XG_MP1 (I1_I108_G4_0 I1_I108_G0_0n XI1_I108_I32_XG_p1 VDD) gpdk090_pmos1v w=0.48u l=0.1u ad=0.1632p as=0.1056p pd=1.64u ps=0.92u
    I_MXI1_I108_I20_XG_MP2 (VDD I1_I108_gn2 I1_I108_G2_1 VDD) gpdk090_pmos1v w=0.24u l=0.1u ad=0.0936p as=0.0816p pd=0.92u ps=1.16u
    I_MXI1_I108_I20_XG_MP0 (XI1_I108_I20_XG_p1 I1_I108_pn2 VDD VDD) gpdk090_pmos1v w=0.48u l=0.1u ad=0.1056p as=0.0936p pd=0.92u ps=0.92u
    I_MXI1_I108_I20_XG_MP1 (I1_I108_G2_1 I1_I108_gn1 XI1_I108_I20_XG_p1 VDD) gpdk090_pmos1v w=0.48u l=0.1u ad=0.1632p as=0.1056p pd=1.64u ps=0.92u
    I_MXI1_I72_I17_XG_MP2 (VDD I1_I72_gn0 I1_I72_G0_0 VDD) gpdk090_pmos1v w=0.24u l=0.1u ad=0.0936p as=0.0816p pd=0.92u ps=1.16u
    I_MXI1_I72_I17_XG_MP0 (XI1_I72_I17_XG_p1 I1_I72_pn0 VDD VDD) gpdk090_pmos1v w=0.48u l=0.1u ad=0.1056p as=0.0936p pd=0.92u ps=0.92u
    I_MXI1_I72_I17_XG_MP1 (I1_I72_G0_0 I1_I72_cinn XI1_I72_I17_XG_p1 VDD) gpdk090_pmos1v w=0.48u l=0.1u ad=0.1632p as=0.1056p pd=1.64u ps=0.92u
    I_MXI1_I60_I17_XG_MP2 (VDD I1_I60_gn0 I1_I60_G0_0 VDD) gpdk090_pmos1v w=0.24u l=0.1u ad=0.0936p as=0.0816p pd=0.92u ps=1.16u
    I_MXI1_I60_I17_XG_MP0 (XI1_I60_I17_XG_p1 I1_I60_pn0 VDD VDD) gpdk090_pmos1v w=0.48u l=0.1u ad=0.1056p as=0.0936p pd=0.92u ps=0.92u
    I_MXI1_I60_I17_XG_MP1 (I1_I60_G0_0 I1_I60_cinn XI1_I60_I17_XG_p1 VDD) gpdk090_pmos1v w=0.48u l=0.1u ad=0.1632p as=0.1056p pd=1.64u ps=0.92u
    I_MXI1_I48_I17_XG_MP2 (VDD I1_I48_gn0 I1_I48_G0_0 VDD) gpdk090_pmos1v w=0.24u l=0.1u ad=0.0936p as=0.0816p pd=0.92u ps=1.16u
    I_MXI1_I48_I17_XG_MP0 (XI1_I48_I17_XG_p1 I1_I48_pn0 VDD VDD) gpdk090_pmos1v w=0.48u l=0.1u ad=0.1056p as=0.0936p pd=0.92u ps=0.92u
    I_MXI1_I48_I17_XG_MP1 (I1_I48_G0_0 I1_I48_cinn XI1_I48_I17_XG_p1 VDD) gpdk090_pmos1v w=0.48u l=0.1u ad=0.1632p as=0.1056p pd=1.64u ps=0.92u
    I_MXI1_I108_I35_XG_MP2 (VDD I1_I108_G6_3n I1_c5_7 VDD) gpdk090_pmos1v w=0.24u l=0.1u ad=0.0936p as=0.0816p pd=0.92u ps=1.16u
    I_MXI1_I108_I35_XG_MP0 (XI1_I108_I35_XG_p1 I1_I108_P6_3n VDD VDD) gpdk090_pmos1v w=0.48u l=0.1u ad=0.1056p as=0.0936p pd=0.92u ps=0.92u
    I_MXI1_I108_I35_XG_MP1 (I1_c5_7 I1_I108_G2_0n XI1_I108_I35_XG_p1 VDD) gpdk090_pmos1v w=0.48u l=0.1u ad=0.1632p as=0.1056p pd=1.64u ps=0.92u
    I_MXI1_I108_I22_XG_MP2 (VDD I1_I108_gn4 I1_I108_G4_3 VDD) gpdk090_pmos1v w=0.24u l=0.1u ad=0.0936p as=0.0816p pd=0.92u ps=1.16u
    I_MXI1_I108_I22_XG_MP0 (XI1_I108_I22_XG_p1 I1_I108_pn4 VDD VDD) gpdk090_pmos1v w=0.48u l=0.1u ad=0.1056p as=0.0936p pd=0.92u ps=0.92u
    I_MXI1_I108_I22_XG_MP1 (I1_I108_G4_3 I1_I108_gn3 XI1_I108_I22_XG_p1 VDD) gpdk090_pmos1v w=0.48u l=0.1u ad=0.1632p as=0.1056p pd=1.64u ps=0.92u
    I_MXI1_I108_I21_XG_MP2 (VDD I1_I108_gn3 I1_I108_G3_2 VDD) gpdk090_pmos1v w=0.24u l=0.1u ad=0.0936p as=0.0816p pd=0.92u ps=1.16u
    I_MXI1_I108_I21_XG_MP0 (XI1_I108_I21_XG_p1 I1_I108_pn3 VDD VDD) gpdk090_pmos1v w=0.48u l=0.1u ad=0.1056p as=0.0936p pd=0.92u ps=0.92u
    I_MXI1_I108_I21_XG_MP1 (I1_I108_G3_2 I1_I108_gn2 XI1_I108_I21_XG_p1 VDD) gpdk090_pmos1v w=0.48u l=0.1u ad=0.1632p as=0.1056p pd=1.64u ps=0.92u
    I_MXI1_I84_I19_XG_MP2 (VDD I1_I84_gn1 I1_I84_G1_0 VDD) gpdk090_pmos1v w=0.24u l=0.1u ad=0.0936p as=0.0816p pd=0.92u ps=1.16u
    I_MXI1_I84_I19_XG_MP0 (XI1_I84_I19_XG_p1 I1_I84_pn1 VDD VDD) gpdk090_pmos1v w=0.48u l=0.1u ad=0.1056p as=0.0936p pd=0.92u ps=0.92u
    I_MXI1_I84_I19_XG_MP1 (I1_I84_G1_0 I1_I84_G0_0n XI1_I84_I19_XG_p1 VDD) gpdk090_pmos1v w=0.48u l=0.1u ad=0.1632p as=0.1056p pd=1.64u ps=0.92u
    I_MXI1_I84_I20_XG_MP2 (VDD I1_I84_gn2 I1_I84_G2_1 VDD) gpdk090_pmos1v w=0.24u l=0.1u ad=0.0936p as=0.0816p pd=0.92u ps=1.16u
    I_MXI1_I84_I20_XG_MP0 (XI1_I84_I20_XG_p1 I1_I84_pn2 VDD VDD) gpdk090_pmos1v w=0.48u l=0.1u ad=0.1056p as=0.0936p pd=0.92u ps=0.92u
    I_MXI1_I84_I20_XG_MP1 (I1_I84_G2_1 I1_I84_gn1 XI1_I84_I20_XG_p1 VDD) gpdk090_pmos1v w=0.48u l=0.1u ad=0.1632p as=0.1056p pd=1.64u ps=0.92u
    I_MXI1_I72_I19_XG_MP2 (VDD I1_I72_gn1 I1_I72_G1_0 VDD) gpdk090_pmos1v w=0.24u l=0.1u ad=0.0936p as=0.0816p pd=0.92u ps=1.16u
    I_MXI1_I72_I19_XG_MP0 (XI1_I72_I19_XG_p1 I1_I72_pn1 VDD VDD) gpdk090_pmos1v w=0.48u l=0.1u ad=0.1056p as=0.0936p pd=0.92u ps=0.92u
    I_MXI1_I72_I19_XG_MP1 (I1_I72_G1_0 I1_I72_G0_0n XI1_I72_I19_XG_p1 VDD) gpdk090_pmos1v w=0.48u l=0.1u ad=0.1632p as=0.1056p pd=1.64u ps=0.92u
    I_MXI1_I48_I19_XG_MP2 (VDD I1_I48_gn1 I1_I48_G1_0 VDD) gpdk090_pmos1v w=0.24u l=0.1u ad=0.0936p as=0.0816p pd=0.92u ps=1.16u
    I_MXI1_I48_I19_XG_MP0 (XI1_I48_I19_XG_p1 I1_I48_pn1 VDD VDD) gpdk090_pmos1v w=0.48u l=0.1u ad=0.1056p as=0.0936p pd=0.92u ps=0.92u
    I_MXI1_I48_I19_XG_MP1 (I1_I48_G1_0 I1_I48_G0_0n XI1_I48_I19_XG_p1 VDD) gpdk090_pmos1v w=0.48u l=0.1u ad=0.1632p as=0.1056p pd=1.64u ps=0.92u
    I_MXI1_I48_I20_XG_MP2 (VDD I1_I48_gn2 I1_I48_G2_1 VDD) gpdk090_pmos1v w=0.24u l=0.1u ad=0.0936p as=0.0816p pd=0.92u ps=1.16u
    I_MXI1_I48_I20_XG_MP0 (XI1_I48_I20_XG_p1 I1_I48_pn2 VDD VDD) gpdk090_pmos1v w=0.48u l=0.1u ad=0.1056p as=0.0936p pd=0.92u ps=0.92u
    I_MXI1_I48_I20_XG_MP1 (I1_I48_G2_1 I1_I48_gn1 XI1_I48_I20_XG_p1 VDD) gpdk090_pmos1v w=0.48u l=0.1u ad=0.1632p as=0.1056p pd=1.64u ps=0.92u
    I_MXI1_I48_I21_XG_MP2 (VDD I1_I48_gn3 I1_I48_G3_2 VDD) gpdk090_pmos1v w=0.24u l=0.1u ad=0.0936p as=0.0816p pd=0.92u ps=1.16u
    I_MXI1_I48_I21_XG_MP0 (XI1_I48_I21_XG_p1 I1_I48_pn3 VDD VDD) gpdk090_pmos1v w=0.48u l=0.1u ad=0.1056p as=0.0936p pd=0.92u ps=0.92u
    I_MXI1_I48_I21_XG_MP1 (I1_I48_G3_2 I1_I48_gn2 XI1_I48_I21_XG_p1 VDD) gpdk090_pmos1v w=0.48u l=0.1u ad=0.1632p as=0.1056p pd=1.64u ps=0.92u
    I_MXI1_I108_I34_XG_MP2 (VDD I1_I108_G5_2n I1_I108_G5_0 VDD) gpdk090_pmos1v w=0.24u l=0.1u ad=0.0936p as=0.0816p pd=0.92u ps=1.16u
    I_MXI1_I108_I34_XG_MP0 (XI1_I108_I34_XG_p1 I1_I108_P5_2n VDD VDD) gpdk090_pmos1v w=0.48u l=0.1u ad=0.1056p as=0.0936p pd=0.92u ps=0.92u
    I_MXI1_I108_I34_XG_MP1 (I1_I108_G5_0 I1_I108_G1_0n XI1_I108_I34_XG_p1 VDD) gpdk090_pmos1v w=0.48u l=0.1u ad=0.1632p as=0.1056p pd=1.64u ps=0.92u
    I_MXI1_I108_I36_XG_MP2 (VDD I1_I108_G7_4n I1_c5_8 VDD) gpdk090_pmos1v w=0.24u l=0.1u ad=0.0936p as=0.0816p pd=0.92u ps=1.16u
    I_MXI1_I108_I36_XG_MP0 (XI1_I108_I36_XG_p1 I1_I108_P7_4n VDD VDD) gpdk090_pmos1v w=0.48u l=0.1u ad=0.1056p as=0.0936p pd=0.92u ps=0.92u
    I_MXI1_I108_I36_XG_MP1 (I1_c5_8 I1_I108_G3_0n XI1_I108_I36_XG_p1 VDD) gpdk090_pmos1v w=0.48u l=0.1u ad=0.1632p as=0.1056p pd=1.64u ps=0.92u
    I_MXI1_I96_I19_XG_MP2 (VDD I1_I96_gn1 I1_I96_G1_0 VDD) gpdk090_pmos1v w=0.24u l=0.1u ad=0.0936p as=0.0816p pd=0.92u ps=1.16u
    I_MXI1_I96_I19_XG_MP0 (XI1_I96_I19_XG_p1 I1_I96_pn1 VDD VDD) gpdk090_pmos1v w=0.48u l=0.1u ad=0.1056p as=0.0936p pd=0.92u ps=0.92u
    I_MXI1_I96_I19_XG_MP1 (I1_I96_G1_0 I1_I96_G0_0n XI1_I96_I19_XG_p1 VDD) gpdk090_pmos1v w=0.48u l=0.1u ad=0.1632p as=0.1056p pd=1.64u ps=0.92u
    I_MXI1_I96_I20_XG_MP2 (VDD I1_I96_gn2 I1_I96_G2_1 VDD) gpdk090_pmos1v w=0.24u l=0.1u ad=0.0936p as=0.0816p pd=0.92u ps=1.16u
    I_MXI1_I96_I20_XG_MP0 (XI1_I96_I20_XG_p1 I1_I96_pn2 VDD VDD) gpdk090_pmos1v w=0.48u l=0.1u ad=0.1056p as=0.0936p pd=0.92u ps=0.92u
    I_MXI1_I96_I20_XG_MP1 (I1_I96_G2_1 I1_I96_gn1 XI1_I96_I20_XG_p1 VDD) gpdk090_pmos1v w=0.48u l=0.1u ad=0.1632p as=0.1056p pd=1.64u ps=0.92u
    I_MXI1_I84_I32_XG_MP2 (VDD I1_I84_G4_1n I1_I84_G4_0 VDD) gpdk090_pmos1v w=0.24u l=0.1u ad=0.0936p as=0.0816p pd=0.92u ps=1.16u
    I_MXI1_I84_I32_XG_MP0 (XI1_I84_I32_XG_p1 I1_I84_P4_1n VDD VDD) gpdk090_pmos1v w=0.48u l=0.1u ad=0.1056p as=0.0936p pd=0.92u ps=0.92u
    I_MXI1_I84_I32_XG_MP1 (I1_I84_G4_0 I1_I84_G0_0n XI1_I84_I32_XG_p1 VDD) gpdk090_pmos1v w=0.48u l=0.1u ad=0.1632p as=0.1056p pd=1.64u ps=0.92u
    I_MXI1_I84_I21_XG_MP2 (VDD I1_I84_gn3 I1_I84_G3_2 VDD) gpdk090_pmos1v w=0.24u l=0.1u ad=0.0936p as=0.0816p pd=0.92u ps=1.16u
    I_MXI1_I84_I21_XG_MP0 (XI1_I84_I21_XG_p1 I1_I84_pn3 VDD VDD) gpdk090_pmos1v w=0.48u l=0.1u ad=0.1056p as=0.0936p pd=0.92u ps=0.92u
    I_MXI1_I84_I21_XG_MP1 (I1_I84_G3_2 I1_I84_gn2 XI1_I84_I21_XG_p1 VDD) gpdk090_pmos1v w=0.48u l=0.1u ad=0.1632p as=0.1056p pd=1.64u ps=0.92u
    I_MXI1_I72_I32_XG_MP2 (VDD I1_I72_G4_1n I1_I72_G4_0 VDD) gpdk090_pmos1v w=0.24u l=0.1u ad=0.0936p as=0.0816p pd=0.92u ps=1.16u
    I_MXI1_I72_I32_XG_MP0 (XI1_I72_I32_XG_p1 I1_I72_P4_1n VDD VDD) gpdk090_pmos1v w=0.48u l=0.1u ad=0.1056p as=0.0936p pd=0.92u ps=0.92u
    I_MXI1_I72_I32_XG_MP1 (I1_I72_G4_0 I1_I72_G0_0n XI1_I72_I32_XG_p1 VDD) gpdk090_pmos1v w=0.48u l=0.1u ad=0.1632p as=0.1056p pd=1.64u ps=0.92u
    I_MXI1_I72_I20_XG_MP2 (VDD I1_I72_gn2 I1_I72_G2_1 VDD) gpdk090_pmos1v w=0.24u l=0.1u ad=0.0936p as=0.0816p pd=0.92u ps=1.16u
    I_MXI1_I72_I20_XG_MP0 (XI1_I72_I20_XG_p1 I1_I72_pn2 VDD VDD) gpdk090_pmos1v w=0.48u l=0.1u ad=0.1056p as=0.0936p pd=0.92u ps=0.92u
    I_MXI1_I72_I20_XG_MP1 (I1_I72_G2_1 I1_I72_gn1 XI1_I72_I20_XG_p1 VDD) gpdk090_pmos1v w=0.48u l=0.1u ad=0.1632p as=0.1056p pd=1.64u ps=0.92u
    I_MXI1_I60_I19_XG_MP2 (VDD I1_I60_gn1 I1_I60_G1_0 VDD) gpdk090_pmos1v w=0.24u l=0.1u ad=0.0936p as=0.0816p pd=0.92u ps=1.16u
    I_MXI1_I60_I19_XG_MP0 (XI1_I60_I19_XG_p1 I1_I60_pn1 VDD VDD) gpdk090_pmos1v w=0.48u l=0.1u ad=0.1056p as=0.0936p pd=0.92u ps=0.92u
    I_MXI1_I60_I19_XG_MP1 (I1_I60_G1_0 I1_I60_G0_0n XI1_I60_I19_XG_p1 VDD) gpdk090_pmos1v w=0.48u l=0.1u ad=0.1632p as=0.1056p pd=1.64u ps=0.92u
    I_MXI1_I60_I20_XG_MP2 (VDD I1_I60_gn2 I1_I60_G2_1 VDD) gpdk090_pmos1v w=0.24u l=0.1u ad=0.0936p as=0.0816p pd=0.92u ps=1.16u
    I_MXI1_I60_I20_XG_MP0 (XI1_I60_I20_XG_p1 I1_I60_pn2 VDD VDD) gpdk090_pmos1v w=0.48u l=0.1u ad=0.1056p as=0.0936p pd=0.92u ps=0.92u
    I_MXI1_I60_I20_XG_MP1 (I1_I60_G2_1 I1_I60_gn1 XI1_I60_I20_XG_p1 VDD) gpdk090_pmos1v w=0.48u l=0.1u ad=0.1632p as=0.1056p pd=1.64u ps=0.92u
    I_MXI1_I48_I32_XG_MP2 (VDD I1_I48_G4_1n I1_I48_G4_0 VDD) gpdk090_pmos1v w=0.24u l=0.1u ad=0.0936p as=0.0816p pd=0.92u ps=1.16u
    I_MXI1_I48_I32_XG_MP0 (XI1_I48_I32_XG_p1 I1_I48_P4_1n VDD VDD) gpdk090_pmos1v w=0.48u l=0.1u ad=0.1056p as=0.0936p pd=0.92u ps=0.92u
    I_MXI1_I48_I32_XG_MP1 (I1_I48_G4_0 I1_I48_G0_0n XI1_I48_I32_XG_p1 VDD) gpdk090_pmos1v w=0.48u l=0.1u ad=0.1632p as=0.1056p pd=1.64u ps=0.92u
    I_MXI1_I48_I22_XG_MP2 (VDD I1_I48_gn4 I1_I48_G4_3 VDD) gpdk090_pmos1v w=0.24u l=0.1u ad=0.0936p as=0.0816p pd=0.92u ps=1.16u
    I_MXI1_I48_I22_XG_MP0 (XI1_I48_I22_XG_p1 I1_I48_pn4 VDD VDD) gpdk090_pmos1v w=0.48u l=0.1u ad=0.1056p as=0.0936p pd=0.92u ps=0.92u
    I_MXI1_I48_I22_XG_MP1 (I1_I48_G4_3 I1_I48_gn3 XI1_I48_I22_XG_p1 VDD) gpdk090_pmos1v w=0.48u l=0.1u ad=0.1632p as=0.1056p pd=1.64u ps=0.92u
    I_MXI1_I108_I24_XG_MP2 (VDD I1_I108_gn6 I1_I108_G6_5 VDD) gpdk090_pmos1v w=0.24u l=0.1u ad=0.0936p as=0.0816p pd=0.92u ps=1.16u
    I_MXI1_I108_I24_XG_MP0 (XI1_I108_I24_XG_p1 I1_I108_pn6 VDD VDD) gpdk090_pmos1v w=0.48u l=0.1u ad=0.1056p as=0.0936p pd=0.92u ps=0.92u
    I_MXI1_I108_I24_XG_MP1 (I1_I108_G6_5 I1_I108_gn5 XI1_I108_I24_XG_p1 VDD) gpdk090_pmos1v w=0.48u l=0.1u ad=0.1632p as=0.1056p pd=1.64u ps=0.92u
    I_MXI1_I108_I23_XG_MP2 (VDD I1_I108_gn5 I1_I108_G5_4 VDD) gpdk090_pmos1v w=0.24u l=0.1u ad=0.0936p as=0.0816p pd=0.92u ps=1.16u
    I_MXI1_I108_I23_XG_MP0 (XI1_I108_I23_XG_p1 I1_I108_pn5 VDD VDD) gpdk090_pmos1v w=0.48u l=0.1u ad=0.1056p as=0.0936p pd=0.92u ps=0.92u
    I_MXI1_I108_I23_XG_MP1 (I1_I108_G5_4 I1_I108_gn4 XI1_I108_I23_XG_p1 VDD) gpdk090_pmos1v w=0.48u l=0.1u ad=0.1632p as=0.1056p pd=1.64u ps=0.92u
    I_MXI1_I96_I32_XG_MP2 (VDD I1_I96_G4_1n I1_I96_G4_0 VDD) gpdk090_pmos1v w=0.24u l=0.1u ad=0.0936p as=0.0816p pd=0.92u ps=1.16u
    I_MXI1_I96_I32_XG_MP0 (XI1_I96_I32_XG_p1 I1_I96_P4_1n VDD VDD) gpdk090_pmos1v w=0.48u l=0.1u ad=0.1056p as=0.0936p pd=0.92u ps=0.92u
    I_MXI1_I96_I32_XG_MP1 (I1_I96_G4_0 I1_I96_G0_0n XI1_I96_I32_XG_p1 VDD) gpdk090_pmos1v w=0.48u l=0.1u ad=0.1632p as=0.1056p pd=1.64u ps=0.92u
    I_MXI1_I96_I22_XG_MP2 (VDD I1_I96_gn4 I1_I96_G4_3 VDD) gpdk090_pmos1v w=0.24u l=0.1u ad=0.0936p as=0.0816p pd=0.92u ps=1.16u
    I_MXI1_I96_I22_XG_MP0 (XI1_I96_I22_XG_p1 I1_I96_pn4 VDD VDD) gpdk090_pmos1v w=0.48u l=0.1u ad=0.1056p as=0.0936p pd=0.92u ps=0.92u
    I_MXI1_I96_I22_XG_MP1 (I1_I96_G4_3 I1_I96_gn3 XI1_I96_I22_XG_p1 VDD) gpdk090_pmos1v w=0.48u l=0.1u ad=0.1632p as=0.1056p pd=1.64u ps=0.92u
    I_MXI1_I96_I21_XG_MP2 (VDD I1_I96_gn3 I1_I96_G3_2 VDD) gpdk090_pmos1v w=0.24u l=0.1u ad=0.0936p as=0.0816p pd=0.92u ps=1.16u
    I_MXI1_I96_I21_XG_MP0 (XI1_I96_I21_XG_p1 I1_I96_pn3 VDD VDD) gpdk090_pmos1v w=0.48u l=0.1u ad=0.1056p as=0.0936p pd=0.92u ps=0.92u
    I_MXI1_I96_I21_XG_MP1 (I1_I96_G3_2 I1_I96_gn2 XI1_I96_I21_XG_p1 VDD) gpdk090_pmos1v w=0.48u l=0.1u ad=0.1632p as=0.1056p pd=1.64u ps=0.92u
    I_MXI1_I84_I22_XG_MP2 (VDD I1_I84_gn4 I1_I84_G4_3 VDD) gpdk090_pmos1v w=0.24u l=0.1u ad=0.0936p as=0.0816p pd=0.92u ps=1.16u
    I_MXI1_I84_I22_XG_MP0 (XI1_I84_I22_XG_p1 I1_I84_pn4 VDD VDD) gpdk090_pmos1v w=0.48u l=0.1u ad=0.1056p as=0.0936p pd=0.92u ps=0.92u
    I_MXI1_I84_I22_XG_MP1 (I1_I84_G4_3 I1_I84_gn3 XI1_I84_I22_XG_p1 VDD) gpdk090_pmos1v w=0.48u l=0.1u ad=0.1632p as=0.1056p pd=1.64u ps=0.92u
    I_MXI1_I72_I35_XG_MP2 (VDD I1_I72_G6_3n I1_c2_7 VDD) gpdk090_pmos1v w=0.24u l=0.1u ad=0.0936p as=0.0816p pd=0.92u ps=1.16u
    I_MXI1_I72_I35_XG_MP0 (XI1_I72_I35_XG_p1 I1_I72_P6_3n VDD VDD) gpdk090_pmos1v w=0.48u l=0.1u ad=0.1056p as=0.0936p pd=0.92u ps=0.92u
    I_MXI1_I72_I35_XG_MP1 (I1_c2_7 I1_I72_G2_0n XI1_I72_I35_XG_p1 VDD) gpdk090_pmos1v w=0.48u l=0.1u ad=0.1632p as=0.1056p pd=1.64u ps=0.92u
    I_MXI1_I72_I21_XG_MP2 (VDD I1_I72_gn3 I1_I72_G3_2 VDD) gpdk090_pmos1v w=0.24u l=0.1u ad=0.0936p as=0.0816p pd=0.92u ps=1.16u
    I_MXI1_I72_I21_XG_MP0 (XI1_I72_I21_XG_p1 I1_I72_pn3 VDD VDD) gpdk090_pmos1v w=0.48u l=0.1u ad=0.1056p as=0.0936p pd=0.92u ps=0.92u
    I_MXI1_I72_I21_XG_MP1 (I1_I72_G3_2 I1_I72_gn2 XI1_I72_I21_XG_p1 VDD) gpdk090_pmos1v w=0.48u l=0.1u ad=0.1632p as=0.1056p pd=1.64u ps=0.92u
    I_MXI1_I72_I22_XG_MP2 (VDD I1_I72_gn4 I1_I72_G4_3 VDD) gpdk090_pmos1v w=0.24u l=0.1u ad=0.0936p as=0.0816p pd=0.92u ps=1.16u
    I_MXI1_I72_I22_XG_MP0 (XI1_I72_I22_XG_p1 I1_I72_pn4 VDD VDD) gpdk090_pmos1v w=0.48u l=0.1u ad=0.1056p as=0.0936p pd=0.92u ps=0.92u
    I_MXI1_I72_I22_XG_MP1 (I1_I72_G4_3 I1_I72_gn3 XI1_I72_I22_XG_p1 VDD) gpdk090_pmos1v w=0.48u l=0.1u ad=0.1632p as=0.1056p pd=1.64u ps=0.92u
    I_MXI1_I60_I32_XG_MP2 (VDD I1_I60_G4_1n I1_I60_G4_0 VDD) gpdk090_pmos1v w=0.24u l=0.1u ad=0.0936p as=0.0816p pd=0.92u ps=1.16u
    I_MXI1_I60_I32_XG_MP0 (XI1_I60_I32_XG_p1 I1_I60_P4_1n VDD VDD) gpdk090_pmos1v w=0.48u l=0.1u ad=0.1056p as=0.0936p pd=0.92u ps=0.92u
    I_MXI1_I60_I32_XG_MP1 (I1_I60_G4_0 I1_I60_G0_0n XI1_I60_I32_XG_p1 VDD) gpdk090_pmos1v w=0.48u l=0.1u ad=0.1632p as=0.1056p pd=1.64u ps=0.92u
    I_MXI1_I60_I35_XG_MP2 (VDD I1_I60_G6_3n I1_c1_7 VDD) gpdk090_pmos1v w=0.24u l=0.1u ad=0.0936p as=0.0816p pd=0.92u ps=1.16u
    I_MXI1_I60_I35_XG_MP0 (XI1_I60_I35_XG_p1 I1_I60_P6_3n VDD VDD) gpdk090_pmos1v w=0.48u l=0.1u ad=0.1056p as=0.0936p pd=0.92u ps=0.92u
    I_MXI1_I60_I35_XG_MP1 (I1_c1_7 I1_I60_G2_0n XI1_I60_I35_XG_p1 VDD) gpdk090_pmos1v w=0.48u l=0.1u ad=0.1632p as=0.1056p pd=1.64u ps=0.92u
    I_MXI1_I60_I21_XG_MP2 (VDD I1_I60_gn3 I1_I60_G3_2 VDD) gpdk090_pmos1v w=0.24u l=0.1u ad=0.0936p as=0.0816p pd=0.92u ps=1.16u
    I_MXI1_I60_I21_XG_MP0 (XI1_I60_I21_XG_p1 I1_I60_pn3 VDD VDD) gpdk090_pmos1v w=0.48u l=0.1u ad=0.1056p as=0.0936p pd=0.92u ps=0.92u
    I_MXI1_I60_I21_XG_MP1 (I1_I60_G3_2 I1_I60_gn2 XI1_I60_I21_XG_p1 VDD) gpdk090_pmos1v w=0.48u l=0.1u ad=0.1632p as=0.1056p pd=1.64u ps=0.92u
    I_MXI1_I60_I22_XG_MP2 (VDD I1_I60_gn4 I1_I60_G4_3 VDD) gpdk090_pmos1v w=0.24u l=0.1u ad=0.0936p as=0.0816p pd=0.92u ps=1.16u
    I_MXI1_I60_I22_XG_MP0 (XI1_I60_I22_XG_p1 I1_I60_pn4 VDD VDD) gpdk090_pmos1v w=0.48u l=0.1u ad=0.1056p as=0.0936p pd=0.92u ps=0.92u
    I_MXI1_I60_I22_XG_MP1 (I1_I60_G4_3 I1_I60_gn3 XI1_I60_I22_XG_p1 VDD) gpdk090_pmos1v w=0.48u l=0.1u ad=0.1632p as=0.1056p pd=1.64u ps=0.92u
    I_MXI1_I48_I35_XG_MP2 (VDD I1_I48_G6_3n I1_c0_7 VDD) gpdk090_pmos1v w=0.24u l=0.1u ad=0.0936p as=0.0816p pd=0.92u ps=1.16u
    I_MXI1_I48_I35_XG_MP0 (XI1_I48_I35_XG_p1 I1_I48_P6_3n VDD VDD) gpdk090_pmos1v w=0.48u l=0.1u ad=0.1056p as=0.0936p pd=0.92u ps=0.92u
    I_MXI1_I48_I35_XG_MP1 (I1_c0_7 I1_I48_G2_0n XI1_I48_I35_XG_p1 VDD) gpdk090_pmos1v w=0.48u l=0.1u ad=0.1632p as=0.1056p pd=1.64u ps=0.92u
    I_MXI1_I48_I34_XG_MP2 (VDD I1_I48_G5_2n I1_I48_G5_0 VDD) gpdk090_pmos1v w=0.24u l=0.1u ad=0.0936p as=0.0816p pd=0.92u ps=1.16u
    I_MXI1_I48_I34_XG_MP0 (XI1_I48_I34_XG_p1 I1_I48_P5_2n VDD VDD) gpdk090_pmos1v w=0.48u l=0.1u ad=0.1056p as=0.0936p pd=0.92u ps=0.92u
    I_MXI1_I48_I34_XG_MP1 (I1_I48_G5_0 I1_I48_G1_0n XI1_I48_I34_XG_p1 VDD) gpdk090_pmos1v w=0.48u l=0.1u ad=0.1632p as=0.1056p pd=1.64u ps=0.92u
    I_MXI1_I108_I25_XG_MP2 (VDD I1_I108_gn7 I1_I108_G7_6 VDD) gpdk090_pmos1v w=0.24u l=0.1u ad=0.0936p as=0.0816p pd=0.92u ps=1.16u
    I_MXI1_I108_I25_XG_MP0 (XI1_I108_I25_XG_p1 I1_I108_pn7 VDD VDD) gpdk090_pmos1v w=0.48u l=0.1u ad=0.1056p as=0.0936p pd=0.92u ps=0.92u
    I_MXI1_I108_I25_XG_MP1 (I1_I108_G7_6 I1_I108_gn6 XI1_I108_I25_XG_p1 VDD) gpdk090_pmos1v w=0.48u l=0.1u ad=0.1632p as=0.1056p pd=1.64u ps=0.92u
    I_MXI1_I96_I35_XG_MP2 (VDD I1_I96_G6_3n I1_c4_7 VDD) gpdk090_pmos1v w=0.24u l=0.1u ad=0.0936p as=0.0816p pd=0.92u ps=1.16u
    I_MXI1_I96_I35_XG_MP0 (XI1_I96_I35_XG_p1 I1_I96_P6_3n VDD VDD) gpdk090_pmos1v w=0.48u l=0.1u ad=0.1056p as=0.0936p pd=0.92u ps=0.92u
    I_MXI1_I96_I35_XG_MP1 (I1_c4_7 I1_I96_G2_0n XI1_I96_I35_XG_p1 VDD) gpdk090_pmos1v w=0.48u l=0.1u ad=0.1632p as=0.1056p pd=1.64u ps=0.92u
    I_MXI1_I96_I24_XG_MP2 (VDD I1_I96_gn6 I1_I96_G6_5 VDD) gpdk090_pmos1v w=0.24u l=0.1u ad=0.0936p as=0.0816p pd=0.92u ps=1.16u
    I_MXI1_I96_I24_XG_MP0 (XI1_I96_I24_XG_p1 I1_I96_pn6 VDD VDD) gpdk090_pmos1v w=0.48u l=0.1u ad=0.1056p as=0.0936p pd=0.92u ps=0.92u
    I_MXI1_I96_I24_XG_MP1 (I1_I96_G6_5 I1_I96_gn5 XI1_I96_I24_XG_p1 VDD) gpdk090_pmos1v w=0.48u l=0.1u ad=0.1632p as=0.1056p pd=1.64u ps=0.92u
    I_MXI1_I96_I23_XG_MP2 (VDD I1_I96_gn5 I1_I96_G5_4 VDD) gpdk090_pmos1v w=0.24u l=0.1u ad=0.0936p as=0.0816p pd=0.92u ps=1.16u
    I_MXI1_I96_I23_XG_MP0 (XI1_I96_I23_XG_p1 I1_I96_pn5 VDD VDD) gpdk090_pmos1v w=0.48u l=0.1u ad=0.1056p as=0.0936p pd=0.92u ps=0.92u
    I_MXI1_I96_I23_XG_MP1 (I1_I96_G5_4 I1_I96_gn4 XI1_I96_I23_XG_p1 VDD) gpdk090_pmos1v w=0.48u l=0.1u ad=0.1632p as=0.1056p pd=1.64u ps=0.92u
    I_MXI1_I84_I34_XG_MP2 (VDD I1_I84_G5_2n I1_I84_G5_0 VDD) gpdk090_pmos1v w=0.24u l=0.1u ad=0.0936p as=0.0816p pd=0.92u ps=1.16u
    I_MXI1_I84_I34_XG_MP0 (XI1_I84_I34_XG_p1 I1_I84_P5_2n VDD VDD) gpdk090_pmos1v w=0.48u l=0.1u ad=0.1056p as=0.0936p pd=0.92u ps=0.92u
    I_MXI1_I84_I34_XG_MP1 (I1_I84_G5_0 I1_I84_G1_0n XI1_I84_I34_XG_p1 VDD) gpdk090_pmos1v w=0.48u l=0.1u ad=0.1632p as=0.1056p pd=1.64u ps=0.92u
    I_MXI1_I84_I35_XG_MP2 (VDD I1_I84_G6_3n I1_c3_7 VDD) gpdk090_pmos1v w=0.24u l=0.1u ad=0.0936p as=0.0816p pd=0.92u ps=1.16u
    I_MXI1_I84_I35_XG_MP0 (XI1_I84_I35_XG_p1 I1_I84_P6_3n VDD VDD) gpdk090_pmos1v w=0.48u l=0.1u ad=0.1056p as=0.0936p pd=0.92u ps=0.92u
    I_MXI1_I84_I35_XG_MP1 (I1_c3_7 I1_I84_G2_0n XI1_I84_I35_XG_p1 VDD) gpdk090_pmos1v w=0.48u l=0.1u ad=0.1632p as=0.1056p pd=1.64u ps=0.92u
    I_MXI1_I84_I23_XG_MP2 (VDD I1_I84_gn5 I1_I84_G5_4 VDD) gpdk090_pmos1v w=0.24u l=0.1u ad=0.0936p as=0.0816p pd=0.92u ps=1.16u
    I_MXI1_I84_I23_XG_MP0 (XI1_I84_I23_XG_p1 I1_I84_pn5 VDD VDD) gpdk090_pmos1v w=0.48u l=0.1u ad=0.1056p as=0.0936p pd=0.92u ps=0.92u
    I_MXI1_I84_I23_XG_MP1 (I1_I84_G5_4 I1_I84_gn4 XI1_I84_I23_XG_p1 VDD) gpdk090_pmos1v w=0.48u l=0.1u ad=0.1632p as=0.1056p pd=1.64u ps=0.92u
    I_MXI1_I72_I23_XG_MP2 (VDD I1_I72_gn5 I1_I72_G5_4 VDD) gpdk090_pmos1v w=0.24u l=0.1u ad=0.0936p as=0.0816p pd=0.92u ps=1.16u
    I_MXI1_I72_I23_XG_MP0 (XI1_I72_I23_XG_p1 I1_I72_pn5 VDD VDD) gpdk090_pmos1v w=0.48u l=0.1u ad=0.1056p as=0.0936p pd=0.92u ps=0.92u
    I_MXI1_I72_I23_XG_MP1 (I1_I72_G5_4 I1_I72_gn4 XI1_I72_I23_XG_p1 VDD) gpdk090_pmos1v w=0.48u l=0.1u ad=0.1632p as=0.1056p pd=1.64u ps=0.92u
    I_MXI1_I72_I24_XG_MP2 (VDD I1_I72_gn6 I1_I72_G6_5 VDD) gpdk090_pmos1v w=0.24u l=0.1u ad=0.0936p as=0.0816p pd=0.92u ps=1.16u
    I_MXI1_I72_I24_XG_MP0 (XI1_I72_I24_XG_p1 I1_I72_pn6 VDD VDD) gpdk090_pmos1v w=0.48u l=0.1u ad=0.1056p as=0.0936p pd=0.92u ps=0.92u
    I_MXI1_I72_I24_XG_MP1 (I1_I72_G6_5 I1_I72_gn5 XI1_I72_I24_XG_p1 VDD) gpdk090_pmos1v w=0.48u l=0.1u ad=0.1632p as=0.1056p pd=1.64u ps=0.92u
    I_MXI1_I60_I23_XG_MP2 (VDD I1_I60_gn5 I1_I60_G5_4 VDD) gpdk090_pmos1v w=0.24u l=0.1u ad=0.0936p as=0.0816p pd=0.92u ps=1.16u
    I_MXI1_I60_I23_XG_MP0 (XI1_I60_I23_XG_p1 I1_I60_pn5 VDD VDD) gpdk090_pmos1v w=0.48u l=0.1u ad=0.1056p as=0.0936p pd=0.92u ps=0.92u
    I_MXI1_I60_I23_XG_MP1 (I1_I60_G5_4 I1_I60_gn4 XI1_I60_I23_XG_p1 VDD) gpdk090_pmos1v w=0.48u l=0.1u ad=0.1632p as=0.1056p pd=1.64u ps=0.92u
    I_MXI1_I60_I24_XG_MP2 (VDD I1_I60_gn6 I1_I60_G6_5 VDD) gpdk090_pmos1v w=0.24u l=0.1u ad=0.0936p as=0.0816p pd=0.92u ps=1.16u
    I_MXI1_I60_I24_XG_MP0 (XI1_I60_I24_XG_p1 I1_I60_pn6 VDD VDD) gpdk090_pmos1v w=0.48u l=0.1u ad=0.1056p as=0.0936p pd=0.92u ps=0.92u
    I_MXI1_I60_I24_XG_MP1 (I1_I60_G6_5 I1_I60_gn5 XI1_I60_I24_XG_p1 VDD) gpdk090_pmos1v w=0.48u l=0.1u ad=0.1632p as=0.1056p pd=1.64u ps=0.92u
    I_MXI1_I48_I24_XG_MP2 (VDD I1_I48_gn6 I1_I48_G6_5 VDD) gpdk090_pmos1v w=0.24u l=0.1u ad=0.0936p as=0.0816p pd=0.92u ps=1.16u
    I_MXI1_I48_I24_XG_MP0 (XI1_I48_I24_XG_p1 I1_I48_pn6 VDD VDD) gpdk090_pmos1v w=0.48u l=0.1u ad=0.1056p as=0.0936p pd=0.92u ps=0.92u
    I_MXI1_I48_I24_XG_MP1 (I1_I48_G6_5 I1_I48_gn5 XI1_I48_I24_XG_p1 VDD) gpdk090_pmos1v w=0.48u l=0.1u ad=0.1632p as=0.1056p pd=1.64u ps=0.92u
    I_MXI1_I48_I23_XG_MP2 (VDD I1_I48_gn5 I1_I48_G5_4 VDD) gpdk090_pmos1v w=0.24u l=0.1u ad=0.0936p as=0.0816p pd=0.92u ps=1.16u
    I_MXI1_I48_I23_XG_MP0 (XI1_I48_I23_XG_p1 I1_I48_pn5 VDD VDD) gpdk090_pmos1v w=0.48u l=0.1u ad=0.1056p as=0.0936p pd=0.92u ps=0.92u
    I_MXI1_I48_I23_XG_MP1 (I1_I48_G5_4 I1_I48_gn4 XI1_I48_I23_XG_p1 VDD) gpdk090_pmos1v w=0.48u l=0.1u ad=0.1632p as=0.1056p pd=1.64u ps=0.92u
    I_MXI1_I96_I34_XG_MP2 (VDD I1_I96_G5_2n I1_I96_G5_0 VDD) gpdk090_pmos1v w=0.24u l=0.1u ad=0.0936p as=0.0816p pd=0.92u ps=1.16u
    I_MXI1_I96_I34_XG_MP0 (XI1_I96_I34_XG_p1 I1_I96_P5_2n VDD VDD) gpdk090_pmos1v w=0.48u l=0.1u ad=0.1056p as=0.0936p pd=0.92u ps=0.92u
    I_MXI1_I96_I34_XG_MP1 (I1_I96_G5_0 I1_I96_G1_0n XI1_I96_I34_XG_p1 VDD) gpdk090_pmos1v w=0.48u l=0.1u ad=0.1632p as=0.1056p pd=1.64u ps=0.92u
    I_MXI1_I84_I24_XG_MP2 (VDD I1_I84_gn6 I1_I84_G6_5 VDD) gpdk090_pmos1v w=0.24u l=0.1u ad=0.0936p as=0.0816p pd=0.92u ps=1.16u
    I_MXI1_I84_I24_XG_MP0 (XI1_I84_I24_XG_p1 I1_I84_pn6 VDD VDD) gpdk090_pmos1v w=0.48u l=0.1u ad=0.1056p as=0.0936p pd=0.92u ps=0.92u
    I_MXI1_I84_I24_XG_MP1 (I1_I84_G6_5 I1_I84_gn5 XI1_I84_I24_XG_p1 VDD) gpdk090_pmos1v w=0.48u l=0.1u ad=0.1632p as=0.1056p pd=1.64u ps=0.92u
    I_MXI1_I84_I25_XG_MP2 (VDD I1_I84_gn7 I1_I84_G7_6 VDD) gpdk090_pmos1v w=0.24u l=0.1u ad=0.0936p as=0.0816p pd=0.92u ps=1.16u
    I_MXI1_I84_I25_XG_MP0 (XI1_I84_I25_XG_p1 I1_I84_pn7 VDD VDD) gpdk090_pmos1v w=0.48u l=0.1u ad=0.1056p as=0.0936p pd=0.92u ps=0.92u
    I_MXI1_I84_I25_XG_MP1 (I1_I84_G7_6 I1_I84_gn6 XI1_I84_I25_XG_p1 VDD) gpdk090_pmos1v w=0.48u l=0.1u ad=0.1632p as=0.1056p pd=1.64u ps=0.92u
    I_MXI1_I72_I34_XG_MP2 (VDD I1_I72_G5_2n I1_I72_G5_0 VDD) gpdk090_pmos1v w=0.24u l=0.1u ad=0.0936p as=0.0816p pd=0.92u ps=1.16u
    I_MXI1_I72_I34_XG_MP0 (XI1_I72_I34_XG_p1 I1_I72_P5_2n VDD VDD) gpdk090_pmos1v w=0.48u l=0.1u ad=0.1056p as=0.0936p pd=0.92u ps=0.92u
    I_MXI1_I72_I34_XG_MP1 (I1_I72_G5_0 I1_I72_G1_0n XI1_I72_I34_XG_p1 VDD) gpdk090_pmos1v w=0.48u l=0.1u ad=0.1632p as=0.1056p pd=1.64u ps=0.92u
    I_MXI1_I60_I34_XG_MP2 (VDD I1_I60_G5_2n I1_I60_G5_0 VDD) gpdk090_pmos1v w=0.24u l=0.1u ad=0.0936p as=0.0816p pd=0.92u ps=1.16u
    I_MXI1_I60_I34_XG_MP0 (XI1_I60_I34_XG_p1 I1_I60_P5_2n VDD VDD) gpdk090_pmos1v w=0.48u l=0.1u ad=0.1056p as=0.0936p pd=0.92u ps=0.92u
    I_MXI1_I60_I34_XG_MP1 (I1_I60_G5_0 I1_I60_G1_0n XI1_I60_I34_XG_p1 VDD) gpdk090_pmos1v w=0.48u l=0.1u ad=0.1632p as=0.1056p pd=1.64u ps=0.92u
    I_MXI1_I48_I25_XG_MP2 (VDD I1_I48_gn7 I1_I48_G7_6 VDD) gpdk090_pmos1v w=0.24u l=0.1u ad=0.0936p as=0.0816p pd=0.92u ps=1.16u
    I_MXI1_I48_I25_XG_MP0 (XI1_I48_I25_XG_p1 I1_I48_pn7 VDD VDD) gpdk090_pmos1v w=0.48u l=0.1u ad=0.1056p as=0.0936p pd=0.92u ps=0.92u
    I_MXI1_I48_I25_XG_MP1 (I1_I48_G7_6 I1_I48_gn6 XI1_I48_I25_XG_p1 VDD) gpdk090_pmos1v w=0.48u l=0.1u ad=0.1632p as=0.1056p pd=1.64u ps=0.92u
    I_MXI1_I48_I36_XG_MP2 (VDD I1_I48_G7_4n I1_c0_8 VDD) gpdk090_pmos1v w=0.24u l=0.1u ad=0.0936p as=0.0816p pd=0.92u ps=1.16u
    I_MXI1_I48_I36_XG_MP0 (XI1_I48_I36_XG_p1 I1_I48_P7_4n VDD VDD) gpdk090_pmos1v w=0.48u l=0.1u ad=0.1056p as=0.0936p pd=0.92u ps=0.92u
    I_MXI1_I48_I36_XG_MP1 (I1_c0_8 I1_I48_G3_0n XI1_I48_I36_XG_p1 VDD) gpdk090_pmos1v w=0.48u l=0.1u ad=0.1632p as=0.1056p pd=1.64u ps=0.92u
    I_MXI1_I96_I36_XG_MP2 (VDD I1_I96_G7_4n I1_c4_8 VDD) gpdk090_pmos1v w=0.24u l=0.1u ad=0.0936p as=0.0816p pd=0.92u ps=1.16u
    I_MXI1_I96_I36_XG_MP0 (XI1_I96_I36_XG_p1 I1_I96_P7_4n VDD VDD) gpdk090_pmos1v w=0.48u l=0.1u ad=0.1056p as=0.0936p pd=0.92u ps=0.92u
    I_MXI1_I96_I36_XG_MP1 (I1_c4_8 I1_I96_G3_0n XI1_I96_I36_XG_p1 VDD) gpdk090_pmos1v w=0.48u l=0.1u ad=0.1632p as=0.1056p pd=1.64u ps=0.92u
    I_MXI1_I96_I25_XG_MP2 (VDD I1_I96_gn7 I1_I96_G7_6 VDD) gpdk090_pmos1v w=0.24u l=0.1u ad=0.0936p as=0.0816p pd=0.92u ps=1.16u
    I_MXI1_I96_I25_XG_MP0 (XI1_I96_I25_XG_p1 I1_I96_pn7 VDD VDD) gpdk090_pmos1v w=0.48u l=0.1u ad=0.1056p as=0.0936p pd=0.92u ps=0.92u
    I_MXI1_I96_I25_XG_MP1 (I1_I96_G7_6 I1_I96_gn6 XI1_I96_I25_XG_p1 VDD) gpdk090_pmos1v w=0.48u l=0.1u ad=0.1632p as=0.1056p pd=1.64u ps=0.92u
    I_MXI1_I84_I36_XG_MP2 (VDD I1_I84_G7_4n I1_c3_8 VDD) gpdk090_pmos1v w=0.24u l=0.1u ad=0.0936p as=0.0816p pd=0.92u ps=1.16u
    I_MXI1_I84_I36_XG_MP0 (XI1_I84_I36_XG_p1 I1_I84_P7_4n VDD VDD) gpdk090_pmos1v w=0.48u l=0.1u ad=0.1056p as=0.0936p pd=0.92u ps=0.92u
    I_MXI1_I84_I36_XG_MP1 (I1_c3_8 I1_I84_G3_0n XI1_I84_I36_XG_p1 VDD) gpdk090_pmos1v w=0.48u l=0.1u ad=0.1632p as=0.1056p pd=1.64u ps=0.92u
    I_MXI1_I72_I36_XG_MP2 (VDD I1_I72_G7_4n I1_c2_8 VDD) gpdk090_pmos1v w=0.24u l=0.1u ad=0.0936p as=0.0816p pd=0.92u ps=1.16u
    I_MXI1_I72_I36_XG_MP0 (XI1_I72_I36_XG_p1 I1_I72_P7_4n VDD VDD) gpdk090_pmos1v w=0.48u l=0.1u ad=0.1056p as=0.0936p pd=0.92u ps=0.92u
    I_MXI1_I72_I36_XG_MP1 (I1_c2_8 I1_I72_G3_0n XI1_I72_I36_XG_p1 VDD) gpdk090_pmos1v w=0.48u l=0.1u ad=0.1632p as=0.1056p pd=1.64u ps=0.92u
    I_MXI1_I72_I25_XG_MP2 (VDD I1_I72_gn7 I1_I72_G7_6 VDD) gpdk090_pmos1v w=0.24u l=0.1u ad=0.0936p as=0.0816p pd=0.92u ps=1.16u
    I_MXI1_I72_I25_XG_MP0 (XI1_I72_I25_XG_p1 I1_I72_pn7 VDD VDD) gpdk090_pmos1v w=0.48u l=0.1u ad=0.1056p as=0.0936p pd=0.92u ps=0.92u
    I_MXI1_I72_I25_XG_MP1 (I1_I72_G7_6 I1_I72_gn6 XI1_I72_I25_XG_p1 VDD) gpdk090_pmos1v w=0.48u l=0.1u ad=0.1632p as=0.1056p pd=1.64u ps=0.92u
    I_MXI1_I60_I36_XG_MP2 (VDD I1_I60_G7_4n I1_c1_8 VDD) gpdk090_pmos1v w=0.24u l=0.1u ad=0.0936p as=0.0816p pd=0.92u ps=1.16u
    I_MXI1_I60_I36_XG_MP0 (XI1_I60_I36_XG_p1 I1_I60_P7_4n VDD VDD) gpdk090_pmos1v w=0.48u l=0.1u ad=0.1056p as=0.0936p pd=0.92u ps=0.92u
    I_MXI1_I60_I36_XG_MP1 (I1_c1_8 I1_I60_G3_0n XI1_I60_I36_XG_p1 VDD) gpdk090_pmos1v w=0.48u l=0.1u ad=0.1632p as=0.1056p pd=1.64u ps=0.92u
    I_MXI1_I60_I25_XG_MP2 (VDD I1_I60_gn7 I1_I60_G7_6 VDD) gpdk090_pmos1v w=0.24u l=0.1u ad=0.0936p as=0.0816p pd=0.92u ps=1.16u
    I_MXI1_I60_I25_XG_MP0 (XI1_I60_I25_XG_p1 I1_I60_pn7 VDD VDD) gpdk090_pmos1v w=0.48u l=0.1u ad=0.1056p as=0.0936p pd=0.92u ps=0.92u
    I_MXI1_I60_I25_XG_MP1 (I1_I60_G7_6 I1_I60_gn6 XI1_I60_I25_XG_p1 VDD) gpdk090_pmos1v w=0.48u l=0.1u ad=0.1632p as=0.1056p pd=1.64u ps=0.92u
    I_MXI0_I42_MP12 (VDD B_7 XI0_I42_xbn VDD) gpdk090_pmos1v w=0.24u l=0.1u ad=0.0816p as=0.0816p pd=1.16u ps=1.16u
    I_MXI0_I42_MP18 (XI0_I42_xp1 XI0_I42_xbn VDD VDD) gpdk090_pmos1v w=0.48u l=0.1u ad=0.1056p as=0.1632p pd=0.92u ps=1.64u
    I_MXI0_I42_MP20 (I0_pp3_8 B_7 XI0_I42_xp1 VDD) gpdk090_pmos1v w=0.48u l=0.1u ad=0.1056p as=0.1056p pd=0.92u ps=0.92u
    I_MXI0_I42_MP19 (XI0_I42_xp1 XI0_I42_xan I0_pp3_8 VDD) gpdk090_pmos1v w=0.48u l=0.1u ad=0.1056p as=0.1056p pd=0.92u ps=0.92u
    I_MXI0_I42_MP17 (VDD XI0_I42_xn XI0_I42_xp1 VDD) gpdk090_pmos1v w=0.48u l=0.1u ad=0.1632p as=0.1056p pd=1.64u ps=0.92u
    I_MXI0_I42_MP6 (XI0_I42_p1 A_7 VDD VDD) gpdk090_pmos1v w=0.48u l=0.1u ad=0.1056p as=0.1632p pd=0.92u ps=1.64u
    I_MXI0_I42_MP8 (XI0_I42_xn A_7 XI0_I42_p1 VDD) gpdk090_pmos1v w=0.48u l=0.1u ad=0.1056p as=0.1056p pd=0.92u ps=0.92u
    I_MXI0_I42_MP7 (XI0_I42_p1 I0_two3 XI0_I42_xn VDD) gpdk090_pmos1v w=0.48u l=0.1u ad=0.1056p as=0.1056p pd=0.92u ps=0.92u
    I_MXI0_I42_MP5 (VDD I0_one3 XI0_I42_p1 VDD) gpdk090_pmos1v w=0.48u l=0.1u ad=0.1632p as=0.1056p pd=1.64u ps=0.92u
    I_MXI0_I42_MP10 (XI0_I42_xan XI0_I42_xn VDD VDD) gpdk090_pmos1v w=0.24u l=0.1u ad=0.0816p as=0.0816p pd=1.16u ps=1.16u
    I_MXI0_I30_MP12 (VDD B_5 XI0_I30_xbn VDD) gpdk090_pmos1v w=0.24u l=0.1u ad=0.0816p as=0.0816p pd=1.16u ps=1.16u
    I_MXI0_I30_MP18 (XI0_I30_xp1 XI0_I30_xbn VDD VDD) gpdk090_pmos1v w=0.48u l=0.1u ad=0.1056p as=0.1632p pd=0.92u ps=1.64u
    I_MXI0_I30_MP20 (I0_pp2_7 B_5 XI0_I30_xp1 VDD) gpdk090_pmos1v w=0.48u l=0.1u ad=0.1056p as=0.1056p pd=0.92u ps=0.92u
    I_MXI0_I30_MP19 (XI0_I30_xp1 XI0_I30_xan I0_pp2_7 VDD) gpdk090_pmos1v w=0.48u l=0.1u ad=0.1056p as=0.1056p pd=0.92u ps=0.92u
    I_MXI0_I30_MP17 (VDD XI0_I30_xn XI0_I30_xp1 VDD) gpdk090_pmos1v w=0.48u l=0.1u ad=0.1632p as=0.1056p pd=1.64u ps=0.92u
    I_MXI0_I30_MP6 (XI0_I30_p1 A_7 VDD VDD) gpdk090_pmos1v w=0.48u l=0.1u ad=0.1056p as=0.1632p pd=0.92u ps=1.64u
    I_MXI0_I30_MP8 (XI0_I30_xn A_6 XI0_I30_p1 VDD) gpdk090_pmos1v w=0.48u l=0.1u ad=0.1056p as=0.1056p pd=0.92u ps=0.92u
    I_MXI0_I30_MP7 (XI0_I30_p1 I0_two2 XI0_I30_xn VDD) gpdk090_pmos1v w=0.48u l=0.1u ad=0.1056p as=0.1056p pd=0.92u ps=0.92u
    I_MXI0_I30_MP5 (VDD I0_one2 XI0_I30_p1 VDD) gpdk090_pmos1v w=0.48u l=0.1u ad=0.1632p as=0.1056p pd=1.64u ps=0.92u
    I_MXI0_I30_MP10 (XI0_I30_xan XI0_I30_xn VDD VDD) gpdk090_pmos1v w=0.24u l=0.1u ad=0.0816p as=0.0816p pd=1.16u ps=1.16u
    I_MXI0_I31_MP12 (VDD B_5 XI0_I31_xbn VDD) gpdk090_pmos1v w=0.24u l=0.1u ad=0.0816p as=0.0816p pd=1.16u ps=1.16u
    I_MXI0_I31_MP18 (XI0_I31_xp1 XI0_I31_xbn VDD VDD) gpdk090_pmos1v w=0.48u l=0.1u ad=0.1056p as=0.1632p pd=0.92u ps=1.64u
    I_MXI0_I31_MP20 (I0_pp2_8 B_5 XI0_I31_xp1 VDD) gpdk090_pmos1v w=0.48u l=0.1u ad=0.1056p as=0.1056p pd=0.92u ps=0.92u
    I_MXI0_I31_MP19 (XI0_I31_xp1 XI0_I31_xan I0_pp2_8 VDD) gpdk090_pmos1v w=0.48u l=0.1u ad=0.1056p as=0.1056p pd=0.92u ps=0.92u
    I_MXI0_I31_MP17 (VDD XI0_I31_xn XI0_I31_xp1 VDD) gpdk090_pmos1v w=0.48u l=0.1u ad=0.1632p as=0.1056p pd=1.64u ps=0.92u
    I_MXI0_I31_MP6 (XI0_I31_p1 A_7 VDD VDD) gpdk090_pmos1v w=0.48u l=0.1u ad=0.1056p as=0.1632p pd=0.92u ps=1.64u
    I_MXI0_I31_MP8 (XI0_I31_xn A_7 XI0_I31_p1 VDD) gpdk090_pmos1v w=0.48u l=0.1u ad=0.1056p as=0.1056p pd=0.92u ps=0.92u
    I_MXI0_I31_MP7 (XI0_I31_p1 I0_two2 XI0_I31_xn VDD) gpdk090_pmos1v w=0.48u l=0.1u ad=0.1056p as=0.1056p pd=0.92u ps=0.92u
    I_MXI0_I31_MP5 (VDD I0_one2 XI0_I31_p1 VDD) gpdk090_pmos1v w=0.48u l=0.1u ad=0.1632p as=0.1056p pd=1.64u ps=0.92u
    I_MXI0_I31_MP10 (XI0_I31_xan XI0_I31_xn VDD VDD) gpdk090_pmos1v w=0.24u l=0.1u ad=0.0816p as=0.0816p pd=1.16u ps=1.16u
    I_MXI0_I40_MP12 (VDD B_7 XI0_I40_xbn VDD) gpdk090_pmos1v w=0.24u l=0.1u ad=0.0816p as=0.0816p pd=1.16u ps=1.16u
    I_MXI0_I40_MP18 (XI0_I40_xp1 XI0_I40_xbn VDD VDD) gpdk090_pmos1v w=0.48u l=0.1u ad=0.1056p as=0.1632p pd=0.92u ps=1.64u
    I_MXI0_I40_MP20 (I0_pp3_6 B_7 XI0_I40_xp1 VDD) gpdk090_pmos1v w=0.48u l=0.1u ad=0.1056p as=0.1056p pd=0.92u ps=0.92u
    I_MXI0_I40_MP19 (XI0_I40_xp1 XI0_I40_xan I0_pp3_6 VDD) gpdk090_pmos1v w=0.48u l=0.1u ad=0.1056p as=0.1056p pd=0.92u ps=0.92u
    I_MXI0_I40_MP17 (VDD XI0_I40_xn XI0_I40_xp1 VDD) gpdk090_pmos1v w=0.48u l=0.1u ad=0.1632p as=0.1056p pd=1.64u ps=0.92u
    I_MXI0_I40_MP6 (XI0_I40_p1 A_6 VDD VDD) gpdk090_pmos1v w=0.48u l=0.1u ad=0.1056p as=0.1632p pd=0.92u ps=1.64u
    I_MXI0_I40_MP8 (XI0_I40_xn A_5 XI0_I40_p1 VDD) gpdk090_pmos1v w=0.48u l=0.1u ad=0.1056p as=0.1056p pd=0.92u ps=0.92u
    I_MXI0_I40_MP7 (XI0_I40_p1 I0_two3 XI0_I40_xn VDD) gpdk090_pmos1v w=0.48u l=0.1u ad=0.1056p as=0.1056p pd=0.92u ps=0.92u
    I_MXI0_I40_MP5 (VDD I0_one3 XI0_I40_p1 VDD) gpdk090_pmos1v w=0.48u l=0.1u ad=0.1632p as=0.1056p pd=1.64u ps=0.92u
    I_MXI0_I40_MP10 (XI0_I40_xan XI0_I40_xn VDD VDD) gpdk090_pmos1v w=0.24u l=0.1u ad=0.0816p as=0.0816p pd=1.16u ps=1.16u
    I_MXI0_I41_MP12 (VDD B_7 XI0_I41_xbn VDD) gpdk090_pmos1v w=0.24u l=0.1u ad=0.0816p as=0.0816p pd=1.16u ps=1.16u
    I_MXI0_I41_MP18 (XI0_I41_xp1 XI0_I41_xbn VDD VDD) gpdk090_pmos1v w=0.48u l=0.1u ad=0.1056p as=0.1632p pd=0.92u ps=1.64u
    I_MXI0_I41_MP20 (I0_pp3_7 B_7 XI0_I41_xp1 VDD) gpdk090_pmos1v w=0.48u l=0.1u ad=0.1056p as=0.1056p pd=0.92u ps=0.92u
    I_MXI0_I41_MP19 (XI0_I41_xp1 XI0_I41_xan I0_pp3_7 VDD) gpdk090_pmos1v w=0.48u l=0.1u ad=0.1056p as=0.1056p pd=0.92u ps=0.92u
    I_MXI0_I41_MP17 (VDD XI0_I41_xn XI0_I41_xp1 VDD) gpdk090_pmos1v w=0.48u l=0.1u ad=0.1632p as=0.1056p pd=1.64u ps=0.92u
    I_MXI0_I41_MP6 (XI0_I41_p1 A_7 VDD VDD) gpdk090_pmos1v w=0.48u l=0.1u ad=0.1056p as=0.1632p pd=0.92u ps=1.64u
    I_MXI0_I41_MP8 (XI0_I41_xn A_6 XI0_I41_p1 VDD) gpdk090_pmos1v w=0.48u l=0.1u ad=0.1056p as=0.1056p pd=0.92u ps=0.92u
    I_MXI0_I41_MP7 (XI0_I41_p1 I0_two3 XI0_I41_xn VDD) gpdk090_pmos1v w=0.48u l=0.1u ad=0.1056p as=0.1056p pd=0.92u ps=0.92u
    I_MXI0_I41_MP5 (VDD I0_one3 XI0_I41_p1 VDD) gpdk090_pmos1v w=0.48u l=0.1u ad=0.1632p as=0.1056p pd=1.64u ps=0.92u
    I_MXI0_I41_MP10 (XI0_I41_xan XI0_I41_xn VDD VDD) gpdk090_pmos1v w=0.24u l=0.1u ad=0.0816p as=0.0816p pd=1.16u ps=1.16u
    I_MXI0_I29_MP12 (VDD B_5 XI0_I29_xbn VDD) gpdk090_pmos1v w=0.24u l=0.1u ad=0.0816p as=0.0816p pd=1.16u ps=1.16u
    I_MXI0_I29_MP18 (XI0_I29_xp1 XI0_I29_xbn VDD VDD) gpdk090_pmos1v w=0.48u l=0.1u ad=0.1056p as=0.1632p pd=0.92u ps=1.64u
    I_MXI0_I29_MP20 (I0_pp2_6 B_5 XI0_I29_xp1 VDD) gpdk090_pmos1v w=0.48u l=0.1u ad=0.1056p as=0.1056p pd=0.92u ps=0.92u
    I_MXI0_I29_MP19 (XI0_I29_xp1 XI0_I29_xan I0_pp2_6 VDD) gpdk090_pmos1v w=0.48u l=0.1u ad=0.1056p as=0.1056p pd=0.92u ps=0.92u
    I_MXI0_I29_MP17 (VDD XI0_I29_xn XI0_I29_xp1 VDD) gpdk090_pmos1v w=0.48u l=0.1u ad=0.1632p as=0.1056p pd=1.64u ps=0.92u
    I_MXI0_I29_MP6 (XI0_I29_p1 A_6 VDD VDD) gpdk090_pmos1v w=0.48u l=0.1u ad=0.1056p as=0.1632p pd=0.92u ps=1.64u
    I_MXI0_I29_MP8 (XI0_I29_xn A_5 XI0_I29_p1 VDD) gpdk090_pmos1v w=0.48u l=0.1u ad=0.1056p as=0.1056p pd=0.92u ps=0.92u
    I_MXI0_I29_MP7 (XI0_I29_p1 I0_two2 XI0_I29_xn VDD) gpdk090_pmos1v w=0.48u l=0.1u ad=0.1056p as=0.1056p pd=0.92u ps=0.92u
    I_MXI0_I29_MP5 (VDD I0_one2 XI0_I29_p1 VDD) gpdk090_pmos1v w=0.48u l=0.1u ad=0.1632p as=0.1056p pd=1.64u ps=0.92u
    I_MXI0_I29_MP10 (XI0_I29_xan XI0_I29_xn VDD VDD) gpdk090_pmos1v w=0.24u l=0.1u ad=0.0816p as=0.0816p pd=1.16u ps=1.16u
    I_MXI0_I20_MP12 (VDD B_3 XI0_I20_xbn VDD) gpdk090_pmos1v w=0.24u l=0.1u ad=0.0816p as=0.0816p pd=1.16u ps=1.16u
    I_MXI0_I20_MP18 (XI0_I20_xp1 XI0_I20_xbn VDD VDD) gpdk090_pmos1v w=0.48u l=0.1u ad=0.1056p as=0.1632p pd=0.92u ps=1.64u
    I_MXI0_I20_MP20 (I0_pp1_8 B_3 XI0_I20_xp1 VDD) gpdk090_pmos1v w=0.48u l=0.1u ad=0.1056p as=0.1056p pd=0.92u ps=0.92u
    I_MXI0_I20_MP19 (XI0_I20_xp1 XI0_I20_xan I0_pp1_8 VDD) gpdk090_pmos1v w=0.48u l=0.1u ad=0.1056p as=0.1056p pd=0.92u ps=0.92u
    I_MXI0_I20_MP17 (VDD XI0_I20_xn XI0_I20_xp1 VDD) gpdk090_pmos1v w=0.48u l=0.1u ad=0.1632p as=0.1056p pd=1.64u ps=0.92u
    I_MXI0_I20_MP6 (XI0_I20_p1 A_7 VDD VDD) gpdk090_pmos1v w=0.48u l=0.1u ad=0.1056p as=0.1632p pd=0.92u ps=1.64u
    I_MXI0_I20_MP8 (XI0_I20_xn A_7 XI0_I20_p1 VDD) gpdk090_pmos1v w=0.48u l=0.1u ad=0.1056p as=0.1056p pd=0.92u ps=0.92u
    I_MXI0_I20_MP7 (XI0_I20_p1 I0_two1 XI0_I20_xn VDD) gpdk090_pmos1v w=0.48u l=0.1u ad=0.1056p as=0.1056p pd=0.92u ps=0.92u
    I_MXI0_I20_MP5 (VDD I0_one1 XI0_I20_p1 VDD) gpdk090_pmos1v w=0.48u l=0.1u ad=0.1632p as=0.1056p pd=1.64u ps=0.92u
    I_MXI0_I20_MP10 (XI0_I20_xan XI0_I20_xn VDD VDD) gpdk090_pmos1v w=0.24u l=0.1u ad=0.0816p as=0.0816p pd=1.16u ps=1.16u
    I_MXI0_I28_MP12 (VDD B_5 XI0_I28_xbn VDD) gpdk090_pmos1v w=0.24u l=0.1u ad=0.0816p as=0.0816p pd=1.16u ps=1.16u
    I_MXI0_I28_MP18 (XI0_I28_xp1 XI0_I28_xbn VDD VDD) gpdk090_pmos1v w=0.48u l=0.1u ad=0.1056p as=0.1632p pd=0.92u ps=1.64u
    I_MXI0_I28_MP20 (I0_pp2_5 B_5 XI0_I28_xp1 VDD) gpdk090_pmos1v w=0.48u l=0.1u ad=0.1056p as=0.1056p pd=0.92u ps=0.92u
    I_MXI0_I28_MP19 (XI0_I28_xp1 XI0_I28_xan I0_pp2_5 VDD) gpdk090_pmos1v w=0.48u l=0.1u ad=0.1056p as=0.1056p pd=0.92u ps=0.92u
    I_MXI0_I28_MP17 (VDD XI0_I28_xn XI0_I28_xp1 VDD) gpdk090_pmos1v w=0.48u l=0.1u ad=0.1632p as=0.1056p pd=1.64u ps=0.92u
    I_MXI0_I28_MP6 (XI0_I28_p1 A_5 VDD VDD) gpdk090_pmos1v w=0.48u l=0.1u ad=0.1056p as=0.1632p pd=0.92u ps=1.64u
    I_MXI0_I28_MP8 (XI0_I28_xn A_4 XI0_I28_p1 VDD) gpdk090_pmos1v w=0.48u l=0.1u ad=0.1056p as=0.1056p pd=0.92u ps=0.92u
    I_MXI0_I28_MP7 (XI0_I28_p1 I0_two2 XI0_I28_xn VDD) gpdk090_pmos1v w=0.48u l=0.1u ad=0.1056p as=0.1056p pd=0.92u ps=0.92u
    I_MXI0_I28_MP5 (VDD I0_one2 XI0_I28_p1 VDD) gpdk090_pmos1v w=0.48u l=0.1u ad=0.1632p as=0.1056p pd=1.64u ps=0.92u
    I_MXI0_I28_MP10 (XI0_I28_xan XI0_I28_xn VDD VDD) gpdk090_pmos1v w=0.24u l=0.1u ad=0.0816p as=0.0816p pd=1.16u ps=1.16u
    I_MXI0_I19_MP12 (VDD B_3 XI0_I19_xbn VDD) gpdk090_pmos1v w=0.24u l=0.1u ad=0.0816p as=0.0816p pd=1.16u ps=1.16u
    I_MXI0_I19_MP18 (XI0_I19_xp1 XI0_I19_xbn VDD VDD) gpdk090_pmos1v w=0.48u l=0.1u ad=0.1056p as=0.1632p pd=0.92u ps=1.64u
    I_MXI0_I19_MP20 (I0_pp1_7 B_3 XI0_I19_xp1 VDD) gpdk090_pmos1v w=0.48u l=0.1u ad=0.1056p as=0.1056p pd=0.92u ps=0.92u
    I_MXI0_I19_MP19 (XI0_I19_xp1 XI0_I19_xan I0_pp1_7 VDD) gpdk090_pmos1v w=0.48u l=0.1u ad=0.1056p as=0.1056p pd=0.92u ps=0.92u
    I_MXI0_I19_MP17 (VDD XI0_I19_xn XI0_I19_xp1 VDD) gpdk090_pmos1v w=0.48u l=0.1u ad=0.1632p as=0.1056p pd=1.64u ps=0.92u
    I_MXI0_I19_MP6 (XI0_I19_p1 A_7 VDD VDD) gpdk090_pmos1v w=0.48u l=0.1u ad=0.1056p as=0.1632p pd=0.92u ps=1.64u
    I_MXI0_I19_MP8 (XI0_I19_xn A_6 XI0_I19_p1 VDD) gpdk090_pmos1v w=0.48u l=0.1u ad=0.1056p as=0.1056p pd=0.92u ps=0.92u
    I_MXI0_I19_MP7 (XI0_I19_p1 I0_two1 XI0_I19_xn VDD) gpdk090_pmos1v w=0.48u l=0.1u ad=0.1056p as=0.1056p pd=0.92u ps=0.92u
    I_MXI0_I19_MP5 (VDD I0_one1 XI0_I19_p1 VDD) gpdk090_pmos1v w=0.48u l=0.1u ad=0.1632p as=0.1056p pd=1.64u ps=0.92u
    I_MXI0_I19_MP10 (XI0_I19_xan XI0_I19_xn VDD VDD) gpdk090_pmos1v w=0.24u l=0.1u ad=0.0816p as=0.0816p pd=1.16u ps=1.16u
    I_MXI0_I38_MP12 (VDD B_7 XI0_I38_xbn VDD) gpdk090_pmos1v w=0.24u l=0.1u ad=0.0816p as=0.0816p pd=1.16u ps=1.16u
    I_MXI0_I38_MP18 (XI0_I38_xp1 XI0_I38_xbn VDD VDD) gpdk090_pmos1v w=0.48u l=0.1u ad=0.1056p as=0.1632p pd=0.92u ps=1.64u
    I_MXI0_I38_MP20 (I0_pp3_4 B_7 XI0_I38_xp1 VDD) gpdk090_pmos1v w=0.48u l=0.1u ad=0.1056p as=0.1056p pd=0.92u ps=0.92u
    I_MXI0_I38_MP19 (XI0_I38_xp1 XI0_I38_xan I0_pp3_4 VDD) gpdk090_pmos1v w=0.48u l=0.1u ad=0.1056p as=0.1056p pd=0.92u ps=0.92u
    I_MXI0_I38_MP17 (VDD XI0_I38_xn XI0_I38_xp1 VDD) gpdk090_pmos1v w=0.48u l=0.1u ad=0.1632p as=0.1056p pd=1.64u ps=0.92u
    I_MXI0_I38_MP6 (XI0_I38_p1 A_4 VDD VDD) gpdk090_pmos1v w=0.48u l=0.1u ad=0.1056p as=0.1632p pd=0.92u ps=1.64u
    I_MXI0_I38_MP8 (XI0_I38_xn A_3 XI0_I38_p1 VDD) gpdk090_pmos1v w=0.48u l=0.1u ad=0.1056p as=0.1056p pd=0.92u ps=0.92u
    I_MXI0_I38_MP7 (XI0_I38_p1 I0_two3 XI0_I38_xn VDD) gpdk090_pmos1v w=0.48u l=0.1u ad=0.1056p as=0.1056p pd=0.92u ps=0.92u
    I_MXI0_I38_MP5 (VDD I0_one3 XI0_I38_p1 VDD) gpdk090_pmos1v w=0.48u l=0.1u ad=0.1632p as=0.1056p pd=1.64u ps=0.92u
    I_MXI0_I38_MP10 (XI0_I38_xan XI0_I38_xn VDD VDD) gpdk090_pmos1v w=0.24u l=0.1u ad=0.0816p as=0.0816p pd=1.16u ps=1.16u
    I_MXI0_I39_MP12 (VDD B_7 XI0_I39_xbn VDD) gpdk090_pmos1v w=0.24u l=0.1u ad=0.0816p as=0.0816p pd=1.16u ps=1.16u
    I_MXI0_I39_MP18 (XI0_I39_xp1 XI0_I39_xbn VDD VDD) gpdk090_pmos1v w=0.48u l=0.1u ad=0.1056p as=0.1632p pd=0.92u ps=1.64u
    I_MXI0_I39_MP20 (I0_pp3_5 B_7 XI0_I39_xp1 VDD) gpdk090_pmos1v w=0.48u l=0.1u ad=0.1056p as=0.1056p pd=0.92u ps=0.92u
    I_MXI0_I39_MP19 (XI0_I39_xp1 XI0_I39_xan I0_pp3_5 VDD) gpdk090_pmos1v w=0.48u l=0.1u ad=0.1056p as=0.1056p pd=0.92u ps=0.92u
    I_MXI0_I39_MP17 (VDD XI0_I39_xn XI0_I39_xp1 VDD) gpdk090_pmos1v w=0.48u l=0.1u ad=0.1632p as=0.1056p pd=1.64u ps=0.92u
    I_MXI0_I39_MP6 (XI0_I39_p1 A_5 VDD VDD) gpdk090_pmos1v w=0.48u l=0.1u ad=0.1056p as=0.1632p pd=0.92u ps=1.64u
    I_MXI0_I39_MP8 (XI0_I39_xn A_4 XI0_I39_p1 VDD) gpdk090_pmos1v w=0.48u l=0.1u ad=0.1056p as=0.1056p pd=0.92u ps=0.92u
    I_MXI0_I39_MP7 (XI0_I39_p1 I0_two3 XI0_I39_xn VDD) gpdk090_pmos1v w=0.48u l=0.1u ad=0.1056p as=0.1056p pd=0.92u ps=0.92u
    I_MXI0_I39_MP5 (VDD I0_one3 XI0_I39_p1 VDD) gpdk090_pmos1v w=0.48u l=0.1u ad=0.1632p as=0.1056p pd=1.64u ps=0.92u
    I_MXI0_I39_MP10 (XI0_I39_xan XI0_I39_xn VDD VDD) gpdk090_pmos1v w=0.24u l=0.1u ad=0.0816p as=0.0816p pd=1.16u ps=1.16u
    I_MXI0_I18_MP12 (VDD B_3 XI0_I18_xbn VDD) gpdk090_pmos1v w=0.24u l=0.1u ad=0.0816p as=0.0816p pd=1.16u ps=1.16u
    I_MXI0_I18_MP18 (XI0_I18_xp1 XI0_I18_xbn VDD VDD) gpdk090_pmos1v w=0.48u l=0.1u ad=0.1056p as=0.1632p pd=0.92u ps=1.64u
    I_MXI0_I18_MP20 (I0_pp1_6 B_3 XI0_I18_xp1 VDD) gpdk090_pmos1v w=0.48u l=0.1u ad=0.1056p as=0.1056p pd=0.92u ps=0.92u
    I_MXI0_I18_MP19 (XI0_I18_xp1 XI0_I18_xan I0_pp1_6 VDD) gpdk090_pmos1v w=0.48u l=0.1u ad=0.1056p as=0.1056p pd=0.92u ps=0.92u
    I_MXI0_I18_MP17 (VDD XI0_I18_xn XI0_I18_xp1 VDD) gpdk090_pmos1v w=0.48u l=0.1u ad=0.1632p as=0.1056p pd=1.64u ps=0.92u
    I_MXI0_I18_MP6 (XI0_I18_p1 A_6 VDD VDD) gpdk090_pmos1v w=0.48u l=0.1u ad=0.1056p as=0.1632p pd=0.92u ps=1.64u
    I_MXI0_I18_MP8 (XI0_I18_xn A_5 XI0_I18_p1 VDD) gpdk090_pmos1v w=0.48u l=0.1u ad=0.1056p as=0.1056p pd=0.92u ps=0.92u
    I_MXI0_I18_MP7 (XI0_I18_p1 I0_two1 XI0_I18_xn VDD) gpdk090_pmos1v w=0.48u l=0.1u ad=0.1056p as=0.1056p pd=0.92u ps=0.92u
    I_MXI0_I18_MP5 (VDD I0_one1 XI0_I18_p1 VDD) gpdk090_pmos1v w=0.48u l=0.1u ad=0.1632p as=0.1056p pd=1.64u ps=0.92u
    I_MXI0_I18_MP10 (XI0_I18_xan XI0_I18_xn VDD VDD) gpdk090_pmos1v w=0.24u l=0.1u ad=0.0816p as=0.0816p pd=1.16u ps=1.16u
    I_MXI0_I27_MP12 (VDD B_5 XI0_I27_xbn VDD) gpdk090_pmos1v w=0.24u l=0.1u ad=0.0816p as=0.0816p pd=1.16u ps=1.16u
    I_MXI0_I27_MP18 (XI0_I27_xp1 XI0_I27_xbn VDD VDD) gpdk090_pmos1v w=0.48u l=0.1u ad=0.1056p as=0.1632p pd=0.92u ps=1.64u
    I_MXI0_I27_MP20 (I0_pp2_4 B_5 XI0_I27_xp1 VDD) gpdk090_pmos1v w=0.48u l=0.1u ad=0.1056p as=0.1056p pd=0.92u ps=0.92u
    I_MXI0_I27_MP19 (XI0_I27_xp1 XI0_I27_xan I0_pp2_4 VDD) gpdk090_pmos1v w=0.48u l=0.1u ad=0.1056p as=0.1056p pd=0.92u ps=0.92u
    I_MXI0_I27_MP17 (VDD XI0_I27_xn XI0_I27_xp1 VDD) gpdk090_pmos1v w=0.48u l=0.1u ad=0.1632p as=0.1056p pd=1.64u ps=0.92u
    I_MXI0_I27_MP6 (XI0_I27_p1 A_4 VDD VDD) gpdk090_pmos1v w=0.48u l=0.1u ad=0.1056p as=0.1632p pd=0.92u ps=1.64u
    I_MXI0_I27_MP8 (XI0_I27_xn A_3 XI0_I27_p1 VDD) gpdk090_pmos1v w=0.48u l=0.1u ad=0.1056p as=0.1056p pd=0.92u ps=0.92u
    I_MXI0_I27_MP7 (XI0_I27_p1 I0_two2 XI0_I27_xn VDD) gpdk090_pmos1v w=0.48u l=0.1u ad=0.1056p as=0.1056p pd=0.92u ps=0.92u
    I_MXI0_I27_MP5 (VDD I0_one2 XI0_I27_p1 VDD) gpdk090_pmos1v w=0.48u l=0.1u ad=0.1632p as=0.1056p pd=1.64u ps=0.92u
    I_MXI0_I27_MP10 (XI0_I27_xan XI0_I27_xn VDD VDD) gpdk090_pmos1v w=0.24u l=0.1u ad=0.0816p as=0.0816p pd=1.16u ps=1.16u
    I_MXI0_I37_MP12 (VDD B_7 XI0_I37_xbn VDD) gpdk090_pmos1v w=0.24u l=0.1u ad=0.0816p as=0.0816p pd=1.16u ps=1.16u
    I_MXI0_I37_MP18 (XI0_I37_xp1 XI0_I37_xbn VDD VDD) gpdk090_pmos1v w=0.48u l=0.1u ad=0.1056p as=0.1632p pd=0.92u ps=1.64u
    I_MXI0_I37_MP20 (I0_pp3_3 B_7 XI0_I37_xp1 VDD) gpdk090_pmos1v w=0.48u l=0.1u ad=0.1056p as=0.1056p pd=0.92u ps=0.92u
    I_MXI0_I37_MP19 (XI0_I37_xp1 XI0_I37_xan I0_pp3_3 VDD) gpdk090_pmos1v w=0.48u l=0.1u ad=0.1056p as=0.1056p pd=0.92u ps=0.92u
    I_MXI0_I37_MP17 (VDD XI0_I37_xn XI0_I37_xp1 VDD) gpdk090_pmos1v w=0.48u l=0.1u ad=0.1632p as=0.1056p pd=1.64u ps=0.92u
    I_MXI0_I37_MP6 (XI0_I37_p1 A_3 VDD VDD) gpdk090_pmos1v w=0.48u l=0.1u ad=0.1056p as=0.1632p pd=0.92u ps=1.64u
    I_MXI0_I37_MP8 (XI0_I37_xn A_2 XI0_I37_p1 VDD) gpdk090_pmos1v w=0.48u l=0.1u ad=0.1056p as=0.1056p pd=0.92u ps=0.92u
    I_MXI0_I37_MP7 (XI0_I37_p1 I0_two3 XI0_I37_xn VDD) gpdk090_pmos1v w=0.48u l=0.1u ad=0.1056p as=0.1056p pd=0.92u ps=0.92u
    I_MXI0_I37_MP5 (VDD I0_one3 XI0_I37_p1 VDD) gpdk090_pmos1v w=0.48u l=0.1u ad=0.1632p as=0.1056p pd=1.64u ps=0.92u
    I_MXI0_I37_MP10 (XI0_I37_xan XI0_I37_xn VDD VDD) gpdk090_pmos1v w=0.24u l=0.1u ad=0.0816p as=0.0816p pd=1.16u ps=1.16u
    I_MXI0_I26_MP12 (VDD B_5 XI0_I26_xbn VDD) gpdk090_pmos1v w=0.24u l=0.1u ad=0.0816p as=0.0816p pd=1.16u ps=1.16u
    I_MXI0_I26_MP18 (XI0_I26_xp1 XI0_I26_xbn VDD VDD) gpdk090_pmos1v w=0.48u l=0.1u ad=0.1056p as=0.1632p pd=0.92u ps=1.64u
    I_MXI0_I26_MP20 (I0_pp2_3 B_5 XI0_I26_xp1 VDD) gpdk090_pmos1v w=0.48u l=0.1u ad=0.1056p as=0.1056p pd=0.92u ps=0.92u
    I_MXI0_I26_MP19 (XI0_I26_xp1 XI0_I26_xan I0_pp2_3 VDD) gpdk090_pmos1v w=0.48u l=0.1u ad=0.1056p as=0.1056p pd=0.92u ps=0.92u
    I_MXI0_I26_MP17 (VDD XI0_I26_xn XI0_I26_xp1 VDD) gpdk090_pmos1v w=0.48u l=0.1u ad=0.1632p as=0.1056p pd=1.64u ps=0.92u
    I_MXI0_I26_MP6 (XI0_I26_p1 A_3 VDD VDD) gpdk090_pmos1v w=0.48u l=0.1u ad=0.1056p as=0.1632p pd=0.92u ps=1.64u
    I_MXI0_I26_MP8 (XI0_I26_xn A_2 XI0_I26_p1 VDD) gpdk090_pmos1v w=0.48u l=0.1u ad=0.1056p as=0.1056p pd=0.92u ps=0.92u
    I_MXI0_I26_MP7 (XI0_I26_p1 I0_two2 XI0_I26_xn VDD) gpdk090_pmos1v w=0.48u l=0.1u ad=0.1056p as=0.1056p pd=0.92u ps=0.92u
    I_MXI0_I26_MP5 (VDD I0_one2 XI0_I26_p1 VDD) gpdk090_pmos1v w=0.48u l=0.1u ad=0.1632p as=0.1056p pd=1.64u ps=0.92u
    I_MXI0_I26_MP10 (XI0_I26_xan XI0_I26_xn VDD VDD) gpdk090_pmos1v w=0.24u l=0.1u ad=0.0816p as=0.0816p pd=1.16u ps=1.16u
    I_MXI0_I36_MP12 (VDD B_7 XI0_I36_xbn VDD) gpdk090_pmos1v w=0.24u l=0.1u ad=0.0816p as=0.0816p pd=1.16u ps=1.16u
    I_MXI0_I36_MP18 (XI0_I36_xp1 XI0_I36_xbn VDD VDD) gpdk090_pmos1v w=0.48u l=0.1u ad=0.1056p as=0.1632p pd=0.92u ps=1.64u
    I_MXI0_I36_MP20 (I0_pp3_2 B_7 XI0_I36_xp1 VDD) gpdk090_pmos1v w=0.48u l=0.1u ad=0.1056p as=0.1056p pd=0.92u ps=0.92u
    I_MXI0_I36_MP19 (XI0_I36_xp1 XI0_I36_xan I0_pp3_2 VDD) gpdk090_pmos1v w=0.48u l=0.1u ad=0.1056p as=0.1056p pd=0.92u ps=0.92u
    I_MXI0_I36_MP17 (VDD XI0_I36_xn XI0_I36_xp1 VDD) gpdk090_pmos1v w=0.48u l=0.1u ad=0.1632p as=0.1056p pd=1.64u ps=0.92u
    I_MXI0_I36_MP6 (XI0_I36_p1 A_2 VDD VDD) gpdk090_pmos1v w=0.48u l=0.1u ad=0.1056p as=0.1632p pd=0.92u ps=1.64u
    I_MXI0_I36_MP8 (XI0_I36_xn A_1 XI0_I36_p1 VDD) gpdk090_pmos1v w=0.48u l=0.1u ad=0.1056p as=0.1056p pd=0.92u ps=0.92u
    I_MXI0_I36_MP7 (XI0_I36_p1 I0_two3 XI0_I36_xn VDD) gpdk090_pmos1v w=0.48u l=0.1u ad=0.1056p as=0.1056p pd=0.92u ps=0.92u
    I_MXI0_I36_MP5 (VDD I0_one3 XI0_I36_p1 VDD) gpdk090_pmos1v w=0.48u l=0.1u ad=0.1632p as=0.1056p pd=1.64u ps=0.92u
    I_MXI0_I36_MP10 (XI0_I36_xan XI0_I36_xn VDD VDD) gpdk090_pmos1v w=0.24u l=0.1u ad=0.0816p as=0.0816p pd=1.16u ps=1.16u
    I_MXI0_I15_MP12 (VDD B_3 XI0_I15_xbn VDD) gpdk090_pmos1v w=0.24u l=0.1u ad=0.0816p as=0.0816p pd=1.16u ps=1.16u
    I_MXI0_I15_MP18 (XI0_I15_xp1 XI0_I15_xbn VDD VDD) gpdk090_pmos1v w=0.48u l=0.1u ad=0.1056p as=0.1632p pd=0.92u ps=1.64u
    I_MXI0_I15_MP20 (I0_pp1_3 B_3 XI0_I15_xp1 VDD) gpdk090_pmos1v w=0.48u l=0.1u ad=0.1056p as=0.1056p pd=0.92u ps=0.92u
    I_MXI0_I15_MP19 (XI0_I15_xp1 XI0_I15_xan I0_pp1_3 VDD) gpdk090_pmos1v w=0.48u l=0.1u ad=0.1056p as=0.1056p pd=0.92u ps=0.92u
    I_MXI0_I15_MP17 (VDD XI0_I15_xn XI0_I15_xp1 VDD) gpdk090_pmos1v w=0.48u l=0.1u ad=0.1632p as=0.1056p pd=1.64u ps=0.92u
    I_MXI0_I15_MP6 (XI0_I15_p1 A_3 VDD VDD) gpdk090_pmos1v w=0.48u l=0.1u ad=0.1056p as=0.1632p pd=0.92u ps=1.64u
    I_MXI0_I15_MP8 (XI0_I15_xn A_2 XI0_I15_p1 VDD) gpdk090_pmos1v w=0.48u l=0.1u ad=0.1056p as=0.1056p pd=0.92u ps=0.92u
    I_MXI0_I15_MP7 (XI0_I15_p1 I0_two1 XI0_I15_xn VDD) gpdk090_pmos1v w=0.48u l=0.1u ad=0.1056p as=0.1056p pd=0.92u ps=0.92u
    I_MXI0_I15_MP5 (VDD I0_one1 XI0_I15_p1 VDD) gpdk090_pmos1v w=0.48u l=0.1u ad=0.1632p as=0.1056p pd=1.64u ps=0.92u
    I_MXI0_I15_MP10 (XI0_I15_xan XI0_I15_xn VDD VDD) gpdk090_pmos1v w=0.24u l=0.1u ad=0.0816p as=0.0816p pd=1.16u ps=1.16u
    I_MXI0_I17_MP12 (VDD B_3 XI0_I17_xbn VDD) gpdk090_pmos1v w=0.24u l=0.1u ad=0.0816p as=0.0816p pd=1.16u ps=1.16u
    I_MXI0_I17_MP18 (XI0_I17_xp1 XI0_I17_xbn VDD VDD) gpdk090_pmos1v w=0.48u l=0.1u ad=0.1056p as=0.1632p pd=0.92u ps=1.64u
    I_MXI0_I17_MP20 (I0_pp1_5 B_3 XI0_I17_xp1 VDD) gpdk090_pmos1v w=0.48u l=0.1u ad=0.1056p as=0.1056p pd=0.92u ps=0.92u
    I_MXI0_I17_MP19 (XI0_I17_xp1 XI0_I17_xan I0_pp1_5 VDD) gpdk090_pmos1v w=0.48u l=0.1u ad=0.1056p as=0.1056p pd=0.92u ps=0.92u
    I_MXI0_I17_MP17 (VDD XI0_I17_xn XI0_I17_xp1 VDD) gpdk090_pmos1v w=0.48u l=0.1u ad=0.1632p as=0.1056p pd=1.64u ps=0.92u
    I_MXI0_I17_MP6 (XI0_I17_p1 A_5 VDD VDD) gpdk090_pmos1v w=0.48u l=0.1u ad=0.1056p as=0.1632p pd=0.92u ps=1.64u
    I_MXI0_I17_MP8 (XI0_I17_xn A_4 XI0_I17_p1 VDD) gpdk090_pmos1v w=0.48u l=0.1u ad=0.1056p as=0.1056p pd=0.92u ps=0.92u
    I_MXI0_I17_MP7 (XI0_I17_p1 I0_two1 XI0_I17_xn VDD) gpdk090_pmos1v w=0.48u l=0.1u ad=0.1056p as=0.1056p pd=0.92u ps=0.92u
    I_MXI0_I17_MP5 (VDD I0_one1 XI0_I17_p1 VDD) gpdk090_pmos1v w=0.48u l=0.1u ad=0.1632p as=0.1056p pd=1.64u ps=0.92u
    I_MXI0_I17_MP10 (XI0_I17_xan XI0_I17_xn VDD VDD) gpdk090_pmos1v w=0.24u l=0.1u ad=0.0816p as=0.0816p pd=1.16u ps=1.16u
    I_MXI0_I25_MP12 (VDD B_5 XI0_I25_xbn VDD) gpdk090_pmos1v w=0.24u l=0.1u ad=0.0816p as=0.0816p pd=1.16u ps=1.16u
    I_MXI0_I25_MP18 (XI0_I25_xp1 XI0_I25_xbn VDD VDD) gpdk090_pmos1v w=0.48u l=0.1u ad=0.1056p as=0.1632p pd=0.92u ps=1.64u
    I_MXI0_I25_MP20 (I0_pp2_2 B_5 XI0_I25_xp1 VDD) gpdk090_pmos1v w=0.48u l=0.1u ad=0.1056p as=0.1056p pd=0.92u ps=0.92u
    I_MXI0_I25_MP19 (XI0_I25_xp1 XI0_I25_xan I0_pp2_2 VDD) gpdk090_pmos1v w=0.48u l=0.1u ad=0.1056p as=0.1056p pd=0.92u ps=0.92u
    I_MXI0_I25_MP17 (VDD XI0_I25_xn XI0_I25_xp1 VDD) gpdk090_pmos1v w=0.48u l=0.1u ad=0.1632p as=0.1056p pd=1.64u ps=0.92u
    I_MXI0_I25_MP6 (XI0_I25_p1 A_2 VDD VDD) gpdk090_pmos1v w=0.48u l=0.1u ad=0.1056p as=0.1632p pd=0.92u ps=1.64u
    I_MXI0_I25_MP8 (XI0_I25_xn A_1 XI0_I25_p1 VDD) gpdk090_pmos1v w=0.48u l=0.1u ad=0.1056p as=0.1056p pd=0.92u ps=0.92u
    I_MXI0_I25_MP7 (XI0_I25_p1 I0_two2 XI0_I25_xn VDD) gpdk090_pmos1v w=0.48u l=0.1u ad=0.1056p as=0.1056p pd=0.92u ps=0.92u
    I_MXI0_I25_MP5 (VDD I0_one2 XI0_I25_p1 VDD) gpdk090_pmos1v w=0.48u l=0.1u ad=0.1632p as=0.1056p pd=1.64u ps=0.92u
    I_MXI0_I25_MP10 (XI0_I25_xan XI0_I25_xn VDD VDD) gpdk090_pmos1v w=0.24u l=0.1u ad=0.0816p as=0.0816p pd=1.16u ps=1.16u
    I_MXI0_I34_MP12 (VDD B_7 XI0_I34_xbn VDD) gpdk090_pmos1v w=0.24u l=0.1u ad=0.0816p as=0.0816p pd=1.16u ps=1.16u
    I_MXI0_I34_MP18 (XI0_I34_xp1 XI0_I34_xbn VDD VDD) gpdk090_pmos1v w=0.48u l=0.1u ad=0.1056p as=0.1632p pd=0.92u ps=1.64u
    I_MXI0_I34_MP20 (I0_pp3_0 B_7 XI0_I34_xp1 VDD) gpdk090_pmos1v w=0.48u l=0.1u ad=0.1056p as=0.1056p pd=0.92u ps=0.92u
    I_MXI0_I34_MP19 (XI0_I34_xp1 XI0_I34_xan I0_pp3_0 VDD) gpdk090_pmos1v w=0.48u l=0.1u ad=0.1056p as=0.1056p pd=0.92u ps=0.92u
    I_MXI0_I34_MP17 (VDD XI0_I34_xn XI0_I34_xp1 VDD) gpdk090_pmos1v w=0.48u l=0.1u ad=0.1632p as=0.1056p pd=1.64u ps=0.92u
    I_MXI0_I34_MP6 (XI0_I34_p1 A_0 VDD VDD) gpdk090_pmos1v w=0.48u l=0.1u ad=0.1056p as=0.1632p pd=0.92u ps=1.64u
    I_MXI0_I34_MP8 (XI0_I34_xn VSS XI0_I34_p1 VDD) gpdk090_pmos1v w=0.48u l=0.1u ad=0.1056p as=0.1056p pd=0.92u ps=0.92u
    I_MXI0_I34_MP7 (XI0_I34_p1 I0_two3 XI0_I34_xn VDD) gpdk090_pmos1v w=0.48u l=0.1u ad=0.1056p as=0.1056p pd=0.92u ps=0.92u
    I_MXI0_I34_MP5 (VDD I0_one3 XI0_I34_p1 VDD) gpdk090_pmos1v w=0.48u l=0.1u ad=0.1632p as=0.1056p pd=1.64u ps=0.92u
    I_MXI0_I34_MP10 (XI0_I34_xan XI0_I34_xn VDD VDD) gpdk090_pmos1v w=0.24u l=0.1u ad=0.0816p as=0.0816p pd=1.16u ps=1.16u
    I_MXI0_I35_MP12 (VDD B_7 XI0_I35_xbn VDD) gpdk090_pmos1v w=0.24u l=0.1u ad=0.0816p as=0.0816p pd=1.16u ps=1.16u
    I_MXI0_I35_MP18 (XI0_I35_xp1 XI0_I35_xbn VDD VDD) gpdk090_pmos1v w=0.48u l=0.1u ad=0.1056p as=0.1632p pd=0.92u ps=1.64u
    I_MXI0_I35_MP20 (I0_pp3_1 B_7 XI0_I35_xp1 VDD) gpdk090_pmos1v w=0.48u l=0.1u ad=0.1056p as=0.1056p pd=0.92u ps=0.92u
    I_MXI0_I35_MP19 (XI0_I35_xp1 XI0_I35_xan I0_pp3_1 VDD) gpdk090_pmos1v w=0.48u l=0.1u ad=0.1056p as=0.1056p pd=0.92u ps=0.92u
    I_MXI0_I35_MP17 (VDD XI0_I35_xn XI0_I35_xp1 VDD) gpdk090_pmos1v w=0.48u l=0.1u ad=0.1632p as=0.1056p pd=1.64u ps=0.92u
    I_MXI0_I35_MP6 (XI0_I35_p1 A_1 VDD VDD) gpdk090_pmos1v w=0.48u l=0.1u ad=0.1056p as=0.1632p pd=0.92u ps=1.64u
    I_MXI0_I35_MP8 (XI0_I35_xn A_0 XI0_I35_p1 VDD) gpdk090_pmos1v w=0.48u l=0.1u ad=0.1056p as=0.1056p pd=0.92u ps=0.92u
    I_MXI0_I35_MP7 (XI0_I35_p1 I0_two3 XI0_I35_xn VDD) gpdk090_pmos1v w=0.48u l=0.1u ad=0.1056p as=0.1056p pd=0.92u ps=0.92u
    I_MXI0_I35_MP5 (VDD I0_one3 XI0_I35_p1 VDD) gpdk090_pmos1v w=0.48u l=0.1u ad=0.1632p as=0.1056p pd=1.64u ps=0.92u
    I_MXI0_I35_MP10 (XI0_I35_xan XI0_I35_xn VDD VDD) gpdk090_pmos1v w=0.24u l=0.1u ad=0.0816p as=0.0816p pd=1.16u ps=1.16u
    I_MXI0_I14_MP12 (VDD B_3 XI0_I14_xbn VDD) gpdk090_pmos1v w=0.24u l=0.1u ad=0.0816p as=0.0816p pd=1.16u ps=1.16u
    I_MXI0_I14_MP18 (XI0_I14_xp1 XI0_I14_xbn VDD VDD) gpdk090_pmos1v w=0.48u l=0.1u ad=0.1056p as=0.1632p pd=0.92u ps=1.64u
    I_MXI0_I14_MP20 (I0_pp1_2 B_3 XI0_I14_xp1 VDD) gpdk090_pmos1v w=0.48u l=0.1u ad=0.1056p as=0.1056p pd=0.92u ps=0.92u
    I_MXI0_I14_MP19 (XI0_I14_xp1 XI0_I14_xan I0_pp1_2 VDD) gpdk090_pmos1v w=0.48u l=0.1u ad=0.1056p as=0.1056p pd=0.92u ps=0.92u
    I_MXI0_I14_MP17 (VDD XI0_I14_xn XI0_I14_xp1 VDD) gpdk090_pmos1v w=0.48u l=0.1u ad=0.1632p as=0.1056p pd=1.64u ps=0.92u
    I_MXI0_I14_MP6 (XI0_I14_p1 A_2 VDD VDD) gpdk090_pmos1v w=0.48u l=0.1u ad=0.1056p as=0.1632p pd=0.92u ps=1.64u
    I_MXI0_I14_MP8 (XI0_I14_xn A_1 XI0_I14_p1 VDD) gpdk090_pmos1v w=0.48u l=0.1u ad=0.1056p as=0.1056p pd=0.92u ps=0.92u
    I_MXI0_I14_MP7 (XI0_I14_p1 I0_two1 XI0_I14_xn VDD) gpdk090_pmos1v w=0.48u l=0.1u ad=0.1056p as=0.1056p pd=0.92u ps=0.92u
    I_MXI0_I14_MP5 (VDD I0_one1 XI0_I14_p1 VDD) gpdk090_pmos1v w=0.48u l=0.1u ad=0.1632p as=0.1056p pd=1.64u ps=0.92u
    I_MXI0_I14_MP10 (XI0_I14_xan XI0_I14_xn VDD VDD) gpdk090_pmos1v w=0.24u l=0.1u ad=0.0816p as=0.0816p pd=1.16u ps=1.16u
    I_MXI0_I24_MP12 (VDD B_5 XI0_I24_xbn VDD) gpdk090_pmos1v w=0.24u l=0.1u ad=0.0816p as=0.0816p pd=1.16u ps=1.16u
    I_MXI0_I24_MP18 (XI0_I24_xp1 XI0_I24_xbn VDD VDD) gpdk090_pmos1v w=0.48u l=0.1u ad=0.1056p as=0.1632p pd=0.92u ps=1.64u
    I_MXI0_I24_MP20 (I0_pp2_1 B_5 XI0_I24_xp1 VDD) gpdk090_pmos1v w=0.48u l=0.1u ad=0.1056p as=0.1056p pd=0.92u ps=0.92u
    I_MXI0_I24_MP19 (XI0_I24_xp1 XI0_I24_xan I0_pp2_1 VDD) gpdk090_pmos1v w=0.48u l=0.1u ad=0.1056p as=0.1056p pd=0.92u ps=0.92u
    I_MXI0_I24_MP17 (VDD XI0_I24_xn XI0_I24_xp1 VDD) gpdk090_pmos1v w=0.48u l=0.1u ad=0.1632p as=0.1056p pd=1.64u ps=0.92u
    I_MXI0_I24_MP6 (XI0_I24_p1 A_1 VDD VDD) gpdk090_pmos1v w=0.48u l=0.1u ad=0.1056p as=0.1632p pd=0.92u ps=1.64u
    I_MXI0_I24_MP8 (XI0_I24_xn A_0 XI0_I24_p1 VDD) gpdk090_pmos1v w=0.48u l=0.1u ad=0.1056p as=0.1056p pd=0.92u ps=0.92u
    I_MXI0_I24_MP7 (XI0_I24_p1 I0_two2 XI0_I24_xn VDD) gpdk090_pmos1v w=0.48u l=0.1u ad=0.1056p as=0.1056p pd=0.92u ps=0.92u
    I_MXI0_I24_MP5 (VDD I0_one2 XI0_I24_p1 VDD) gpdk090_pmos1v w=0.48u l=0.1u ad=0.1632p as=0.1056p pd=1.64u ps=0.92u
    I_MXI0_I24_MP10 (XI0_I24_xan XI0_I24_xn VDD VDD) gpdk090_pmos1v w=0.24u l=0.1u ad=0.0816p as=0.0816p pd=1.16u ps=1.16u
    I_MXI0_I16_MP12 (VDD B_3 XI0_I16_xbn VDD) gpdk090_pmos1v w=0.24u l=0.1u ad=0.0816p as=0.0816p pd=1.16u ps=1.16u
    I_MXI0_I16_MP18 (XI0_I16_xp1 XI0_I16_xbn VDD VDD) gpdk090_pmos1v w=0.48u l=0.1u ad=0.1056p as=0.1632p pd=0.92u ps=1.64u
    I_MXI0_I16_MP20 (I0_pp1_4 B_3 XI0_I16_xp1 VDD) gpdk090_pmos1v w=0.48u l=0.1u ad=0.1056p as=0.1056p pd=0.92u ps=0.92u
    I_MXI0_I16_MP19 (XI0_I16_xp1 XI0_I16_xan I0_pp1_4 VDD) gpdk090_pmos1v w=0.48u l=0.1u ad=0.1056p as=0.1056p pd=0.92u ps=0.92u
    I_MXI0_I16_MP17 (VDD XI0_I16_xn XI0_I16_xp1 VDD) gpdk090_pmos1v w=0.48u l=0.1u ad=0.1632p as=0.1056p pd=1.64u ps=0.92u
    I_MXI0_I16_MP6 (XI0_I16_p1 A_4 VDD VDD) gpdk090_pmos1v w=0.48u l=0.1u ad=0.1056p as=0.1632p pd=0.92u ps=1.64u
    I_MXI0_I16_MP8 (XI0_I16_xn A_3 XI0_I16_p1 VDD) gpdk090_pmos1v w=0.48u l=0.1u ad=0.1056p as=0.1056p pd=0.92u ps=0.92u
    I_MXI0_I16_MP7 (XI0_I16_p1 I0_two1 XI0_I16_xn VDD) gpdk090_pmos1v w=0.48u l=0.1u ad=0.1056p as=0.1056p pd=0.92u ps=0.92u
    I_MXI0_I16_MP5 (VDD I0_one1 XI0_I16_p1 VDD) gpdk090_pmos1v w=0.48u l=0.1u ad=0.1632p as=0.1056p pd=1.64u ps=0.92u
    I_MXI0_I16_MP10 (XI0_I16_xan XI0_I16_xn VDD VDD) gpdk090_pmos1v w=0.24u l=0.1u ad=0.0816p as=0.0816p pd=1.16u ps=1.16u
    I_MXI0_I23_MP12 (VDD B_5 XI0_I23_xbn VDD) gpdk090_pmos1v w=0.24u l=0.1u ad=0.0816p as=0.0816p pd=1.16u ps=1.16u
    I_MXI0_I23_MP18 (XI0_I23_xp1 XI0_I23_xbn VDD VDD) gpdk090_pmos1v w=0.48u l=0.1u ad=0.1056p as=0.1632p pd=0.92u ps=1.64u
    I_MXI0_I23_MP20 (I0_pp2_0 B_5 XI0_I23_xp1 VDD) gpdk090_pmos1v w=0.48u l=0.1u ad=0.1056p as=0.1056p pd=0.92u ps=0.92u
    I_MXI0_I23_MP19 (XI0_I23_xp1 XI0_I23_xan I0_pp2_0 VDD) gpdk090_pmos1v w=0.48u l=0.1u ad=0.1056p as=0.1056p pd=0.92u ps=0.92u
    I_MXI0_I23_MP17 (VDD XI0_I23_xn XI0_I23_xp1 VDD) gpdk090_pmos1v w=0.48u l=0.1u ad=0.1632p as=0.1056p pd=1.64u ps=0.92u
    I_MXI0_I23_MP6 (XI0_I23_p1 A_0 VDD VDD) gpdk090_pmos1v w=0.48u l=0.1u ad=0.1056p as=0.1632p pd=0.92u ps=1.64u
    I_MXI0_I23_MP8 (XI0_I23_xn VSS XI0_I23_p1 VDD) gpdk090_pmos1v w=0.48u l=0.1u ad=0.1056p as=0.1056p pd=0.92u ps=0.92u
    I_MXI0_I23_MP7 (XI0_I23_p1 I0_two2 XI0_I23_xn VDD) gpdk090_pmos1v w=0.48u l=0.1u ad=0.1056p as=0.1056p pd=0.92u ps=0.92u
    I_MXI0_I23_MP5 (VDD I0_one2 XI0_I23_p1 VDD) gpdk090_pmos1v w=0.48u l=0.1u ad=0.1632p as=0.1056p pd=1.64u ps=0.92u
    I_MXI0_I23_MP10 (XI0_I23_xan XI0_I23_xn VDD VDD) gpdk090_pmos1v w=0.24u l=0.1u ad=0.0816p as=0.0816p pd=1.16u ps=1.16u
    I_MXI0_I6_MP12 (VDD B_1 XI0_I6_xbn VDD) gpdk090_pmos1v w=0.24u l=0.1u ad=0.0816p as=0.0816p pd=1.16u ps=1.16u
    I_MXI0_I6_MP18 (XI0_I6_xp1 XI0_I6_xbn VDD VDD) gpdk090_pmos1v w=0.48u l=0.1u ad=0.1056p as=0.1632p pd=0.92u ps=1.64u
    I_MXI0_I6_MP20 (I0_pp0_5 B_1 XI0_I6_xp1 VDD) gpdk090_pmos1v w=0.48u l=0.1u ad=0.1056p as=0.1056p pd=0.92u ps=0.92u
    I_MXI0_I6_MP19 (XI0_I6_xp1 XI0_I6_xan I0_pp0_5 VDD) gpdk090_pmos1v w=0.48u l=0.1u ad=0.1056p as=0.1056p pd=0.92u ps=0.92u
    I_MXI0_I6_MP17 (VDD XI0_I6_xn XI0_I6_xp1 VDD) gpdk090_pmos1v w=0.48u l=0.1u ad=0.1632p as=0.1056p pd=1.64u ps=0.92u
    I_MXI0_I6_MP6 (XI0_I6_p1 A_5 VDD VDD) gpdk090_pmos1v w=0.48u l=0.1u ad=0.1056p as=0.1632p pd=0.92u ps=1.64u
    I_MXI0_I6_MP8 (XI0_I6_xn A_4 XI0_I6_p1 VDD) gpdk090_pmos1v w=0.48u l=0.1u ad=0.1056p as=0.1056p pd=0.92u ps=0.92u
    I_MXI0_I6_MP7 (XI0_I6_p1 I0_two0 XI0_I6_xn VDD) gpdk090_pmos1v w=0.48u l=0.1u ad=0.1056p as=0.1056p pd=0.92u ps=0.92u
    I_MXI0_I6_MP5 (VDD I0_one0 XI0_I6_p1 VDD) gpdk090_pmos1v w=0.48u l=0.1u ad=0.1632p as=0.1056p pd=1.64u ps=0.92u
    I_MXI0_I6_MP10 (XI0_I6_xan XI0_I6_xn VDD VDD) gpdk090_pmos1v w=0.24u l=0.1u ad=0.0816p as=0.0816p pd=1.16u ps=1.16u
    I_MXI0_I8_MP12 (VDD B_1 XI0_I8_xbn VDD) gpdk090_pmos1v w=0.24u l=0.1u ad=0.0816p as=0.0816p pd=1.16u ps=1.16u
    I_MXI0_I8_MP18 (XI0_I8_xp1 XI0_I8_xbn VDD VDD) gpdk090_pmos1v w=0.48u l=0.1u ad=0.1056p as=0.1632p pd=0.92u ps=1.64u
    I_MXI0_I8_MP20 (I0_pp0_7 B_1 XI0_I8_xp1 VDD) gpdk090_pmos1v w=0.48u l=0.1u ad=0.1056p as=0.1056p pd=0.92u ps=0.92u
    I_MXI0_I8_MP19 (XI0_I8_xp1 XI0_I8_xan I0_pp0_7 VDD) gpdk090_pmos1v w=0.48u l=0.1u ad=0.1056p as=0.1056p pd=0.92u ps=0.92u
    I_MXI0_I8_MP17 (VDD XI0_I8_xn XI0_I8_xp1 VDD) gpdk090_pmos1v w=0.48u l=0.1u ad=0.1632p as=0.1056p pd=1.64u ps=0.92u
    I_MXI0_I8_MP6 (XI0_I8_p1 A_7 VDD VDD) gpdk090_pmos1v w=0.48u l=0.1u ad=0.1056p as=0.1632p pd=0.92u ps=1.64u
    I_MXI0_I8_MP8 (XI0_I8_xn A_6 XI0_I8_p1 VDD) gpdk090_pmos1v w=0.48u l=0.1u ad=0.1056p as=0.1056p pd=0.92u ps=0.92u
    I_MXI0_I8_MP7 (XI0_I8_p1 I0_two0 XI0_I8_xn VDD) gpdk090_pmos1v w=0.48u l=0.1u ad=0.1056p as=0.1056p pd=0.92u ps=0.92u
    I_MXI0_I8_MP5 (VDD I0_one0 XI0_I8_p1 VDD) gpdk090_pmos1v w=0.48u l=0.1u ad=0.1632p as=0.1056p pd=1.64u ps=0.92u
    I_MXI0_I8_MP10 (XI0_I8_xan XI0_I8_xn VDD VDD) gpdk090_pmos1v w=0.24u l=0.1u ad=0.0816p as=0.0816p pd=1.16u ps=1.16u
    I_MXI0_I12_MP12 (VDD B_3 XI0_I12_xbn VDD) gpdk090_pmos1v w=0.24u l=0.1u ad=0.0816p as=0.0816p pd=1.16u ps=1.16u
    I_MXI0_I12_MP18 (XI0_I12_xp1 XI0_I12_xbn VDD VDD) gpdk090_pmos1v w=0.48u l=0.1u ad=0.1056p as=0.1632p pd=0.92u ps=1.64u
    I_MXI0_I12_MP20 (I0_pp1_0 B_3 XI0_I12_xp1 VDD) gpdk090_pmos1v w=0.48u l=0.1u ad=0.1056p as=0.1056p pd=0.92u ps=0.92u
    I_MXI0_I12_MP19 (XI0_I12_xp1 XI0_I12_xan I0_pp1_0 VDD) gpdk090_pmos1v w=0.48u l=0.1u ad=0.1056p as=0.1056p pd=0.92u ps=0.92u
    I_MXI0_I12_MP17 (VDD XI0_I12_xn XI0_I12_xp1 VDD) gpdk090_pmos1v w=0.48u l=0.1u ad=0.1632p as=0.1056p pd=1.64u ps=0.92u
    I_MXI0_I12_MP6 (XI0_I12_p1 A_0 VDD VDD) gpdk090_pmos1v w=0.48u l=0.1u ad=0.1056p as=0.1632p pd=0.92u ps=1.64u
    I_MXI0_I12_MP8 (XI0_I12_xn VSS XI0_I12_p1 VDD) gpdk090_pmos1v w=0.48u l=0.1u ad=0.1056p as=0.1056p pd=0.92u ps=0.92u
    I_MXI0_I12_MP7 (XI0_I12_p1 I0_two1 XI0_I12_xn VDD) gpdk090_pmos1v w=0.48u l=0.1u ad=0.1056p as=0.1056p pd=0.92u ps=0.92u
    I_MXI0_I12_MP5 (VDD I0_one1 XI0_I12_p1 VDD) gpdk090_pmos1v w=0.48u l=0.1u ad=0.1632p as=0.1056p pd=1.64u ps=0.92u
    I_MXI0_I12_MP10 (XI0_I12_xan XI0_I12_xn VDD VDD) gpdk090_pmos1v w=0.24u l=0.1u ad=0.0816p as=0.0816p pd=1.16u ps=1.16u
    I_MXI0_I13_MP12 (VDD B_3 XI0_I13_xbn VDD) gpdk090_pmos1v w=0.24u l=0.1u ad=0.0816p as=0.0816p pd=1.16u ps=1.16u
    I_MXI0_I13_MP18 (XI0_I13_xp1 XI0_I13_xbn VDD VDD) gpdk090_pmos1v w=0.48u l=0.1u ad=0.1056p as=0.1632p pd=0.92u ps=1.64u
    I_MXI0_I13_MP20 (I0_pp1_1 B_3 XI0_I13_xp1 VDD) gpdk090_pmos1v w=0.48u l=0.1u ad=0.1056p as=0.1056p pd=0.92u ps=0.92u
    I_MXI0_I13_MP19 (XI0_I13_xp1 XI0_I13_xan I0_pp1_1 VDD) gpdk090_pmos1v w=0.48u l=0.1u ad=0.1056p as=0.1056p pd=0.92u ps=0.92u
    I_MXI0_I13_MP17 (VDD XI0_I13_xn XI0_I13_xp1 VDD) gpdk090_pmos1v w=0.48u l=0.1u ad=0.1632p as=0.1056p pd=1.64u ps=0.92u
    I_MXI0_I13_MP6 (XI0_I13_p1 A_1 VDD VDD) gpdk090_pmos1v w=0.48u l=0.1u ad=0.1056p as=0.1632p pd=0.92u ps=1.64u
    I_MXI0_I13_MP8 (XI0_I13_xn A_0 XI0_I13_p1 VDD) gpdk090_pmos1v w=0.48u l=0.1u ad=0.1056p as=0.1056p pd=0.92u ps=0.92u
    I_MXI0_I13_MP7 (XI0_I13_p1 I0_two1 XI0_I13_xn VDD) gpdk090_pmos1v w=0.48u l=0.1u ad=0.1056p as=0.1056p pd=0.92u ps=0.92u
    I_MXI0_I13_MP5 (VDD I0_one1 XI0_I13_p1 VDD) gpdk090_pmos1v w=0.48u l=0.1u ad=0.1632p as=0.1056p pd=1.64u ps=0.92u
    I_MXI0_I13_MP10 (XI0_I13_xan XI0_I13_xn VDD VDD) gpdk090_pmos1v w=0.24u l=0.1u ad=0.0816p as=0.0816p pd=1.16u ps=1.16u
    I_MXI0_I5_MP12 (VDD B_1 XI0_I5_xbn VDD) gpdk090_pmos1v w=0.24u l=0.1u ad=0.0816p as=0.0816p pd=1.16u ps=1.16u
    I_MXI0_I5_MP18 (XI0_I5_xp1 XI0_I5_xbn VDD VDD) gpdk090_pmos1v w=0.48u l=0.1u ad=0.1056p as=0.1632p pd=0.92u ps=1.64u
    I_MXI0_I5_MP20 (I0_pp0_4 B_1 XI0_I5_xp1 VDD) gpdk090_pmos1v w=0.48u l=0.1u ad=0.1056p as=0.1056p pd=0.92u ps=0.92u
    I_MXI0_I5_MP19 (XI0_I5_xp1 XI0_I5_xan I0_pp0_4 VDD) gpdk090_pmos1v w=0.48u l=0.1u ad=0.1056p as=0.1056p pd=0.92u ps=0.92u
    I_MXI0_I5_MP17 (VDD XI0_I5_xn XI0_I5_xp1 VDD) gpdk090_pmos1v w=0.48u l=0.1u ad=0.1632p as=0.1056p pd=1.64u ps=0.92u
    I_MXI0_I5_MP6 (XI0_I5_p1 A_4 VDD VDD) gpdk090_pmos1v w=0.48u l=0.1u ad=0.1056p as=0.1632p pd=0.92u ps=1.64u
    I_MXI0_I5_MP8 (XI0_I5_xn A_3 XI0_I5_p1 VDD) gpdk090_pmos1v w=0.48u l=0.1u ad=0.1056p as=0.1056p pd=0.92u ps=0.92u
    I_MXI0_I5_MP7 (XI0_I5_p1 I0_two0 XI0_I5_xn VDD) gpdk090_pmos1v w=0.48u l=0.1u ad=0.1056p as=0.1056p pd=0.92u ps=0.92u
    I_MXI0_I5_MP5 (VDD I0_one0 XI0_I5_p1 VDD) gpdk090_pmos1v w=0.48u l=0.1u ad=0.1632p as=0.1056p pd=1.64u ps=0.92u
    I_MXI0_I5_MP10 (XI0_I5_xan XI0_I5_xn VDD VDD) gpdk090_pmos1v w=0.24u l=0.1u ad=0.0816p as=0.0816p pd=1.16u ps=1.16u
    I_MXI0_I9_MP12 (VDD B_1 XI0_I9_xbn VDD) gpdk090_pmos1v w=0.24u l=0.1u ad=0.0816p as=0.0816p pd=1.16u ps=1.16u
    I_MXI0_I9_MP18 (XI0_I9_xp1 XI0_I9_xbn VDD VDD) gpdk090_pmos1v w=0.48u l=0.1u ad=0.1056p as=0.1632p pd=0.92u ps=1.64u
    I_MXI0_I9_MP20 (I0_pp0_8 B_1 XI0_I9_xp1 VDD) gpdk090_pmos1v w=0.48u l=0.1u ad=0.1056p as=0.1056p pd=0.92u ps=0.92u
    I_MXI0_I9_MP19 (XI0_I9_xp1 XI0_I9_xan I0_pp0_8 VDD) gpdk090_pmos1v w=0.48u l=0.1u ad=0.1056p as=0.1056p pd=0.92u ps=0.92u
    I_MXI0_I9_MP17 (VDD XI0_I9_xn XI0_I9_xp1 VDD) gpdk090_pmos1v w=0.48u l=0.1u ad=0.1632p as=0.1056p pd=1.64u ps=0.92u
    I_MXI0_I9_MP6 (XI0_I9_p1 A_7 VDD VDD) gpdk090_pmos1v w=0.48u l=0.1u ad=0.1056p as=0.1632p pd=0.92u ps=1.64u
    I_MXI0_I9_MP8 (XI0_I9_xn A_7 XI0_I9_p1 VDD) gpdk090_pmos1v w=0.48u l=0.1u ad=0.1056p as=0.1056p pd=0.92u ps=0.92u
    I_MXI0_I9_MP7 (XI0_I9_p1 I0_two0 XI0_I9_xn VDD) gpdk090_pmos1v w=0.48u l=0.1u ad=0.1056p as=0.1056p pd=0.92u ps=0.92u
    I_MXI0_I9_MP5 (VDD I0_one0 XI0_I9_p1 VDD) gpdk090_pmos1v w=0.48u l=0.1u ad=0.1632p as=0.1056p pd=1.64u ps=0.92u
    I_MXI0_I9_MP10 (XI0_I9_xan XI0_I9_xn VDD VDD) gpdk090_pmos1v w=0.24u l=0.1u ad=0.0816p as=0.0816p pd=1.16u ps=1.16u
    I_MXI0_I7_MP12 (VDD B_1 XI0_I7_xbn VDD) gpdk090_pmos1v w=0.24u l=0.1u ad=0.0816p as=0.0816p pd=1.16u ps=1.16u
    I_MXI0_I7_MP18 (XI0_I7_xp1 XI0_I7_xbn VDD VDD) gpdk090_pmos1v w=0.48u l=0.1u ad=0.1056p as=0.1632p pd=0.92u ps=1.64u
    I_MXI0_I7_MP20 (I0_pp0_6 B_1 XI0_I7_xp1 VDD) gpdk090_pmos1v w=0.48u l=0.1u ad=0.1056p as=0.1056p pd=0.92u ps=0.92u
    I_MXI0_I7_MP19 (XI0_I7_xp1 XI0_I7_xan I0_pp0_6 VDD) gpdk090_pmos1v w=0.48u l=0.1u ad=0.1056p as=0.1056p pd=0.92u ps=0.92u
    I_MXI0_I7_MP17 (VDD XI0_I7_xn XI0_I7_xp1 VDD) gpdk090_pmos1v w=0.48u l=0.1u ad=0.1632p as=0.1056p pd=1.64u ps=0.92u
    I_MXI0_I7_MP6 (XI0_I7_p1 A_6 VDD VDD) gpdk090_pmos1v w=0.48u l=0.1u ad=0.1056p as=0.1632p pd=0.92u ps=1.64u
    I_MXI0_I7_MP8 (XI0_I7_xn A_5 XI0_I7_p1 VDD) gpdk090_pmos1v w=0.48u l=0.1u ad=0.1056p as=0.1056p pd=0.92u ps=0.92u
    I_MXI0_I7_MP7 (XI0_I7_p1 I0_two0 XI0_I7_xn VDD) gpdk090_pmos1v w=0.48u l=0.1u ad=0.1056p as=0.1056p pd=0.92u ps=0.92u
    I_MXI0_I7_MP5 (VDD I0_one0 XI0_I7_p1 VDD) gpdk090_pmos1v w=0.48u l=0.1u ad=0.1632p as=0.1056p pd=1.64u ps=0.92u
    I_MXI0_I7_MP10 (XI0_I7_xan XI0_I7_xn VDD VDD) gpdk090_pmos1v w=0.24u l=0.1u ad=0.0816p as=0.0816p pd=1.16u ps=1.16u
    I_MXI0_I4_MP12 (VDD B_1 XI0_I4_xbn VDD) gpdk090_pmos1v w=0.24u l=0.1u ad=0.0816p as=0.0816p pd=1.16u ps=1.16u
    I_MXI0_I4_MP18 (XI0_I4_xp1 XI0_I4_xbn VDD VDD) gpdk090_pmos1v w=0.48u l=0.1u ad=0.1056p as=0.1632p pd=0.92u ps=1.64u
    I_MXI0_I4_MP20 (I0_pp0_3 B_1 XI0_I4_xp1 VDD) gpdk090_pmos1v w=0.48u l=0.1u ad=0.1056p as=0.1056p pd=0.92u ps=0.92u
    I_MXI0_I4_MP19 (XI0_I4_xp1 XI0_I4_xan I0_pp0_3 VDD) gpdk090_pmos1v w=0.48u l=0.1u ad=0.1056p as=0.1056p pd=0.92u ps=0.92u
    I_MXI0_I4_MP17 (VDD XI0_I4_xn XI0_I4_xp1 VDD) gpdk090_pmos1v w=0.48u l=0.1u ad=0.1632p as=0.1056p pd=1.64u ps=0.92u
    I_MXI0_I4_MP6 (XI0_I4_p1 A_3 VDD VDD) gpdk090_pmos1v w=0.48u l=0.1u ad=0.1056p as=0.1632p pd=0.92u ps=1.64u
    I_MXI0_I4_MP8 (XI0_I4_xn A_2 XI0_I4_p1 VDD) gpdk090_pmos1v w=0.48u l=0.1u ad=0.1056p as=0.1056p pd=0.92u ps=0.92u
    I_MXI0_I4_MP7 (XI0_I4_p1 I0_two0 XI0_I4_xn VDD) gpdk090_pmos1v w=0.48u l=0.1u ad=0.1056p as=0.1056p pd=0.92u ps=0.92u
    I_MXI0_I4_MP5 (VDD I0_one0 XI0_I4_p1 VDD) gpdk090_pmos1v w=0.48u l=0.1u ad=0.1632p as=0.1056p pd=1.64u ps=0.92u
    I_MXI0_I4_MP10 (XI0_I4_xan XI0_I4_xn VDD VDD) gpdk090_pmos1v w=0.24u l=0.1u ad=0.0816p as=0.0816p pd=1.16u ps=1.16u
    I_MXI0_I2_MP12 (VDD B_1 XI0_I2_xbn VDD) gpdk090_pmos1v w=0.24u l=0.1u ad=0.0816p as=0.0816p pd=1.16u ps=1.16u
    I_MXI0_I2_MP18 (XI0_I2_xp1 XI0_I2_xbn VDD VDD) gpdk090_pmos1v w=0.48u l=0.1u ad=0.1056p as=0.1632p pd=0.92u ps=1.64u
    I_MXI0_I2_MP20 (I0_pp0_1 B_1 XI0_I2_xp1 VDD) gpdk090_pmos1v w=0.48u l=0.1u ad=0.1056p as=0.1056p pd=0.92u ps=0.92u
    I_MXI0_I2_MP19 (XI0_I2_xp1 XI0_I2_xan I0_pp0_1 VDD) gpdk090_pmos1v w=0.48u l=0.1u ad=0.1056p as=0.1056p pd=0.92u ps=0.92u
    I_MXI0_I2_MP17 (VDD XI0_I2_xn XI0_I2_xp1 VDD) gpdk090_pmos1v w=0.48u l=0.1u ad=0.1632p as=0.1056p pd=1.64u ps=0.92u
    I_MXI0_I2_MP6 (XI0_I2_p1 A_1 VDD VDD) gpdk090_pmos1v w=0.48u l=0.1u ad=0.1056p as=0.1632p pd=0.92u ps=1.64u
    I_MXI0_I2_MP8 (XI0_I2_xn A_0 XI0_I2_p1 VDD) gpdk090_pmos1v w=0.48u l=0.1u ad=0.1056p as=0.1056p pd=0.92u ps=0.92u
    I_MXI0_I2_MP7 (XI0_I2_p1 I0_two0 XI0_I2_xn VDD) gpdk090_pmos1v w=0.48u l=0.1u ad=0.1056p as=0.1056p pd=0.92u ps=0.92u
    I_MXI0_I2_MP5 (VDD I0_one0 XI0_I2_p1 VDD) gpdk090_pmos1v w=0.48u l=0.1u ad=0.1632p as=0.1056p pd=1.64u ps=0.92u
    I_MXI0_I2_MP10 (XI0_I2_xan XI0_I2_xn VDD VDD) gpdk090_pmos1v w=0.24u l=0.1u ad=0.0816p as=0.0816p pd=1.16u ps=1.16u
    I_MXI0_I1_MP12 (VDD B_1 XI0_I1_xbn VDD) gpdk090_pmos1v w=0.24u l=0.1u ad=0.0816p as=0.0816p pd=1.16u ps=1.16u
    I_MXI0_I1_MP18 (XI0_I1_xp1 XI0_I1_xbn VDD VDD) gpdk090_pmos1v w=0.48u l=0.1u ad=0.1056p as=0.1632p pd=0.92u ps=1.64u
    I_MXI0_I1_MP20 (I0_pp0_0 B_1 XI0_I1_xp1 VDD) gpdk090_pmos1v w=0.48u l=0.1u ad=0.1056p as=0.1056p pd=0.92u ps=0.92u
    I_MXI0_I1_MP19 (XI0_I1_xp1 XI0_I1_xan I0_pp0_0 VDD) gpdk090_pmos1v w=0.48u l=0.1u ad=0.1056p as=0.1056p pd=0.92u ps=0.92u
    I_MXI0_I1_MP17 (VDD XI0_I1_xn XI0_I1_xp1 VDD) gpdk090_pmos1v w=0.48u l=0.1u ad=0.1632p as=0.1056p pd=1.64u ps=0.92u
    I_MXI0_I1_MP6 (XI0_I1_p1 A_0 VDD VDD) gpdk090_pmos1v w=0.48u l=0.1u ad=0.1056p as=0.1632p pd=0.92u ps=1.64u
    I_MXI0_I1_MP8 (XI0_I1_xn VSS XI0_I1_p1 VDD) gpdk090_pmos1v w=0.48u l=0.1u ad=0.1056p as=0.1056p pd=0.92u ps=0.92u
    I_MXI0_I1_MP7 (XI0_I1_p1 I0_two0 XI0_I1_xn VDD) gpdk090_pmos1v w=0.48u l=0.1u ad=0.1056p as=0.1056p pd=0.92u ps=0.92u
    I_MXI0_I1_MP5 (VDD I0_one0 XI0_I1_p1 VDD) gpdk090_pmos1v w=0.48u l=0.1u ad=0.1632p as=0.1056p pd=1.64u ps=0.92u
    I_MXI0_I1_MP10 (XI0_I1_xan XI0_I1_xn VDD VDD) gpdk090_pmos1v w=0.24u l=0.1u ad=0.0816p as=0.0816p pd=1.16u ps=1.16u
    I_MXI0_I3_MP12 (VDD B_1 XI0_I3_xbn VDD) gpdk090_pmos1v w=0.24u l=0.1u ad=0.0816p as=0.0816p pd=1.16u ps=1.16u
    I_MXI0_I3_MP18 (XI0_I3_xp1 XI0_I3_xbn VDD VDD) gpdk090_pmos1v w=0.48u l=0.1u ad=0.1056p as=0.1632p pd=0.92u ps=1.64u
    I_MXI0_I3_MP20 (I0_pp0_2 B_1 XI0_I3_xp1 VDD) gpdk090_pmos1v w=0.48u l=0.1u ad=0.1056p as=0.1056p pd=0.92u ps=0.92u
    I_MXI0_I3_MP19 (XI0_I3_xp1 XI0_I3_xan I0_pp0_2 VDD) gpdk090_pmos1v w=0.48u l=0.1u ad=0.1056p as=0.1056p pd=0.92u ps=0.92u
    I_MXI0_I3_MP17 (VDD XI0_I3_xn XI0_I3_xp1 VDD) gpdk090_pmos1v w=0.48u l=0.1u ad=0.1632p as=0.1056p pd=1.64u ps=0.92u
    I_MXI0_I3_MP6 (XI0_I3_p1 A_2 VDD VDD) gpdk090_pmos1v w=0.48u l=0.1u ad=0.1056p as=0.1632p pd=0.92u ps=1.64u
    I_MXI0_I3_MP8 (XI0_I3_xn A_1 XI0_I3_p1 VDD) gpdk090_pmos1v w=0.48u l=0.1u ad=0.1056p as=0.1056p pd=0.92u ps=0.92u
    I_MXI0_I3_MP7 (XI0_I3_p1 I0_two0 XI0_I3_xn VDD) gpdk090_pmos1v w=0.48u l=0.1u ad=0.1056p as=0.1056p pd=0.92u ps=0.92u
    I_MXI0_I3_MP5 (VDD I0_one0 XI0_I3_p1 VDD) gpdk090_pmos1v w=0.48u l=0.1u ad=0.1632p as=0.1056p pd=1.64u ps=0.92u
    I_MXI0_I3_MP10 (XI0_I3_xan XI0_I3_xn VDD VDD) gpdk090_pmos1v w=0.24u l=0.1u ad=0.0816p as=0.0816p pd=1.16u ps=1.16u
    I_MXI2_I3_I115_MP1 (I2_I3_hd14 DIVR_6 VDD VDD) gpdk090_pmos1v w=0.24u l=0.1u ad=0.0528p as=0.0816p pd=0.68u ps=1.16u
    I_MXI2_I3_I115_MP0 (VDD I2_SEL_DIV I2_I3_hd14 VDD) gpdk090_pmos1v w=0.24u l=0.1u ad=0.0816p as=0.0528p pd=1.16u ps=0.68u
    I_MXI2_I3_I116_MP1 (Y_14 I2_I3_hd14 VDD VDD) gpdk090_pmos1v w=0.24u l=0.1u ad=0.0528p as=0.0816p pd=0.68u ps=1.16u
    I_MXI2_I3_I116_MP0 (VDD I2_I3_hm14 Y_14 VDD) gpdk090_pmos1v w=0.24u l=0.1u ad=0.0816p as=0.0528p pd=1.16u ps=0.68u
    I_MXI2_I3_I119_MP1 (Y_15 I2_I3_hd15 VDD VDD) gpdk090_pmos1v w=0.24u l=0.1u ad=0.0528p as=0.0816p pd=0.68u ps=1.16u
    I_MXI2_I3_I119_MP0 (VDD I2_I3_hm15 Y_15 VDD) gpdk090_pmos1v w=0.24u l=0.1u ad=0.0816p as=0.0528p pd=1.16u ps=0.68u
    I_MXI2_I3_I117_MP1 (I2_I3_hm15 MULP_15 VDD VDD) gpdk090_pmos1v w=0.24u l=0.1u ad=0.0528p as=0.0816p pd=0.68u ps=1.16u
    I_MXI2_I3_I117_MP0 (VDD I2_SEL_MUL I2_I3_hm15 VDD) gpdk090_pmos1v w=0.24u l=0.1u ad=0.0816p as=0.0528p pd=1.16u ps=0.68u
    I_MXI2_I3_I114_MP1 (I2_I3_hm14 MULP_14 VDD VDD) gpdk090_pmos1v w=0.24u l=0.1u ad=0.0528p as=0.0816p pd=0.68u ps=1.16u
    I_MXI2_I3_I114_MP0 (VDD I2_SEL_MUL I2_I3_hm14 VDD) gpdk090_pmos1v w=0.24u l=0.1u ad=0.0816p as=0.0528p pd=1.16u ps=0.68u
    I_MXI0_I77_I29_XP_MP1 (I0_I77_P5_2n I0_I77_P3_2 VDD VDD) gpdk090_pmos1v w=0.24u l=0.1u ad=0.0528p as=0.0816p pd=0.68u ps=1.16u
    I_MXI0_I77_I29_XP_MP0 (VDD I0_I77_P5_4 I0_I77_P5_2n VDD) gpdk090_pmos1v w=0.24u l=0.1u ad=0.0816p as=0.0528p pd=1.16u ps=0.68u
    I_MXI0_I77_I31_XP_MP1 (I0_I77_P7_4n I0_I77_P5_4 VDD VDD) gpdk090_pmos1v w=0.24u l=0.1u ad=0.0528p as=0.0816p pd=0.68u ps=1.16u
    I_MXI0_I77_I31_XP_MP0 (VDD I0_I77_P7_6 I0_I77_P7_4n VDD) gpdk090_pmos1v w=0.24u l=0.1u ad=0.0816p as=0.0528p pd=1.16u ps=0.68u
    I_MXI0_I77_I7_MP1 (I0_I77_gn7 I0_ha25_0 VDD VDD) gpdk090_pmos1v w=0.24u l=0.1u ad=0.0528p as=0.0816p pd=0.68u ps=1.16u
    I_MXI0_I77_I7_MP0 (VDD I0_ha24_1 I0_I77_gn7 VDD) gpdk090_pmos1v w=0.24u l=0.1u ad=0.0816p as=0.0528p pd=1.16u ps=0.68u
    I_MXI2_I0_I6_MP1 (I2_I0_h10 I2_I0_opn2 VDD VDD) gpdk090_pmos1v w=0.24u l=0.1u ad=0.0528p as=0.0816p pd=0.68u ps=1.16u
    I_MXI2_I0_I6_MP0 (VDD OP_3 I2_I0_h10 VDD) gpdk090_pmos1v w=0.24u l=0.1u ad=0.0816p as=0.0528p pd=1.16u ps=0.68u
    I_MXI2_I0_I5_MP1 (I2_I0_h01 OP_2 VDD VDD) gpdk090_pmos1v w=0.24u l=0.1u ad=0.0528p as=0.0816p pd=0.68u ps=1.16u
    I_MXI2_I0_I5_MP0 (VDD I2_I0_opn3 I2_I0_h01 VDD) gpdk090_pmos1v w=0.24u l=0.1u ad=0.0816p as=0.0528p pd=1.16u ps=0.68u
    I_MXI2_I3_I118_MP1 (I2_I3_hd15 DIVR_7 VDD VDD) gpdk090_pmos1v w=0.24u l=0.1u ad=0.0528p as=0.0816p pd=0.68u ps=1.16u
    I_MXI2_I3_I118_MP0 (VDD I2_SEL_DIV I2_I3_hd15 VDD) gpdk090_pmos1v w=0.24u l=0.1u ad=0.0816p as=0.0528p pd=1.16u ps=0.68u
    I_MXI2_I3_I112_MP1 (I2_I3_hd13 DIVR_5 VDD VDD) gpdk090_pmos1v w=0.24u l=0.1u ad=0.0528p as=0.0816p pd=0.68u ps=1.16u
    I_MXI2_I3_I112_MP0 (VDD I2_SEL_DIV I2_I3_hd13 VDD) gpdk090_pmos1v w=0.24u l=0.1u ad=0.0816p as=0.0528p pd=1.16u ps=0.68u
    I_MXI2_I3_I113_MP1 (Y_13 I2_I3_hd13 VDD VDD) gpdk090_pmos1v w=0.24u l=0.1u ad=0.0528p as=0.0816p pd=0.68u ps=1.16u
    I_MXI2_I3_I113_MP0 (VDD I2_I3_hm13 Y_13 VDD) gpdk090_pmos1v w=0.24u l=0.1u ad=0.0816p as=0.0528p pd=1.16u ps=0.68u
    I_MXI2_I3_I109_MP1 (I2_I3_hd12 DIVR_4 VDD VDD) gpdk090_pmos1v w=0.24u l=0.1u ad=0.0528p as=0.0816p pd=0.68u ps=1.16u
    I_MXI2_I3_I109_MP0 (VDD I2_SEL_DIV I2_I3_hd12 VDD) gpdk090_pmos1v w=0.24u l=0.1u ad=0.0816p as=0.0528p pd=1.16u ps=0.68u
    I_MXI2_I3_I110_MP1 (Y_12 I2_I3_hd12 VDD VDD) gpdk090_pmos1v w=0.24u l=0.1u ad=0.0528p as=0.0816p pd=0.68u ps=1.16u
    I_MXI2_I3_I110_MP0 (VDD I2_I3_hm12 Y_12 VDD) gpdk090_pmos1v w=0.24u l=0.1u ad=0.0816p as=0.0528p pd=1.16u ps=0.68u
    I_MXI2_I4_I11_MP1 (I2_I4_zb3 I2_I4_za7 VDD VDD) gpdk090_pmos1v w=0.24u l=0.1u ad=0.0528p as=0.0816p pd=0.68u ps=1.16u
    I_MXI2_I4_I11_MP0 (VDD I2_I4_za6 I2_I4_zb3 VDD) gpdk090_pmos1v w=0.24u l=0.1u ad=0.0816p as=0.0528p pd=1.16u ps=0.68u
    I_MXI2_I4_I10_MP1 (I2_I4_zb2 I2_I4_za5 VDD VDD) gpdk090_pmos1v w=0.24u l=0.1u ad=0.0528p as=0.0816p pd=0.68u ps=1.16u
    I_MXI2_I4_I10_MP0 (VDD I2_I4_za4 I2_I4_zb2 VDD) gpdk090_pmos1v w=0.24u l=0.1u ad=0.0816p as=0.0528p pd=1.16u ps=0.68u
    I_MXI2_I4_I14_MP1 (I2_I4_zd I2_I4_zc1 VDD VDD) gpdk090_pmos1v w=0.24u l=0.1u ad=0.0528p as=0.0816p pd=0.68u ps=1.16u
    I_MXI2_I4_I14_MP0 (VDD I2_I4_zc0 I2_I4_zd VDD) gpdk090_pmos1v w=0.24u l=0.1u ad=0.0816p as=0.0528p pd=1.16u ps=0.68u
    I_MXI2_I3_I111_MP1 (I2_I3_hm13 MULP_13 VDD VDD) gpdk090_pmos1v w=0.24u l=0.1u ad=0.0528p as=0.0816p pd=0.68u ps=1.16u
    I_MXI2_I3_I111_MP0 (VDD I2_SEL_MUL I2_I3_hm13 VDD) gpdk090_pmos1v w=0.24u l=0.1u ad=0.0816p as=0.0528p pd=1.16u ps=0.68u
    I_MXI2_I3_I108_MP1 (I2_I3_hm12 MULP_12 VDD VDD) gpdk090_pmos1v w=0.24u l=0.1u ad=0.0528p as=0.0816p pd=0.68u ps=1.16u
    I_MXI2_I3_I108_MP0 (VDD I2_SEL_MUL I2_I3_hm12 VDD) gpdk090_pmos1v w=0.24u l=0.1u ad=0.0816p as=0.0528p pd=1.16u ps=0.68u
    I_MXI0_I77_I30_XP_MP1 (I0_I77_P6_3n I0_I77_P4_3 VDD VDD) gpdk090_pmos1v w=0.24u l=0.1u ad=0.0528p as=0.0816p pd=0.68u ps=1.16u
    I_MXI0_I77_I30_XP_MP0 (VDD I0_I77_P6_5 I0_I77_P6_3n VDD) gpdk090_pmos1v w=0.24u l=0.1u ad=0.0816p as=0.0528p pd=1.16u ps=0.68u
    I_MXI0_I77_I4_MP1 (I0_I77_gn4 I0_ha22_0 VDD VDD) gpdk090_pmos1v w=0.24u l=0.1u ad=0.0528p as=0.0816p pd=0.68u ps=1.16u
    I_MXI0_I77_I4_MP0 (VDD I0_ha21_1 I0_I77_gn4 VDD) gpdk090_pmos1v w=0.24u l=0.1u ad=0.0816p as=0.0528p pd=1.16u ps=0.68u
    I_MXI0_I77_I5_MP1 (I0_I77_gn5 I0_ha23_0 VDD VDD) gpdk090_pmos1v w=0.24u l=0.1u ad=0.0528p as=0.0816p pd=0.68u ps=1.16u
    I_MXI0_I77_I5_MP0 (VDD I0_ha22_1 I0_I77_gn5 VDD) gpdk090_pmos1v w=0.24u l=0.1u ad=0.0816p as=0.0528p pd=1.16u ps=0.68u
    I_MXI0_I77_I6_MP1 (I0_I77_gn6 I0_ha24_0 VDD VDD) gpdk090_pmos1v w=0.24u l=0.1u ad=0.0528p as=0.0816p pd=0.68u ps=1.16u
    I_MXI0_I77_I6_MP0 (VDD I0_ha23_1 I0_I77_gn6 VDD) gpdk090_pmos1v w=0.24u l=0.1u ad=0.0816p as=0.0528p pd=1.16u ps=0.68u
    I_MXI2_I3_I91_MP1 (I2_I3_o7_1 I2_I3_n7_3 VDD VDD) gpdk090_pmos1v w=0.24u l=0.1u ad=0.0528p as=0.0816p pd=0.68u ps=1.16u
    I_MXI2_I3_I91_MP0 (VDD I2_I3_n7_2 I2_I3_o7_1 VDD) gpdk090_pmos1v w=0.24u l=0.1u ad=0.0816p as=0.0528p pd=1.16u ps=0.68u
    I_MXI2_I3_I87_MP1 (I2_I3_n7_3 I2_NOT_7 VDD VDD) gpdk090_pmos1v w=0.24u l=0.1u ad=0.0528p as=0.0816p pd=0.68u ps=1.16u
    I_MXI2_I3_I87_MP0 (VDD I2_SEL_NOT I2_I3_n7_3 VDD) gpdk090_pmos1v w=0.24u l=0.1u ad=0.0816p as=0.0528p pd=1.16u ps=0.68u
    I_MXI2_I3_I86_MP1 (I2_I3_n7_2 I2_XOR_7 VDD VDD) gpdk090_pmos1v w=0.24u l=0.1u ad=0.0528p as=0.0816p pd=0.68u ps=1.16u
    I_MXI2_I3_I86_MP0 (VDD I2_SEL_XOR I2_I3_n7_2 VDD) gpdk090_pmos1v w=0.24u l=0.1u ad=0.0816p as=0.0528p pd=1.16u ps=0.68u
    I_MXI2_I0_I8_MP1 (I2_I0_l01 OP_0 VDD VDD) gpdk090_pmos1v w=0.24u l=0.1u ad=0.0528p as=0.0816p pd=0.68u ps=1.16u
    I_MXI2_I0_I8_MP0 (VDD I2_I0_opn1 I2_I0_l01 VDD) gpdk090_pmos1v w=0.24u l=0.1u ad=0.0816p as=0.0528p pd=1.16u ps=0.68u
    I_MXI2_I0_I4_MP1 (I2_I0_h00 I2_I0_opn2 VDD VDD) gpdk090_pmos1v w=0.24u l=0.1u ad=0.0528p as=0.0816p pd=0.68u ps=1.16u
    I_MXI2_I0_I4_MP0 (VDD I2_I0_opn3 I2_I0_h00 VDD) gpdk090_pmos1v w=0.24u l=0.1u ad=0.0816p as=0.0528p pd=1.16u ps=0.68u
    I_MXI2_I0_I7_MP1 (I2_I0_l00 I2_I0_opn0 VDD VDD) gpdk090_pmos1v w=0.24u l=0.1u ad=0.0528p as=0.0816p pd=0.68u ps=1.16u
    I_MXI2_I0_I7_MP0 (VDD I2_I0_opn1 I2_I0_l00 VDD) gpdk090_pmos1v w=0.24u l=0.1u ad=0.0816p as=0.0528p pd=1.16u ps=0.68u
    I_MXI1_I152_I29_XP_MP1 (I1_I152_P5_2n I1_I152_P3_2 VDD VDD) gpdk090_pmos1v w=0.24u l=0.1u ad=0.0528p as=0.0816p pd=0.68u ps=1.16u
    I_MXI1_I152_I29_XP_MP0 (VDD I1_I152_P5_4 I1_I152_P5_2n VDD) gpdk090_pmos1v w=0.24u l=0.1u ad=0.0816p as=0.0528p pd=1.16u ps=0.68u
    I_MXI2_I3_I106_MP1 (I2_I3_hd11 DIVR_3 VDD VDD) gpdk090_pmos1v w=0.24u l=0.1u ad=0.0528p as=0.0816p pd=0.68u ps=1.16u
    I_MXI2_I3_I106_MP0 (VDD I2_SEL_DIV I2_I3_hd11 VDD) gpdk090_pmos1v w=0.24u l=0.1u ad=0.0816p as=0.0528p pd=1.16u ps=0.68u
    I_MXI2_I3_I107_MP1 (Y_11 I2_I3_hd11 VDD VDD) gpdk090_pmos1v w=0.24u l=0.1u ad=0.0528p as=0.0816p pd=0.68u ps=1.16u
    I_MXI2_I3_I107_MP0 (VDD I2_I3_hm11 Y_11 VDD) gpdk090_pmos1v w=0.24u l=0.1u ad=0.0816p as=0.0528p pd=1.16u ps=0.68u
    I_MXI2_I3_I103_MP1 (I2_I3_hd10 DIVR_2 VDD VDD) gpdk090_pmos1v w=0.24u l=0.1u ad=0.0528p as=0.0816p pd=0.68u ps=1.16u
    I_MXI2_I3_I103_MP0 (VDD I2_SEL_DIV I2_I3_hd10 VDD) gpdk090_pmos1v w=0.24u l=0.1u ad=0.0816p as=0.0528p pd=1.16u ps=0.68u
    I_MXI2_I3_I104_MP1 (Y_10 I2_I3_hd10 VDD VDD) gpdk090_pmos1v w=0.24u l=0.1u ad=0.0528p as=0.0816p pd=0.68u ps=1.16u
    I_MXI2_I3_I104_MP0 (VDD I2_I3_hm10 Y_10 VDD) gpdk090_pmos1v w=0.24u l=0.1u ad=0.0816p as=0.0528p pd=1.16u ps=0.68u
    I_MXI2_I3_I105_MP1 (I2_I3_hm11 MULP_11 VDD VDD) gpdk090_pmos1v w=0.24u l=0.1u ad=0.0528p as=0.0816p pd=0.68u ps=1.16u
    I_MXI2_I3_I105_MP0 (VDD I2_SEL_MUL I2_I3_hm11 VDD) gpdk090_pmos1v w=0.24u l=0.1u ad=0.0816p as=0.0528p pd=1.16u ps=0.68u
    I_MXI2_I3_I102_MP1 (I2_I3_hm10 MULP_10 VDD VDD) gpdk090_pmos1v w=0.24u l=0.1u ad=0.0528p as=0.0816p pd=0.68u ps=1.16u
    I_MXI2_I3_I102_MP0 (VDD I2_SEL_MUL I2_I3_hm10 VDD) gpdk090_pmos1v w=0.24u l=0.1u ad=0.0816p as=0.0528p pd=1.16u ps=0.68u
    I_MXI0_I77_I28_XP_MP1 (I0_I77_P4_1n I0_I77_P2_1 VDD VDD) gpdk090_pmos1v w=0.24u l=0.1u ad=0.0528p as=0.0816p pd=0.68u ps=1.16u
    I_MXI0_I77_I28_XP_MP0 (VDD I0_I77_P4_3 I0_I77_P4_1n VDD) gpdk090_pmos1v w=0.24u l=0.1u ad=0.0816p as=0.0528p pd=1.16u ps=0.68u
    I_MXI0_I77_I3_MP1 (I0_I77_gn3 I0_ha21_0 VDD VDD) gpdk090_pmos1v w=0.24u l=0.1u ad=0.0528p as=0.0816p pd=0.68u ps=1.16u
    I_MXI0_I77_I3_MP0 (VDD I0_ha20_1 I0_I77_gn3 VDD) gpdk090_pmos1v w=0.24u l=0.1u ad=0.0816p as=0.0528p pd=1.16u ps=0.68u
    I_MXI2_I3_I85_MP1 (I2_I3_n7_1 I2_OR_7 VDD VDD) gpdk090_pmos1v w=0.24u l=0.1u ad=0.0528p as=0.0816p pd=0.68u ps=1.16u
    I_MXI2_I3_I85_MP0 (VDD I2_SEL_OR I2_I3_n7_1 VDD) gpdk090_pmos1v w=0.24u l=0.1u ad=0.0816p as=0.0528p pd=1.16u ps=0.68u
    I_MXI2_I3_I90_MP1 (I2_I3_o7_0 I2_I3_n7_1 VDD VDD) gpdk090_pmos1v w=0.24u l=0.1u ad=0.0528p as=0.0816p pd=0.68u ps=1.16u
    I_MXI2_I3_I90_MP0 (VDD I2_I3_n7_0 I2_I3_o7_0 VDD) gpdk090_pmos1v w=0.24u l=0.1u ad=0.0816p as=0.0528p pd=1.16u ps=0.68u
    I_MXI2_I3_I84_MP1 (I2_I3_n7_0 I2_AND_7 VDD VDD) gpdk090_pmos1v w=0.24u l=0.1u ad=0.0528p as=0.0816p pd=0.68u ps=1.16u
    I_MXI2_I3_I84_MP0 (VDD I2_SEL_AND I2_I3_n7_0 VDD) gpdk090_pmos1v w=0.24u l=0.1u ad=0.0816p as=0.0528p pd=1.16u ps=0.68u
    I_MXI2_I2_I42_MP1 (I2_I2_nand7 B_7 VDD VDD) gpdk090_pmos1v w=0.24u l=0.1u ad=0.0528p as=0.0816p pd=0.68u ps=1.16u
    I_MXI2_I2_I42_MP0 (VDD A_7 I2_I2_nand7 VDD) gpdk090_pmos1v w=0.24u l=0.1u ad=0.0816p as=0.0528p pd=1.16u ps=0.68u
    I_MXI2_I0_I10_MP1 (I2_I0_l11 OP_0 VDD VDD) gpdk090_pmos1v w=0.24u l=0.1u ad=0.0528p as=0.0816p pd=0.68u ps=1.16u
    I_MXI2_I0_I10_MP0 (VDD OP_1 I2_I0_l11 VDD) gpdk090_pmos1v w=0.24u l=0.1u ad=0.0816p as=0.0528p pd=1.16u ps=0.68u
    I_MXI2_I0_I9_MP1 (I2_I0_l10 I2_I0_opn0 VDD VDD) gpdk090_pmos1v w=0.24u l=0.1u ad=0.0528p as=0.0816p pd=0.68u ps=1.16u
    I_MXI2_I0_I9_MP0 (VDD OP_1 I2_I0_l10 VDD) gpdk090_pmos1v w=0.24u l=0.1u ad=0.0816p as=0.0528p pd=1.16u ps=0.68u
    I_MXI2_I3_I66_MP1 (I2_I3_o5_0 I2_I3_n5_1 VDD VDD) gpdk090_pmos1v w=0.24u l=0.1u ad=0.0528p as=0.0816p pd=0.68u ps=1.16u
    I_MXI2_I3_I66_MP0 (VDD I2_I3_n5_0 I2_I3_o5_0 VDD) gpdk090_pmos1v w=0.24u l=0.1u ad=0.0816p as=0.0528p pd=1.16u ps=0.68u
    I_MXI2_I3_I60_MP1 (I2_I3_n5_0 I2_AND_5 VDD VDD) gpdk090_pmos1v w=0.24u l=0.1u ad=0.0528p as=0.0816p pd=0.68u ps=1.16u
    I_MXI2_I3_I60_MP0 (VDD I2_SEL_AND I2_I3_n5_0 VDD) gpdk090_pmos1v w=0.24u l=0.1u ad=0.0816p as=0.0528p pd=1.16u ps=0.68u
    I_MXI2_I2_I30_MP1 (I2_I2_nand5 B_5 VDD VDD) gpdk090_pmos1v w=0.24u l=0.1u ad=0.0528p as=0.0816p pd=0.68u ps=1.16u
    I_MXI2_I2_I30_MP0 (VDD A_5 I2_I2_nand5 VDD) gpdk090_pmos1v w=0.24u l=0.1u ad=0.0816p as=0.0528p pd=1.16u ps=0.68u
    I_MXI1_I152_I31_XP_MP1 (I1_I152_P7_4n I1_I152_P5_4 VDD VDD) gpdk090_pmos1v w=0.24u l=0.1u ad=0.0528p as=0.0816p pd=0.68u ps=1.16u
    I_MXI1_I152_I31_XP_MP0 (VDD I1_I152_P7_6 I1_I152_P7_4n VDD) gpdk090_pmos1v w=0.24u l=0.1u ad=0.0816p as=0.0528p pd=1.16u ps=0.68u
    I_MXI2_I3_I100_MP1 (I2_I3_hd9 DIVR_1 VDD VDD) gpdk090_pmos1v w=0.24u l=0.1u ad=0.0528p as=0.0816p pd=0.68u ps=1.16u
    I_MXI2_I3_I100_MP0 (VDD I2_SEL_DIV I2_I3_hd9 VDD) gpdk090_pmos1v w=0.24u l=0.1u ad=0.0816p as=0.0528p pd=1.16u ps=0.68u
    I_MXI2_I3_I101_MP1 (Y_9 I2_I3_hd9 VDD VDD) gpdk090_pmos1v w=0.24u l=0.1u ad=0.0528p as=0.0816p pd=0.68u ps=1.16u
    I_MXI2_I3_I101_MP0 (VDD I2_I3_hm9 Y_9 VDD) gpdk090_pmos1v w=0.24u l=0.1u ad=0.0816p as=0.0528p pd=1.16u ps=0.68u
    I_MXI0_I77_I1_MP1 (I0_I77_gn1 I0_ha19_0 VDD VDD) gpdk090_pmos1v w=0.24u l=0.1u ad=0.0528p as=0.0816p pd=0.68u ps=1.16u
    I_MXI0_I77_I1_MP0 (VDD I0_ha18_1 I0_I77_gn1 VDD) gpdk090_pmos1v w=0.24u l=0.1u ad=0.0816p as=0.0528p pd=1.16u ps=0.68u
    I_MXI0_I77_I2_MP1 (I0_I77_gn2 I0_ha20_0 VDD VDD) gpdk090_pmos1v w=0.24u l=0.1u ad=0.0528p as=0.0816p pd=0.68u ps=1.16u
    I_MXI0_I77_I2_MP0 (VDD I0_ha19_1 I0_I77_gn2 VDD) gpdk090_pmos1v w=0.24u l=0.1u ad=0.0816p as=0.0528p pd=1.16u ps=0.68u
    I_MXI2_I3_I73_MP1 (I2_I3_n6_1 I2_OR_6 VDD VDD) gpdk090_pmos1v w=0.24u l=0.1u ad=0.0528p as=0.0816p pd=0.68u ps=1.16u
    I_MXI2_I3_I73_MP0 (VDD I2_SEL_OR I2_I3_n6_1 VDD) gpdk090_pmos1v w=0.24u l=0.1u ad=0.0816p as=0.0528p pd=1.16u ps=0.68u
    I_MXI2_I3_I78_MP1 (I2_I3_o6_0 I2_I3_n6_1 VDD VDD) gpdk090_pmos1v w=0.24u l=0.1u ad=0.0528p as=0.0816p pd=0.68u ps=1.16u
    I_MXI2_I3_I78_MP0 (VDD I2_I3_n6_0 I2_I3_o6_0 VDD) gpdk090_pmos1v w=0.24u l=0.1u ad=0.0816p as=0.0528p pd=1.16u ps=0.68u
    I_MXI2_I3_I72_MP1 (I2_I3_n6_0 I2_AND_6 VDD VDD) gpdk090_pmos1v w=0.24u l=0.1u ad=0.0528p as=0.0816p pd=0.68u ps=1.16u
    I_MXI2_I3_I72_MP0 (VDD I2_SEL_AND I2_I3_n6_0 VDD) gpdk090_pmos1v w=0.24u l=0.1u ad=0.0816p as=0.0528p pd=1.16u ps=0.68u
    I_MXI2_I3_I79_MP1 (I2_I3_o6_1 I2_I3_n6_3 VDD VDD) gpdk090_pmos1v w=0.24u l=0.1u ad=0.0528p as=0.0816p pd=0.68u ps=1.16u
    I_MXI2_I3_I79_MP0 (VDD I2_I3_n6_2 I2_I3_o6_1 VDD) gpdk090_pmos1v w=0.24u l=0.1u ad=0.0816p as=0.0528p pd=1.16u ps=0.68u
    I_MXI2_I3_I75_MP1 (I2_I3_n6_3 I2_NOT_6 VDD VDD) gpdk090_pmos1v w=0.24u l=0.1u ad=0.0528p as=0.0816p pd=0.68u ps=1.16u
    I_MXI2_I3_I75_MP0 (VDD I2_SEL_NOT I2_I3_n6_3 VDD) gpdk090_pmos1v w=0.24u l=0.1u ad=0.0816p as=0.0528p pd=1.16u ps=0.68u
    I_MXI2_I3_I63_MP1 (I2_I3_n5_3 I2_NOT_5 VDD VDD) gpdk090_pmos1v w=0.24u l=0.1u ad=0.0528p as=0.0816p pd=0.68u ps=1.16u
    I_MXI2_I3_I63_MP0 (VDD I2_SEL_NOT I2_I3_n5_3 VDD) gpdk090_pmos1v w=0.24u l=0.1u ad=0.0816p as=0.0528p pd=1.16u ps=0.68u
    I_MXI2_I3_I37_MP1 (I2_I3_n3_1 I2_OR_3 VDD VDD) gpdk090_pmos1v w=0.24u l=0.1u ad=0.0528p as=0.0816p pd=0.68u ps=1.16u
    I_MXI2_I3_I37_MP0 (VDD I2_SEL_OR I2_I3_n3_1 VDD) gpdk090_pmos1v w=0.24u l=0.1u ad=0.0816p as=0.0528p pd=1.16u ps=0.68u
    I_MXI2_I3_I67_MP1 (I2_I3_o5_1 I2_I3_n5_3 VDD VDD) gpdk090_pmos1v w=0.24u l=0.1u ad=0.0528p as=0.0816p pd=0.68u ps=1.16u
    I_MXI2_I3_I67_MP0 (VDD I2_I3_n5_2 I2_I3_o5_1 VDD) gpdk090_pmos1v w=0.24u l=0.1u ad=0.0816p as=0.0528p pd=1.16u ps=0.68u
    I_MXI2_I3_I42_MP1 (I2_I3_o3_0 I2_I3_n3_1 VDD VDD) gpdk090_pmos1v w=0.24u l=0.1u ad=0.0528p as=0.0816p pd=0.68u ps=1.16u
    I_MXI2_I3_I42_MP0 (VDD I2_I3_n3_0 I2_I3_o3_0 VDD) gpdk090_pmos1v w=0.24u l=0.1u ad=0.0816p as=0.0528p pd=1.16u ps=0.68u
    I_MXI2_I3_I36_MP1 (I2_I3_n3_0 I2_AND_3 VDD VDD) gpdk090_pmos1v w=0.24u l=0.1u ad=0.0528p as=0.0816p pd=0.68u ps=1.16u
    I_MXI2_I3_I36_MP0 (VDD I2_SEL_AND I2_I3_n3_0 VDD) gpdk090_pmos1v w=0.24u l=0.1u ad=0.0816p as=0.0528p pd=1.16u ps=0.68u
    I_MXI2_I3_I61_MP1 (I2_I3_n5_1 I2_OR_5 VDD VDD) gpdk090_pmos1v w=0.24u l=0.1u ad=0.0528p as=0.0816p pd=0.68u ps=1.16u
    I_MXI2_I3_I61_MP0 (VDD I2_SEL_OR I2_I3_n5_1 VDD) gpdk090_pmos1v w=0.24u l=0.1u ad=0.0816p as=0.0528p pd=1.16u ps=0.68u
    I_MXI2_I3_I39_MP1 (I2_I3_n3_3 I2_NOT_3 VDD VDD) gpdk090_pmos1v w=0.24u l=0.1u ad=0.0528p as=0.0816p pd=0.68u ps=1.16u
    I_MXI2_I3_I39_MP0 (VDD I2_SEL_NOT I2_I3_n3_3 VDD) gpdk090_pmos1v w=0.24u l=0.1u ad=0.0816p as=0.0528p pd=1.16u ps=0.68u
    I_MXI2_I3_I62_MP1 (I2_I3_n5_2 I2_XOR_5 VDD VDD) gpdk090_pmos1v w=0.24u l=0.1u ad=0.0528p as=0.0816p pd=0.68u ps=1.16u
    I_MXI2_I3_I62_MP0 (VDD I2_SEL_XOR I2_I3_n5_2 VDD) gpdk090_pmos1v w=0.24u l=0.1u ad=0.0816p as=0.0528p pd=1.16u ps=0.68u
    I_MXI2_I3_I43_MP1 (I2_I3_o3_1 I2_I3_n3_3 VDD VDD) gpdk090_pmos1v w=0.24u l=0.1u ad=0.0528p as=0.0816p pd=0.68u ps=1.16u
    I_MXI2_I3_I43_MP0 (VDD I2_I3_n3_2 I2_I3_o3_1 VDD) gpdk090_pmos1v w=0.24u l=0.1u ad=0.0816p as=0.0528p pd=1.16u ps=0.68u
    I_MXI1_I152_I7_MP1 (I1_I152_gn7 I1_dm7 VDD VDD) gpdk090_pmos1v w=0.24u l=0.1u ad=0.0528p as=0.0816p pd=0.68u ps=1.16u
    I_MXI1_I152_I7_MP0 (VDD I1_p7_7 I1_I152_gn7 VDD) gpdk090_pmos1v w=0.24u l=0.1u ad=0.0816p as=0.0528p pd=1.16u ps=0.68u
    I_MXI1_I152_I6_MP1 (I1_I152_gn6 I1_dm6 VDD VDD) gpdk090_pmos1v w=0.24u l=0.1u ad=0.0528p as=0.0816p pd=0.68u ps=1.16u
    I_MXI1_I152_I6_MP0 (VDD I1_p7_6 I1_I152_gn6 VDD) gpdk090_pmos1v w=0.24u l=0.1u ad=0.0816p as=0.0528p pd=1.16u ps=0.68u
    I_MXI1_I152_I30_XP_MP1 (I1_I152_P6_3n I1_I152_P4_3 VDD VDD) gpdk090_pmos1v w=0.24u l=0.1u ad=0.0528p as=0.0816p pd=0.68u ps=1.16u
    I_MXI1_I152_I30_XP_MP0 (VDD I1_I152_P6_5 I1_I152_P6_3n VDD) gpdk090_pmos1v w=0.24u l=0.1u ad=0.0816p as=0.0528p pd=1.16u ps=0.68u
    I_MXI1_I152_I28_XP_MP1 (I1_I152_P4_1n I1_I152_P2_1 VDD VDD) gpdk090_pmos1v w=0.24u l=0.1u ad=0.0528p as=0.0816p pd=0.68u ps=1.16u
    I_MXI1_I152_I28_XP_MP0 (VDD I1_I152_P4_3 I1_I152_P4_1n VDD) gpdk090_pmos1v w=0.24u l=0.1u ad=0.0816p as=0.0528p pd=1.16u ps=0.68u
    I_MXI2_I3_I99_MP1 (I2_I3_hm9 MULP_9 VDD VDD) gpdk090_pmos1v w=0.24u l=0.1u ad=0.0528p as=0.0816p pd=0.68u ps=1.16u
    I_MXI2_I3_I99_MP0 (VDD I2_SEL_MUL I2_I3_hm9 VDD) gpdk090_pmos1v w=0.24u l=0.1u ad=0.0816p as=0.0528p pd=1.16u ps=0.68u
    I_MXI2_I3_I98_MP1 (Y_8 I2_I3_hd8 VDD VDD) gpdk090_pmos1v w=0.24u l=0.1u ad=0.0528p as=0.0816p pd=0.68u ps=1.16u
    I_MXI2_I3_I98_MP0 (VDD I2_I3_hm8 Y_8 VDD) gpdk090_pmos1v w=0.24u l=0.1u ad=0.0816p as=0.0528p pd=1.16u ps=0.68u
    I_MXI2_I3_I96_MP1 (I2_I3_hm8 MULP_8 VDD VDD) gpdk090_pmos1v w=0.24u l=0.1u ad=0.0528p as=0.0816p pd=0.68u ps=1.16u
    I_MXI2_I3_I96_MP0 (VDD I2_SEL_MUL I2_I3_hm8 VDD) gpdk090_pmos1v w=0.24u l=0.1u ad=0.0816p as=0.0528p pd=1.16u ps=0.68u
    I_MXI0_I77_I0_MP1 (I0_I77_gn0 I0_ha18_0 VDD VDD) gpdk090_pmos1v w=0.24u l=0.1u ad=0.0528p as=0.0816p pd=0.68u ps=1.16u
    I_MXI0_I77_I0_MP0 (VDD I0_ha17_1 I0_I77_gn0 VDD) gpdk090_pmos1v w=0.24u l=0.1u ad=0.0816p as=0.0528p pd=1.16u ps=0.68u
    I_MXI2_I2_I36_MP1 (I2_I2_nand6 B_6 VDD VDD) gpdk090_pmos1v w=0.24u l=0.1u ad=0.0528p as=0.0816p pd=0.68u ps=1.16u
    I_MXI2_I2_I36_MP0 (VDD A_6 I2_I2_nand6 VDD) gpdk090_pmos1v w=0.24u l=0.1u ad=0.0816p as=0.0528p pd=1.16u ps=0.68u
    I_MXI2_I3_I74_MP1 (I2_I3_n6_2 I2_XOR_6 VDD VDD) gpdk090_pmos1v w=0.24u l=0.1u ad=0.0528p as=0.0816p pd=0.68u ps=1.16u
    I_MXI2_I3_I74_MP0 (VDD I2_SEL_XOR I2_I3_n6_2 VDD) gpdk090_pmos1v w=0.24u l=0.1u ad=0.0816p as=0.0528p pd=1.16u ps=0.68u
    I_MXI2_I1_I8_I6_MP1 (I2_I1_I8_gn6 I2_I1_bx6 VDD VDD) gpdk090_pmos1v w=0.24u l=0.1u ad=0.0528p as=0.0816p pd=0.68u ps=1.16u
    I_MXI2_I1_I8_I6_MP0 (VDD A_6 I2_I1_I8_gn6 VDD) gpdk090_pmos1v w=0.24u l=0.1u ad=0.0816p as=0.0528p pd=1.16u ps=0.68u
    I_MXI2_I2_I18_MP1 (I2_I2_nand3 B_3 VDD VDD) gpdk090_pmos1v w=0.24u l=0.1u ad=0.0528p as=0.0816p pd=0.68u ps=1.16u
    I_MXI2_I2_I18_MP0 (VDD A_3 I2_I2_nand3 VDD) gpdk090_pmos1v w=0.24u l=0.1u ad=0.0816p as=0.0528p pd=1.16u ps=0.68u
    I_MXI2_I3_I38_MP1 (I2_I3_n3_2 I2_XOR_3 VDD VDD) gpdk090_pmos1v w=0.24u l=0.1u ad=0.0528p as=0.0816p pd=0.68u ps=1.16u
    I_MXI2_I3_I38_MP0 (VDD I2_SEL_XOR I2_I3_n3_2 VDD) gpdk090_pmos1v w=0.24u l=0.1u ad=0.0816p as=0.0528p pd=1.16u ps=0.68u
    I_MXI1_I152_I5_MP1 (I1_I152_gn5 I1_dm5 VDD VDD) gpdk090_pmos1v w=0.24u l=0.1u ad=0.0528p as=0.0816p pd=0.68u ps=1.16u
    I_MXI1_I152_I5_MP0 (VDD I1_p7_5 I1_I152_gn5 VDD) gpdk090_pmos1v w=0.24u l=0.1u ad=0.0816p as=0.0528p pd=1.16u ps=0.68u
    I_MXI1_I152_I4_MP1 (I1_I152_gn4 I1_dm4 VDD VDD) gpdk090_pmos1v w=0.24u l=0.1u ad=0.0528p as=0.0816p pd=0.68u ps=1.16u
    I_MXI1_I152_I4_MP0 (VDD I1_p7_4 I1_I152_gn4 VDD) gpdk090_pmos1v w=0.24u l=0.1u ad=0.0816p as=0.0528p pd=1.16u ps=0.68u
    I_MXI1_I152_I2_MP1 (I1_I152_gn2 I1_dm2 VDD VDD) gpdk090_pmos1v w=0.24u l=0.1u ad=0.0528p as=0.0816p pd=0.68u ps=1.16u
    I_MXI1_I152_I2_MP0 (VDD I1_p7_2 I1_I152_gn2 VDD) gpdk090_pmos1v w=0.24u l=0.1u ad=0.0816p as=0.0528p pd=1.16u ps=0.68u
    I_MXI1_I152_I1_MP1 (I1_I152_gn1 I1_dm1 VDD VDD) gpdk090_pmos1v w=0.24u l=0.1u ad=0.0528p as=0.0816p pd=0.68u ps=1.16u
    I_MXI1_I152_I1_MP0 (VDD I1_p7_1 I1_I152_gn1 VDD) gpdk090_pmos1v w=0.24u l=0.1u ad=0.0816p as=0.0528p pd=1.16u ps=0.68u
    I_MXI1_I174_MP1 (I1_nrkn1 DIVR_0 VDD VDD) gpdk090_pmos1v w=0.24u l=0.1u ad=0.0528p as=0.0816p pd=0.68u ps=1.16u
    I_MXI1_I174_MP0 (VDD A_7 I1_nrkn1 VDD) gpdk090_pmos1v w=0.24u l=0.1u ad=0.0816p as=0.0528p pd=1.16u ps=0.68u
    I_MXI2_I3_I97_MP1 (I2_I3_hd8 DIVR_0 VDD VDD) gpdk090_pmos1v w=0.24u l=0.1u ad=0.0528p as=0.0816p pd=0.68u ps=1.16u
    I_MXI2_I3_I97_MP0 (VDD I2_SEL_DIV I2_I3_hd8 VDD) gpdk090_pmos1v w=0.24u l=0.1u ad=0.0816p as=0.0528p pd=1.16u ps=0.68u
    I_MXI2_I3_I88_MP1 (I2_I3_n7_4 MULP_7 VDD VDD) gpdk090_pmos1v w=0.24u l=0.1u ad=0.0528p as=0.0816p pd=0.68u ps=1.16u
    I_MXI2_I3_I88_MP0 (VDD I2_SEL_MUL I2_I3_n7_4 VDD) gpdk090_pmos1v w=0.24u l=0.1u ad=0.0816p as=0.0528p pd=1.16u ps=0.68u
    I_MXI2_I3_I92_MP1 (I2_I3_o7_2 I2_I3_n7_5 VDD VDD) gpdk090_pmos1v w=0.24u l=0.1u ad=0.0528p as=0.0816p pd=0.68u ps=1.16u
    I_MXI2_I3_I92_MP0 (VDD I2_I3_n7_4 I2_I3_o7_2 VDD) gpdk090_pmos1v w=0.24u l=0.1u ad=0.0816p as=0.0528p pd=1.16u ps=0.68u
    I_MXI2_I3_I95_MP1 (Y_7 I2_I3_q7_2 VDD VDD) gpdk090_pmos1v w=0.24u l=0.1u ad=0.0528p as=0.0816p pd=0.68u ps=1.16u
    I_MXI2_I3_I95_MP0 (VDD I2_I3_q7_1 Y_7 VDD) gpdk090_pmos1v w=0.24u l=0.1u ad=0.0816p as=0.0528p pd=1.16u ps=0.68u
    I_MXI2_I1_I8_I7_MP1 (I2_I1_I8_gn7 I2_I1_bx7 VDD VDD) gpdk090_pmos1v w=0.24u l=0.1u ad=0.0528p as=0.0816p pd=0.68u ps=1.16u
    I_MXI2_I1_I8_I7_MP0 (VDD A_7 I2_I1_I8_gn7 VDD) gpdk090_pmos1v w=0.24u l=0.1u ad=0.0816p as=0.0528p pd=1.16u ps=0.68u
    I_MXI2_I1_I8_I5_MP1 (I2_I1_I8_gn5 I2_I1_bx5 VDD VDD) gpdk090_pmos1v w=0.24u l=0.1u ad=0.0528p as=0.0816p pd=0.68u ps=1.16u
    I_MXI2_I1_I8_I5_MP0 (VDD A_5 I2_I1_I8_gn5 VDD) gpdk090_pmos1v w=0.24u l=0.1u ad=0.0816p as=0.0528p pd=1.16u ps=0.68u
    I_MXI1_I132_I31_XP_MP1 (I1_I132_P7_4n I1_I132_P5_4 VDD VDD) gpdk090_pmos1v w=0.24u l=0.1u ad=0.0528p as=0.0816p pd=0.68u ps=1.16u
    I_MXI1_I132_I31_XP_MP0 (VDD I1_I132_P7_6 I1_I132_P7_4n VDD) gpdk090_pmos1v w=0.24u l=0.1u ad=0.0816p as=0.0528p pd=1.16u ps=0.68u
    I_MXI1_I132_I29_XP_MP1 (I1_I132_P5_2n I1_I132_P3_2 VDD VDD) gpdk090_pmos1v w=0.24u l=0.1u ad=0.0528p as=0.0816p pd=0.68u ps=1.16u
    I_MXI1_I132_I29_XP_MP0 (VDD I1_I132_P5_4 I1_I132_P5_2n VDD) gpdk090_pmos1v w=0.24u l=0.1u ad=0.0816p as=0.0528p pd=1.16u ps=0.68u
    I_MXI1_I152_I3_MP1 (I1_I152_gn3 I1_dm3 VDD VDD) gpdk090_pmos1v w=0.24u l=0.1u ad=0.0528p as=0.0816p pd=0.68u ps=1.16u
    I_MXI1_I152_I3_MP0 (VDD I1_p7_3 I1_I152_gn3 VDD) gpdk090_pmos1v w=0.24u l=0.1u ad=0.0816p as=0.0528p pd=1.16u ps=0.68u
    I_MXI1_I152_I0_MP1 (I1_I152_gn0 I1_dm0 VDD VDD) gpdk090_pmos1v w=0.24u l=0.1u ad=0.0528p as=0.0816p pd=0.68u ps=1.16u
    I_MXI1_I152_I0_MP0 (VDD I1_p7_0 I1_I152_gn0 VDD) gpdk090_pmos1v w=0.24u l=0.1u ad=0.0816p as=0.0528p pd=1.16u ps=0.68u
    I_MXI2_I3_I76_MP1 (I2_I3_n6_4 MULP_6 VDD VDD) gpdk090_pmos1v w=0.24u l=0.1u ad=0.0528p as=0.0816p pd=0.68u ps=1.16u
    I_MXI2_I3_I76_MP0 (VDD I2_SEL_MUL I2_I3_n6_4 VDD) gpdk090_pmos1v w=0.24u l=0.1u ad=0.0816p as=0.0528p pd=1.16u ps=0.68u
    I_MXI2_I3_I80_MP1 (I2_I3_o6_2 I2_I3_n6_5 VDD VDD) gpdk090_pmos1v w=0.24u l=0.1u ad=0.0528p as=0.0816p pd=0.68u ps=1.16u
    I_MXI2_I3_I80_MP0 (VDD I2_I3_n6_4 I2_I3_o6_2 VDD) gpdk090_pmos1v w=0.24u l=0.1u ad=0.0816p as=0.0528p pd=1.16u ps=0.68u
    I_MXI2_I3_I83_MP1 (Y_6 I2_I3_q6_2 VDD VDD) gpdk090_pmos1v w=0.24u l=0.1u ad=0.0528p as=0.0816p pd=0.68u ps=1.16u
    I_MXI2_I3_I83_MP0 (VDD I2_I3_q6_1 Y_6 VDD) gpdk090_pmos1v w=0.24u l=0.1u ad=0.0816p as=0.0528p pd=1.16u ps=0.68u
    I_MXI2_I1_I8_I31_XP_MP1 (I2_I1_I8_P7_4n I2_I1_I8_P5_4 VDD VDD) gpdk090_pmos1v w=0.24u l=0.1u ad=0.0528p as=0.0816p pd=0.68u ps=1.16u
    I_MXI2_I1_I8_I31_XP_MP0 (VDD I2_I1_I8_P7_6 I2_I1_I8_P7_4n VDD) gpdk090_pmos1v w=0.24u l=0.1u ad=0.0816p as=0.0528p pd=1.16u ps=0.68u
    I_MXI2_I1_I8_I3_MP1 (I2_I1_I8_gn3 I2_I1_bx3 VDD VDD) gpdk090_pmos1v w=0.24u l=0.1u ad=0.0528p as=0.0816p pd=0.68u ps=1.16u
    I_MXI2_I1_I8_I3_MP0 (VDD A_3 I2_I1_I8_gn3 VDD) gpdk090_pmos1v w=0.24u l=0.1u ad=0.0816p as=0.0528p pd=1.16u ps=0.68u
    I_MXI1_I150_MP1 (I1_dmn7 I1_p7_8 VDD VDD) gpdk090_pmos1v w=0.24u l=0.1u ad=0.0528p as=0.0816p pd=0.68u ps=1.16u
    I_MXI1_I150_MP0 (VDD I1_dd7 I1_dmn7 VDD) gpdk090_pmos1v w=0.24u l=0.1u ad=0.0816p as=0.0528p pd=1.16u ps=0.68u
    I_MXI1_I132_I30_XP_MP1 (I1_I132_P6_3n I1_I132_P4_3 VDD VDD) gpdk090_pmos1v w=0.24u l=0.1u ad=0.0528p as=0.0816p pd=0.68u ps=1.16u
    I_MXI1_I132_I30_XP_MP0 (VDD I1_I132_P6_5 I1_I132_P6_3n VDD) gpdk090_pmos1v w=0.24u l=0.1u ad=0.0816p as=0.0528p pd=1.16u ps=0.68u
    I_MXI1_I132_I28_XP_MP1 (I1_I132_P4_1n I1_I132_P2_1 VDD VDD) gpdk090_pmos1v w=0.24u l=0.1u ad=0.0528p as=0.0816p pd=0.68u ps=1.16u
    I_MXI1_I132_I28_XP_MP0 (VDD I1_I132_P4_3 I1_I132_P4_1n VDD) gpdk090_pmos1v w=0.24u l=0.1u ad=0.0816p as=0.0528p pd=1.16u ps=0.68u
    I_MXI2_I4_I19_MP1 (I2_I4_v1 I2_I4_ovf VDD VDD) gpdk090_pmos1v w=0.24u l=0.1u ad=0.0528p as=0.0816p pd=0.68u ps=1.16u
    I_MXI2_I4_I19_MP0 (VDD I2_SEL_AS I2_I4_v1 VDD) gpdk090_pmos1v w=0.24u l=0.1u ad=0.0816p as=0.0528p pd=1.16u ps=0.68u
    I_MXI2_I4_I9_MP1 (I2_I4_zb1 I2_I4_za3 VDD VDD) gpdk090_pmos1v w=0.24u l=0.1u ad=0.0528p as=0.0816p pd=0.68u ps=1.16u
    I_MXI2_I4_I9_MP0 (VDD I2_I4_za2 I2_I4_zb1 VDD) gpdk090_pmos1v w=0.24u l=0.1u ad=0.0816p as=0.0528p pd=1.16u ps=0.68u
    I_MXI2_I3_I71_MP1 (Y_5 I2_I3_q5_2 VDD VDD) gpdk090_pmos1v w=0.24u l=0.1u ad=0.0528p as=0.0816p pd=0.68u ps=1.16u
    I_MXI2_I3_I71_MP0 (VDD I2_I3_q5_1 Y_5 VDD) gpdk090_pmos1v w=0.24u l=0.1u ad=0.0816p as=0.0528p pd=1.16u ps=0.68u
    I_MXI2_I4_I16_MP1 (I2_I4_cn I2_SEL_AS VDD VDD) gpdk090_pmos1v w=0.24u l=0.1u ad=0.0528p as=0.0816p pd=0.68u ps=1.16u
    I_MXI2_I4_I16_MP0 (VDD I2_C8 I2_I4_cn VDD) gpdk090_pmos1v w=0.24u l=0.1u ad=0.0816p as=0.0528p pd=1.16u ps=0.68u
    I_MXI2_I1_I8_I29_XP_MP1 (I2_I1_I8_P5_2n I2_I1_I8_P3_2 VDD VDD) gpdk090_pmos1v w=0.24u l=0.1u ad=0.0528p as=0.0816p pd=0.68u ps=1.16u
    I_MXI2_I1_I8_I29_XP_MP0 (VDD I2_I1_I8_P5_4 I2_I1_I8_P5_2n VDD) gpdk090_pmos1v w=0.24u l=0.1u ad=0.0816p as=0.0528p pd=1.16u ps=0.68u
    I_MXI2_I1_I8_I30_XP_MP1 (I2_I1_I8_P6_3n I2_I1_I8_P4_3 VDD VDD) gpdk090_pmos1v w=0.24u l=0.1u ad=0.0528p as=0.0816p pd=0.68u ps=1.16u
    I_MXI2_I1_I8_I30_XP_MP0 (VDD I2_I1_I8_P6_5 I2_I1_I8_P6_3n VDD) gpdk090_pmos1v w=0.24u l=0.1u ad=0.0816p as=0.0528p pd=1.16u ps=0.68u
    I_MXI2_I1_I8_I4_MP1 (I2_I1_I8_gn4 I2_I1_bx4 VDD VDD) gpdk090_pmos1v w=0.24u l=0.1u ad=0.0528p as=0.0816p pd=0.68u ps=1.16u
    I_MXI2_I1_I8_I4_MP0 (VDD A_4 I2_I1_I8_gn4 VDD) gpdk090_pmos1v w=0.24u l=0.1u ad=0.0816p as=0.0528p pd=1.16u ps=0.68u
    I_MXI1_I132_I7_MP1 (I1_I132_gn7 I1_b7_7 VDD VDD) gpdk090_pmos1v w=0.24u l=0.1u ad=0.0528p as=0.0816p pd=0.68u ps=1.16u
    I_MXI1_I132_I7_MP0 (VDD I1_p6_6 I1_I132_gn7 VDD) gpdk090_pmos1v w=0.24u l=0.1u ad=0.0816p as=0.0528p pd=1.16u ps=0.68u
    I_MXI1_I132_I6_MP1 (I1_I132_gn6 I1_b7_6 VDD VDD) gpdk090_pmos1v w=0.24u l=0.1u ad=0.0528p as=0.0816p pd=0.68u ps=1.16u
    I_MXI1_I132_I6_MP0 (VDD I1_p6_5 I1_I132_gn6 VDD) gpdk090_pmos1v w=0.24u l=0.1u ad=0.0816p as=0.0528p pd=1.16u ps=0.68u
    I_MXI1_I148_MP1 (I1_dmn6 I1_p7_8 VDD VDD) gpdk090_pmos1v w=0.24u l=0.1u ad=0.0528p as=0.0816p pd=0.68u ps=1.16u
    I_MXI1_I148_MP0 (VDD I1_dd6 I1_dmn6 VDD) gpdk090_pmos1v w=0.24u l=0.1u ad=0.0816p as=0.0528p pd=1.16u ps=0.68u
    I_MXI1_I132_I5_MP1 (I1_I132_gn5 I1_b7_5 VDD VDD) gpdk090_pmos1v w=0.24u l=0.1u ad=0.0528p as=0.0816p pd=0.68u ps=1.16u
    I_MXI1_I132_I5_MP0 (VDD I1_p6_4 I1_I132_gn5 VDD) gpdk090_pmos1v w=0.24u l=0.1u ad=0.0816p as=0.0528p pd=1.16u ps=0.68u
    I_MXI1_I132_I4_MP1 (I1_I132_gn4 I1_b7_4 VDD VDD) gpdk090_pmos1v w=0.24u l=0.1u ad=0.0528p as=0.0816p pd=0.68u ps=1.16u
    I_MXI1_I132_I4_MP0 (VDD I1_p6_3 I1_I132_gn4 VDD) gpdk090_pmos1v w=0.24u l=0.1u ad=0.0816p as=0.0528p pd=1.16u ps=0.68u
    I_MXI1_I132_I3_MP1 (I1_I132_gn3 I1_b7_3 VDD VDD) gpdk090_pmos1v w=0.24u l=0.1u ad=0.0528p as=0.0816p pd=0.68u ps=1.16u
    I_MXI1_I132_I3_MP0 (VDD I1_p6_2 I1_I132_gn3 VDD) gpdk090_pmos1v w=0.24u l=0.1u ad=0.0816p as=0.0528p pd=1.16u ps=0.68u
    I_MXI1_I142_MP1 (I1_dmn3 I1_p7_8 VDD VDD) gpdk090_pmos1v w=0.24u l=0.1u ad=0.0528p as=0.0816p pd=0.68u ps=1.16u
    I_MXI1_I142_MP0 (VDD I1_dd3 I1_dmn3 VDD) gpdk090_pmos1v w=0.24u l=0.1u ad=0.0816p as=0.0528p pd=1.16u ps=0.68u
    I_MXI1_I132_I1_MP1 (I1_I132_gn1 I1_b7_1 VDD VDD) gpdk090_pmos1v w=0.24u l=0.1u ad=0.0528p as=0.0816p pd=0.68u ps=1.16u
    I_MXI1_I132_I1_MP0 (VDD I1_p6_0 I1_I132_gn1 VDD) gpdk090_pmos1v w=0.24u l=0.1u ad=0.0816p as=0.0528p pd=1.16u ps=0.68u
    I_MXI1_I138_MP1 (I1_dmn1 I1_p7_8 VDD VDD) gpdk090_pmos1v w=0.24u l=0.1u ad=0.0528p as=0.0816p pd=0.68u ps=1.16u
    I_MXI1_I138_MP0 (VDD I1_dd1 I1_dmn1 VDD) gpdk090_pmos1v w=0.24u l=0.1u ad=0.0816p as=0.0528p pd=1.16u ps=0.68u
    I_MXI1_I136_MP1 (I1_dmn0 I1_p7_8 VDD VDD) gpdk090_pmos1v w=0.24u l=0.1u ad=0.0528p as=0.0816p pd=0.68u ps=1.16u
    I_MXI1_I136_MP0 (VDD B_0 I1_dmn0 VDD) gpdk090_pmos1v w=0.24u l=0.1u ad=0.0816p as=0.0528p pd=1.16u ps=0.68u
    I_MXI1_I132_I0_MP1 (I1_I132_gn0 I1_b7_0 VDD VDD) gpdk090_pmos1v w=0.24u l=0.1u ad=0.0528p as=0.0816p pd=0.68u ps=1.16u
    I_MXI1_I132_I0_MP0 (VDD A_0 I1_I132_gn0 VDD) gpdk090_pmos1v w=0.24u l=0.1u ad=0.0816p as=0.0528p pd=1.16u ps=0.68u
    I_MXI2_I3_I64_MP1 (I2_I3_n5_4 MULP_5 VDD VDD) gpdk090_pmos1v w=0.24u l=0.1u ad=0.0528p as=0.0816p pd=0.68u ps=1.16u
    I_MXI2_I3_I64_MP0 (VDD I2_SEL_MUL I2_I3_n5_4 VDD) gpdk090_pmos1v w=0.24u l=0.1u ad=0.0816p as=0.0528p pd=1.16u ps=0.68u
    I_MXI2_I3_I68_MP1 (I2_I3_o5_2 I2_I3_n5_5 VDD VDD) gpdk090_pmos1v w=0.24u l=0.1u ad=0.0528p as=0.0816p pd=0.68u ps=1.16u
    I_MXI2_I3_I68_MP0 (VDD I2_I3_n5_4 I2_I3_o5_2 VDD) gpdk090_pmos1v w=0.24u l=0.1u ad=0.0816p as=0.0528p pd=1.16u ps=0.68u
    I_MXI2_I3_I89_MP1 (I2_I3_n7_5 DIVQ_7 VDD VDD) gpdk090_pmos1v w=0.24u l=0.1u ad=0.0528p as=0.0816p pd=0.68u ps=1.16u
    I_MXI2_I3_I89_MP0 (VDD I2_SEL_DIV I2_I3_n7_5 VDD) gpdk090_pmos1v w=0.24u l=0.1u ad=0.0816p as=0.0528p pd=1.16u ps=0.68u
    I_MXI2_I4_I20_MP1 (I2_I4_v2 DIVV VDD VDD) gpdk090_pmos1v w=0.24u l=0.1u ad=0.0528p as=0.0816p pd=0.68u ps=1.16u
    I_MXI2_I4_I20_MP0 (VDD I2_SEL_DIV I2_I4_v2 VDD) gpdk090_pmos1v w=0.24u l=0.1u ad=0.0816p as=0.0528p pd=1.16u ps=0.68u
    I_MXI2_I4_I21_MP1 (V I2_I4_v2 VDD VDD) gpdk090_pmos1v w=0.24u l=0.1u ad=0.0528p as=0.0816p pd=0.68u ps=1.16u
    I_MXI2_I4_I21_MP0 (VDD I2_I4_v1 V VDD) gpdk090_pmos1v w=0.24u l=0.1u ad=0.0816p as=0.0528p pd=1.16u ps=0.68u
    I_MXI2_I1_I8_I28_XP_MP1 (I2_I1_I8_P4_1n I2_I1_I8_P2_1 VDD VDD) gpdk090_pmos1v w=0.24u l=0.1u ad=0.0528p as=0.0816p pd=0.68u ps=1.16u
    I_MXI2_I1_I8_I28_XP_MP0 (VDD I2_I1_I8_P4_3 I2_I1_I8_P4_1n VDD) gpdk090_pmos1v w=0.24u l=0.1u ad=0.0816p as=0.0528p pd=1.16u ps=0.68u
    I_MXI1_I146_MP1 (I1_dmn5 I1_p7_8 VDD VDD) gpdk090_pmos1v w=0.24u l=0.1u ad=0.0528p as=0.0816p pd=0.68u ps=1.16u
    I_MXI1_I146_MP0 (VDD I1_dd5 I1_dmn5 VDD) gpdk090_pmos1v w=0.24u l=0.1u ad=0.0816p as=0.0528p pd=1.16u ps=0.68u
    I_MXI1_I144_MP1 (I1_dmn4 I1_p7_8 VDD VDD) gpdk090_pmos1v w=0.24u l=0.1u ad=0.0528p as=0.0816p pd=0.68u ps=1.16u
    I_MXI1_I144_MP0 (VDD I1_dd4 I1_dmn4 VDD) gpdk090_pmos1v w=0.24u l=0.1u ad=0.0816p as=0.0528p pd=1.16u ps=0.68u
    I_MXI1_I140_MP1 (I1_dmn2 I1_p7_8 VDD VDD) gpdk090_pmos1v w=0.24u l=0.1u ad=0.0528p as=0.0816p pd=0.68u ps=1.16u
    I_MXI1_I140_MP0 (VDD I1_dd2 I1_dmn2 VDD) gpdk090_pmos1v w=0.24u l=0.1u ad=0.0816p as=0.0528p pd=1.16u ps=0.68u
    I_MXI1_I132_I2_MP1 (I1_I132_gn2 I1_b7_2 VDD VDD) gpdk090_pmos1v w=0.24u l=0.1u ad=0.0528p as=0.0816p pd=0.68u ps=1.16u
    I_MXI1_I132_I2_MP0 (VDD I1_p6_1 I1_I132_gn2 VDD) gpdk090_pmos1v w=0.24u l=0.1u ad=0.0816p as=0.0528p pd=1.16u ps=0.68u
    I_MXI1_I154_MP1 (I1_nqkn1 DIVQ_0 VDD VDD) gpdk090_pmos1v w=0.24u l=0.1u ad=0.0528p as=0.0816p pd=0.68u ps=1.16u
    I_MXI1_I154_MP0 (VDD I1_sq I1_nqkn1 VDD) gpdk090_pmos1v w=0.24u l=0.1u ad=0.0816p as=0.0528p pd=1.16u ps=0.68u
    I_MXI2_I3_I65_MP1 (I2_I3_n5_5 DIVQ_5 VDD VDD) gpdk090_pmos1v w=0.24u l=0.1u ad=0.0528p as=0.0816p pd=0.68u ps=1.16u
    I_MXI2_I3_I65_MP0 (VDD I2_SEL_DIV I2_I3_n5_5 VDD) gpdk090_pmos1v w=0.24u l=0.1u ad=0.0816p as=0.0528p pd=1.16u ps=0.68u
    I_MXI2_I3_I56_MP1 (I2_I3_o4_2 I2_I3_n4_5 VDD VDD) gpdk090_pmos1v w=0.24u l=0.1u ad=0.0528p as=0.0816p pd=0.68u ps=1.16u
    I_MXI2_I3_I56_MP0 (VDD I2_I3_n4_4 I2_I3_o4_2 VDD) gpdk090_pmos1v w=0.24u l=0.1u ad=0.0816p as=0.0528p pd=1.16u ps=0.68u
    I_MXI2_I3_I52_MP1 (I2_I3_n4_4 MULP_4 VDD VDD) gpdk090_pmos1v w=0.24u l=0.1u ad=0.0528p as=0.0816p pd=0.68u ps=1.16u
    I_MXI2_I3_I52_MP0 (VDD I2_SEL_MUL I2_I3_n4_4 VDD) gpdk090_pmos1v w=0.24u l=0.1u ad=0.0816p as=0.0528p pd=1.16u ps=0.68u
    I_MXI1_I199_MP1 (I1_z2_1 I1_z1_3 VDD VDD) gpdk090_pmos1v w=0.24u l=0.1u ad=0.0528p as=0.0816p pd=0.68u ps=1.16u
    I_MXI1_I199_MP0 (VDD I1_z1_2 I1_z2_1 VDD) gpdk090_pmos1v w=0.24u l=0.1u ad=0.0816p as=0.0528p pd=1.16u ps=0.68u
    I_MXI2_I4_I22_MP1 (I2_I4_dzn DIVDZ VDD VDD) gpdk090_pmos1v w=0.24u l=0.1u ad=0.0528p as=0.0816p pd=0.68u ps=1.16u
    I_MXI2_I4_I22_MP0 (VDD I2_SEL_DIV I2_I4_dzn VDD) gpdk090_pmos1v w=0.24u l=0.1u ad=0.0816p as=0.0528p pd=1.16u ps=0.68u
    I_MXI2_I1_I8_I0_MP1 (I2_I1_I8_gn0 I2_I1_bx0 VDD VDD) gpdk090_pmos1v w=0.24u l=0.1u ad=0.0528p as=0.0816p pd=0.68u ps=1.16u
    I_MXI2_I1_I8_I0_MP0 (VDD A_0 I2_I1_I8_gn0 VDD) gpdk090_pmos1v w=0.24u l=0.1u ad=0.0816p as=0.0528p pd=1.16u ps=0.68u
    I_MXI2_I3_I59_MP1 (Y_4 I2_I3_q4_2 VDD VDD) gpdk090_pmos1v w=0.24u l=0.1u ad=0.0528p as=0.0816p pd=0.68u ps=1.16u
    I_MXI2_I3_I59_MP0 (VDD I2_I3_q4_1 Y_4 VDD) gpdk090_pmos1v w=0.24u l=0.1u ad=0.0816p as=0.0528p pd=1.16u ps=0.68u
    I_MXI2_I1_I8_I1_MP1 (I2_I1_I8_gn1 I2_I1_bx1 VDD VDD) gpdk090_pmos1v w=0.24u l=0.1u ad=0.0528p as=0.0816p pd=0.68u ps=1.16u
    I_MXI2_I1_I8_I1_MP0 (VDD A_1 I2_I1_I8_gn1 VDD) gpdk090_pmos1v w=0.24u l=0.1u ad=0.0816p as=0.0528p pd=1.16u ps=0.68u
    I_MXI2_I1_I8_I2_MP1 (I2_I1_I8_gn2 I2_I1_bx2 VDD VDD) gpdk090_pmos1v w=0.24u l=0.1u ad=0.0528p as=0.0816p pd=0.68u ps=1.16u
    I_MXI2_I1_I8_I2_MP0 (VDD A_2 I2_I1_I8_gn2 VDD) gpdk090_pmos1v w=0.24u l=0.1u ad=0.0816p as=0.0528p pd=1.16u ps=0.68u
    I_MXI1_I120_I30_XP_MP1 (I1_I120_P6_3n I1_I120_P4_3 VDD VDD) gpdk090_pmos1v w=0.24u l=0.1u ad=0.0528p as=0.0816p pd=0.68u ps=1.16u
    I_MXI1_I120_I30_XP_MP0 (VDD I1_I120_P6_5 I1_I120_P6_3n VDD) gpdk090_pmos1v w=0.24u l=0.1u ad=0.0816p as=0.0528p pd=1.16u ps=0.68u
    I_MXI1_I120_I28_XP_MP1 (I1_I120_P4_1n I1_I120_P2_1 VDD VDD) gpdk090_pmos1v w=0.24u l=0.1u ad=0.0528p as=0.0816p pd=0.68u ps=1.16u
    I_MXI1_I120_I28_XP_MP0 (VDD I1_I120_P4_3 I1_I120_P4_1n VDD) gpdk090_pmos1v w=0.24u l=0.1u ad=0.0816p as=0.0528p pd=1.16u ps=0.68u
    I_MXI1_I120_I0_MP1 (I1_I120_gn0 I1_b6_0 VDD VDD) gpdk090_pmos1v w=0.24u l=0.1u ad=0.0528p as=0.0816p pd=0.68u ps=1.16u
    I_MXI1_I120_I0_MP0 (VDD I1_aa1 I1_I120_gn0 VDD) gpdk090_pmos1v w=0.24u l=0.1u ad=0.0816p as=0.0528p pd=1.16u ps=0.68u
    I_MXI2_I3_I17_MP1 (I2_I3_n1_5 DIVQ_1 VDD VDD) gpdk090_pmos1v w=0.24u l=0.1u ad=0.0528p as=0.0816p pd=0.68u ps=1.16u
    I_MXI2_I3_I17_MP0 (VDD I2_SEL_DIV I2_I3_n1_5 VDD) gpdk090_pmos1v w=0.24u l=0.1u ad=0.0816p as=0.0528p pd=1.16u ps=0.68u
    I_MXI2_I3_I53_MP1 (I2_I3_n4_5 DIVQ_4 VDD VDD) gpdk090_pmos1v w=0.24u l=0.1u ad=0.0528p as=0.0816p pd=0.68u ps=1.16u
    I_MXI2_I3_I53_MP0 (VDD I2_SEL_DIV I2_I3_n4_5 VDD) gpdk090_pmos1v w=0.24u l=0.1u ad=0.0816p as=0.0528p pd=1.16u ps=0.68u
    I_MXI2_I3_I29_MP1 (I2_I3_n2_5 DIVQ_2 VDD VDD) gpdk090_pmos1v w=0.24u l=0.1u ad=0.0528p as=0.0816p pd=0.68u ps=1.16u
    I_MXI2_I3_I29_MP0 (VDD I2_SEL_DIV I2_I3_n2_5 VDD) gpdk090_pmos1v w=0.24u l=0.1u ad=0.0816p as=0.0528p pd=1.16u ps=0.68u
    I_MXI2_I3_I5_MP1 (I2_I3_n0_5 DIVQ_0 VDD VDD) gpdk090_pmos1v w=0.24u l=0.1u ad=0.0528p as=0.0816p pd=0.68u ps=1.16u
    I_MXI2_I3_I5_MP0 (VDD I2_SEL_DIV I2_I3_n0_5 VDD) gpdk090_pmos1v w=0.24u l=0.1u ad=0.0816p as=0.0528p pd=1.16u ps=0.68u
    I_MXI2_I3_I40_MP1 (I2_I3_n3_4 MULP_3 VDD VDD) gpdk090_pmos1v w=0.24u l=0.1u ad=0.0528p as=0.0816p pd=0.68u ps=1.16u
    I_MXI2_I3_I40_MP0 (VDD I2_SEL_MUL I2_I3_n3_4 VDD) gpdk090_pmos1v w=0.24u l=0.1u ad=0.0816p as=0.0528p pd=1.16u ps=0.68u
    I_MXI2_I3_I77_MP1 (I2_I3_n6_5 DIVQ_6 VDD VDD) gpdk090_pmos1v w=0.24u l=0.1u ad=0.0528p as=0.0816p pd=0.68u ps=1.16u
    I_MXI2_I3_I77_MP0 (VDD I2_SEL_DIV I2_I3_n6_5 VDD) gpdk090_pmos1v w=0.24u l=0.1u ad=0.0816p as=0.0528p pd=1.16u ps=0.68u
    I_MXI2_I3_I41_MP1 (I2_I3_n3_5 DIVQ_3 VDD VDD) gpdk090_pmos1v w=0.24u l=0.1u ad=0.0528p as=0.0816p pd=0.68u ps=1.16u
    I_MXI2_I3_I41_MP0 (VDD I2_SEL_DIV I2_I3_n3_5 VDD) gpdk090_pmos1v w=0.24u l=0.1u ad=0.0816p as=0.0528p pd=1.16u ps=0.68u
    I_MXI2_I3_I44_MP1 (I2_I3_o3_2 I2_I3_n3_5 VDD VDD) gpdk090_pmos1v w=0.24u l=0.1u ad=0.0528p as=0.0816p pd=0.68u ps=1.16u
    I_MXI2_I3_I44_MP0 (VDD I2_I3_n3_4 I2_I3_o3_2 VDD) gpdk090_pmos1v w=0.24u l=0.1u ad=0.0816p as=0.0528p pd=1.16u ps=0.68u
    I_MXI2_I3_I28_MP1 (I2_I3_n2_4 MULP_2 VDD VDD) gpdk090_pmos1v w=0.24u l=0.1u ad=0.0528p as=0.0816p pd=0.68u ps=1.16u
    I_MXI2_I3_I28_MP0 (VDD I2_SEL_MUL I2_I3_n2_4 VDD) gpdk090_pmos1v w=0.24u l=0.1u ad=0.0816p as=0.0528p pd=1.16u ps=0.68u
    I_MXI2_I3_I32_MP1 (I2_I3_o2_2 I2_I3_n2_5 VDD VDD) gpdk090_pmos1v w=0.24u l=0.1u ad=0.0528p as=0.0816p pd=0.68u ps=1.16u
    I_MXI2_I3_I32_MP0 (VDD I2_I3_n2_4 I2_I3_o2_2 VDD) gpdk090_pmos1v w=0.24u l=0.1u ad=0.0816p as=0.0528p pd=1.16u ps=0.68u
    I_MXI2_I3_I20_MP1 (I2_I3_o1_2 I2_I3_n1_5 VDD VDD) gpdk090_pmos1v w=0.24u l=0.1u ad=0.0528p as=0.0816p pd=0.68u ps=1.16u
    I_MXI2_I3_I20_MP0 (VDD I2_I3_n1_4 I2_I3_o1_2 VDD) gpdk090_pmos1v w=0.24u l=0.1u ad=0.0816p as=0.0528p pd=1.16u ps=0.68u
    I_MXI2_I3_I16_MP1 (I2_I3_n1_4 MULP_1 VDD VDD) gpdk090_pmos1v w=0.24u l=0.1u ad=0.0528p as=0.0816p pd=0.68u ps=1.16u
    I_MXI2_I3_I16_MP0 (VDD I2_SEL_MUL I2_I3_n1_4 VDD) gpdk090_pmos1v w=0.24u l=0.1u ad=0.0816p as=0.0528p pd=1.16u ps=0.68u
    I_MXI1_I202_MP1 (I1_vn I1_sqn VDD VDD) gpdk090_pmos1v w=0.24u l=0.1u ad=0.0528p as=0.0816p pd=0.68u ps=1.16u
    I_MXI1_I202_MP0 (VDD DIVQ_7 I1_vn VDD) gpdk090_pmos1v w=0.24u l=0.1u ad=0.0816p as=0.0528p pd=1.16u ps=0.68u
    I_MXI2_I3_I4_MP1 (I2_I3_n0_4 MULP_0 VDD VDD) gpdk090_pmos1v w=0.24u l=0.1u ad=0.0528p as=0.0816p pd=0.68u ps=1.16u
    I_MXI2_I3_I4_MP0 (VDD I2_SEL_MUL I2_I3_n0_4 VDD) gpdk090_pmos1v w=0.24u l=0.1u ad=0.0816p as=0.0528p pd=1.16u ps=0.68u
    I_MXI2_I3_I8_MP1 (I2_I3_o0_2 I2_I3_n0_5 VDD VDD) gpdk090_pmos1v w=0.24u l=0.1u ad=0.0528p as=0.0816p pd=0.68u ps=1.16u
    I_MXI2_I3_I8_MP0 (VDD I2_I3_n0_4 I2_I3_o0_2 VDD) gpdk090_pmos1v w=0.24u l=0.1u ad=0.0816p as=0.0528p pd=1.16u ps=0.68u
    I_MXI1_I198_MP1 (I1_z2_0 I1_z1_1 VDD VDD) gpdk090_pmos1v w=0.24u l=0.1u ad=0.0528p as=0.0816p pd=0.68u ps=1.16u
    I_MXI1_I198_MP0 (VDD I1_z1_0 I1_z2_0 VDD) gpdk090_pmos1v w=0.24u l=0.1u ad=0.0816p as=0.0528p pd=1.16u ps=0.68u
    I_MXI2_I4_I8_MP1 (I2_I4_zb0 I2_I4_za1 VDD VDD) gpdk090_pmos1v w=0.24u l=0.1u ad=0.0528p as=0.0816p pd=0.68u ps=1.16u
    I_MXI2_I4_I8_MP0 (VDD I2_I4_za0 I2_I4_zb0 VDD) gpdk090_pmos1v w=0.24u l=0.1u ad=0.0816p as=0.0528p pd=1.16u ps=0.68u
    I_MXI2_I3_I47_MP1 (Y_3 I2_I3_q3_2 VDD VDD) gpdk090_pmos1v w=0.24u l=0.1u ad=0.0528p as=0.0816p pd=0.68u ps=1.16u
    I_MXI2_I3_I47_MP0 (VDD I2_I3_q3_1 Y_3 VDD) gpdk090_pmos1v w=0.24u l=0.1u ad=0.0816p as=0.0528p pd=1.16u ps=0.68u
    I_MXI1_I120_I29_XP_MP1 (I1_I120_P5_2n I1_I120_P3_2 VDD VDD) gpdk090_pmos1v w=0.24u l=0.1u ad=0.0528p as=0.0816p pd=0.68u ps=1.16u
    I_MXI1_I120_I29_XP_MP0 (VDD I1_I120_P5_4 I1_I120_P5_2n VDD) gpdk090_pmos1v w=0.24u l=0.1u ad=0.0816p as=0.0528p pd=1.16u ps=0.68u
    I_MXI1_I120_I31_XP_MP1 (I1_I120_P7_4n I1_I120_P5_4 VDD VDD) gpdk090_pmos1v w=0.24u l=0.1u ad=0.0528p as=0.0816p pd=0.68u ps=1.16u
    I_MXI1_I120_I31_XP_MP0 (VDD I1_I120_P7_6 I1_I120_P7_4n VDD) gpdk090_pmos1v w=0.24u l=0.1u ad=0.0816p as=0.0528p pd=1.16u ps=0.68u
    I_MXI1_I120_I3_MP1 (I1_I120_gn3 I1_b6_3 VDD VDD) gpdk090_pmos1v w=0.24u l=0.1u ad=0.0528p as=0.0816p pd=0.68u ps=1.16u
    I_MXI1_I120_I3_MP0 (VDD I1_p5_2 I1_I120_gn3 VDD) gpdk090_pmos1v w=0.24u l=0.1u ad=0.0816p as=0.0528p pd=1.16u ps=0.68u
    I_MXI1_I120_I2_MP1 (I1_I120_gn2 I1_b6_2 VDD VDD) gpdk090_pmos1v w=0.24u l=0.1u ad=0.0528p as=0.0816p pd=0.68u ps=1.16u
    I_MXI1_I120_I2_MP0 (VDD I1_p5_1 I1_I120_gn2 VDD) gpdk090_pmos1v w=0.24u l=0.1u ad=0.0816p as=0.0528p pd=1.16u ps=0.68u
    I_MXI1_I120_I1_MP1 (I1_I120_gn1 I1_b6_1 VDD VDD) gpdk090_pmos1v w=0.24u l=0.1u ad=0.0528p as=0.0816p pd=0.68u ps=1.16u
    I_MXI1_I120_I1_MP0 (VDD I1_p5_0 I1_I120_gn1 VDD) gpdk090_pmos1v w=0.24u l=0.1u ad=0.0816p as=0.0528p pd=1.16u ps=0.68u
    I_MXI1_I0_MP1 (I1_nakn1 A_0 VDD VDD) gpdk090_pmos1v w=0.24u l=0.1u ad=0.0528p as=0.0816p pd=0.68u ps=1.16u
    I_MXI1_I0_MP0 (VDD A_7 I1_nakn1 VDD) gpdk090_pmos1v w=0.24u l=0.1u ad=0.0816p as=0.0528p pd=1.16u ps=0.68u
    I_MXI2_I3_I11_MP1 (Y_0 I2_I3_q0_2 VDD VDD) gpdk090_pmos1v w=0.24u l=0.1u ad=0.0528p as=0.0816p pd=0.68u ps=1.16u
    I_MXI2_I3_I11_MP0 (VDD I2_I3_q0_1 Y_0 VDD) gpdk090_pmos1v w=0.24u l=0.1u ad=0.0816p as=0.0528p pd=1.16u ps=0.68u
    I_MXI2_I3_I3_MP1 (I2_I3_n0_3 I2_NOT_0 VDD VDD) gpdk090_pmos1v w=0.24u l=0.1u ad=0.0528p as=0.0816p pd=0.68u ps=1.16u
    I_MXI2_I3_I3_MP0 (VDD I2_SEL_NOT I2_I3_n0_3 VDD) gpdk090_pmos1v w=0.24u l=0.1u ad=0.0816p as=0.0528p pd=1.16u ps=0.68u
    I_MXI2_I3_I23_MP1 (Y_1 I2_I3_q1_2 VDD VDD) gpdk090_pmos1v w=0.24u l=0.1u ad=0.0528p as=0.0816p pd=0.68u ps=1.16u
    I_MXI2_I3_I23_MP0 (VDD I2_I3_q1_1 Y_1 VDD) gpdk090_pmos1v w=0.24u l=0.1u ad=0.0816p as=0.0528p pd=1.16u ps=0.68u
    I_MXI2_I3_I7_MP1 (I2_I3_o0_1 I2_I3_n0_3 VDD VDD) gpdk090_pmos1v w=0.24u l=0.1u ad=0.0528p as=0.0816p pd=0.68u ps=1.16u
    I_MXI2_I3_I7_MP0 (VDD I2_I3_n0_2 I2_I3_o0_1 VDD) gpdk090_pmos1v w=0.24u l=0.1u ad=0.0816p as=0.0528p pd=1.16u ps=0.68u
    I_MXI2_I3_I35_MP1 (Y_2 I2_I3_q2_2 VDD VDD) gpdk090_pmos1v w=0.24u l=0.1u ad=0.0528p as=0.0816p pd=0.68u ps=1.16u
    I_MXI2_I3_I35_MP0 (VDD I2_I3_q2_1 Y_2 VDD) gpdk090_pmos1v w=0.24u l=0.1u ad=0.0816p as=0.0528p pd=1.16u ps=0.68u
    I_MXI2_I3_I55_MP1 (I2_I3_o4_1 I2_I3_n4_3 VDD VDD) gpdk090_pmos1v w=0.24u l=0.1u ad=0.0528p as=0.0816p pd=0.68u ps=1.16u
    I_MXI2_I3_I55_MP0 (VDD I2_I3_n4_2 I2_I3_o4_1 VDD) gpdk090_pmos1v w=0.24u l=0.1u ad=0.0816p as=0.0528p pd=1.16u ps=0.68u
    I_MXI2_I3_I51_MP1 (I2_I3_n4_3 I2_NOT_4 VDD VDD) gpdk090_pmos1v w=0.24u l=0.1u ad=0.0528p as=0.0816p pd=0.68u ps=1.16u
    I_MXI2_I3_I51_MP0 (VDD I2_SEL_NOT I2_I3_n4_3 VDD) gpdk090_pmos1v w=0.24u l=0.1u ad=0.0816p as=0.0528p pd=1.16u ps=0.68u
    I_MXI2_I3_I50_MP1 (I2_I3_n4_2 I2_XOR_4 VDD VDD) gpdk090_pmos1v w=0.24u l=0.1u ad=0.0528p as=0.0816p pd=0.68u ps=1.16u
    I_MXI2_I3_I50_MP0 (VDD I2_SEL_XOR I2_I3_n4_2 VDD) gpdk090_pmos1v w=0.24u l=0.1u ad=0.0816p as=0.0528p pd=1.16u ps=0.68u
    I_MXI1_I120_I6_MP1 (I1_I120_gn6 I1_b6_6 VDD VDD) gpdk090_pmos1v w=0.24u l=0.1u ad=0.0528p as=0.0816p pd=0.68u ps=1.16u
    I_MXI1_I120_I6_MP0 (VDD I1_p5_5 I1_I120_gn6 VDD) gpdk090_pmos1v w=0.24u l=0.1u ad=0.0816p as=0.0528p pd=1.16u ps=0.68u
    I_MXI1_I120_I4_MP1 (I1_I120_gn4 I1_b6_4 VDD VDD) gpdk090_pmos1v w=0.24u l=0.1u ad=0.0528p as=0.0816p pd=0.68u ps=1.16u
    I_MXI1_I120_I4_MP0 (VDD I1_p5_3 I1_I120_gn4 VDD) gpdk090_pmos1v w=0.24u l=0.1u ad=0.0816p as=0.0528p pd=1.16u ps=0.68u
    I_MXI1_I20_MP1 (I1_nbkn1 B_0 VDD VDD) gpdk090_pmos1v w=0.24u l=0.1u ad=0.0528p as=0.0816p pd=0.68u ps=1.16u
    I_MXI1_I20_MP0 (VDD B_7 I1_nbkn1 VDD) gpdk090_pmos1v w=0.24u l=0.1u ad=0.0816p as=0.0528p pd=1.16u ps=0.68u
    I_MXI2_I2_I0_MP1 (I2_I2_nand0 B_0 VDD VDD) gpdk090_pmos1v w=0.24u l=0.1u ad=0.0528p as=0.0816p pd=0.68u ps=1.16u
    I_MXI2_I2_I0_MP0 (VDD A_0 I2_I2_nand0 VDD) gpdk090_pmos1v w=0.24u l=0.1u ad=0.0816p as=0.0528p pd=1.16u ps=0.68u
    I_MXI2_I3_I2_MP1 (I2_I3_n0_2 I2_XOR_0 VDD VDD) gpdk090_pmos1v w=0.24u l=0.1u ad=0.0528p as=0.0816p pd=0.68u ps=1.16u
    I_MXI2_I3_I2_MP0 (VDD I2_SEL_XOR I2_I3_n0_2 VDD) gpdk090_pmos1v w=0.24u l=0.1u ad=0.0816p as=0.0528p pd=1.16u ps=0.68u
    I_MXI2_I3_I19_MP1 (I2_I3_o1_1 I2_I3_n1_3 VDD VDD) gpdk090_pmos1v w=0.24u l=0.1u ad=0.0528p as=0.0816p pd=0.68u ps=1.16u
    I_MXI2_I3_I19_MP0 (VDD I2_I3_n1_2 I2_I3_o1_1 VDD) gpdk090_pmos1v w=0.24u l=0.1u ad=0.0816p as=0.0528p pd=1.16u ps=0.68u
    I_MXI2_I3_I15_MP1 (I2_I3_n1_3 I2_NOT_1 VDD VDD) gpdk090_pmos1v w=0.24u l=0.1u ad=0.0528p as=0.0816p pd=0.68u ps=1.16u
    I_MXI2_I3_I15_MP0 (VDD I2_SEL_NOT I2_I3_n1_3 VDD) gpdk090_pmos1v w=0.24u l=0.1u ad=0.0816p as=0.0528p pd=1.16u ps=0.68u
    I_MXI2_I2_I6_MP1 (I2_I2_nand1 B_1 VDD VDD) gpdk090_pmos1v w=0.24u l=0.1u ad=0.0528p as=0.0816p pd=0.68u ps=1.16u
    I_MXI2_I2_I6_MP0 (VDD A_1 I2_I2_nand1 VDD) gpdk090_pmos1v w=0.24u l=0.1u ad=0.0816p as=0.0528p pd=1.16u ps=0.68u
    I_MXI2_I3_I14_MP1 (I2_I3_n1_2 I2_XOR_1 VDD VDD) gpdk090_pmos1v w=0.24u l=0.1u ad=0.0528p as=0.0816p pd=0.68u ps=1.16u
    I_MXI2_I3_I14_MP0 (VDD I2_SEL_XOR I2_I3_n1_2 VDD) gpdk090_pmos1v w=0.24u l=0.1u ad=0.0816p as=0.0528p pd=1.16u ps=0.68u
    I_MXI2_I3_I54_MP1 (I2_I3_o4_0 I2_I3_n4_1 VDD VDD) gpdk090_pmos1v w=0.24u l=0.1u ad=0.0528p as=0.0816p pd=0.68u ps=1.16u
    I_MXI2_I3_I54_MP0 (VDD I2_I3_n4_0 I2_I3_o4_0 VDD) gpdk090_pmos1v w=0.24u l=0.1u ad=0.0816p as=0.0528p pd=1.16u ps=0.68u
    I_MXI2_I3_I49_MP1 (I2_I3_n4_1 I2_OR_4 VDD VDD) gpdk090_pmos1v w=0.24u l=0.1u ad=0.0528p as=0.0816p pd=0.68u ps=1.16u
    I_MXI2_I3_I49_MP0 (VDD I2_SEL_OR I2_I3_n4_1 VDD) gpdk090_pmos1v w=0.24u l=0.1u ad=0.0816p as=0.0528p pd=1.16u ps=0.68u
    I_MXI2_I3_I48_MP1 (I2_I3_n4_0 I2_AND_4 VDD VDD) gpdk090_pmos1v w=0.24u l=0.1u ad=0.0528p as=0.0816p pd=0.68u ps=1.16u
    I_MXI2_I3_I48_MP0 (VDD I2_SEL_AND I2_I3_n4_0 VDD) gpdk090_pmos1v w=0.24u l=0.1u ad=0.0816p as=0.0528p pd=1.16u ps=0.68u
    I_MXI2_I2_I12_MP1 (I2_I2_nand2 B_2 VDD VDD) gpdk090_pmos1v w=0.24u l=0.1u ad=0.0528p as=0.0816p pd=0.68u ps=1.16u
    I_MXI2_I2_I12_MP0 (VDD A_2 I2_I2_nand2 VDD) gpdk090_pmos1v w=0.24u l=0.1u ad=0.0816p as=0.0528p pd=1.16u ps=0.68u
    I_MXI2_I2_I24_MP1 (I2_I2_nand4 B_4 VDD VDD) gpdk090_pmos1v w=0.24u l=0.1u ad=0.0528p as=0.0816p pd=0.68u ps=1.16u
    I_MXI2_I2_I24_MP0 (VDD A_4 I2_I2_nand4 VDD) gpdk090_pmos1v w=0.24u l=0.1u ad=0.0816p as=0.0528p pd=1.16u ps=0.68u
    I_MXI1_I120_I7_MP1 (I1_I120_gn7 I1_b6_7 VDD VDD) gpdk090_pmos1v w=0.24u l=0.1u ad=0.0528p as=0.0816p pd=0.68u ps=1.16u
    I_MXI1_I120_I7_MP0 (VDD I1_p5_6 I1_I120_gn7 VDD) gpdk090_pmos1v w=0.24u l=0.1u ad=0.0816p as=0.0528p pd=1.16u ps=0.68u
    I_MXI1_I120_I5_MP1 (I1_I120_gn5 I1_b6_5 VDD VDD) gpdk090_pmos1v w=0.24u l=0.1u ad=0.0528p as=0.0816p pd=0.68u ps=1.16u
    I_MXI1_I120_I5_MP0 (VDD I1_p5_4 I1_I120_gn5 VDD) gpdk090_pmos1v w=0.24u l=0.1u ad=0.0816p as=0.0528p pd=1.16u ps=0.68u
    I_MXI1_I108_I1_MP1 (I1_I108_gn1 I1_b5_1 VDD VDD) gpdk090_pmos1v w=0.24u l=0.1u ad=0.0528p as=0.0816p pd=0.68u ps=1.16u
    I_MXI1_I108_I1_MP0 (VDD I1_p4_0 I1_I108_gn1 VDD) gpdk090_pmos1v w=0.24u l=0.1u ad=0.0816p as=0.0528p pd=1.16u ps=0.68u
    I_MXI1_I108_I0_MP1 (I1_I108_gn0 I1_b5_0 VDD VDD) gpdk090_pmos1v w=0.24u l=0.1u ad=0.0528p as=0.0816p pd=0.68u ps=1.16u
    I_MXI1_I108_I0_MP0 (VDD I1_aa2 I1_I108_gn0 VDD) gpdk090_pmos1v w=0.24u l=0.1u ad=0.0816p as=0.0528p pd=1.16u ps=0.68u
    I_MXI1_I96_I0_MP1 (I1_I96_gn0 I1_b4_0 VDD VDD) gpdk090_pmos1v w=0.24u l=0.1u ad=0.0528p as=0.0816p pd=0.68u ps=1.16u
    I_MXI1_I96_I0_MP0 (VDD I1_aa3 I1_I96_gn0 VDD) gpdk090_pmos1v w=0.24u l=0.1u ad=0.0816p as=0.0528p pd=1.16u ps=0.68u
    I_MXI1_I84_I0_MP1 (I1_I84_gn0 I1_b3_0 VDD VDD) gpdk090_pmos1v w=0.24u l=0.1u ad=0.0528p as=0.0816p pd=0.68u ps=1.16u
    I_MXI1_I84_I0_MP0 (VDD I1_aa4 I1_I84_gn0 VDD) gpdk090_pmos1v w=0.24u l=0.1u ad=0.0816p as=0.0528p pd=1.16u ps=0.68u
    I_MXI1_I60_I0_MP1 (I1_I60_gn0 I1_b1_0 VDD VDD) gpdk090_pmos1v w=0.24u l=0.1u ad=0.0528p as=0.0816p pd=0.68u ps=1.16u
    I_MXI1_I60_I0_MP0 (VDD I1_aa6 I1_I60_gn0 VDD) gpdk090_pmos1v w=0.24u l=0.1u ad=0.0816p as=0.0528p pd=1.16u ps=0.68u
    I_MXI2_I3_I1_MP1 (I2_I3_n0_1 I2_OR_0 VDD VDD) gpdk090_pmos1v w=0.24u l=0.1u ad=0.0528p as=0.0816p pd=0.68u ps=1.16u
    I_MXI2_I3_I1_MP0 (VDD I2_SEL_OR I2_I3_n0_1 VDD) gpdk090_pmos1v w=0.24u l=0.1u ad=0.0816p as=0.0528p pd=1.16u ps=0.68u
    I_MXI2_I3_I6_MP1 (I2_I3_o0_0 I2_I3_n0_1 VDD VDD) gpdk090_pmos1v w=0.24u l=0.1u ad=0.0528p as=0.0816p pd=0.68u ps=1.16u
    I_MXI2_I3_I6_MP0 (VDD I2_I3_n0_0 I2_I3_o0_0 VDD) gpdk090_pmos1v w=0.24u l=0.1u ad=0.0816p as=0.0528p pd=1.16u ps=0.68u
    I_MXI2_I3_I0_MP1 (I2_I3_n0_0 I2_AND_0 VDD VDD) gpdk090_pmos1v w=0.24u l=0.1u ad=0.0528p as=0.0816p pd=0.68u ps=1.16u
    I_MXI2_I3_I0_MP0 (VDD I2_SEL_AND I2_I3_n0_0 VDD) gpdk090_pmos1v w=0.24u l=0.1u ad=0.0816p as=0.0528p pd=1.16u ps=0.68u
    I_MXI2_I3_I13_MP1 (I2_I3_n1_1 I2_OR_1 VDD VDD) gpdk090_pmos1v w=0.24u l=0.1u ad=0.0528p as=0.0816p pd=0.68u ps=1.16u
    I_MXI2_I3_I13_MP0 (VDD I2_SEL_OR I2_I3_n1_1 VDD) gpdk090_pmos1v w=0.24u l=0.1u ad=0.0816p as=0.0528p pd=1.16u ps=0.68u
    I_MXI2_I3_I18_MP1 (I2_I3_o1_0 I2_I3_n1_1 VDD VDD) gpdk090_pmos1v w=0.24u l=0.1u ad=0.0528p as=0.0816p pd=0.68u ps=1.16u
    I_MXI2_I3_I18_MP0 (VDD I2_I3_n1_0 I2_I3_o1_0 VDD) gpdk090_pmos1v w=0.24u l=0.1u ad=0.0816p as=0.0528p pd=1.16u ps=0.68u
    I_MXI2_I3_I12_MP1 (I2_I3_n1_0 I2_AND_1 VDD VDD) gpdk090_pmos1v w=0.24u l=0.1u ad=0.0528p as=0.0816p pd=0.68u ps=1.16u
    I_MXI2_I3_I12_MP0 (VDD I2_SEL_AND I2_I3_n1_0 VDD) gpdk090_pmos1v w=0.24u l=0.1u ad=0.0816p as=0.0528p pd=1.16u ps=0.68u
    I_MXI2_I3_I27_MP1 (I2_I3_n2_3 I2_NOT_2 VDD VDD) gpdk090_pmos1v w=0.24u l=0.1u ad=0.0528p as=0.0816p pd=0.68u ps=1.16u
    I_MXI2_I3_I27_MP0 (VDD I2_SEL_NOT I2_I3_n2_3 VDD) gpdk090_pmos1v w=0.24u l=0.1u ad=0.0816p as=0.0528p pd=1.16u ps=0.68u
    I_MXI2_I3_I30_MP1 (I2_I3_o2_0 I2_I3_n2_1 VDD VDD) gpdk090_pmos1v w=0.24u l=0.1u ad=0.0528p as=0.0816p pd=0.68u ps=1.16u
    I_MXI2_I3_I30_MP0 (VDD I2_I3_n2_0 I2_I3_o2_0 VDD) gpdk090_pmos1v w=0.24u l=0.1u ad=0.0816p as=0.0528p pd=1.16u ps=0.68u
    I_MXI2_I3_I24_MP1 (I2_I3_n2_0 I2_AND_2 VDD VDD) gpdk090_pmos1v w=0.24u l=0.1u ad=0.0528p as=0.0816p pd=0.68u ps=1.16u
    I_MXI2_I3_I24_MP0 (VDD I2_SEL_AND I2_I3_n2_0 VDD) gpdk090_pmos1v w=0.24u l=0.1u ad=0.0816p as=0.0528p pd=1.16u ps=0.68u
    I_MXI2_I3_I31_MP1 (I2_I3_o2_1 I2_I3_n2_3 VDD VDD) gpdk090_pmos1v w=0.24u l=0.1u ad=0.0528p as=0.0816p pd=0.68u ps=1.16u
    I_MXI2_I3_I31_MP0 (VDD I2_I3_n2_2 I2_I3_o2_1 VDD) gpdk090_pmos1v w=0.24u l=0.1u ad=0.0816p as=0.0528p pd=1.16u ps=0.68u
    I_MXI2_I3_I26_MP1 (I2_I3_n2_2 I2_XOR_2 VDD VDD) gpdk090_pmos1v w=0.24u l=0.1u ad=0.0528p as=0.0816p pd=0.68u ps=1.16u
    I_MXI2_I3_I26_MP0 (VDD I2_SEL_XOR I2_I3_n2_2 VDD) gpdk090_pmos1v w=0.24u l=0.1u ad=0.0816p as=0.0528p pd=1.16u ps=0.68u
    I_MXI1_I108_I28_XP_MP1 (I1_I108_P4_1n I1_I108_P2_1 VDD VDD) gpdk090_pmos1v w=0.24u l=0.1u ad=0.0528p as=0.0816p pd=0.68u ps=1.16u
    I_MXI1_I108_I28_XP_MP0 (VDD I1_I108_P4_3 I1_I108_P4_1n VDD) gpdk090_pmos1v w=0.24u l=0.1u ad=0.0816p as=0.0528p pd=1.16u ps=0.68u
    I_MXI1_I108_I2_MP1 (I1_I108_gn2 I1_b5_2 VDD VDD) gpdk090_pmos1v w=0.24u l=0.1u ad=0.0528p as=0.0816p pd=0.68u ps=1.16u
    I_MXI1_I108_I2_MP0 (VDD I1_p4_1 I1_I108_gn2 VDD) gpdk090_pmos1v w=0.24u l=0.1u ad=0.0816p as=0.0528p pd=1.16u ps=0.68u
    I_MXI1_I72_I0_MP1 (I1_I72_gn0 I1_b2_0 VDD VDD) gpdk090_pmos1v w=0.24u l=0.1u ad=0.0528p as=0.0816p pd=0.68u ps=1.16u
    I_MXI1_I72_I0_MP0 (VDD I1_aa5 I1_I72_gn0 VDD) gpdk090_pmos1v w=0.24u l=0.1u ad=0.0816p as=0.0528p pd=1.16u ps=0.68u
    I_MXI1_I48_I0_MP1 (I1_I48_gn0 I1_b0_0 VDD VDD) gpdk090_pmos1v w=0.24u l=0.1u ad=0.0528p as=0.0816p pd=0.68u ps=1.16u
    I_MXI1_I48_I0_MP0 (VDD I1_aa7 I1_I48_gn0 VDD) gpdk090_pmos1v w=0.24u l=0.1u ad=0.0816p as=0.0528p pd=1.16u ps=0.68u
    I_MXI1_I48_I2_MP1 (I1_I48_gn2 I1_b0_2 VDD VDD) gpdk090_pmos1v w=0.24u l=0.1u ad=0.0528p as=0.0816p pd=0.68u ps=1.16u
    I_MXI1_I48_I2_MP0 (VDD VSS I1_I48_gn2 VDD) gpdk090_pmos1v w=0.24u l=0.1u ad=0.0816p as=0.0528p pd=1.16u ps=0.68u
    I_MXI2_I3_I25_MP1 (I2_I3_n2_1 I2_OR_2 VDD VDD) gpdk090_pmos1v w=0.24u l=0.1u ad=0.0528p as=0.0816p pd=0.68u ps=1.16u
    I_MXI2_I3_I25_MP0 (VDD I2_SEL_OR I2_I3_n2_1 VDD) gpdk090_pmos1v w=0.24u l=0.1u ad=0.0816p as=0.0528p pd=1.16u ps=0.68u
    I_MXI1_I48_I3_MP1 (I1_I48_gn3 I1_b0_3 VDD VDD) gpdk090_pmos1v w=0.24u l=0.1u ad=0.0528p as=0.0816p pd=0.68u ps=1.16u
    I_MXI1_I48_I3_MP0 (VDD VSS I1_I48_gn3 VDD) gpdk090_pmos1v w=0.24u l=0.1u ad=0.0816p as=0.0528p pd=1.16u ps=0.68u
    I_MXI1_I108_I29_XP_MP1 (I1_I108_P5_2n I1_I108_P3_2 VDD VDD) gpdk090_pmos1v w=0.24u l=0.1u ad=0.0528p as=0.0816p pd=0.68u ps=1.16u
    I_MXI1_I108_I29_XP_MP0 (VDD I1_I108_P5_4 I1_I108_P5_2n VDD) gpdk090_pmos1v w=0.24u l=0.1u ad=0.0816p as=0.0528p pd=1.16u ps=0.68u
    I_MXI1_I108_I30_XP_MP1 (I1_I108_P6_3n I1_I108_P4_3 VDD VDD) gpdk090_pmos1v w=0.24u l=0.1u ad=0.0528p as=0.0816p pd=0.68u ps=1.16u
    I_MXI1_I108_I30_XP_MP0 (VDD I1_I108_P6_5 I1_I108_P6_3n VDD) gpdk090_pmos1v w=0.24u l=0.1u ad=0.0816p as=0.0528p pd=1.16u ps=0.68u
    I_MXI1_I108_I3_MP1 (I1_I108_gn3 I1_b5_3 VDD VDD) gpdk090_pmos1v w=0.24u l=0.1u ad=0.0528p as=0.0816p pd=0.68u ps=1.16u
    I_MXI1_I108_I3_MP0 (VDD I1_p4_2 I1_I108_gn3 VDD) gpdk090_pmos1v w=0.24u l=0.1u ad=0.0816p as=0.0528p pd=1.16u ps=0.68u
    I_MXI1_I96_I2_MP1 (I1_I96_gn2 I1_b4_2 VDD VDD) gpdk090_pmos1v w=0.24u l=0.1u ad=0.0528p as=0.0816p pd=0.68u ps=1.16u
    I_MXI1_I96_I2_MP0 (VDD I1_p3_1 I1_I96_gn2 VDD) gpdk090_pmos1v w=0.24u l=0.1u ad=0.0816p as=0.0528p pd=1.16u ps=0.68u
    I_MXI1_I96_I1_MP1 (I1_I96_gn1 I1_b4_1 VDD VDD) gpdk090_pmos1v w=0.24u l=0.1u ad=0.0528p as=0.0816p pd=0.68u ps=1.16u
    I_MXI1_I96_I1_MP0 (VDD I1_p3_0 I1_I96_gn1 VDD) gpdk090_pmos1v w=0.24u l=0.1u ad=0.0816p as=0.0528p pd=1.16u ps=0.68u
    I_MXI1_I84_I1_MP1 (I1_I84_gn1 I1_b3_1 VDD VDD) gpdk090_pmos1v w=0.24u l=0.1u ad=0.0528p as=0.0816p pd=0.68u ps=1.16u
    I_MXI1_I84_I1_MP0 (VDD I1_p2_0 I1_I84_gn1 VDD) gpdk090_pmos1v w=0.24u l=0.1u ad=0.0816p as=0.0528p pd=1.16u ps=0.68u
    I_MXI1_I84_I2_MP1 (I1_I84_gn2 I1_b3_2 VDD VDD) gpdk090_pmos1v w=0.24u l=0.1u ad=0.0528p as=0.0816p pd=0.68u ps=1.16u
    I_MXI1_I84_I2_MP0 (VDD I1_p2_1 I1_I84_gn2 VDD) gpdk090_pmos1v w=0.24u l=0.1u ad=0.0816p as=0.0528p pd=1.16u ps=0.68u
    I_MXI1_I72_I1_MP1 (I1_I72_gn1 I1_b2_1 VDD VDD) gpdk090_pmos1v w=0.24u l=0.1u ad=0.0528p as=0.0816p pd=0.68u ps=1.16u
    I_MXI1_I72_I1_MP0 (VDD I1_p1_0 I1_I72_gn1 VDD) gpdk090_pmos1v w=0.24u l=0.1u ad=0.0816p as=0.0528p pd=1.16u ps=0.68u
    I_MXI1_I72_I2_MP1 (I1_I72_gn2 I1_b2_2 VDD VDD) gpdk090_pmos1v w=0.24u l=0.1u ad=0.0528p as=0.0816p pd=0.68u ps=1.16u
    I_MXI1_I72_I2_MP0 (VDD I1_p1_1 I1_I72_gn2 VDD) gpdk090_pmos1v w=0.24u l=0.1u ad=0.0816p as=0.0528p pd=1.16u ps=0.68u
    I_MXI1_I60_I1_MP1 (I1_I60_gn1 I1_b1_1 VDD VDD) gpdk090_pmos1v w=0.24u l=0.1u ad=0.0528p as=0.0816p pd=0.68u ps=1.16u
    I_MXI1_I60_I1_MP0 (VDD I1_p0_0 I1_I60_gn1 VDD) gpdk090_pmos1v w=0.24u l=0.1u ad=0.0816p as=0.0528p pd=1.16u ps=0.68u
    I_MXI1_I60_I2_MP1 (I1_I60_gn2 I1_b1_2 VDD VDD) gpdk090_pmos1v w=0.24u l=0.1u ad=0.0528p as=0.0816p pd=0.68u ps=1.16u
    I_MXI1_I60_I2_MP0 (VDD I1_p0_1 I1_I60_gn2 VDD) gpdk090_pmos1v w=0.24u l=0.1u ad=0.0816p as=0.0528p pd=1.16u ps=0.68u
    I_MXI1_I48_I1_MP1 (I1_I48_gn1 I1_b0_1 VDD VDD) gpdk090_pmos1v w=0.24u l=0.1u ad=0.0528p as=0.0816p pd=0.68u ps=1.16u
    I_MXI1_I48_I1_MP0 (VDD VSS I1_I48_gn1 VDD) gpdk090_pmos1v w=0.24u l=0.1u ad=0.0816p as=0.0528p pd=1.16u ps=0.68u
    I_MXI1_I108_I31_XP_MP1 (I1_I108_P7_4n I1_I108_P5_4 VDD VDD) gpdk090_pmos1v w=0.24u l=0.1u ad=0.0528p as=0.0816p pd=0.68u ps=1.16u
    I_MXI1_I108_I31_XP_MP0 (VDD I1_I108_P7_6 I1_I108_P7_4n VDD) gpdk090_pmos1v w=0.24u l=0.1u ad=0.0816p as=0.0528p pd=1.16u ps=0.68u
    I_MXI1_I108_I4_MP1 (I1_I108_gn4 I1_b5_4 VDD VDD) gpdk090_pmos1v w=0.24u l=0.1u ad=0.0528p as=0.0816p pd=0.68u ps=1.16u
    I_MXI1_I108_I4_MP0 (VDD I1_p4_3 I1_I108_gn4 VDD) gpdk090_pmos1v w=0.24u l=0.1u ad=0.0816p as=0.0528p pd=1.16u ps=0.68u
    I_MXI1_I96_I3_MP1 (I1_I96_gn3 I1_b4_3 VDD VDD) gpdk090_pmos1v w=0.24u l=0.1u ad=0.0528p as=0.0816p pd=0.68u ps=1.16u
    I_MXI1_I96_I3_MP0 (VDD I1_p3_2 I1_I96_gn3 VDD) gpdk090_pmos1v w=0.24u l=0.1u ad=0.0816p as=0.0528p pd=1.16u ps=0.68u
    I_MXI1_I84_I28_XP_MP1 (I1_I84_P4_1n I1_I84_P2_1 VDD VDD) gpdk090_pmos1v w=0.24u l=0.1u ad=0.0528p as=0.0816p pd=0.68u ps=1.16u
    I_MXI1_I84_I28_XP_MP0 (VDD I1_I84_P4_3 I1_I84_P4_1n VDD) gpdk090_pmos1v w=0.24u l=0.1u ad=0.0816p as=0.0528p pd=1.16u ps=0.68u
    I_MXI1_I84_I3_MP1 (I1_I84_gn3 I1_b3_3 VDD VDD) gpdk090_pmos1v w=0.24u l=0.1u ad=0.0528p as=0.0816p pd=0.68u ps=1.16u
    I_MXI1_I84_I3_MP0 (VDD I1_p2_2 I1_I84_gn3 VDD) gpdk090_pmos1v w=0.24u l=0.1u ad=0.0816p as=0.0528p pd=1.16u ps=0.68u
    I_MXI1_I72_I28_XP_MP1 (I1_I72_P4_1n I1_I72_P2_1 VDD VDD) gpdk090_pmos1v w=0.24u l=0.1u ad=0.0528p as=0.0816p pd=0.68u ps=1.16u
    I_MXI1_I72_I28_XP_MP0 (VDD I1_I72_P4_3 I1_I72_P4_1n VDD) gpdk090_pmos1v w=0.24u l=0.1u ad=0.0816p as=0.0528p pd=1.16u ps=0.68u
    I_MXI1_I72_I3_MP1 (I1_I72_gn3 I1_b2_3 VDD VDD) gpdk090_pmos1v w=0.24u l=0.1u ad=0.0528p as=0.0816p pd=0.68u ps=1.16u
    I_MXI1_I72_I3_MP0 (VDD I1_p1_2 I1_I72_gn3 VDD) gpdk090_pmos1v w=0.24u l=0.1u ad=0.0816p as=0.0528p pd=1.16u ps=0.68u
    I_MXI1_I60_I28_XP_MP1 (I1_I60_P4_1n I1_I60_P2_1 VDD VDD) gpdk090_pmos1v w=0.24u l=0.1u ad=0.0528p as=0.0816p pd=0.68u ps=1.16u
    I_MXI1_I60_I28_XP_MP0 (VDD I1_I60_P4_3 I1_I60_P4_1n VDD) gpdk090_pmos1v w=0.24u l=0.1u ad=0.0816p as=0.0528p pd=1.16u ps=0.68u
    I_MXI1_I60_I3_MP1 (I1_I60_gn3 I1_b1_3 VDD VDD) gpdk090_pmos1v w=0.24u l=0.1u ad=0.0528p as=0.0816p pd=0.68u ps=1.16u
    I_MXI1_I60_I3_MP0 (VDD I1_p0_2 I1_I60_gn3 VDD) gpdk090_pmos1v w=0.24u l=0.1u ad=0.0816p as=0.0528p pd=1.16u ps=0.68u
    I_MXI1_I48_I28_XP_MP1 (I1_I48_P4_1n I1_I48_P2_1 VDD VDD) gpdk090_pmos1v w=0.24u l=0.1u ad=0.0528p as=0.0816p pd=0.68u ps=1.16u
    I_MXI1_I48_I28_XP_MP0 (VDD I1_I48_P4_3 I1_I48_P4_1n VDD) gpdk090_pmos1v w=0.24u l=0.1u ad=0.0816p as=0.0528p pd=1.16u ps=0.68u
    I_MXI1_I48_I4_MP1 (I1_I48_gn4 I1_b0_4 VDD VDD) gpdk090_pmos1v w=0.24u l=0.1u ad=0.0528p as=0.0816p pd=0.68u ps=1.16u
    I_MXI1_I48_I4_MP0 (VDD VSS I1_I48_gn4 VDD) gpdk090_pmos1v w=0.24u l=0.1u ad=0.0816p as=0.0528p pd=1.16u ps=0.68u
    I_MXI1_I108_I5_MP1 (I1_I108_gn5 I1_b5_5 VDD VDD) gpdk090_pmos1v w=0.24u l=0.1u ad=0.0528p as=0.0816p pd=0.68u ps=1.16u
    I_MXI1_I108_I5_MP0 (VDD I1_p4_4 I1_I108_gn5 VDD) gpdk090_pmos1v w=0.24u l=0.1u ad=0.0816p as=0.0528p pd=1.16u ps=0.68u
    I_MXI1_I96_I28_XP_MP1 (I1_I96_P4_1n I1_I96_P2_1 VDD VDD) gpdk090_pmos1v w=0.24u l=0.1u ad=0.0528p as=0.0816p pd=0.68u ps=1.16u
    I_MXI1_I96_I28_XP_MP0 (VDD I1_I96_P4_3 I1_I96_P4_1n VDD) gpdk090_pmos1v w=0.24u l=0.1u ad=0.0816p as=0.0528p pd=1.16u ps=0.68u
    I_MXI1_I84_I4_MP1 (I1_I84_gn4 I1_b3_4 VDD VDD) gpdk090_pmos1v w=0.24u l=0.1u ad=0.0528p as=0.0816p pd=0.68u ps=1.16u
    I_MXI1_I84_I4_MP0 (VDD I1_p2_3 I1_I84_gn4 VDD) gpdk090_pmos1v w=0.24u l=0.1u ad=0.0816p as=0.0528p pd=1.16u ps=0.68u
    I_MXI1_I72_I30_XP_MP1 (I1_I72_P6_3n I1_I72_P4_3 VDD VDD) gpdk090_pmos1v w=0.24u l=0.1u ad=0.0528p as=0.0816p pd=0.68u ps=1.16u
    I_MXI1_I72_I30_XP_MP0 (VDD I1_I72_P6_5 I1_I72_P6_3n VDD) gpdk090_pmos1v w=0.24u l=0.1u ad=0.0816p as=0.0528p pd=1.16u ps=0.68u
    I_MXI1_I72_I4_MP1 (I1_I72_gn4 I1_b2_4 VDD VDD) gpdk090_pmos1v w=0.24u l=0.1u ad=0.0528p as=0.0816p pd=0.68u ps=1.16u
    I_MXI1_I72_I4_MP0 (VDD I1_p1_3 I1_I72_gn4 VDD) gpdk090_pmos1v w=0.24u l=0.1u ad=0.0816p as=0.0528p pd=1.16u ps=0.68u
    I_MXI1_I60_I30_XP_MP1 (I1_I60_P6_3n I1_I60_P4_3 VDD VDD) gpdk090_pmos1v w=0.24u l=0.1u ad=0.0528p as=0.0816p pd=0.68u ps=1.16u
    I_MXI1_I60_I30_XP_MP0 (VDD I1_I60_P6_5 I1_I60_P6_3n VDD) gpdk090_pmos1v w=0.24u l=0.1u ad=0.0816p as=0.0528p pd=1.16u ps=0.68u
    I_MXI1_I60_I4_MP1 (I1_I60_gn4 I1_b1_4 VDD VDD) gpdk090_pmos1v w=0.24u l=0.1u ad=0.0528p as=0.0816p pd=0.68u ps=1.16u
    I_MXI1_I60_I4_MP0 (VDD I1_p0_3 I1_I60_gn4 VDD) gpdk090_pmos1v w=0.24u l=0.1u ad=0.0816p as=0.0528p pd=1.16u ps=0.68u
    I_MXI1_I48_I30_XP_MP1 (I1_I48_P6_3n I1_I48_P4_3 VDD VDD) gpdk090_pmos1v w=0.24u l=0.1u ad=0.0528p as=0.0816p pd=0.68u ps=1.16u
    I_MXI1_I48_I30_XP_MP0 (VDD I1_I48_P6_5 I1_I48_P6_3n VDD) gpdk090_pmos1v w=0.24u l=0.1u ad=0.0816p as=0.0528p pd=1.16u ps=0.68u
    I_MXI1_I48_I29_XP_MP1 (I1_I48_P5_2n I1_I48_P3_2 VDD VDD) gpdk090_pmos1v w=0.24u l=0.1u ad=0.0528p as=0.0816p pd=0.68u ps=1.16u
    I_MXI1_I48_I29_XP_MP0 (VDD I1_I48_P5_4 I1_I48_P5_2n VDD) gpdk090_pmos1v w=0.24u l=0.1u ad=0.0816p as=0.0528p pd=1.16u ps=0.68u
    I_MXI1_I108_I6_MP1 (I1_I108_gn6 I1_b5_6 VDD VDD) gpdk090_pmos1v w=0.24u l=0.1u ad=0.0528p as=0.0816p pd=0.68u ps=1.16u
    I_MXI1_I108_I6_MP0 (VDD I1_p4_5 I1_I108_gn6 VDD) gpdk090_pmos1v w=0.24u l=0.1u ad=0.0816p as=0.0528p pd=1.16u ps=0.68u
    I_MXI1_I96_I29_XP_MP1 (I1_I96_P5_2n I1_I96_P3_2 VDD VDD) gpdk090_pmos1v w=0.24u l=0.1u ad=0.0528p as=0.0816p pd=0.68u ps=1.16u
    I_MXI1_I96_I29_XP_MP0 (VDD I1_I96_P5_4 I1_I96_P5_2n VDD) gpdk090_pmos1v w=0.24u l=0.1u ad=0.0816p as=0.0528p pd=1.16u ps=0.68u
    I_MXI1_I96_I30_XP_MP1 (I1_I96_P6_3n I1_I96_P4_3 VDD VDD) gpdk090_pmos1v w=0.24u l=0.1u ad=0.0528p as=0.0816p pd=0.68u ps=1.16u
    I_MXI1_I96_I30_XP_MP0 (VDD I1_I96_P6_5 I1_I96_P6_3n VDD) gpdk090_pmos1v w=0.24u l=0.1u ad=0.0816p as=0.0528p pd=1.16u ps=0.68u
    I_MXI1_I96_I4_MP1 (I1_I96_gn4 I1_b4_4 VDD VDD) gpdk090_pmos1v w=0.24u l=0.1u ad=0.0528p as=0.0816p pd=0.68u ps=1.16u
    I_MXI1_I96_I4_MP0 (VDD I1_p3_3 I1_I96_gn4 VDD) gpdk090_pmos1v w=0.24u l=0.1u ad=0.0816p as=0.0528p pd=1.16u ps=0.68u
    I_MXI1_I84_I29_XP_MP1 (I1_I84_P5_2n I1_I84_P3_2 VDD VDD) gpdk090_pmos1v w=0.24u l=0.1u ad=0.0528p as=0.0816p pd=0.68u ps=1.16u
    I_MXI1_I84_I29_XP_MP0 (VDD I1_I84_P5_4 I1_I84_P5_2n VDD) gpdk090_pmos1v w=0.24u l=0.1u ad=0.0816p as=0.0528p pd=1.16u ps=0.68u
    I_MXI1_I84_I30_XP_MP1 (I1_I84_P6_3n I1_I84_P4_3 VDD VDD) gpdk090_pmos1v w=0.24u l=0.1u ad=0.0528p as=0.0816p pd=0.68u ps=1.16u
    I_MXI1_I84_I30_XP_MP0 (VDD I1_I84_P6_5 I1_I84_P6_3n VDD) gpdk090_pmos1v w=0.24u l=0.1u ad=0.0816p as=0.0528p pd=1.16u ps=0.68u
    I_MXI1_I84_I5_MP1 (I1_I84_gn5 I1_b3_5 VDD VDD) gpdk090_pmos1v w=0.24u l=0.1u ad=0.0528p as=0.0816p pd=0.68u ps=1.16u
    I_MXI1_I84_I5_MP0 (VDD I1_p2_4 I1_I84_gn5 VDD) gpdk090_pmos1v w=0.24u l=0.1u ad=0.0816p as=0.0528p pd=1.16u ps=0.68u
    I_MXI1_I72_I6_MP1 (I1_I72_gn6 I1_b2_6 VDD VDD) gpdk090_pmos1v w=0.24u l=0.1u ad=0.0528p as=0.0816p pd=0.68u ps=1.16u
    I_MXI1_I72_I6_MP0 (VDD I1_p1_5 I1_I72_gn6 VDD) gpdk090_pmos1v w=0.24u l=0.1u ad=0.0816p as=0.0528p pd=1.16u ps=0.68u
    I_MXI1_I72_I5_MP1 (I1_I72_gn5 I1_b2_5 VDD VDD) gpdk090_pmos1v w=0.24u l=0.1u ad=0.0528p as=0.0816p pd=0.68u ps=1.16u
    I_MXI1_I72_I5_MP0 (VDD I1_p1_4 I1_I72_gn5 VDD) gpdk090_pmos1v w=0.24u l=0.1u ad=0.0816p as=0.0528p pd=1.16u ps=0.68u
    I_MXI1_I60_I5_MP1 (I1_I60_gn5 I1_b1_5 VDD VDD) gpdk090_pmos1v w=0.24u l=0.1u ad=0.0528p as=0.0816p pd=0.68u ps=1.16u
    I_MXI1_I60_I5_MP0 (VDD I1_p0_4 I1_I60_gn5 VDD) gpdk090_pmos1v w=0.24u l=0.1u ad=0.0816p as=0.0528p pd=1.16u ps=0.68u
    I_MXI1_I48_I5_MP1 (I1_I48_gn5 I1_b0_5 VDD VDD) gpdk090_pmos1v w=0.24u l=0.1u ad=0.0528p as=0.0816p pd=0.68u ps=1.16u
    I_MXI1_I48_I5_MP0 (VDD VSS I1_I48_gn5 VDD) gpdk090_pmos1v w=0.24u l=0.1u ad=0.0816p as=0.0528p pd=1.16u ps=0.68u
    I_MXI1_I108_I7_MP1 (I1_I108_gn7 I1_b5_7 VDD VDD) gpdk090_pmos1v w=0.24u l=0.1u ad=0.0528p as=0.0816p pd=0.68u ps=1.16u
    I_MXI1_I108_I7_MP0 (VDD I1_p4_6 I1_I108_gn7 VDD) gpdk090_pmos1v w=0.24u l=0.1u ad=0.0816p as=0.0528p pd=1.16u ps=0.68u
    I_MXI1_I96_I31_XP_MP1 (I1_I96_P7_4n I1_I96_P5_4 VDD VDD) gpdk090_pmos1v w=0.24u l=0.1u ad=0.0528p as=0.0816p pd=0.68u ps=1.16u
    I_MXI1_I96_I31_XP_MP0 (VDD I1_I96_P7_6 I1_I96_P7_4n VDD) gpdk090_pmos1v w=0.24u l=0.1u ad=0.0816p as=0.0528p pd=1.16u ps=0.68u
    I_MXI1_I96_I6_MP1 (I1_I96_gn6 I1_b4_6 VDD VDD) gpdk090_pmos1v w=0.24u l=0.1u ad=0.0528p as=0.0816p pd=0.68u ps=1.16u
    I_MXI1_I96_I6_MP0 (VDD I1_p3_5 I1_I96_gn6 VDD) gpdk090_pmos1v w=0.24u l=0.1u ad=0.0816p as=0.0528p pd=1.16u ps=0.68u
    I_MXI1_I96_I5_MP1 (I1_I96_gn5 I1_b4_5 VDD VDD) gpdk090_pmos1v w=0.24u l=0.1u ad=0.0528p as=0.0816p pd=0.68u ps=1.16u
    I_MXI1_I96_I5_MP0 (VDD I1_p3_4 I1_I96_gn5 VDD) gpdk090_pmos1v w=0.24u l=0.1u ad=0.0816p as=0.0528p pd=1.16u ps=0.68u
    I_MXI1_I84_I31_XP_MP1 (I1_I84_P7_4n I1_I84_P5_4 VDD VDD) gpdk090_pmos1v w=0.24u l=0.1u ad=0.0528p as=0.0816p pd=0.68u ps=1.16u
    I_MXI1_I84_I31_XP_MP0 (VDD I1_I84_P7_6 I1_I84_P7_4n VDD) gpdk090_pmos1v w=0.24u l=0.1u ad=0.0816p as=0.0528p pd=1.16u ps=0.68u
    I_MXI1_I84_I7_MP1 (I1_I84_gn7 I1_b3_7 VDD VDD) gpdk090_pmos1v w=0.24u l=0.1u ad=0.0528p as=0.0816p pd=0.68u ps=1.16u
    I_MXI1_I84_I7_MP0 (VDD I1_p2_6 I1_I84_gn7 VDD) gpdk090_pmos1v w=0.24u l=0.1u ad=0.0816p as=0.0528p pd=1.16u ps=0.68u
    I_MXI1_I84_I6_MP1 (I1_I84_gn6 I1_b3_6 VDD VDD) gpdk090_pmos1v w=0.24u l=0.1u ad=0.0528p as=0.0816p pd=0.68u ps=1.16u
    I_MXI1_I84_I6_MP0 (VDD I1_p2_5 I1_I84_gn6 VDD) gpdk090_pmos1v w=0.24u l=0.1u ad=0.0816p as=0.0528p pd=1.16u ps=0.68u
    I_MXI1_I72_I29_XP_MP1 (I1_I72_P5_2n I1_I72_P3_2 VDD VDD) gpdk090_pmos1v w=0.24u l=0.1u ad=0.0528p as=0.0816p pd=0.68u ps=1.16u
    I_MXI1_I72_I29_XP_MP0 (VDD I1_I72_P5_4 I1_I72_P5_2n VDD) gpdk090_pmos1v w=0.24u l=0.1u ad=0.0816p as=0.0528p pd=1.16u ps=0.68u
    I_MXI1_I72_I31_XP_MP1 (I1_I72_P7_4n I1_I72_P5_4 VDD VDD) gpdk090_pmos1v w=0.24u l=0.1u ad=0.0528p as=0.0816p pd=0.68u ps=1.16u
    I_MXI1_I72_I31_XP_MP0 (VDD I1_I72_P7_6 I1_I72_P7_4n VDD) gpdk090_pmos1v w=0.24u l=0.1u ad=0.0816p as=0.0528p pd=1.16u ps=0.68u
    I_MXI1_I60_I29_XP_MP1 (I1_I60_P5_2n I1_I60_P3_2 VDD VDD) gpdk090_pmos1v w=0.24u l=0.1u ad=0.0528p as=0.0816p pd=0.68u ps=1.16u
    I_MXI1_I60_I29_XP_MP0 (VDD I1_I60_P5_4 I1_I60_P5_2n VDD) gpdk090_pmos1v w=0.24u l=0.1u ad=0.0816p as=0.0528p pd=1.16u ps=0.68u
    I_MXI1_I60_I31_XP_MP1 (I1_I60_P7_4n I1_I60_P5_4 VDD VDD) gpdk090_pmos1v w=0.24u l=0.1u ad=0.0528p as=0.0816p pd=0.68u ps=1.16u
    I_MXI1_I60_I31_XP_MP0 (VDD I1_I60_P7_6 I1_I60_P7_4n VDD) gpdk090_pmos1v w=0.24u l=0.1u ad=0.0816p as=0.0528p pd=1.16u ps=0.68u
    I_MXI1_I60_I6_MP1 (I1_I60_gn6 I1_b1_6 VDD VDD) gpdk090_pmos1v w=0.24u l=0.1u ad=0.0528p as=0.0816p pd=0.68u ps=1.16u
    I_MXI1_I60_I6_MP0 (VDD I1_p0_5 I1_I60_gn6 VDD) gpdk090_pmos1v w=0.24u l=0.1u ad=0.0816p as=0.0528p pd=1.16u ps=0.68u
    I_MXI1_I48_I6_MP1 (I1_I48_gn6 I1_b0_6 VDD VDD) gpdk090_pmos1v w=0.24u l=0.1u ad=0.0528p as=0.0816p pd=0.68u ps=1.16u
    I_MXI1_I48_I6_MP0 (VDD VSS I1_I48_gn6 VDD) gpdk090_pmos1v w=0.24u l=0.1u ad=0.0816p as=0.0528p pd=1.16u ps=0.68u
    I_MXI1_I48_I31_XP_MP1 (I1_I48_P7_4n I1_I48_P5_4 VDD VDD) gpdk090_pmos1v w=0.24u l=0.1u ad=0.0528p as=0.0816p pd=0.68u ps=1.16u
    I_MXI1_I48_I31_XP_MP0 (VDD I1_I48_P7_6 I1_I48_P7_4n VDD) gpdk090_pmos1v w=0.24u l=0.1u ad=0.0816p as=0.0528p pd=1.16u ps=0.68u
    I_MXI1_I96_I7_MP1 (I1_I96_gn7 I1_b4_7 VDD VDD) gpdk090_pmos1v w=0.24u l=0.1u ad=0.0528p as=0.0816p pd=0.68u ps=1.16u
    I_MXI1_I96_I7_MP0 (VDD I1_p3_6 I1_I96_gn7 VDD) gpdk090_pmos1v w=0.24u l=0.1u ad=0.0816p as=0.0528p pd=1.16u ps=0.68u
    I_MXI1_I72_I7_MP1 (I1_I72_gn7 I1_b2_7 VDD VDD) gpdk090_pmos1v w=0.24u l=0.1u ad=0.0528p as=0.0816p pd=0.68u ps=1.16u
    I_MXI1_I72_I7_MP0 (VDD I1_p1_6 I1_I72_gn7 VDD) gpdk090_pmos1v w=0.24u l=0.1u ad=0.0816p as=0.0528p pd=1.16u ps=0.68u
    I_MXI1_I60_I7_MP1 (I1_I60_gn7 I1_b1_7 VDD VDD) gpdk090_pmos1v w=0.24u l=0.1u ad=0.0528p as=0.0816p pd=0.68u ps=1.16u
    I_MXI1_I60_I7_MP0 (VDD I1_p0_6 I1_I60_gn7 VDD) gpdk090_pmos1v w=0.24u l=0.1u ad=0.0816p as=0.0528p pd=1.16u ps=0.68u
    I_MXI1_I48_I7_MP1 (I1_I48_gn7 I1_b0_7 VDD VDD) gpdk090_pmos1v w=0.24u l=0.1u ad=0.0528p as=0.0816p pd=0.68u ps=1.16u
    I_MXI1_I48_I7_MP0 (VDD VSS I1_I48_gn7 VDD) gpdk090_pmos1v w=0.24u l=0.1u ad=0.0816p as=0.0528p pd=1.16u ps=0.68u
    I_MXI2_I4_I7_MP0 (XI2_I4_I7_p1 Y_14 VDD VDD) gpdk090_pmos1v w=0.48u l=0.1u ad=0.1056p as=0.1632p pd=0.92u ps=1.64u
    I_MXI2_I4_I7_MP1 (I2_I4_za7 Y_15 XI2_I4_I7_p1 VDD) gpdk090_pmos1v w=0.48u l=0.1u ad=0.1632p as=0.1056p pd=1.64u ps=0.92u
    I_MXI0_I77_I25_XP_MP0 (XI0_I77_I25_XP_p1 I0_I77_pn7 VDD VDD) gpdk090_pmos1v w=0.48u l=0.1u ad=0.1056p as=0.1632p pd=0.92u ps=1.64u
    I_MXI0_I77_I25_XP_MP1 (I0_I77_P7_6 I0_I77_pn6 XI0_I77_I25_XP_p1 VDD) gpdk090_pmos1v w=0.48u l=0.1u ad=0.1632p as=0.1056p pd=1.64u ps=0.92u
    I_MXI2_I4_I6_MP0 (XI2_I4_I6_p1 Y_12 VDD VDD) gpdk090_pmos1v w=0.48u l=0.1u ad=0.1056p as=0.1632p pd=0.92u ps=1.64u
    I_MXI2_I4_I6_MP1 (I2_I4_za6 Y_13 XI2_I4_I6_p1 VDD) gpdk090_pmos1v w=0.48u l=0.1u ad=0.1632p as=0.1056p pd=1.64u ps=0.92u
    I_MXI2_I4_I5_MP0 (XI2_I4_I5_p1 Y_10 VDD VDD) gpdk090_pmos1v w=0.48u l=0.1u ad=0.1056p as=0.1632p pd=0.92u ps=1.64u
    I_MXI2_I4_I5_MP1 (I2_I4_za5 Y_11 XI2_I4_I5_p1 VDD) gpdk090_pmos1v w=0.48u l=0.1u ad=0.1632p as=0.1056p pd=1.64u ps=0.92u
    I_MXI2_I4_I13_MP0 (XI2_I4_I13_p1 I2_I4_zb2 VDD VDD) gpdk090_pmos1v w=0.48u l=0.1u ad=0.1056p as=0.1632p pd=0.92u ps=1.64u
    I_MXI2_I4_I13_MP1 (I2_I4_zc1 I2_I4_zb3 XI2_I4_I13_p1 VDD) gpdk090_pmos1v w=0.48u l=0.1u ad=0.1632p as=0.1056p pd=1.64u ps=0.92u
    I_MXI0_I77_I24_XP_MP0 (XI0_I77_I24_XP_p1 I0_I77_pn6 VDD VDD) gpdk090_pmos1v w=0.48u l=0.1u ad=0.1056p as=0.1632p pd=0.92u ps=1.64u
    I_MXI0_I77_I24_XP_MP1 (I0_I77_P6_5 I0_I77_pn5 XI0_I77_I24_XP_p1 VDD) gpdk090_pmos1v w=0.48u l=0.1u ad=0.1632p as=0.1056p pd=1.64u ps=0.92u
    I_MXI0_I77_I23_XP_MP0 (XI0_I77_I23_XP_p1 I0_I77_pn5 VDD VDD) gpdk090_pmos1v w=0.48u l=0.1u ad=0.1056p as=0.1632p pd=0.92u ps=1.64u
    I_MXI0_I77_I23_XP_MP1 (I0_I77_P5_4 I0_I77_pn4 XI0_I77_I23_XP_p1 VDD) gpdk090_pmos1v w=0.48u l=0.1u ad=0.1632p as=0.1056p pd=1.64u ps=0.92u
    I_MXI2_I0_I17_MP0 (XI2_I0_I17_p1 I2_I0_h10 VDD VDD) gpdk090_pmos1v w=0.48u l=0.1u ad=0.1056p as=0.1632p pd=0.92u ps=1.64u
    I_MXI2_I0_I17_MP1 (I2_SEL_DIV I2_I0_l11 XI2_I0_I17_p1 VDD) gpdk090_pmos1v w=0.48u l=0.1u ad=0.1632p as=0.1056p pd=1.64u ps=0.92u
    I_MXI2_I0_I16_MP0 (XI2_I0_I16_p1 I2_I0_h10 VDD VDD) gpdk090_pmos1v w=0.48u l=0.1u ad=0.1056p as=0.1632p pd=0.92u ps=1.64u
    I_MXI2_I0_I16_MP1 (I2_SEL_MUL I2_I0_l01 XI2_I0_I16_p1 VDD) gpdk090_pmos1v w=0.48u l=0.1u ad=0.1632p as=0.1056p pd=1.64u ps=0.92u
    I_MXI2_I0_I15_MP0 (XI2_I0_I15_p1 I2_I0_h01 VDD VDD) gpdk090_pmos1v w=0.48u l=0.1u ad=0.1056p as=0.1632p pd=0.92u ps=1.64u
    I_MXI2_I0_I15_MP1 (I2_SEL_NOT I2_I0_l01 XI2_I0_I15_p1 VDD) gpdk090_pmos1v w=0.48u l=0.1u ad=0.1632p as=0.1056p pd=1.64u ps=0.92u
    I_MXI2_I0_I14_MP0 (XI2_I0_I14_p1 I2_I0_h01 VDD VDD) gpdk090_pmos1v w=0.48u l=0.1u ad=0.1056p as=0.1632p pd=0.92u ps=1.64u
    I_MXI2_I0_I14_MP1 (I2_SEL_XOR I2_I0_l00 XI2_I0_I14_p1 VDD) gpdk090_pmos1v w=0.48u l=0.1u ad=0.1632p as=0.1056p pd=1.64u ps=0.92u
    I_MXI0_I77_I22_XP_MP0 (XI0_I77_I22_XP_p1 I0_I77_pn4 VDD VDD) gpdk090_pmos1v w=0.48u l=0.1u ad=0.1056p as=0.1632p pd=0.92u ps=1.64u
    I_MXI0_I77_I22_XP_MP1 (I0_I77_P4_3 I0_I77_pn3 XI0_I77_I22_XP_p1 VDD) gpdk090_pmos1v w=0.48u l=0.1u ad=0.1632p as=0.1056p pd=1.64u ps=0.92u
    I_MXI0_I77_I21_XP_MP0 (XI0_I77_I21_XP_p1 I0_I77_pn3 VDD VDD) gpdk090_pmos1v w=0.48u l=0.1u ad=0.1056p as=0.1632p pd=0.92u ps=1.64u
    I_MXI0_I77_I21_XP_MP1 (I0_I77_P3_2 I0_I77_pn2 XI0_I77_I21_XP_p1 VDD) gpdk090_pmos1v w=0.48u l=0.1u ad=0.1632p as=0.1056p pd=1.64u ps=0.92u
    I_MXI2_I2_I44_MP0 (XI2_I2_I44_p1 A_7 VDD VDD) gpdk090_pmos1v w=0.48u l=0.1u ad=0.1056p as=0.1632p pd=0.92u ps=1.64u
    I_MXI2_I2_I44_MP1 (I2_I2_nor7 B_7 XI2_I2_I44_p1 VDD) gpdk090_pmos1v w=0.48u l=0.1u ad=0.1632p as=0.1056p pd=1.64u ps=0.92u
    I_MXI2_I3_I93_MP0 (XI2_I3_I93_p1 I2_I3_o7_0 VDD VDD) gpdk090_pmos1v w=0.48u l=0.1u ad=0.1056p as=0.1632p pd=0.92u ps=1.64u
    I_MXI2_I3_I93_MP1 (I2_I3_q7_1 I2_I3_o7_1 XI2_I3_I93_p1 VDD) gpdk090_pmos1v w=0.48u l=0.1u ad=0.1632p as=0.1056p pd=1.64u ps=0.92u
    I_MXI2_I0_I13_MP0 (XI2_I0_I13_p1 I2_I0_h00 VDD VDD) gpdk090_pmos1v w=0.48u l=0.1u ad=0.1056p as=0.1632p pd=0.92u ps=1.64u
    I_MXI2_I0_I13_MP1 (I2_SEL_OR I2_I0_l11 XI2_I0_I13_p1 VDD) gpdk090_pmos1v w=0.48u l=0.1u ad=0.1632p as=0.1056p pd=1.64u ps=0.92u
    I_MXI2_I0_I11_MP0 (XI2_I0_I11_p1 I2_I0_h00 VDD VDD) gpdk090_pmos1v w=0.48u l=0.1u ad=0.1056p as=0.1632p pd=0.92u ps=1.64u
    I_MXI2_I0_I11_MP1 (I2_SEL_AS OP_1 XI2_I0_I11_p1 VDD) gpdk090_pmos1v w=0.48u l=0.1u ad=0.1632p as=0.1056p pd=1.64u ps=0.92u
    I_MXI2_I0_I12_MP0 (XI2_I0_I12_p1 I2_I0_h00 VDD VDD) gpdk090_pmos1v w=0.48u l=0.1u ad=0.1056p as=0.1632p pd=0.92u ps=1.64u
    I_MXI2_I0_I12_MP1 (I2_SEL_AND I2_I0_l10 XI2_I0_I12_p1 VDD) gpdk090_pmos1v w=0.48u l=0.1u ad=0.1632p as=0.1056p pd=1.64u ps=0.92u
    I_MXI1_I152_I25_XP_MP0 (XI1_I152_I25_XP_p1 I1_I152_pn7 VDD VDD) gpdk090_pmos1v w=0.48u l=0.1u ad=0.1056p as=0.1632p pd=0.92u ps=1.64u
    I_MXI1_I152_I25_XP_MP1 (I1_I152_P7_6 I1_I152_pn6 XI1_I152_I25_XP_p1 VDD) gpdk090_pmos1v w=0.48u l=0.1u ad=0.1632p as=0.1056p pd=1.64u ps=0.92u
    I_MXI1_I152_I23_XP_MP0 (XI1_I152_I23_XP_p1 I1_I152_pn5 VDD VDD) gpdk090_pmos1v w=0.48u l=0.1u ad=0.1056p as=0.1632p pd=0.92u ps=1.64u
    I_MXI1_I152_I23_XP_MP1 (I1_I152_P5_4 I1_I152_pn4 XI1_I152_I23_XP_p1 VDD) gpdk090_pmos1v w=0.48u l=0.1u ad=0.1632p as=0.1056p pd=1.64u ps=0.92u
    I_MXI1_I152_I21_XP_MP0 (XI1_I152_I21_XP_p1 I1_I152_pn3 VDD VDD) gpdk090_pmos1v w=0.48u l=0.1u ad=0.1056p as=0.1632p pd=0.92u ps=1.64u
    I_MXI1_I152_I21_XP_MP1 (I1_I152_P3_2 I1_I152_pn2 XI1_I152_I21_XP_p1 VDD) gpdk090_pmos1v w=0.48u l=0.1u ad=0.1632p as=0.1056p pd=1.64u ps=0.92u
    I_MXI2_I4_I4_MP0 (XI2_I4_I4_p1 Y_8 VDD VDD) gpdk090_pmos1v w=0.48u l=0.1u ad=0.1056p as=0.1632p pd=0.92u ps=1.64u
    I_MXI2_I4_I4_MP1 (I2_I4_za4 Y_9 XI2_I4_I4_p1 VDD) gpdk090_pmos1v w=0.48u l=0.1u ad=0.1632p as=0.1056p pd=1.64u ps=0.92u
    I_MXI0_I77_I20_XP_MP0 (XI0_I77_I20_XP_p1 I0_I77_pn2 VDD VDD) gpdk090_pmos1v w=0.48u l=0.1u ad=0.1056p as=0.1632p pd=0.92u ps=1.64u
    I_MXI0_I77_I20_XP_MP1 (I0_I77_P2_1 I0_I77_pn1 XI0_I77_I20_XP_p1 VDD) gpdk090_pmos1v w=0.48u l=0.1u ad=0.1632p as=0.1056p pd=1.64u ps=0.92u
    I_MXI2_I3_I81_MP0 (XI2_I3_I81_p1 I2_I3_o6_0 VDD VDD) gpdk090_pmos1v w=0.48u l=0.1u ad=0.1056p as=0.1632p pd=0.92u ps=1.64u
    I_MXI2_I3_I81_MP1 (I2_I3_q6_1 I2_I3_o6_1 XI2_I3_I81_p1 VDD) gpdk090_pmos1v w=0.48u l=0.1u ad=0.1632p as=0.1056p pd=1.64u ps=0.92u
    I_MXI2_I3_I69_MP0 (XI2_I3_I69_p1 I2_I3_o5_0 VDD VDD) gpdk090_pmos1v w=0.48u l=0.1u ad=0.1056p as=0.1632p pd=0.92u ps=1.64u
    I_MXI2_I3_I69_MP1 (I2_I3_q5_1 I2_I3_o5_1 XI2_I3_I69_p1 VDD) gpdk090_pmos1v w=0.48u l=0.1u ad=0.1632p as=0.1056p pd=1.64u ps=0.92u
    I_MXI2_I3_I45_MP0 (XI2_I3_I45_p1 I2_I3_o3_0 VDD VDD) gpdk090_pmos1v w=0.48u l=0.1u ad=0.1056p as=0.1632p pd=0.92u ps=1.64u
    I_MXI2_I3_I45_MP1 (I2_I3_q3_1 I2_I3_o3_1 XI2_I3_I45_p1 VDD) gpdk090_pmos1v w=0.48u l=0.1u ad=0.1632p as=0.1056p pd=1.64u ps=0.92u
    I_MXI2_I2_I32_MP0 (XI2_I2_I32_p1 A_5 VDD VDD) gpdk090_pmos1v w=0.48u l=0.1u ad=0.1056p as=0.1632p pd=0.92u ps=1.64u
    I_MXI2_I2_I32_MP1 (I2_I2_nor5 B_5 XI2_I2_I32_p1 VDD) gpdk090_pmos1v w=0.48u l=0.1u ad=0.1632p as=0.1056p pd=1.64u ps=0.92u
    I_MXI1_I152_I24_XP_MP0 (XI1_I152_I24_XP_p1 I1_I152_pn6 VDD VDD) gpdk090_pmos1v w=0.48u l=0.1u ad=0.1056p as=0.1632p pd=0.92u ps=1.64u
    I_MXI1_I152_I24_XP_MP1 (I1_I152_P6_5 I1_I152_pn5 XI1_I152_I24_XP_p1 VDD) gpdk090_pmos1v w=0.48u l=0.1u ad=0.1632p as=0.1056p pd=1.64u ps=0.92u
    I_MXI1_I152_I22_XP_MP0 (XI1_I152_I22_XP_p1 I1_I152_pn4 VDD VDD) gpdk090_pmos1v w=0.48u l=0.1u ad=0.1056p as=0.1632p pd=0.92u ps=1.64u
    I_MXI1_I152_I22_XP_MP1 (I1_I152_P4_3 I1_I152_pn3 XI1_I152_I22_XP_p1 VDD) gpdk090_pmos1v w=0.48u l=0.1u ad=0.1632p as=0.1056p pd=1.64u ps=0.92u
    I_MXI1_I152_I20_XP_MP0 (XI1_I152_I20_XP_p1 I1_I152_pn2 VDD VDD) gpdk090_pmos1v w=0.48u l=0.1u ad=0.1056p as=0.1632p pd=0.92u ps=1.64u
    I_MXI1_I152_I20_XP_MP1 (I1_I152_P2_1 I1_I152_pn1 XI1_I152_I20_XP_p1 VDD) gpdk090_pmos1v w=0.48u l=0.1u ad=0.1632p as=0.1056p pd=1.64u ps=0.92u
    I_MXI2_I2_I38_MP0 (XI2_I2_I38_p1 A_6 VDD VDD) gpdk090_pmos1v w=0.48u l=0.1u ad=0.1056p as=0.1632p pd=0.92u ps=1.64u
    I_MXI2_I2_I38_MP1 (I2_I2_nor6 B_6 XI2_I2_I38_p1 VDD) gpdk090_pmos1v w=0.48u l=0.1u ad=0.1632p as=0.1056p pd=1.64u ps=0.92u
    I_MXI2_I2_I20_MP0 (XI2_I2_I20_p1 A_3 VDD VDD) gpdk090_pmos1v w=0.48u l=0.1u ad=0.1056p as=0.1632p pd=0.92u ps=1.64u
    I_MXI2_I2_I20_MP1 (I2_I2_nor3 B_3 XI2_I2_I20_p1 VDD) gpdk090_pmos1v w=0.48u l=0.1u ad=0.1632p as=0.1056p pd=1.64u ps=0.92u
    I_MXI2_I1_I8_I25_XP_MP0 (XI2_I1_I8_I25_XP_p1 I2_I1_I8_pn7 VDD VDD) gpdk090_pmos1v w=0.48u l=0.1u ad=0.1056p as=0.1632p pd=0.92u ps=1.64u
    I_MXI2_I1_I8_I25_XP_MP1 (I2_I1_I8_P7_6 I2_I1_I8_pn6 XI2_I1_I8_I25_XP_p1 VDD) gpdk090_pmos1v w=0.48u l=0.1u ad=0.1632p as=0.1056p pd=1.64u ps=0.92u
    I_MXI2_I1_I8_I24_XP_MP0 (XI2_I1_I8_I24_XP_p1 I2_I1_I8_pn6 VDD VDD) gpdk090_pmos1v w=0.48u l=0.1u ad=0.1056p as=0.1632p pd=0.92u ps=1.64u
    I_MXI2_I1_I8_I24_XP_MP1 (I2_I1_I8_P6_5 I2_I1_I8_pn5 XI2_I1_I8_I24_XP_p1 VDD) gpdk090_pmos1v w=0.48u l=0.1u ad=0.1632p as=0.1056p pd=1.64u ps=0.92u
    I_MXI1_I132_I25_XP_MP0 (XI1_I132_I25_XP_p1 I1_I132_pn7 VDD VDD) gpdk090_pmos1v w=0.48u l=0.1u ad=0.1056p as=0.1632p pd=0.92u ps=1.64u
    I_MXI1_I132_I25_XP_MP1 (I1_I132_P7_6 I1_I132_pn6 XI1_I132_I25_XP_p1 VDD) gpdk090_pmos1v w=0.48u l=0.1u ad=0.1632p as=0.1056p pd=1.64u ps=0.92u
    I_MXI1_I132_I23_XP_MP0 (XI1_I132_I23_XP_p1 I1_I132_pn5 VDD VDD) gpdk090_pmos1v w=0.48u l=0.1u ad=0.1056p as=0.1632p pd=0.92u ps=1.64u
    I_MXI1_I132_I23_XP_MP1 (I1_I132_P5_4 I1_I132_pn4 XI1_I132_I23_XP_p1 VDD) gpdk090_pmos1v w=0.48u l=0.1u ad=0.1632p as=0.1056p pd=1.64u ps=0.92u
    I_MXI1_I132_I21_XP_MP0 (XI1_I132_I21_XP_p1 I1_I132_pn3 VDD VDD) gpdk090_pmos1v w=0.48u l=0.1u ad=0.1056p as=0.1632p pd=0.92u ps=1.64u
    I_MXI1_I132_I21_XP_MP1 (I1_I132_P3_2 I1_I132_pn2 XI1_I132_I21_XP_p1 VDD) gpdk090_pmos1v w=0.48u l=0.1u ad=0.1632p as=0.1056p pd=1.64u ps=0.92u
    I_MXI2_I4_I3_MP0 (XI2_I4_I3_p1 Y_6 VDD VDD) gpdk090_pmos1v w=0.48u l=0.1u ad=0.1056p as=0.1632p pd=0.92u ps=1.64u
    I_MXI2_I4_I3_MP1 (I2_I4_za3 Y_7 XI2_I4_I3_p1 VDD) gpdk090_pmos1v w=0.48u l=0.1u ad=0.1632p as=0.1056p pd=1.64u ps=0.92u
    I_MXI2_I1_I8_I23_XP_MP0 (XI2_I1_I8_I23_XP_p1 I2_I1_I8_pn5 VDD VDD) gpdk090_pmos1v w=0.48u l=0.1u ad=0.1056p as=0.1632p pd=0.92u ps=1.64u
    I_MXI2_I1_I8_I23_XP_MP1 (I2_I1_I8_P5_4 I2_I1_I8_pn4 XI2_I1_I8_I23_XP_p1 VDD) gpdk090_pmos1v w=0.48u l=0.1u ad=0.1632p as=0.1056p pd=1.64u ps=0.92u
    I_MXI1_I132_I24_XP_MP0 (XI1_I132_I24_XP_p1 I1_I132_pn6 VDD VDD) gpdk090_pmos1v w=0.48u l=0.1u ad=0.1056p as=0.1632p pd=0.92u ps=1.64u
    I_MXI1_I132_I24_XP_MP1 (I1_I132_P6_5 I1_I132_pn5 XI1_I132_I24_XP_p1 VDD) gpdk090_pmos1v w=0.48u l=0.1u ad=0.1632p as=0.1056p pd=1.64u ps=0.92u
    I_MXI1_I132_I22_XP_MP0 (XI1_I132_I22_XP_p1 I1_I132_pn4 VDD VDD) gpdk090_pmos1v w=0.48u l=0.1u ad=0.1056p as=0.1632p pd=0.92u ps=1.64u
    I_MXI1_I132_I22_XP_MP1 (I1_I132_P4_3 I1_I132_pn3 XI1_I132_I22_XP_p1 VDD) gpdk090_pmos1v w=0.48u l=0.1u ad=0.1632p as=0.1056p pd=1.64u ps=0.92u
    I_MXI1_I132_I20_XP_MP0 (XI1_I132_I20_XP_p1 I1_I132_pn2 VDD VDD) gpdk090_pmos1v w=0.48u l=0.1u ad=0.1056p as=0.1632p pd=0.92u ps=1.64u
    I_MXI1_I132_I20_XP_MP1 (I1_I132_P2_1 I1_I132_pn1 XI1_I132_I20_XP_p1 VDD) gpdk090_pmos1v w=0.48u l=0.1u ad=0.1632p as=0.1056p pd=1.64u ps=0.92u
    I_MXI2_I4_I2_MP0 (XI2_I4_I2_p1 Y_4 VDD VDD) gpdk090_pmos1v w=0.48u l=0.1u ad=0.1056p as=0.1632p pd=0.92u ps=1.64u
    I_MXI2_I4_I2_MP1 (I2_I4_za2 Y_5 XI2_I4_I2_p1 VDD) gpdk090_pmos1v w=0.48u l=0.1u ad=0.1632p as=0.1056p pd=1.64u ps=0.92u
    I_MXI2_I1_I8_I21_XP_MP0 (XI2_I1_I8_I21_XP_p1 I2_I1_I8_pn3 VDD VDD) gpdk090_pmos1v w=0.48u l=0.1u ad=0.1056p as=0.1632p pd=0.92u ps=1.64u
    I_MXI2_I1_I8_I21_XP_MP1 (I2_I1_I8_P3_2 I2_I1_I8_pn2 XI2_I1_I8_I21_XP_p1 VDD) gpdk090_pmos1v w=0.48u l=0.1u ad=0.1632p as=0.1056p pd=1.64u ps=0.92u
    I_MXI2_I1_I8_I22_XP_MP0 (XI2_I1_I8_I22_XP_p1 I2_I1_I8_pn4 VDD VDD) gpdk090_pmos1v w=0.48u l=0.1u ad=0.1056p as=0.1632p pd=0.92u ps=1.64u
    I_MXI2_I1_I8_I22_XP_MP1 (I2_I1_I8_P4_3 I2_I1_I8_pn3 XI2_I1_I8_I22_XP_p1 VDD) gpdk090_pmos1v w=0.48u l=0.1u ad=0.1632p as=0.1056p pd=1.64u ps=0.92u
    I_MXI1_I197_MP0 (XI1_I197_p1 B_6 VDD VDD) gpdk090_pmos1v w=0.48u l=0.1u ad=0.1056p as=0.1632p pd=0.92u ps=1.64u
    I_MXI1_I197_MP1 (I1_z1_3 B_7 XI1_I197_p1 VDD) gpdk090_pmos1v w=0.48u l=0.1u ad=0.1632p as=0.1056p pd=1.64u ps=0.92u
    I_MXI2_I4_I12_MP0 (XI2_I4_I12_p1 I2_I4_zb0 VDD VDD) gpdk090_pmos1v w=0.48u l=0.1u ad=0.1056p as=0.1632p pd=0.92u ps=1.64u
    I_MXI2_I4_I12_MP1 (I2_I4_zc0 I2_I4_zb1 XI2_I4_I12_p1 VDD) gpdk090_pmos1v w=0.48u l=0.1u ad=0.1632p as=0.1056p pd=1.64u ps=0.92u
    I_MXI1_I196_MP0 (XI1_I196_p1 B_4 VDD VDD) gpdk090_pmos1v w=0.48u l=0.1u ad=0.1056p as=0.1632p pd=0.92u ps=1.64u
    I_MXI1_I196_MP1 (I1_z1_2 B_5 XI1_I196_p1 VDD) gpdk090_pmos1v w=0.48u l=0.1u ad=0.1632p as=0.1056p pd=1.64u ps=0.92u
    I_MXI1_I203_MP0 (XI1_I203_p1 I1_vn VDD VDD) gpdk090_pmos1v w=0.48u l=0.1u ad=0.1056p as=0.1632p pd=0.92u ps=1.64u
    I_MXI1_I203_MP1 (DIVV DIVDZ XI1_I203_p1 VDD) gpdk090_pmos1v w=0.48u l=0.1u ad=0.1632p as=0.1056p pd=1.64u ps=0.92u
    I_MXI2_I1_I8_I20_XP_MP0 (XI2_I1_I8_I20_XP_p1 I2_I1_I8_pn2 VDD VDD) gpdk090_pmos1v w=0.48u l=0.1u ad=0.1056p as=0.1632p pd=0.92u ps=1.64u
    I_MXI2_I1_I8_I20_XP_MP1 (I2_I1_I8_P2_1 I2_I1_I8_pn1 XI2_I1_I8_I20_XP_p1 VDD) gpdk090_pmos1v w=0.48u l=0.1u ad=0.1632p as=0.1056p pd=1.64u ps=0.92u
    I_MXI1_I120_I24_XP_MP0 (XI1_I120_I24_XP_p1 I1_I120_pn6 VDD VDD) gpdk090_pmos1v w=0.48u l=0.1u ad=0.1056p as=0.1632p pd=0.92u ps=1.64u
    I_MXI1_I120_I24_XP_MP1 (I1_I120_P6_5 I1_I120_pn5 XI1_I120_I24_XP_p1 VDD) gpdk090_pmos1v w=0.48u l=0.1u ad=0.1632p as=0.1056p pd=1.64u ps=0.92u
    I_MXI1_I120_I20_XP_MP0 (XI1_I120_I20_XP_p1 I1_I120_pn2 VDD VDD) gpdk090_pmos1v w=0.48u l=0.1u ad=0.1056p as=0.1632p pd=0.92u ps=1.64u
    I_MXI1_I120_I20_XP_MP1 (I1_I120_P2_1 I1_I120_pn1 XI1_I120_I20_XP_p1 VDD) gpdk090_pmos1v w=0.48u l=0.1u ad=0.1632p as=0.1056p pd=1.64u ps=0.92u
    I_MXI1_I194_MP0 (XI1_I194_p1 B_0 VDD VDD) gpdk090_pmos1v w=0.48u l=0.1u ad=0.1056p as=0.1632p pd=0.92u ps=1.64u
    I_MXI1_I194_MP1 (I1_z1_0 B_1 XI1_I194_p1 VDD) gpdk090_pmos1v w=0.48u l=0.1u ad=0.1632p as=0.1056p pd=1.64u ps=0.92u
    I_MXI1_I200_MP0 (XI1_I200_p1 I1_z2_0 VDD VDD) gpdk090_pmos1v w=0.48u l=0.1u ad=0.1056p as=0.1632p pd=0.92u ps=1.64u
    I_MXI1_I200_MP1 (DIVDZ I1_z2_1 XI1_I200_p1 VDD) gpdk090_pmos1v w=0.48u l=0.1u ad=0.1632p as=0.1056p pd=1.64u ps=0.92u
    I_MXI1_I195_MP0 (XI1_I195_p1 B_2 VDD VDD) gpdk090_pmos1v w=0.48u l=0.1u ad=0.1056p as=0.1632p pd=0.92u ps=1.64u
    I_MXI1_I195_MP1 (I1_z1_1 B_3 XI1_I195_p1 VDD) gpdk090_pmos1v w=0.48u l=0.1u ad=0.1632p as=0.1056p pd=1.64u ps=0.92u
    I_MXI2_I4_I1_MP0 (XI2_I4_I1_p1 Y_2 VDD VDD) gpdk090_pmos1v w=0.48u l=0.1u ad=0.1056p as=0.1632p pd=0.92u ps=1.64u
    I_MXI2_I4_I1_MP1 (I2_I4_za1 Y_3 XI2_I4_I1_p1 VDD) gpdk090_pmos1v w=0.48u l=0.1u ad=0.1632p as=0.1056p pd=1.64u ps=0.92u
    I_MXI1_I120_I25_XP_MP0 (XI1_I120_I25_XP_p1 I1_I120_pn7 VDD VDD) gpdk090_pmos1v w=0.48u l=0.1u ad=0.1056p as=0.1632p pd=0.92u ps=1.64u
    I_MXI1_I120_I25_XP_MP1 (I1_I120_P7_6 I1_I120_pn6 XI1_I120_I25_XP_p1 VDD) gpdk090_pmos1v w=0.48u l=0.1u ad=0.1632p as=0.1056p pd=1.64u ps=0.92u
    I_MXI1_I120_I23_XP_MP0 (XI1_I120_I23_XP_p1 I1_I120_pn5 VDD VDD) gpdk090_pmos1v w=0.48u l=0.1u ad=0.1056p as=0.1632p pd=0.92u ps=1.64u
    I_MXI1_I120_I23_XP_MP1 (I1_I120_P5_4 I1_I120_pn4 XI1_I120_I23_XP_p1 VDD) gpdk090_pmos1v w=0.48u l=0.1u ad=0.1632p as=0.1056p pd=1.64u ps=0.92u
    I_MXI1_I120_I22_XP_MP0 (XI1_I120_I22_XP_p1 I1_I120_pn4 VDD VDD) gpdk090_pmos1v w=0.48u l=0.1u ad=0.1056p as=0.1632p pd=0.92u ps=1.64u
    I_MXI1_I120_I22_XP_MP1 (I1_I120_P4_3 I1_I120_pn3 XI1_I120_I22_XP_p1 VDD) gpdk090_pmos1v w=0.48u l=0.1u ad=0.1632p as=0.1056p pd=1.64u ps=0.92u
    I_MXI1_I120_I21_XP_MP0 (XI1_I120_I21_XP_p1 I1_I120_pn3 VDD VDD) gpdk090_pmos1v w=0.48u l=0.1u ad=0.1056p as=0.1632p pd=0.92u ps=1.64u
    I_MXI1_I120_I21_XP_MP1 (I1_I120_P3_2 I1_I120_pn2 XI1_I120_I21_XP_p1 VDD) gpdk090_pmos1v w=0.48u l=0.1u ad=0.1632p as=0.1056p pd=1.64u ps=0.92u
    I_MXI2_I3_I9_MP0 (XI2_I3_I9_p1 I2_I3_o0_0 VDD VDD) gpdk090_pmos1v w=0.48u l=0.1u ad=0.1056p as=0.1632p pd=0.92u ps=1.64u
    I_MXI2_I3_I9_MP1 (I2_I3_q0_1 I2_I3_o0_1 XI2_I3_I9_p1 VDD) gpdk090_pmos1v w=0.48u l=0.1u ad=0.1632p as=0.1056p pd=1.64u ps=0.92u
    I_MXI2_I4_I0_MP0 (XI2_I4_I0_p1 Y_0 VDD VDD) gpdk090_pmos1v w=0.48u l=0.1u ad=0.1056p as=0.1632p pd=0.92u ps=1.64u
    I_MXI2_I4_I0_MP1 (I2_I4_za0 Y_1 XI2_I4_I0_p1 VDD) gpdk090_pmos1v w=0.48u l=0.1u ad=0.1632p as=0.1056p pd=1.64u ps=0.92u
    I_MXI2_I3_I21_MP0 (XI2_I3_I21_p1 I2_I3_o1_0 VDD VDD) gpdk090_pmos1v w=0.48u l=0.1u ad=0.1056p as=0.1632p pd=0.92u ps=1.64u
    I_MXI2_I3_I21_MP1 (I2_I3_q1_1 I2_I3_o1_1 XI2_I3_I21_p1 VDD) gpdk090_pmos1v w=0.48u l=0.1u ad=0.1632p as=0.1056p pd=1.64u ps=0.92u
    I_MXI2_I3_I57_MP0 (XI2_I3_I57_p1 I2_I3_o4_0 VDD VDD) gpdk090_pmos1v w=0.48u l=0.1u ad=0.1056p as=0.1632p pd=0.92u ps=1.64u
    I_MXI2_I3_I57_MP1 (I2_I3_q4_1 I2_I3_o4_1 XI2_I3_I57_p1 VDD) gpdk090_pmos1v w=0.48u l=0.1u ad=0.1632p as=0.1056p pd=1.64u ps=0.92u
    I_MXI2_I2_I2_MP0 (XI2_I2_I2_p1 A_0 VDD VDD) gpdk090_pmos1v w=0.48u l=0.1u ad=0.1056p as=0.1632p pd=0.92u ps=1.64u
    I_MXI2_I2_I2_MP1 (I2_I2_nor0 B_0 XI2_I2_I2_p1 VDD) gpdk090_pmos1v w=0.48u l=0.1u ad=0.1632p as=0.1056p pd=1.64u ps=0.92u
    I_MXI2_I2_I8_MP0 (XI2_I2_I8_p1 A_1 VDD VDD) gpdk090_pmos1v w=0.48u l=0.1u ad=0.1056p as=0.1632p pd=0.92u ps=1.64u
    I_MXI2_I2_I8_MP1 (I2_I2_nor1 B_1 XI2_I2_I8_p1 VDD) gpdk090_pmos1v w=0.48u l=0.1u ad=0.1632p as=0.1056p pd=1.64u ps=0.92u
    I_MXI2_I3_I33_MP0 (XI2_I3_I33_p1 I2_I3_o2_0 VDD VDD) gpdk090_pmos1v w=0.48u l=0.1u ad=0.1056p as=0.1632p pd=0.92u ps=1.64u
    I_MXI2_I3_I33_MP1 (I2_I3_q2_1 I2_I3_o2_1 XI2_I3_I33_p1 VDD) gpdk090_pmos1v w=0.48u l=0.1u ad=0.1632p as=0.1056p pd=1.64u ps=0.92u
    I_MXI2_I2_I26_MP0 (XI2_I2_I26_p1 A_4 VDD VDD) gpdk090_pmos1v w=0.48u l=0.1u ad=0.1056p as=0.1632p pd=0.92u ps=1.64u
    I_MXI2_I2_I26_MP1 (I2_I2_nor4 B_4 XI2_I2_I26_p1 VDD) gpdk090_pmos1v w=0.48u l=0.1u ad=0.1632p as=0.1056p pd=1.64u ps=0.92u
    I_MXI1_I108_I20_XP_MP0 (XI1_I108_I20_XP_p1 I1_I108_pn2 VDD VDD) gpdk090_pmos1v w=0.48u l=0.1u ad=0.1056p as=0.1632p pd=0.92u ps=1.64u
    I_MXI1_I108_I20_XP_MP1 (I1_I108_P2_1 I1_I108_pn1 XI1_I108_I20_XP_p1 VDD) gpdk090_pmos1v w=0.48u l=0.1u ad=0.1632p as=0.1056p pd=1.64u ps=0.92u
    I_MXI2_I2_I14_MP0 (XI2_I2_I14_p1 A_2 VDD VDD) gpdk090_pmos1v w=0.48u l=0.1u ad=0.1056p as=0.1632p pd=0.92u ps=1.64u
    I_MXI2_I2_I14_MP1 (I2_I2_nor2 B_2 XI2_I2_I14_p1 VDD) gpdk090_pmos1v w=0.48u l=0.1u ad=0.1632p as=0.1056p pd=1.64u ps=0.92u
    I_MXI1_I108_I21_XP_MP0 (XI1_I108_I21_XP_p1 I1_I108_pn3 VDD VDD) gpdk090_pmos1v w=0.48u l=0.1u ad=0.1056p as=0.1632p pd=0.92u ps=1.64u
    I_MXI1_I108_I21_XP_MP1 (I1_I108_P3_2 I1_I108_pn2 XI1_I108_I21_XP_p1 VDD) gpdk090_pmos1v w=0.48u l=0.1u ad=0.1632p as=0.1056p pd=1.64u ps=0.92u
    I_MXI1_I108_I24_XP_MP0 (XI1_I108_I24_XP_p1 I1_I108_pn6 VDD VDD) gpdk090_pmos1v w=0.48u l=0.1u ad=0.1056p as=0.1632p pd=0.92u ps=1.64u
    I_MXI1_I108_I24_XP_MP1 (I1_I108_P6_5 I1_I108_pn5 XI1_I108_I24_XP_p1 VDD) gpdk090_pmos1v w=0.48u l=0.1u ad=0.1632p as=0.1056p pd=1.64u ps=0.92u
    I_MXI1_I108_I22_XP_MP0 (XI1_I108_I22_XP_p1 I1_I108_pn4 VDD VDD) gpdk090_pmos1v w=0.48u l=0.1u ad=0.1056p as=0.1632p pd=0.92u ps=1.64u
    I_MXI1_I108_I22_XP_MP1 (I1_I108_P4_3 I1_I108_pn3 XI1_I108_I22_XP_p1 VDD) gpdk090_pmos1v w=0.48u l=0.1u ad=0.1632p as=0.1056p pd=1.64u ps=0.92u
    I_MXI1_I84_I20_XP_MP0 (XI1_I84_I20_XP_p1 I1_I84_pn2 VDD VDD) gpdk090_pmos1v w=0.48u l=0.1u ad=0.1056p as=0.1632p pd=0.92u ps=1.64u
    I_MXI1_I84_I20_XP_MP1 (I1_I84_P2_1 I1_I84_pn1 XI1_I84_I20_XP_p1 VDD) gpdk090_pmos1v w=0.48u l=0.1u ad=0.1632p as=0.1056p pd=1.64u ps=0.92u
    I_MXI1_I72_I20_XP_MP0 (XI1_I72_I20_XP_p1 I1_I72_pn2 VDD VDD) gpdk090_pmos1v w=0.48u l=0.1u ad=0.1056p as=0.1632p pd=0.92u ps=1.64u
    I_MXI1_I72_I20_XP_MP1 (I1_I72_P2_1 I1_I72_pn1 XI1_I72_I20_XP_p1 VDD) gpdk090_pmos1v w=0.48u l=0.1u ad=0.1632p as=0.1056p pd=1.64u ps=0.92u
    I_MXI1_I48_I20_XP_MP0 (XI1_I48_I20_XP_p1 I1_I48_pn2 VDD VDD) gpdk090_pmos1v w=0.48u l=0.1u ad=0.1056p as=0.1632p pd=0.92u ps=1.64u
    I_MXI1_I48_I20_XP_MP1 (I1_I48_P2_1 I1_I48_pn1 XI1_I48_I20_XP_p1 VDD) gpdk090_pmos1v w=0.48u l=0.1u ad=0.1632p as=0.1056p pd=1.64u ps=0.92u
    I_MXI1_I108_I23_XP_MP0 (XI1_I108_I23_XP_p1 I1_I108_pn5 VDD VDD) gpdk090_pmos1v w=0.48u l=0.1u ad=0.1056p as=0.1632p pd=0.92u ps=1.64u
    I_MXI1_I108_I23_XP_MP1 (I1_I108_P5_4 I1_I108_pn4 XI1_I108_I23_XP_p1 VDD) gpdk090_pmos1v w=0.48u l=0.1u ad=0.1632p as=0.1056p pd=1.64u ps=0.92u
    I_MXI1_I96_I20_XP_MP0 (XI1_I96_I20_XP_p1 I1_I96_pn2 VDD VDD) gpdk090_pmos1v w=0.48u l=0.1u ad=0.1056p as=0.1632p pd=0.92u ps=1.64u
    I_MXI1_I96_I20_XP_MP1 (I1_I96_P2_1 I1_I96_pn1 XI1_I96_I20_XP_p1 VDD) gpdk090_pmos1v w=0.48u l=0.1u ad=0.1632p as=0.1056p pd=1.64u ps=0.92u
    I_MXI1_I84_I21_XP_MP0 (XI1_I84_I21_XP_p1 I1_I84_pn3 VDD VDD) gpdk090_pmos1v w=0.48u l=0.1u ad=0.1056p as=0.1632p pd=0.92u ps=1.64u
    I_MXI1_I84_I21_XP_MP1 (I1_I84_P3_2 I1_I84_pn2 XI1_I84_I21_XP_p1 VDD) gpdk090_pmos1v w=0.48u l=0.1u ad=0.1632p as=0.1056p pd=1.64u ps=0.92u
    I_MXI1_I72_I21_XP_MP0 (XI1_I72_I21_XP_p1 I1_I72_pn3 VDD VDD) gpdk090_pmos1v w=0.48u l=0.1u ad=0.1056p as=0.1632p pd=0.92u ps=1.64u
    I_MXI1_I72_I21_XP_MP1 (I1_I72_P3_2 I1_I72_pn2 XI1_I72_I21_XP_p1 VDD) gpdk090_pmos1v w=0.48u l=0.1u ad=0.1632p as=0.1056p pd=1.64u ps=0.92u
    I_MXI1_I60_I20_XP_MP0 (XI1_I60_I20_XP_p1 I1_I60_pn2 VDD VDD) gpdk090_pmos1v w=0.48u l=0.1u ad=0.1056p as=0.1632p pd=0.92u ps=1.64u
    I_MXI1_I60_I20_XP_MP1 (I1_I60_P2_1 I1_I60_pn1 XI1_I60_I20_XP_p1 VDD) gpdk090_pmos1v w=0.48u l=0.1u ad=0.1632p as=0.1056p pd=1.64u ps=0.92u
    I_MXI1_I60_I21_XP_MP0 (XI1_I60_I21_XP_p1 I1_I60_pn3 VDD VDD) gpdk090_pmos1v w=0.48u l=0.1u ad=0.1056p as=0.1632p pd=0.92u ps=1.64u
    I_MXI1_I60_I21_XP_MP1 (I1_I60_P3_2 I1_I60_pn2 XI1_I60_I21_XP_p1 VDD) gpdk090_pmos1v w=0.48u l=0.1u ad=0.1632p as=0.1056p pd=1.64u ps=0.92u
    I_MXI1_I48_I21_XP_MP0 (XI1_I48_I21_XP_p1 I1_I48_pn3 VDD VDD) gpdk090_pmos1v w=0.48u l=0.1u ad=0.1056p as=0.1632p pd=0.92u ps=1.64u
    I_MXI1_I48_I21_XP_MP1 (I1_I48_P3_2 I1_I48_pn2 XI1_I48_I21_XP_p1 VDD) gpdk090_pmos1v w=0.48u l=0.1u ad=0.1632p as=0.1056p pd=1.64u ps=0.92u
    I_MXI1_I48_I22_XP_MP0 (XI1_I48_I22_XP_p1 I1_I48_pn4 VDD VDD) gpdk090_pmos1v w=0.48u l=0.1u ad=0.1056p as=0.1632p pd=0.92u ps=1.64u
    I_MXI1_I48_I22_XP_MP1 (I1_I48_P4_3 I1_I48_pn3 XI1_I48_I22_XP_p1 VDD) gpdk090_pmos1v w=0.48u l=0.1u ad=0.1632p as=0.1056p pd=1.64u ps=0.92u
    I_MXI1_I108_I25_XP_MP0 (XI1_I108_I25_XP_p1 I1_I108_pn7 VDD VDD) gpdk090_pmos1v w=0.48u l=0.1u ad=0.1056p as=0.1632p pd=0.92u ps=1.64u
    I_MXI1_I108_I25_XP_MP1 (I1_I108_P7_6 I1_I108_pn6 XI1_I108_I25_XP_p1 VDD) gpdk090_pmos1v w=0.48u l=0.1u ad=0.1632p as=0.1056p pd=1.64u ps=0.92u
    I_MXI1_I96_I21_XP_MP0 (XI1_I96_I21_XP_p1 I1_I96_pn3 VDD VDD) gpdk090_pmos1v w=0.48u l=0.1u ad=0.1056p as=0.1632p pd=0.92u ps=1.64u
    I_MXI1_I96_I21_XP_MP1 (I1_I96_P3_2 I1_I96_pn2 XI1_I96_I21_XP_p1 VDD) gpdk090_pmos1v w=0.48u l=0.1u ad=0.1632p as=0.1056p pd=1.64u ps=0.92u
    I_MXI1_I96_I22_XP_MP0 (XI1_I96_I22_XP_p1 I1_I96_pn4 VDD VDD) gpdk090_pmos1v w=0.48u l=0.1u ad=0.1056p as=0.1632p pd=0.92u ps=1.64u
    I_MXI1_I96_I22_XP_MP1 (I1_I96_P4_3 I1_I96_pn3 XI1_I96_I22_XP_p1 VDD) gpdk090_pmos1v w=0.48u l=0.1u ad=0.1632p as=0.1056p pd=1.64u ps=0.92u
    I_MXI1_I84_I22_XP_MP0 (XI1_I84_I22_XP_p1 I1_I84_pn4 VDD VDD) gpdk090_pmos1v w=0.48u l=0.1u ad=0.1056p as=0.1632p pd=0.92u ps=1.64u
    I_MXI1_I84_I22_XP_MP1 (I1_I84_P4_3 I1_I84_pn3 XI1_I84_I22_XP_p1 VDD) gpdk090_pmos1v w=0.48u l=0.1u ad=0.1632p as=0.1056p pd=1.64u ps=0.92u
    I_MXI1_I72_I22_XP_MP0 (XI1_I72_I22_XP_p1 I1_I72_pn4 VDD VDD) gpdk090_pmos1v w=0.48u l=0.1u ad=0.1056p as=0.1632p pd=0.92u ps=1.64u
    I_MXI1_I72_I22_XP_MP1 (I1_I72_P4_3 I1_I72_pn3 XI1_I72_I22_XP_p1 VDD) gpdk090_pmos1v w=0.48u l=0.1u ad=0.1632p as=0.1056p pd=1.64u ps=0.92u
    I_MXI1_I60_I22_XP_MP0 (XI1_I60_I22_XP_p1 I1_I60_pn4 VDD VDD) gpdk090_pmos1v w=0.48u l=0.1u ad=0.1056p as=0.1632p pd=0.92u ps=1.64u
    I_MXI1_I60_I22_XP_MP1 (I1_I60_P4_3 I1_I60_pn3 XI1_I60_I22_XP_p1 VDD) gpdk090_pmos1v w=0.48u l=0.1u ad=0.1632p as=0.1056p pd=1.64u ps=0.92u
    I_MXI1_I48_I24_XP_MP0 (XI1_I48_I24_XP_p1 I1_I48_pn6 VDD VDD) gpdk090_pmos1v w=0.48u l=0.1u ad=0.1056p as=0.1632p pd=0.92u ps=1.64u
    I_MXI1_I48_I24_XP_MP1 (I1_I48_P6_5 I1_I48_pn5 XI1_I48_I24_XP_p1 VDD) gpdk090_pmos1v w=0.48u l=0.1u ad=0.1632p as=0.1056p pd=1.64u ps=0.92u
    I_MXI1_I48_I23_XP_MP0 (XI1_I48_I23_XP_p1 I1_I48_pn5 VDD VDD) gpdk090_pmos1v w=0.48u l=0.1u ad=0.1056p as=0.1632p pd=0.92u ps=1.64u
    I_MXI1_I48_I23_XP_MP1 (I1_I48_P5_4 I1_I48_pn4 XI1_I48_I23_XP_p1 VDD) gpdk090_pmos1v w=0.48u l=0.1u ad=0.1632p as=0.1056p pd=1.64u ps=0.92u
    I_MXI1_I96_I23_XP_MP0 (XI1_I96_I23_XP_p1 I1_I96_pn5 VDD VDD) gpdk090_pmos1v w=0.48u l=0.1u ad=0.1056p as=0.1632p pd=0.92u ps=1.64u
    I_MXI1_I96_I23_XP_MP1 (I1_I96_P5_4 I1_I96_pn4 XI1_I96_I23_XP_p1 VDD) gpdk090_pmos1v w=0.48u l=0.1u ad=0.1632p as=0.1056p pd=1.64u ps=0.92u
    I_MXI1_I96_I24_XP_MP0 (XI1_I96_I24_XP_p1 I1_I96_pn6 VDD VDD) gpdk090_pmos1v w=0.48u l=0.1u ad=0.1056p as=0.1632p pd=0.92u ps=1.64u
    I_MXI1_I96_I24_XP_MP1 (I1_I96_P6_5 I1_I96_pn5 XI1_I96_I24_XP_p1 VDD) gpdk090_pmos1v w=0.48u l=0.1u ad=0.1632p as=0.1056p pd=1.64u ps=0.92u
    I_MXI1_I84_I23_XP_MP0 (XI1_I84_I23_XP_p1 I1_I84_pn5 VDD VDD) gpdk090_pmos1v w=0.48u l=0.1u ad=0.1056p as=0.1632p pd=0.92u ps=1.64u
    I_MXI1_I84_I23_XP_MP1 (I1_I84_P5_4 I1_I84_pn4 XI1_I84_I23_XP_p1 VDD) gpdk090_pmos1v w=0.48u l=0.1u ad=0.1632p as=0.1056p pd=1.64u ps=0.92u
    I_MXI1_I84_I24_XP_MP0 (XI1_I84_I24_XP_p1 I1_I84_pn6 VDD VDD) gpdk090_pmos1v w=0.48u l=0.1u ad=0.1056p as=0.1632p pd=0.92u ps=1.64u
    I_MXI1_I84_I24_XP_MP1 (I1_I84_P6_5 I1_I84_pn5 XI1_I84_I24_XP_p1 VDD) gpdk090_pmos1v w=0.48u l=0.1u ad=0.1632p as=0.1056p pd=1.64u ps=0.92u
    I_MXI1_I72_I24_XP_MP0 (XI1_I72_I24_XP_p1 I1_I72_pn6 VDD VDD) gpdk090_pmos1v w=0.48u l=0.1u ad=0.1056p as=0.1632p pd=0.92u ps=1.64u
    I_MXI1_I72_I24_XP_MP1 (I1_I72_P6_5 I1_I72_pn5 XI1_I72_I24_XP_p1 VDD) gpdk090_pmos1v w=0.48u l=0.1u ad=0.1632p as=0.1056p pd=1.64u ps=0.92u
    I_MXI1_I72_I23_XP_MP0 (XI1_I72_I23_XP_p1 I1_I72_pn5 VDD VDD) gpdk090_pmos1v w=0.48u l=0.1u ad=0.1056p as=0.1632p pd=0.92u ps=1.64u
    I_MXI1_I72_I23_XP_MP1 (I1_I72_P5_4 I1_I72_pn4 XI1_I72_I23_XP_p1 VDD) gpdk090_pmos1v w=0.48u l=0.1u ad=0.1632p as=0.1056p pd=1.64u ps=0.92u
    I_MXI1_I60_I24_XP_MP0 (XI1_I60_I24_XP_p1 I1_I60_pn6 VDD VDD) gpdk090_pmos1v w=0.48u l=0.1u ad=0.1056p as=0.1632p pd=0.92u ps=1.64u
    I_MXI1_I60_I24_XP_MP1 (I1_I60_P6_5 I1_I60_pn5 XI1_I60_I24_XP_p1 VDD) gpdk090_pmos1v w=0.48u l=0.1u ad=0.1632p as=0.1056p pd=1.64u ps=0.92u
    I_MXI1_I60_I23_XP_MP0 (XI1_I60_I23_XP_p1 I1_I60_pn5 VDD VDD) gpdk090_pmos1v w=0.48u l=0.1u ad=0.1056p as=0.1632p pd=0.92u ps=1.64u
    I_MXI1_I60_I23_XP_MP1 (I1_I60_P5_4 I1_I60_pn4 XI1_I60_I23_XP_p1 VDD) gpdk090_pmos1v w=0.48u l=0.1u ad=0.1632p as=0.1056p pd=1.64u ps=0.92u
    I_MXI1_I96_I25_XP_MP0 (XI1_I96_I25_XP_p1 I1_I96_pn7 VDD VDD) gpdk090_pmos1v w=0.48u l=0.1u ad=0.1056p as=0.1632p pd=0.92u ps=1.64u
    I_MXI1_I96_I25_XP_MP1 (I1_I96_P7_6 I1_I96_pn6 XI1_I96_I25_XP_p1 VDD) gpdk090_pmos1v w=0.48u l=0.1u ad=0.1632p as=0.1056p pd=1.64u ps=0.92u
    I_MXI1_I84_I25_XP_MP0 (XI1_I84_I25_XP_p1 I1_I84_pn7 VDD VDD) gpdk090_pmos1v w=0.48u l=0.1u ad=0.1056p as=0.1632p pd=0.92u ps=1.64u
    I_MXI1_I84_I25_XP_MP1 (I1_I84_P7_6 I1_I84_pn6 XI1_I84_I25_XP_p1 VDD) gpdk090_pmos1v w=0.48u l=0.1u ad=0.1632p as=0.1056p pd=1.64u ps=0.92u
    I_MXI1_I72_I25_XP_MP0 (XI1_I72_I25_XP_p1 I1_I72_pn7 VDD VDD) gpdk090_pmos1v w=0.48u l=0.1u ad=0.1056p as=0.1632p pd=0.92u ps=1.64u
    I_MXI1_I72_I25_XP_MP1 (I1_I72_P7_6 I1_I72_pn6 XI1_I72_I25_XP_p1 VDD) gpdk090_pmos1v w=0.48u l=0.1u ad=0.1632p as=0.1056p pd=1.64u ps=0.92u
    I_MXI1_I60_I25_XP_MP0 (XI1_I60_I25_XP_p1 I1_I60_pn7 VDD VDD) gpdk090_pmos1v w=0.48u l=0.1u ad=0.1056p as=0.1632p pd=0.92u ps=1.64u
    I_MXI1_I60_I25_XP_MP1 (I1_I60_P7_6 I1_I60_pn6 XI1_I60_I25_XP_p1 VDD) gpdk090_pmos1v w=0.48u l=0.1u ad=0.1632p as=0.1056p pd=1.64u ps=0.92u
    I_MXI1_I48_I25_XP_MP0 (XI1_I48_I25_XP_p1 I1_I48_pn7 VDD VDD) gpdk090_pmos1v w=0.48u l=0.1u ad=0.1056p as=0.1632p pd=0.92u ps=1.64u
    I_MXI1_I48_I25_XP_MP1 (I1_I48_P7_6 I1_I48_pn6 XI1_I48_I25_XP_p1 VDD) gpdk090_pmos1v w=0.48u l=0.1u ad=0.1632p as=0.1056p pd=1.64u ps=0.92u
    I_MXI0_I53_MP50 (VDD XI0_I53_s1 XI0_I53_bp4 VDD) gpdk090_pmos1v w=0.36u l=0.1u ad=0.0996p as=0.0792p pd=0.92u ps=0.8u
    I_MXI0_I53_MP47 (XI0_I53_bp3 I0_pp3_5 VDD VDD) gpdk090_pmos1v w=0.48u l=0.1u ad=0.2352p as=0.0996p pd=1.46u ps=0.92u
    I_MXI0_I53_MP49 (XI0_I53_bsn XI0_I53_bcon XI0_I53_bp3 VDD) gpdk090_pmos1v w=0.48u l=0.1u ad=0.0996p as=0.2352p pd=0.92u ps=1.46u
    I_MXI0_I53_MP52 (XI0_I53_bp5 I0_cm9_2 XI0_I53_bsn VDD) gpdk090_pmos1v w=0.36u l=0.1u ad=0.0792p as=0.0996p pd=0.8u ps=0.92u
    I_MXI0_I53_MP51 (XI0_I53_bp4 I0_pp3_5 XI0_I53_bp5 VDD) gpdk090_pmos1v w=0.36u l=0.1u ad=0.0792p as=0.0792p pd=0.8u ps=0.8u
    I_MXI0_I53_MP51_1 (XI0_I53_bp5 I0_pp3_5 XI0_I53_bp4 VDD) gpdk090_pmos1v w=0.36u l=0.1u ad=0.0792p as=0.0792p pd=0.8u ps=0.8u
    I_MXI0_I53_MP52_1 (XI0_I53_bsn I0_cm9_2 XI0_I53_bp5 VDD) gpdk090_pmos1v w=0.36u l=0.1u ad=0.1224p as=0.0792p pd=1.4u ps=0.8u
    I_MXI0_I53_MP54 (VDD XI0_I53_bsn I0_cm10_0 VDD) gpdk090_pmos1v w=0.24u l=0.1u ad=0.0816p as=0.0816p pd=1.16u ps=1.16u
    I_MXI0_I53_MP41 (XI0_I53_bp1 XI0_I53_s1 VDD VDD) gpdk090_pmos1v w=0.48u l=0.1u ad=0.1056p as=0.0936p pd=0.92u ps=0.92u
    I_MXI0_I53_MP42 (XI0_I53_bcon I0_pp3_5 XI0_I53_bp1 VDD) gpdk090_pmos1v w=0.48u l=0.1u ad=0.1056p as=0.1056p pd=0.92u ps=0.92u
    I_MXI0_I53_MP45 (XI0_I53_bp2 I0_cm9_2 XI0_I53_bcon VDD) gpdk090_pmos1v w=0.48u l=0.1u ad=0.1056p as=0.1056p pd=0.92u ps=0.92u
    I_MXI0_I53_MP43 (VDD XI0_I53_s1 XI0_I53_bp2 VDD) gpdk090_pmos1v w=0.48u l=0.1u ad=0.1056p as=0.1056p pd=0.92u ps=0.92u
    I_MXI0_I53_MP44 (XI0_I53_bp2 I0_pp3_5 VDD VDD) gpdk090_pmos1v w=0.48u l=0.1u ad=0.1632p as=0.1056p pd=1.64u ps=0.92u
    I_MXI0_I53_MP56 (VDD XI0_I53_bcon I0_cm10_1 VDD) gpdk090_pmos1v w=0.24u l=0.1u ad=0.0936p as=0.0816p pd=0.92u ps=1.16u
    I_MXI0_I53_MP46 (XI0_I53_bp3 XI0_I53_s1 VDD VDD) gpdk090_pmos1v w=0.48u l=0.1u ad=0.1056p as=0.0936p pd=0.92u ps=0.92u
    I_MXI0_I53_MP48 (VDD I0_cm9_2 XI0_I53_bp3 VDD) gpdk090_pmos1v w=0.48u l=0.1u ad=0.0996p as=0.1056p pd=0.92u ps=0.92u
    I_MXI0_I53_MP50_1 (XI0_I53_bp4 XI0_I53_s1 VDD VDD) gpdk090_pmos1v w=0.36u l=0.1u ad=0.0792p as=0.0996p pd=0.8u ps=0.92u
    I_MXI0_I53_MP26 (VDD XI0_I53_asn XI0_I53_s1 VDD) gpdk090_pmos1v w=0.24u l=0.1u ad=0.0936p as=0.0816p pd=0.92u ps=1.16u
    I_MXI0_I53_MP18 (XI0_I53_ap3 I0_sn0 VDD VDD) gpdk090_pmos1v w=0.48u l=0.1u ad=0.1056p as=0.264p pd=0.92u ps=2.24u
    I_MXI0_I53_MP21 (XI0_I53_asn XI0_I53_acon XI0_I53_ap3 VDD) gpdk090_pmos1v w=0.48u l=0.1u ad=0.0996p as=0.1056p pd=0.92u ps=0.92u
    I_MXI0_I53_MP24 (XI0_I53_ap5 I0_pp2_7 XI0_I53_asn VDD) gpdk090_pmos1v w=0.36u l=0.1u ad=0.0792p as=0.0996p pd=0.8u ps=0.92u
    I_MXI0_I53_MP23 (XI0_I53_ap4 I0_sn1 XI0_I53_ap5 VDD) gpdk090_pmos1v w=0.36u l=0.1u ad=0.0792p as=0.0792p pd=0.8u ps=0.8u
    I_MXI0_I53_MP22 (VDD I0_sn0 XI0_I53_ap4 VDD) gpdk090_pmos1v w=0.36u l=0.1u ad=0.0792p as=0.0792p pd=0.8u ps=0.8u
    I_MXI0_I53_MP22_1 (XI0_I53_ap4 I0_sn0 VDD VDD) gpdk090_pmos1v w=0.36u l=0.1u ad=0.0792p as=0.0792p pd=0.8u ps=0.8u
    I_MXI0_I53_MP23_1 (XI0_I53_ap5 I0_sn1 XI0_I53_ap4 VDD) gpdk090_pmos1v w=0.36u l=0.1u ad=0.0792p as=0.0792p pd=0.8u ps=0.8u
    I_MXI0_I53_MP24_1 (XI0_I53_asn I0_pp2_7 XI0_I53_ap5 VDD) gpdk090_pmos1v w=0.36u l=0.1u ad=0.1224p as=0.0792p pd=1.4u ps=0.8u
    I_MXI0_I53_MP17 (XI0_I53_acon I0_pp2_7 XI0_I53_ap2 VDD) gpdk090_pmos1v w=0.48u l=0.1u ad=0.1056p as=0.1632p pd=0.92u ps=1.64u
    I_MXI0_I53_MP14 (XI0_I53_ap1 I0_sn1 XI0_I53_acon VDD) gpdk090_pmos1v w=0.48u l=0.1u ad=0.1056p as=0.1056p pd=0.92u ps=0.92u
    I_MXI0_I53_MP13 (VDD I0_sn0 XI0_I53_ap1 VDD) gpdk090_pmos1v w=0.48u l=0.1u ad=0.1056p as=0.1056p pd=0.92u ps=0.92u
    I_MXI0_I53_MP15 (XI0_I53_ap2 I0_sn0 VDD VDD) gpdk090_pmos1v w=0.48u l=0.1u ad=0.1056p as=0.1056p pd=0.92u ps=0.92u
    I_MXI0_I53_MP16 (VDD I0_sn1 XI0_I53_ap2 VDD) gpdk090_pmos1v w=0.48u l=0.1u ad=0.0936p as=0.1056p pd=0.92u ps=0.92u
    I_MXI0_I53_MP28 (I0_cm10_2 XI0_I53_acon VDD VDD) gpdk090_pmos1v w=0.24u l=0.1u ad=0.0816p as=0.0936p pd=1.16u ps=0.92u
    I_MXI0_I53_MP19 (XI0_I53_ap3 I0_sn1 VDD VDD) gpdk090_pmos1v w=0.48u l=0.1u ad=0.1056p as=0.1632p pd=0.92u ps=1.64u
    I_MXI0_I53_MP20 (VDD I0_pp2_7 XI0_I53_ap3 VDD) gpdk090_pmos1v w=0.48u l=0.1u ad=0.264p as=0.1056p pd=2.24u ps=0.92u
    I_MXI0_I54_MP50 (VDD XI0_I54_s1 XI0_I54_bp4 VDD) gpdk090_pmos1v w=0.36u l=0.1u ad=0.0996p as=0.0792p pd=0.92u ps=0.8u
    I_MXI0_I54_MP47 (XI0_I54_bp3 VSS VDD VDD) gpdk090_pmos1v w=0.48u l=0.1u ad=0.2352p as=0.0996p pd=1.46u ps=0.92u
    I_MXI0_I54_MP49 (XI0_I54_bsn XI0_I54_bcon XI0_I54_bp3 VDD) gpdk090_pmos1v w=0.48u l=0.1u ad=0.0996p as=0.2352p pd=0.92u ps=1.46u
    I_MXI0_I54_MP52 (XI0_I54_bp5 I0_cm10_2 XI0_I54_bsn VDD) gpdk090_pmos1v w=0.36u l=0.1u ad=0.0792p as=0.0996p pd=0.8u ps=0.92u
    I_MXI0_I54_MP51 (XI0_I54_bp4 VSS XI0_I54_bp5 VDD) gpdk090_pmos1v w=0.36u l=0.1u ad=0.0792p as=0.0792p pd=0.8u ps=0.8u
    I_MXI0_I54_MP51_1 (XI0_I54_bp5 VSS XI0_I54_bp4 VDD) gpdk090_pmos1v w=0.36u l=0.1u ad=0.0792p as=0.0792p pd=0.8u ps=0.8u
    I_MXI0_I54_MP52_1 (XI0_I54_bsn I0_cm10_2 XI0_I54_bp5 VDD) gpdk090_pmos1v w=0.36u l=0.1u ad=0.1224p as=0.0792p pd=1.4u ps=0.8u
    I_MXI0_I54_MP54 (VDD XI0_I54_bsn I0_cm11_0 VDD) gpdk090_pmos1v w=0.24u l=0.1u ad=0.0816p as=0.0816p pd=1.16u ps=1.16u
    I_MXI0_I54_MP41 (XI0_I54_bp1 XI0_I54_s1 VDD VDD) gpdk090_pmos1v w=0.48u l=0.1u ad=0.1056p as=0.0936p pd=0.92u ps=0.92u
    I_MXI0_I54_MP42 (XI0_I54_bcon VSS XI0_I54_bp1 VDD) gpdk090_pmos1v w=0.48u l=0.1u ad=0.1056p as=0.1056p pd=0.92u ps=0.92u
    I_MXI0_I54_MP45 (XI0_I54_bp2 I0_cm10_2 XI0_I54_bcon VDD) gpdk090_pmos1v w=0.48u l=0.1u ad=0.1056p as=0.1056p pd=0.92u ps=0.92u
    I_MXI0_I54_MP43 (VDD XI0_I54_s1 XI0_I54_bp2 VDD) gpdk090_pmos1v w=0.48u l=0.1u ad=0.1056p as=0.1056p pd=0.92u ps=0.92u
    I_MXI0_I54_MP44 (XI0_I54_bp2 VSS VDD VDD) gpdk090_pmos1v w=0.48u l=0.1u ad=0.1632p as=0.1056p pd=1.64u ps=0.92u
    I_MXI0_I54_MP56 (VDD XI0_I54_bcon I0_cm11_1 VDD) gpdk090_pmos1v w=0.24u l=0.1u ad=0.0936p as=0.0816p pd=0.92u ps=1.16u
    I_MXI0_I54_MP46 (XI0_I54_bp3 XI0_I54_s1 VDD VDD) gpdk090_pmos1v w=0.48u l=0.1u ad=0.1056p as=0.0936p pd=0.92u ps=0.92u
    I_MXI0_I54_MP48 (VDD I0_cm10_2 XI0_I54_bp3 VDD) gpdk090_pmos1v w=0.48u l=0.1u ad=0.0996p as=0.1056p pd=0.92u ps=0.92u
    I_MXI0_I54_MP50_1 (XI0_I54_bp4 XI0_I54_s1 VDD VDD) gpdk090_pmos1v w=0.36u l=0.1u ad=0.0792p as=0.0996p pd=0.8u ps=0.92u
    I_MXI0_I54_MP26 (VDD XI0_I54_asn XI0_I54_s1 VDD) gpdk090_pmos1v w=0.24u l=0.1u ad=0.0936p as=0.0816p pd=0.92u ps=1.16u
    I_MXI0_I54_MP18 (XI0_I54_ap3 VDD VDD VDD) gpdk090_pmos1v w=0.48u l=0.1u ad=0.1056p as=0.264p pd=0.92u ps=2.24u
    I_MXI0_I54_MP21 (XI0_I54_asn XI0_I54_acon XI0_I54_ap3 VDD) gpdk090_pmos1v w=0.48u l=0.1u ad=0.0996p as=0.1056p pd=0.92u ps=0.92u
    I_MXI0_I54_MP24 (XI0_I54_ap5 I0_pp3_6 XI0_I54_asn VDD) gpdk090_pmos1v w=0.36u l=0.1u ad=0.0792p as=0.0996p pd=0.8u ps=0.92u
    I_MXI0_I54_MP23 (XI0_I54_ap4 I0_pp2_8 XI0_I54_ap5 VDD) gpdk090_pmos1v w=0.36u l=0.1u ad=0.0792p as=0.0792p pd=0.8u ps=0.8u
    I_MXI0_I54_MP22 (VDD VDD XI0_I54_ap4 VDD) gpdk090_pmos1v w=0.36u l=0.1u ad=0.0792p as=0.0792p pd=0.8u ps=0.8u
    I_MXI0_I54_MP22_1 (XI0_I54_ap4 VDD VDD VDD) gpdk090_pmos1v w=0.36u l=0.1u ad=0.0792p as=0.0792p pd=0.8u ps=0.8u
    I_MXI0_I54_MP23_1 (XI0_I54_ap5 I0_pp2_8 XI0_I54_ap4 VDD) gpdk090_pmos1v w=0.36u l=0.1u ad=0.0792p as=0.0792p pd=0.8u ps=0.8u
    I_MXI0_I54_MP24_1 (XI0_I54_asn I0_pp3_6 XI0_I54_ap5 VDD) gpdk090_pmos1v w=0.36u l=0.1u ad=0.1224p as=0.0792p pd=1.4u ps=0.8u
    I_MXI0_I54_MP17 (XI0_I54_acon I0_pp3_6 XI0_I54_ap2 VDD) gpdk090_pmos1v w=0.48u l=0.1u ad=0.1056p as=0.1632p pd=0.92u ps=1.64u
    I_MXI0_I54_MP14 (XI0_I54_ap1 I0_pp2_8 XI0_I54_acon VDD) gpdk090_pmos1v w=0.48u l=0.1u ad=0.1056p as=0.1056p pd=0.92u ps=0.92u
    I_MXI0_I54_MP13 (VDD VDD XI0_I54_ap1 VDD) gpdk090_pmos1v w=0.48u l=0.1u ad=0.1056p as=0.1056p pd=0.92u ps=0.92u
    I_MXI0_I54_MP15 (XI0_I54_ap2 VDD VDD VDD) gpdk090_pmos1v w=0.48u l=0.1u ad=0.1056p as=0.1056p pd=0.92u ps=0.92u
    I_MXI0_I54_MP16 (VDD I0_pp2_8 XI0_I54_ap2 VDD) gpdk090_pmos1v w=0.48u l=0.1u ad=0.0936p as=0.1056p pd=0.92u ps=0.92u
    I_MXI0_I54_MP28 (I0_cm11_2 XI0_I54_acon VDD VDD) gpdk090_pmos1v w=0.24u l=0.1u ad=0.0816p as=0.0936p pd=1.16u ps=0.92u
    I_MXI0_I54_MP19 (XI0_I54_ap3 I0_pp2_8 VDD VDD) gpdk090_pmos1v w=0.48u l=0.1u ad=0.1056p as=0.1632p pd=0.92u ps=1.64u
    I_MXI0_I54_MP20 (VDD I0_pp3_6 XI0_I54_ap3 VDD) gpdk090_pmos1v w=0.48u l=0.1u ad=0.264p as=0.1056p pd=2.24u ps=0.92u
    I_MXI0_I52_MP50 (VDD XI0_I52_s1 XI0_I52_bp4 VDD) gpdk090_pmos1v w=0.36u l=0.1u ad=0.0996p as=0.0792p pd=0.92u ps=0.8u
    I_MXI0_I52_MP47 (XI0_I52_bp3 I0_pp3_4 VDD VDD) gpdk090_pmos1v w=0.48u l=0.1u ad=0.2352p as=0.0996p pd=1.46u ps=0.92u
    I_MXI0_I52_MP49 (XI0_I52_bsn XI0_I52_bcon XI0_I52_bp3 VDD) gpdk090_pmos1v w=0.48u l=0.1u ad=0.0996p as=0.2352p pd=0.92u ps=1.46u
    I_MXI0_I52_MP52 (XI0_I52_bp5 I0_cm8_2 XI0_I52_bsn VDD) gpdk090_pmos1v w=0.36u l=0.1u ad=0.0792p as=0.0996p pd=0.8u ps=0.92u
    I_MXI0_I52_MP51 (XI0_I52_bp4 I0_pp3_4 XI0_I52_bp5 VDD) gpdk090_pmos1v w=0.36u l=0.1u ad=0.0792p as=0.0792p pd=0.8u ps=0.8u
    I_MXI0_I52_MP51_1 (XI0_I52_bp5 I0_pp3_4 XI0_I52_bp4 VDD) gpdk090_pmos1v w=0.36u l=0.1u ad=0.0792p as=0.0792p pd=0.8u ps=0.8u
    I_MXI0_I52_MP52_1 (XI0_I52_bsn I0_cm8_2 XI0_I52_bp5 VDD) gpdk090_pmos1v w=0.36u l=0.1u ad=0.1224p as=0.0792p pd=1.4u ps=0.8u
    I_MXI0_I52_MP54 (VDD XI0_I52_bsn I0_cm9_0 VDD) gpdk090_pmos1v w=0.24u l=0.1u ad=0.0816p as=0.0816p pd=1.16u ps=1.16u
    I_MXI0_I52_MP41 (XI0_I52_bp1 XI0_I52_s1 VDD VDD) gpdk090_pmos1v w=0.48u l=0.1u ad=0.1056p as=0.0936p pd=0.92u ps=0.92u
    I_MXI0_I52_MP42 (XI0_I52_bcon I0_pp3_4 XI0_I52_bp1 VDD) gpdk090_pmos1v w=0.48u l=0.1u ad=0.1056p as=0.1056p pd=0.92u ps=0.92u
    I_MXI0_I52_MP45 (XI0_I52_bp2 I0_cm8_2 XI0_I52_bcon VDD) gpdk090_pmos1v w=0.48u l=0.1u ad=0.1056p as=0.1056p pd=0.92u ps=0.92u
    I_MXI0_I52_MP43 (VDD XI0_I52_s1 XI0_I52_bp2 VDD) gpdk090_pmos1v w=0.48u l=0.1u ad=0.1056p as=0.1056p pd=0.92u ps=0.92u
    I_MXI0_I52_MP44 (XI0_I52_bp2 I0_pp3_4 VDD VDD) gpdk090_pmos1v w=0.48u l=0.1u ad=0.1632p as=0.1056p pd=1.64u ps=0.92u
    I_MXI0_I52_MP56 (VDD XI0_I52_bcon I0_cm9_1 VDD) gpdk090_pmos1v w=0.24u l=0.1u ad=0.0936p as=0.0816p pd=0.92u ps=1.16u
    I_MXI0_I52_MP46 (XI0_I52_bp3 XI0_I52_s1 VDD VDD) gpdk090_pmos1v w=0.48u l=0.1u ad=0.1056p as=0.0936p pd=0.92u ps=0.92u
    I_MXI0_I52_MP48 (VDD I0_cm8_2 XI0_I52_bp3 VDD) gpdk090_pmos1v w=0.48u l=0.1u ad=0.0996p as=0.1056p pd=0.92u ps=0.92u
    I_MXI0_I52_MP50_1 (XI0_I52_bp4 XI0_I52_s1 VDD VDD) gpdk090_pmos1v w=0.36u l=0.1u ad=0.0792p as=0.0996p pd=0.8u ps=0.92u
    I_MXI0_I52_MP26 (VDD XI0_I52_asn XI0_I52_s1 VDD) gpdk090_pmos1v w=0.24u l=0.1u ad=0.0936p as=0.0816p pd=0.92u ps=1.16u
    I_MXI0_I52_MP18 (XI0_I52_ap3 I0_pp0_8 VDD VDD) gpdk090_pmos1v w=0.48u l=0.1u ad=0.1056p as=0.264p pd=0.92u ps=2.24u
    I_MXI0_I52_MP21 (XI0_I52_asn XI0_I52_acon XI0_I52_ap3 VDD) gpdk090_pmos1v w=0.48u l=0.1u ad=0.0996p as=0.1056p pd=0.92u ps=0.92u
    I_MXI0_I52_MP24 (XI0_I52_ap5 I0_pp2_6 XI0_I52_asn VDD) gpdk090_pmos1v w=0.36u l=0.1u ad=0.0792p as=0.0996p pd=0.8u ps=0.92u
    I_MXI0_I52_MP23 (XI0_I52_ap4 I0_pp1_8 XI0_I52_ap5 VDD) gpdk090_pmos1v w=0.36u l=0.1u ad=0.0792p as=0.0792p pd=0.8u ps=0.8u
    I_MXI0_I52_MP22 (VDD I0_pp0_8 XI0_I52_ap4 VDD) gpdk090_pmos1v w=0.36u l=0.1u ad=0.0792p as=0.0792p pd=0.8u ps=0.8u
    I_MXI0_I52_MP22_1 (XI0_I52_ap4 I0_pp0_8 VDD VDD) gpdk090_pmos1v w=0.36u l=0.1u ad=0.0792p as=0.0792p pd=0.8u ps=0.8u
    I_MXI0_I52_MP23_1 (XI0_I52_ap5 I0_pp1_8 XI0_I52_ap4 VDD) gpdk090_pmos1v w=0.36u l=0.1u ad=0.0792p as=0.0792p pd=0.8u ps=0.8u
    I_MXI0_I52_MP24_1 (XI0_I52_asn I0_pp2_6 XI0_I52_ap5 VDD) gpdk090_pmos1v w=0.36u l=0.1u ad=0.1224p as=0.0792p pd=1.4u ps=0.8u
    I_MXI0_I52_MP17 (XI0_I52_acon I0_pp2_6 XI0_I52_ap2 VDD) gpdk090_pmos1v w=0.48u l=0.1u ad=0.1056p as=0.1632p pd=0.92u ps=1.64u
    I_MXI0_I52_MP14 (XI0_I52_ap1 I0_pp1_8 XI0_I52_acon VDD) gpdk090_pmos1v w=0.48u l=0.1u ad=0.1056p as=0.1056p pd=0.92u ps=0.92u
    I_MXI0_I52_MP13 (VDD I0_pp0_8 XI0_I52_ap1 VDD) gpdk090_pmos1v w=0.48u l=0.1u ad=0.1056p as=0.1056p pd=0.92u ps=0.92u
    I_MXI0_I52_MP15 (XI0_I52_ap2 I0_pp0_8 VDD VDD) gpdk090_pmos1v w=0.48u l=0.1u ad=0.1056p as=0.1056p pd=0.92u ps=0.92u
    I_MXI0_I52_MP16 (VDD I0_pp1_8 XI0_I52_ap2 VDD) gpdk090_pmos1v w=0.48u l=0.1u ad=0.0936p as=0.1056p pd=0.92u ps=0.92u
    I_MXI0_I52_MP28 (I0_cm9_2 XI0_I52_acon VDD VDD) gpdk090_pmos1v w=0.24u l=0.1u ad=0.0816p as=0.0936p pd=1.16u ps=0.92u
    I_MXI0_I52_MP19 (XI0_I52_ap3 I0_pp1_8 VDD VDD) gpdk090_pmos1v w=0.48u l=0.1u ad=0.1056p as=0.1632p pd=0.92u ps=1.64u
    I_MXI0_I52_MP20 (VDD I0_pp2_6 XI0_I52_ap3 VDD) gpdk090_pmos1v w=0.48u l=0.1u ad=0.264p as=0.1056p pd=2.24u ps=0.92u
    I_MXI0_I51_MP50 (VDD XI0_I51_s1 XI0_I51_bp4 VDD) gpdk090_pmos1v w=0.36u l=0.1u ad=0.0996p as=0.0792p pd=0.92u ps=0.8u
    I_MXI0_I51_MP47 (XI0_I51_bp3 I0_pp3_3 VDD VDD) gpdk090_pmos1v w=0.48u l=0.1u ad=0.2352p as=0.0996p pd=1.46u ps=0.92u
    I_MXI0_I51_MP49 (XI0_I51_bsn XI0_I51_bcon XI0_I51_bp3 VDD) gpdk090_pmos1v w=0.48u l=0.1u ad=0.0996p as=0.2352p pd=0.92u ps=1.46u
    I_MXI0_I51_MP52 (XI0_I51_bp5 I0_cm7_2 XI0_I51_bsn VDD) gpdk090_pmos1v w=0.36u l=0.1u ad=0.0792p as=0.0996p pd=0.8u ps=0.92u
    I_MXI0_I51_MP51 (XI0_I51_bp4 I0_pp3_3 XI0_I51_bp5 VDD) gpdk090_pmos1v w=0.36u l=0.1u ad=0.0792p as=0.0792p pd=0.8u ps=0.8u
    I_MXI0_I51_MP51_1 (XI0_I51_bp5 I0_pp3_3 XI0_I51_bp4 VDD) gpdk090_pmos1v w=0.36u l=0.1u ad=0.0792p as=0.0792p pd=0.8u ps=0.8u
    I_MXI0_I51_MP52_1 (XI0_I51_bsn I0_cm7_2 XI0_I51_bp5 VDD) gpdk090_pmos1v w=0.36u l=0.1u ad=0.1224p as=0.0792p pd=1.4u ps=0.8u
    I_MXI0_I51_MP54 (VDD XI0_I51_bsn I0_cm8_0 VDD) gpdk090_pmos1v w=0.24u l=0.1u ad=0.0816p as=0.0816p pd=1.16u ps=1.16u
    I_MXI0_I51_MP41 (XI0_I51_bp1 XI0_I51_s1 VDD VDD) gpdk090_pmos1v w=0.48u l=0.1u ad=0.1056p as=0.0936p pd=0.92u ps=0.92u
    I_MXI0_I51_MP42 (XI0_I51_bcon I0_pp3_3 XI0_I51_bp1 VDD) gpdk090_pmos1v w=0.48u l=0.1u ad=0.1056p as=0.1056p pd=0.92u ps=0.92u
    I_MXI0_I51_MP45 (XI0_I51_bp2 I0_cm7_2 XI0_I51_bcon VDD) gpdk090_pmos1v w=0.48u l=0.1u ad=0.1056p as=0.1056p pd=0.92u ps=0.92u
    I_MXI0_I51_MP43 (VDD XI0_I51_s1 XI0_I51_bp2 VDD) gpdk090_pmos1v w=0.48u l=0.1u ad=0.1056p as=0.1056p pd=0.92u ps=0.92u
    I_MXI0_I51_MP44 (XI0_I51_bp2 I0_pp3_3 VDD VDD) gpdk090_pmos1v w=0.48u l=0.1u ad=0.1632p as=0.1056p pd=1.64u ps=0.92u
    I_MXI0_I51_MP56 (VDD XI0_I51_bcon I0_cm8_1 VDD) gpdk090_pmos1v w=0.24u l=0.1u ad=0.0936p as=0.0816p pd=0.92u ps=1.16u
    I_MXI0_I51_MP46 (XI0_I51_bp3 XI0_I51_s1 VDD VDD) gpdk090_pmos1v w=0.48u l=0.1u ad=0.1056p as=0.0936p pd=0.92u ps=0.92u
    I_MXI0_I51_MP48 (VDD I0_cm7_2 XI0_I51_bp3 VDD) gpdk090_pmos1v w=0.48u l=0.1u ad=0.0996p as=0.1056p pd=0.92u ps=0.92u
    I_MXI0_I51_MP50_1 (XI0_I51_bp4 XI0_I51_s1 VDD VDD) gpdk090_pmos1v w=0.36u l=0.1u ad=0.0792p as=0.0996p pd=0.8u ps=0.92u
    I_MXI0_I51_MP26 (VDD XI0_I51_asn XI0_I51_s1 VDD) gpdk090_pmos1v w=0.24u l=0.1u ad=0.0936p as=0.0816p pd=0.92u ps=1.16u
    I_MXI0_I51_MP18 (XI0_I51_ap3 I0_pp0_8 VDD VDD) gpdk090_pmos1v w=0.48u l=0.1u ad=0.1056p as=0.264p pd=0.92u ps=2.24u
    I_MXI0_I51_MP21 (XI0_I51_asn XI0_I51_acon XI0_I51_ap3 VDD) gpdk090_pmos1v w=0.48u l=0.1u ad=0.0996p as=0.1056p pd=0.92u ps=0.92u
    I_MXI0_I51_MP24 (XI0_I51_ap5 I0_pp2_5 XI0_I51_asn VDD) gpdk090_pmos1v w=0.36u l=0.1u ad=0.0792p as=0.0996p pd=0.8u ps=0.92u
    I_MXI0_I51_MP23 (XI0_I51_ap4 I0_pp1_7 XI0_I51_ap5 VDD) gpdk090_pmos1v w=0.36u l=0.1u ad=0.0792p as=0.0792p pd=0.8u ps=0.8u
    I_MXI0_I51_MP22 (VDD I0_pp0_8 XI0_I51_ap4 VDD) gpdk090_pmos1v w=0.36u l=0.1u ad=0.0792p as=0.0792p pd=0.8u ps=0.8u
    I_MXI0_I51_MP22_1 (XI0_I51_ap4 I0_pp0_8 VDD VDD) gpdk090_pmos1v w=0.36u l=0.1u ad=0.0792p as=0.0792p pd=0.8u ps=0.8u
    I_MXI0_I51_MP23_1 (XI0_I51_ap5 I0_pp1_7 XI0_I51_ap4 VDD) gpdk090_pmos1v w=0.36u l=0.1u ad=0.0792p as=0.0792p pd=0.8u ps=0.8u
    I_MXI0_I51_MP24_1 (XI0_I51_asn I0_pp2_5 XI0_I51_ap5 VDD) gpdk090_pmos1v w=0.36u l=0.1u ad=0.1224p as=0.0792p pd=1.4u ps=0.8u
    I_MXI0_I51_MP17 (XI0_I51_acon I0_pp2_5 XI0_I51_ap2 VDD) gpdk090_pmos1v w=0.48u l=0.1u ad=0.1056p as=0.1632p pd=0.92u ps=1.64u
    I_MXI0_I51_MP14 (XI0_I51_ap1 I0_pp1_7 XI0_I51_acon VDD) gpdk090_pmos1v w=0.48u l=0.1u ad=0.1056p as=0.1056p pd=0.92u ps=0.92u
    I_MXI0_I51_MP13 (VDD I0_pp0_8 XI0_I51_ap1 VDD) gpdk090_pmos1v w=0.48u l=0.1u ad=0.1056p as=0.1056p pd=0.92u ps=0.92u
    I_MXI0_I51_MP15 (XI0_I51_ap2 I0_pp0_8 VDD VDD) gpdk090_pmos1v w=0.48u l=0.1u ad=0.1056p as=0.1056p pd=0.92u ps=0.92u
    I_MXI0_I51_MP16 (VDD I0_pp1_7 XI0_I51_ap2 VDD) gpdk090_pmos1v w=0.48u l=0.1u ad=0.0936p as=0.1056p pd=0.92u ps=0.92u
    I_MXI0_I51_MP28 (I0_cm8_2 XI0_I51_acon VDD VDD) gpdk090_pmos1v w=0.24u l=0.1u ad=0.0816p as=0.0936p pd=1.16u ps=0.92u
    I_MXI0_I51_MP19 (XI0_I51_ap3 I0_pp1_7 VDD VDD) gpdk090_pmos1v w=0.48u l=0.1u ad=0.1056p as=0.1632p pd=0.92u ps=1.64u
    I_MXI0_I51_MP20 (VDD I0_pp2_5 XI0_I51_ap3 VDD) gpdk090_pmos1v w=0.48u l=0.1u ad=0.264p as=0.1056p pd=2.24u ps=0.92u
    I_MXI0_I50_MP50 (VDD XI0_I50_s1 XI0_I50_bp4 VDD) gpdk090_pmos1v w=0.36u l=0.1u ad=0.0996p as=0.0792p pd=0.92u ps=0.8u
    I_MXI0_I50_MP47 (XI0_I50_bp3 I0_pp3_2 VDD VDD) gpdk090_pmos1v w=0.48u l=0.1u ad=0.2352p as=0.0996p pd=1.46u ps=0.92u
    I_MXI0_I50_MP49 (XI0_I50_bsn XI0_I50_bcon XI0_I50_bp3 VDD) gpdk090_pmos1v w=0.48u l=0.1u ad=0.0996p as=0.2352p pd=0.92u ps=1.46u
    I_MXI0_I50_MP52 (XI0_I50_bp5 I0_cm6_2 XI0_I50_bsn VDD) gpdk090_pmos1v w=0.36u l=0.1u ad=0.0792p as=0.0996p pd=0.8u ps=0.92u
    I_MXI0_I50_MP51 (XI0_I50_bp4 I0_pp3_2 XI0_I50_bp5 VDD) gpdk090_pmos1v w=0.36u l=0.1u ad=0.0792p as=0.0792p pd=0.8u ps=0.8u
    I_MXI0_I50_MP51_1 (XI0_I50_bp5 I0_pp3_2 XI0_I50_bp4 VDD) gpdk090_pmos1v w=0.36u l=0.1u ad=0.0792p as=0.0792p pd=0.8u ps=0.8u
    I_MXI0_I50_MP52_1 (XI0_I50_bsn I0_cm6_2 XI0_I50_bp5 VDD) gpdk090_pmos1v w=0.36u l=0.1u ad=0.1224p as=0.0792p pd=1.4u ps=0.8u
    I_MXI0_I50_MP54 (VDD XI0_I50_bsn I0_cm7_0 VDD) gpdk090_pmos1v w=0.24u l=0.1u ad=0.0816p as=0.0816p pd=1.16u ps=1.16u
    I_MXI0_I50_MP41 (XI0_I50_bp1 XI0_I50_s1 VDD VDD) gpdk090_pmos1v w=0.48u l=0.1u ad=0.1056p as=0.0936p pd=0.92u ps=0.92u
    I_MXI0_I50_MP42 (XI0_I50_bcon I0_pp3_2 XI0_I50_bp1 VDD) gpdk090_pmos1v w=0.48u l=0.1u ad=0.1056p as=0.1056p pd=0.92u ps=0.92u
    I_MXI0_I50_MP45 (XI0_I50_bp2 I0_cm6_2 XI0_I50_bcon VDD) gpdk090_pmos1v w=0.48u l=0.1u ad=0.1056p as=0.1056p pd=0.92u ps=0.92u
    I_MXI0_I50_MP43 (VDD XI0_I50_s1 XI0_I50_bp2 VDD) gpdk090_pmos1v w=0.48u l=0.1u ad=0.1056p as=0.1056p pd=0.92u ps=0.92u
    I_MXI0_I50_MP44 (XI0_I50_bp2 I0_pp3_2 VDD VDD) gpdk090_pmos1v w=0.48u l=0.1u ad=0.1632p as=0.1056p pd=1.64u ps=0.92u
    I_MXI0_I50_MP56 (VDD XI0_I50_bcon I0_cm7_1 VDD) gpdk090_pmos1v w=0.24u l=0.1u ad=0.0936p as=0.0816p pd=0.92u ps=1.16u
    I_MXI0_I50_MP46 (XI0_I50_bp3 XI0_I50_s1 VDD VDD) gpdk090_pmos1v w=0.48u l=0.1u ad=0.1056p as=0.0936p pd=0.92u ps=0.92u
    I_MXI0_I50_MP48 (VDD I0_cm6_2 XI0_I50_bp3 VDD) gpdk090_pmos1v w=0.48u l=0.1u ad=0.0996p as=0.1056p pd=0.92u ps=0.92u
    I_MXI0_I50_MP50_1 (XI0_I50_bp4 XI0_I50_s1 VDD VDD) gpdk090_pmos1v w=0.36u l=0.1u ad=0.0792p as=0.0996p pd=0.8u ps=0.92u
    I_MXI0_I50_MP26 (VDD XI0_I50_asn XI0_I50_s1 VDD) gpdk090_pmos1v w=0.24u l=0.1u ad=0.0936p as=0.0816p pd=0.92u ps=1.16u
    I_MXI0_I50_MP18 (XI0_I50_ap3 I0_pp0_8 VDD VDD) gpdk090_pmos1v w=0.48u l=0.1u ad=0.1056p as=0.264p pd=0.92u ps=2.24u
    I_MXI0_I50_MP21 (XI0_I50_asn XI0_I50_acon XI0_I50_ap3 VDD) gpdk090_pmos1v w=0.48u l=0.1u ad=0.0996p as=0.1056p pd=0.92u ps=0.92u
    I_MXI0_I50_MP24 (XI0_I50_ap5 I0_pp2_4 XI0_I50_asn VDD) gpdk090_pmos1v w=0.36u l=0.1u ad=0.0792p as=0.0996p pd=0.8u ps=0.92u
    I_MXI0_I50_MP23 (XI0_I50_ap4 I0_pp1_6 XI0_I50_ap5 VDD) gpdk090_pmos1v w=0.36u l=0.1u ad=0.0792p as=0.0792p pd=0.8u ps=0.8u
    I_MXI0_I50_MP22 (VDD I0_pp0_8 XI0_I50_ap4 VDD) gpdk090_pmos1v w=0.36u l=0.1u ad=0.0792p as=0.0792p pd=0.8u ps=0.8u
    I_MXI0_I50_MP22_1 (XI0_I50_ap4 I0_pp0_8 VDD VDD) gpdk090_pmos1v w=0.36u l=0.1u ad=0.0792p as=0.0792p pd=0.8u ps=0.8u
    I_MXI0_I50_MP23_1 (XI0_I50_ap5 I0_pp1_6 XI0_I50_ap4 VDD) gpdk090_pmos1v w=0.36u l=0.1u ad=0.0792p as=0.0792p pd=0.8u ps=0.8u
    I_MXI0_I50_MP24_1 (XI0_I50_asn I0_pp2_4 XI0_I50_ap5 VDD) gpdk090_pmos1v w=0.36u l=0.1u ad=0.1224p as=0.0792p pd=1.4u ps=0.8u
    I_MXI0_I50_MP17 (XI0_I50_acon I0_pp2_4 XI0_I50_ap2 VDD) gpdk090_pmos1v w=0.48u l=0.1u ad=0.1056p as=0.1632p pd=0.92u ps=1.64u
    I_MXI0_I50_MP14 (XI0_I50_ap1 I0_pp1_6 XI0_I50_acon VDD) gpdk090_pmos1v w=0.48u l=0.1u ad=0.1056p as=0.1056p pd=0.92u ps=0.92u
    I_MXI0_I50_MP13 (VDD I0_pp0_8 XI0_I50_ap1 VDD) gpdk090_pmos1v w=0.48u l=0.1u ad=0.1056p as=0.1056p pd=0.92u ps=0.92u
    I_MXI0_I50_MP15 (XI0_I50_ap2 I0_pp0_8 VDD VDD) gpdk090_pmos1v w=0.48u l=0.1u ad=0.1056p as=0.1056p pd=0.92u ps=0.92u
    I_MXI0_I50_MP16 (VDD I0_pp1_6 XI0_I50_ap2 VDD) gpdk090_pmos1v w=0.48u l=0.1u ad=0.0936p as=0.1056p pd=0.92u ps=0.92u
    I_MXI0_I50_MP28 (I0_cm7_2 XI0_I50_acon VDD VDD) gpdk090_pmos1v w=0.24u l=0.1u ad=0.0816p as=0.0936p pd=1.16u ps=0.92u
    I_MXI0_I50_MP19 (XI0_I50_ap3 I0_pp1_6 VDD VDD) gpdk090_pmos1v w=0.48u l=0.1u ad=0.1056p as=0.1632p pd=0.92u ps=1.64u
    I_MXI0_I50_MP20 (VDD I0_pp2_4 XI0_I50_ap3 VDD) gpdk090_pmos1v w=0.48u l=0.1u ad=0.264p as=0.1056p pd=2.24u ps=0.92u
    I_MXI0_I49_MP50 (VDD XI0_I49_s1 XI0_I49_bp4 VDD) gpdk090_pmos1v w=0.36u l=0.1u ad=0.0996p as=0.0792p pd=0.92u ps=0.8u
    I_MXI0_I49_MP47 (XI0_I49_bp3 I0_pp3_1 VDD VDD) gpdk090_pmos1v w=0.48u l=0.1u ad=0.2352p as=0.0996p pd=1.46u ps=0.92u
    I_MXI0_I49_MP49 (XI0_I49_bsn XI0_I49_bcon XI0_I49_bp3 VDD) gpdk090_pmos1v w=0.48u l=0.1u ad=0.0996p as=0.2352p pd=0.92u ps=1.46u
    I_MXI0_I49_MP52 (XI0_I49_bp5 I0_cm5_2 XI0_I49_bsn VDD) gpdk090_pmos1v w=0.36u l=0.1u ad=0.0792p as=0.0996p pd=0.8u ps=0.92u
    I_MXI0_I49_MP51 (XI0_I49_bp4 I0_pp3_1 XI0_I49_bp5 VDD) gpdk090_pmos1v w=0.36u l=0.1u ad=0.0792p as=0.0792p pd=0.8u ps=0.8u
    I_MXI0_I49_MP51_1 (XI0_I49_bp5 I0_pp3_1 XI0_I49_bp4 VDD) gpdk090_pmos1v w=0.36u l=0.1u ad=0.0792p as=0.0792p pd=0.8u ps=0.8u
    I_MXI0_I49_MP52_1 (XI0_I49_bsn I0_cm5_2 XI0_I49_bp5 VDD) gpdk090_pmos1v w=0.36u l=0.1u ad=0.1224p as=0.0792p pd=1.4u ps=0.8u
    I_MXI0_I49_MP54 (VDD XI0_I49_bsn I0_cm6_0 VDD) gpdk090_pmos1v w=0.24u l=0.1u ad=0.0816p as=0.0816p pd=1.16u ps=1.16u
    I_MXI0_I49_MP41 (XI0_I49_bp1 XI0_I49_s1 VDD VDD) gpdk090_pmos1v w=0.48u l=0.1u ad=0.1056p as=0.0936p pd=0.92u ps=0.92u
    I_MXI0_I49_MP42 (XI0_I49_bcon I0_pp3_1 XI0_I49_bp1 VDD) gpdk090_pmos1v w=0.48u l=0.1u ad=0.1056p as=0.1056p pd=0.92u ps=0.92u
    I_MXI0_I49_MP45 (XI0_I49_bp2 I0_cm5_2 XI0_I49_bcon VDD) gpdk090_pmos1v w=0.48u l=0.1u ad=0.1056p as=0.1056p pd=0.92u ps=0.92u
    I_MXI0_I49_MP43 (VDD XI0_I49_s1 XI0_I49_bp2 VDD) gpdk090_pmos1v w=0.48u l=0.1u ad=0.1056p as=0.1056p pd=0.92u ps=0.92u
    I_MXI0_I49_MP44 (XI0_I49_bp2 I0_pp3_1 VDD VDD) gpdk090_pmos1v w=0.48u l=0.1u ad=0.1632p as=0.1056p pd=1.64u ps=0.92u
    I_MXI0_I49_MP56 (VDD XI0_I49_bcon I0_cm6_1 VDD) gpdk090_pmos1v w=0.24u l=0.1u ad=0.0936p as=0.0816p pd=0.92u ps=1.16u
    I_MXI0_I49_MP46 (XI0_I49_bp3 XI0_I49_s1 VDD VDD) gpdk090_pmos1v w=0.48u l=0.1u ad=0.1056p as=0.0936p pd=0.92u ps=0.92u
    I_MXI0_I49_MP48 (VDD I0_cm5_2 XI0_I49_bp3 VDD) gpdk090_pmos1v w=0.48u l=0.1u ad=0.0996p as=0.1056p pd=0.92u ps=0.92u
    I_MXI0_I49_MP50_1 (XI0_I49_bp4 XI0_I49_s1 VDD VDD) gpdk090_pmos1v w=0.36u l=0.1u ad=0.0792p as=0.0996p pd=0.8u ps=0.92u
    I_MXI0_I49_MP26 (VDD XI0_I49_asn XI0_I49_s1 VDD) gpdk090_pmos1v w=0.24u l=0.1u ad=0.0936p as=0.0816p pd=0.92u ps=1.16u
    I_MXI0_I49_MP18 (XI0_I49_ap3 I0_pp0_7 VDD VDD) gpdk090_pmos1v w=0.48u l=0.1u ad=0.1056p as=0.264p pd=0.92u ps=2.24u
    I_MXI0_I49_MP21 (XI0_I49_asn XI0_I49_acon XI0_I49_ap3 VDD) gpdk090_pmos1v w=0.48u l=0.1u ad=0.0996p as=0.1056p pd=0.92u ps=0.92u
    I_MXI0_I49_MP24 (XI0_I49_ap5 I0_pp2_3 XI0_I49_asn VDD) gpdk090_pmos1v w=0.36u l=0.1u ad=0.0792p as=0.0996p pd=0.8u ps=0.92u
    I_MXI0_I49_MP23 (XI0_I49_ap4 I0_pp1_5 XI0_I49_ap5 VDD) gpdk090_pmos1v w=0.36u l=0.1u ad=0.0792p as=0.0792p pd=0.8u ps=0.8u
    I_MXI0_I49_MP22 (VDD I0_pp0_7 XI0_I49_ap4 VDD) gpdk090_pmos1v w=0.36u l=0.1u ad=0.0792p as=0.0792p pd=0.8u ps=0.8u
    I_MXI0_I49_MP22_1 (XI0_I49_ap4 I0_pp0_7 VDD VDD) gpdk090_pmos1v w=0.36u l=0.1u ad=0.0792p as=0.0792p pd=0.8u ps=0.8u
    I_MXI0_I49_MP23_1 (XI0_I49_ap5 I0_pp1_5 XI0_I49_ap4 VDD) gpdk090_pmos1v w=0.36u l=0.1u ad=0.0792p as=0.0792p pd=0.8u ps=0.8u
    I_MXI0_I49_MP24_1 (XI0_I49_asn I0_pp2_3 XI0_I49_ap5 VDD) gpdk090_pmos1v w=0.36u l=0.1u ad=0.1224p as=0.0792p pd=1.4u ps=0.8u
    I_MXI0_I49_MP17 (XI0_I49_acon I0_pp2_3 XI0_I49_ap2 VDD) gpdk090_pmos1v w=0.48u l=0.1u ad=0.1056p as=0.1632p pd=0.92u ps=1.64u
    I_MXI0_I49_MP14 (XI0_I49_ap1 I0_pp1_5 XI0_I49_acon VDD) gpdk090_pmos1v w=0.48u l=0.1u ad=0.1056p as=0.1056p pd=0.92u ps=0.92u
    I_MXI0_I49_MP13 (VDD I0_pp0_7 XI0_I49_ap1 VDD) gpdk090_pmos1v w=0.48u l=0.1u ad=0.1056p as=0.1056p pd=0.92u ps=0.92u
    I_MXI0_I49_MP15 (XI0_I49_ap2 I0_pp0_7 VDD VDD) gpdk090_pmos1v w=0.48u l=0.1u ad=0.1056p as=0.1056p pd=0.92u ps=0.92u
    I_MXI0_I49_MP16 (VDD I0_pp1_5 XI0_I49_ap2 VDD) gpdk090_pmos1v w=0.48u l=0.1u ad=0.0936p as=0.1056p pd=0.92u ps=0.92u
    I_MXI0_I49_MP28 (I0_cm6_2 XI0_I49_acon VDD VDD) gpdk090_pmos1v w=0.24u l=0.1u ad=0.0816p as=0.0936p pd=1.16u ps=0.92u
    I_MXI0_I49_MP19 (XI0_I49_ap3 I0_pp1_5 VDD VDD) gpdk090_pmos1v w=0.48u l=0.1u ad=0.1056p as=0.1632p pd=0.92u ps=1.64u
    I_MXI0_I49_MP20 (VDD I0_pp2_3 XI0_I49_ap3 VDD) gpdk090_pmos1v w=0.48u l=0.1u ad=0.264p as=0.1056p pd=2.24u ps=0.92u
    I_MXI0_I48_MP50 (VDD XI0_I48_s1 XI0_I48_bp4 VDD) gpdk090_pmos1v w=0.36u l=0.1u ad=0.0996p as=0.0792p pd=0.92u ps=0.8u
    I_MXI0_I48_MP47 (XI0_I48_bp3 I0_pp3_0 VDD VDD) gpdk090_pmos1v w=0.48u l=0.1u ad=0.2352p as=0.0996p pd=1.46u ps=0.92u
    I_MXI0_I48_MP49 (XI0_I48_bsn XI0_I48_bcon XI0_I48_bp3 VDD) gpdk090_pmos1v w=0.48u l=0.1u ad=0.0996p as=0.2352p pd=0.92u ps=1.46u
    I_MXI0_I48_MP52 (XI0_I48_bp5 B_7 XI0_I48_bsn VDD) gpdk090_pmos1v w=0.36u l=0.1u ad=0.0792p as=0.0996p pd=0.8u ps=0.92u
    I_MXI0_I48_MP51 (XI0_I48_bp4 I0_pp3_0 XI0_I48_bp5 VDD) gpdk090_pmos1v w=0.36u l=0.1u ad=0.0792p as=0.0792p pd=0.8u ps=0.8u
    I_MXI0_I48_MP51_1 (XI0_I48_bp5 I0_pp3_0 XI0_I48_bp4 VDD) gpdk090_pmos1v w=0.36u l=0.1u ad=0.0792p as=0.0792p pd=0.8u ps=0.8u
    I_MXI0_I48_MP52_1 (XI0_I48_bsn B_7 XI0_I48_bp5 VDD) gpdk090_pmos1v w=0.36u l=0.1u ad=0.1224p as=0.0792p pd=1.4u ps=0.8u
    I_MXI0_I48_MP54 (VDD XI0_I48_bsn I0_cm5_0 VDD) gpdk090_pmos1v w=0.24u l=0.1u ad=0.0816p as=0.0816p pd=1.16u ps=1.16u
    I_MXI0_I48_MP41 (XI0_I48_bp1 XI0_I48_s1 VDD VDD) gpdk090_pmos1v w=0.48u l=0.1u ad=0.1056p as=0.0936p pd=0.92u ps=0.92u
    I_MXI0_I48_MP42 (XI0_I48_bcon I0_pp3_0 XI0_I48_bp1 VDD) gpdk090_pmos1v w=0.48u l=0.1u ad=0.1056p as=0.1056p pd=0.92u ps=0.92u
    I_MXI0_I48_MP45 (XI0_I48_bp2 B_7 XI0_I48_bcon VDD) gpdk090_pmos1v w=0.48u l=0.1u ad=0.1056p as=0.1056p pd=0.92u ps=0.92u
    I_MXI0_I48_MP43 (VDD XI0_I48_s1 XI0_I48_bp2 VDD) gpdk090_pmos1v w=0.48u l=0.1u ad=0.1056p as=0.1056p pd=0.92u ps=0.92u
    I_MXI0_I48_MP44 (XI0_I48_bp2 I0_pp3_0 VDD VDD) gpdk090_pmos1v w=0.48u l=0.1u ad=0.1632p as=0.1056p pd=1.64u ps=0.92u
    I_MXI0_I48_MP56 (VDD XI0_I48_bcon I0_cm5_1 VDD) gpdk090_pmos1v w=0.24u l=0.1u ad=0.0936p as=0.0816p pd=0.92u ps=1.16u
    I_MXI0_I48_MP46 (XI0_I48_bp3 XI0_I48_s1 VDD VDD) gpdk090_pmos1v w=0.48u l=0.1u ad=0.1056p as=0.0936p pd=0.92u ps=0.92u
    I_MXI0_I48_MP48 (VDD B_7 XI0_I48_bp3 VDD) gpdk090_pmos1v w=0.48u l=0.1u ad=0.0996p as=0.1056p pd=0.92u ps=0.92u
    I_MXI0_I48_MP50_1 (XI0_I48_bp4 XI0_I48_s1 VDD VDD) gpdk090_pmos1v w=0.36u l=0.1u ad=0.0792p as=0.0996p pd=0.8u ps=0.92u
    I_MXI0_I48_MP26 (VDD XI0_I48_asn XI0_I48_s1 VDD) gpdk090_pmos1v w=0.24u l=0.1u ad=0.0936p as=0.0816p pd=0.92u ps=1.16u
    I_MXI0_I48_MP18 (XI0_I48_ap3 I0_pp0_6 VDD VDD) gpdk090_pmos1v w=0.48u l=0.1u ad=0.1056p as=0.264p pd=0.92u ps=2.24u
    I_MXI0_I48_MP21 (XI0_I48_asn XI0_I48_acon XI0_I48_ap3 VDD) gpdk090_pmos1v w=0.48u l=0.1u ad=0.0996p as=0.1056p pd=0.92u ps=0.92u
    I_MXI0_I48_MP24 (XI0_I48_ap5 I0_pp2_2 XI0_I48_asn VDD) gpdk090_pmos1v w=0.36u l=0.1u ad=0.0792p as=0.0996p pd=0.8u ps=0.92u
    I_MXI0_I48_MP23 (XI0_I48_ap4 I0_pp1_4 XI0_I48_ap5 VDD) gpdk090_pmos1v w=0.36u l=0.1u ad=0.0792p as=0.0792p pd=0.8u ps=0.8u
    I_MXI0_I48_MP22 (VDD I0_pp0_6 XI0_I48_ap4 VDD) gpdk090_pmos1v w=0.36u l=0.1u ad=0.0792p as=0.0792p pd=0.8u ps=0.8u
    I_MXI0_I48_MP22_1 (XI0_I48_ap4 I0_pp0_6 VDD VDD) gpdk090_pmos1v w=0.36u l=0.1u ad=0.0792p as=0.0792p pd=0.8u ps=0.8u
    I_MXI0_I48_MP23_1 (XI0_I48_ap5 I0_pp1_4 XI0_I48_ap4 VDD) gpdk090_pmos1v w=0.36u l=0.1u ad=0.0792p as=0.0792p pd=0.8u ps=0.8u
    I_MXI0_I48_MP24_1 (XI0_I48_asn I0_pp2_2 XI0_I48_ap5 VDD) gpdk090_pmos1v w=0.36u l=0.1u ad=0.1224p as=0.0792p pd=1.4u ps=0.8u
    I_MXI0_I48_MP17 (XI0_I48_acon I0_pp2_2 XI0_I48_ap2 VDD) gpdk090_pmos1v w=0.48u l=0.1u ad=0.1056p as=0.1632p pd=0.92u ps=1.64u
    I_MXI0_I48_MP14 (XI0_I48_ap1 I0_pp1_4 XI0_I48_acon VDD) gpdk090_pmos1v w=0.48u l=0.1u ad=0.1056p as=0.1056p pd=0.92u ps=0.92u
    I_MXI0_I48_MP13 (VDD I0_pp0_6 XI0_I48_ap1 VDD) gpdk090_pmos1v w=0.48u l=0.1u ad=0.1056p as=0.1056p pd=0.92u ps=0.92u
    I_MXI0_I48_MP15 (XI0_I48_ap2 I0_pp0_6 VDD VDD) gpdk090_pmos1v w=0.48u l=0.1u ad=0.1056p as=0.1056p pd=0.92u ps=0.92u
    I_MXI0_I48_MP16 (VDD I0_pp1_4 XI0_I48_ap2 VDD) gpdk090_pmos1v w=0.48u l=0.1u ad=0.0936p as=0.1056p pd=0.92u ps=0.92u
    I_MXI0_I48_MP28 (I0_cm5_2 XI0_I48_acon VDD VDD) gpdk090_pmos1v w=0.24u l=0.1u ad=0.0816p as=0.0936p pd=1.16u ps=0.92u
    I_MXI0_I48_MP19 (XI0_I48_ap3 I0_pp1_4 VDD VDD) gpdk090_pmos1v w=0.48u l=0.1u ad=0.1056p as=0.1632p pd=0.92u ps=1.64u
    I_MXI0_I48_MP20 (VDD I0_pp2_2 XI0_I48_ap3 VDD) gpdk090_pmos1v w=0.48u l=0.1u ad=0.264p as=0.1056p pd=2.24u ps=0.92u
    I_MXI2_I4_I15_MP0 (Z I2_I4_zd VDD VDD) gpdk090_pmos1v w=0.24u l=0.1u ad=0.0816p as=0.0816p pd=1.16u ps=1.16u
    I_MXI2_I0_I3_MP0 (I2_I0_opn3 OP_3 VDD VDD) gpdk090_pmos1v w=0.24u l=0.1u ad=0.0816p as=0.0816p pd=1.16u ps=1.16u
    I_MXI2_I0_I2_MP0 (I2_I0_opn2 OP_2 VDD VDD) gpdk090_pmos1v w=0.24u l=0.1u ad=0.0816p as=0.0816p pd=1.16u ps=1.16u
    I_MXI1_I191_MP0 (I1_nrk6 I1_nrkn6 VDD VDD) gpdk090_pmos1v w=0.24u l=0.1u ad=0.0816p as=0.0816p pd=1.16u ps=1.16u
    I_MXI0_I77_I33_MP0 (I0_I77_G1_0n I0_I77_G1_0 VDD VDD) gpdk090_pmos1v w=0.24u l=0.1u ad=0.0816p as=0.0816p pd=1.16u ps=1.16u
    I_MXI0_I43_MP0 (I0_sn3 I0_pp3_8 VDD VDD) gpdk090_pmos1v w=0.24u l=0.1u ad=0.0816p as=0.0816p pd=1.16u ps=1.16u
    I_MXI2_I2_I47_MP0 (I2_NOT_7 A_7 VDD VDD) gpdk090_pmos1v w=0.24u l=0.1u ad=0.0816p as=0.0816p pd=1.16u ps=1.16u
    I_MXI2_I0_I1_MP0 (I2_I0_opn1 OP_1 VDD VDD) gpdk090_pmos1v w=0.24u l=0.1u ad=0.0816p as=0.0816p pd=1.16u ps=1.16u
    I_MXI1_I152_I33_MP0 (I1_I152_G1_0n I1_I152_G1_0 VDD VDD) gpdk090_pmos1v w=0.24u l=0.1u ad=0.0816p as=0.0816p pd=1.16u ps=1.16u
    I_MXI1_I188_MP0 (I1_nrk5 I1_nrkn5 VDD VDD) gpdk090_pmos1v w=0.24u l=0.1u ad=0.0816p as=0.0816p pd=1.16u ps=1.16u
    I_MXI1_I185_MP0 (I1_nrk4 I1_nrkn4 VDD VDD) gpdk090_pmos1v w=0.24u l=0.1u ad=0.0816p as=0.0816p pd=1.16u ps=1.16u
    I_MXI1_I182_MP0 (I1_nrk3 I1_nrkn3 VDD VDD) gpdk090_pmos1v w=0.24u l=0.1u ad=0.0816p as=0.0816p pd=1.16u ps=1.16u
    I_MXI0_I32_MP0 (I0_sn2 I0_pp2_8 VDD VDD) gpdk090_pmos1v w=0.24u l=0.1u ad=0.0816p as=0.0816p pd=1.16u ps=1.16u
    I_MXI2_I2_I45_MP0 (I2_OR_7 I2_I2_nor7 VDD VDD) gpdk090_pmos1v w=0.24u l=0.1u ad=0.0816p as=0.0816p pd=1.16u ps=1.16u
    I_MXI2_I2_I43_MP0 (I2_AND_7 I2_I2_nand7 VDD VDD) gpdk090_pmos1v w=0.24u l=0.1u ad=0.0816p as=0.0816p pd=1.16u ps=1.16u
    I_MXI2_I0_I0_MP0 (I2_I0_opn0 OP_0 VDD VDD) gpdk090_pmos1v w=0.24u l=0.1u ad=0.0816p as=0.0816p pd=1.16u ps=1.16u
    I_MXI2_I2_I31_MP0 (I2_AND_5 I2_I2_nand5 VDD VDD) gpdk090_pmos1v w=0.24u l=0.1u ad=0.0816p as=0.0816p pd=1.16u ps=1.16u
    I_MXI1_I179_MP0 (I1_nrk2 I1_nrkn2 VDD VDD) gpdk090_pmos1v w=0.24u l=0.1u ad=0.0816p as=0.0816p pd=1.16u ps=1.16u
    I_MXI0_I77_I18_MP0 (I0_I77_G0_0n I0_I77_G0_0 VDD VDD) gpdk090_pmos1v w=0.24u l=0.1u ad=0.0816p as=0.0816p pd=1.16u ps=1.16u
    I_MXI0_I21_MP0 (I0_sn1 I0_pp1_8 VDD VDD) gpdk090_pmos1v w=0.24u l=0.1u ad=0.0816p as=0.0816p pd=1.16u ps=1.16u
    I_MXI0_I10_MP0 (I0_sn0 I0_pp0_8 VDD VDD) gpdk090_pmos1v w=0.24u l=0.1u ad=0.0816p as=0.0816p pd=1.16u ps=1.16u
    I_MXI2_I2_I37_MP0 (I2_AND_6 I2_I2_nand6 VDD VDD) gpdk090_pmos1v w=0.24u l=0.1u ad=0.0816p as=0.0816p pd=1.16u ps=1.16u
    I_MXI2_I2_I35_MP0 (I2_NOT_5 A_5 VDD VDD) gpdk090_pmos1v w=0.24u l=0.1u ad=0.0816p as=0.0816p pd=1.16u ps=1.16u
    I_MXI2_I2_I41_MP0 (I2_NOT_6 A_6 VDD VDD) gpdk090_pmos1v w=0.24u l=0.1u ad=0.0816p as=0.0816p pd=1.16u ps=1.16u
    I_MXI2_I2_I33_MP0 (I2_OR_5 I2_I2_nor5 VDD VDD) gpdk090_pmos1v w=0.24u l=0.1u ad=0.0816p as=0.0816p pd=1.16u ps=1.16u
    I_MXI1_I151_MP0 (I1_dm7 I1_dmn7 VDD VDD) gpdk090_pmos1v w=0.24u l=0.1u ad=0.0816p as=0.0816p pd=1.16u ps=1.16u
    I_MXI1_I152_I18_MP0 (I1_I152_G0_0n I1_I152_G0_0 VDD VDD) gpdk090_pmos1v w=0.24u l=0.1u ad=0.0816p as=0.0816p pd=1.16u ps=1.16u
    I_MXI1_I176_MP0 (I1_nrk1 I1_nrkn1 VDD VDD) gpdk090_pmos1v w=0.24u l=0.1u ad=0.0816p as=0.0816p pd=1.16u ps=1.16u
    I_MXI0_I77_I16_MP0 (I0_I77_cinn I0_rc8 VDD VDD) gpdk090_pmos1v w=0.24u l=0.1u ad=0.0816p as=0.0816p pd=1.16u ps=1.16u
    I_MXI2_I2_I39_MP0 (I2_OR_6 I2_I2_nor6 VDD VDD) gpdk090_pmos1v w=0.24u l=0.1u ad=0.0816p as=0.0816p pd=1.16u ps=1.16u
    I_MXI2_I2_I21_MP0 (I2_OR_3 I2_I2_nor3 VDD VDD) gpdk090_pmos1v w=0.24u l=0.1u ad=0.0816p as=0.0816p pd=1.16u ps=1.16u
    I_MXI2_I2_I19_MP0 (I2_AND_3 I2_I2_nand3 VDD VDD) gpdk090_pmos1v w=0.24u l=0.1u ad=0.0816p as=0.0816p pd=1.16u ps=1.16u
    I_MXI2_I2_I23_MP0 (I2_NOT_3 A_3 VDD VDD) gpdk090_pmos1v w=0.24u l=0.1u ad=0.0816p as=0.0816p pd=1.16u ps=1.16u
    I_MXI1_I149_MP0 (I1_dm6 I1_dmn6 VDD VDD) gpdk090_pmos1v w=0.24u l=0.1u ad=0.0816p as=0.0816p pd=1.16u ps=1.16u
    I_MXI1_I147_MP0 (I1_dm5 I1_dmn5 VDD VDD) gpdk090_pmos1v w=0.24u l=0.1u ad=0.0816p as=0.0816p pd=1.16u ps=1.16u
    I_MXI1_I152_I16_MP0 (I1_I152_cinn VSS VDD VDD) gpdk090_pmos1v w=0.24u l=0.1u ad=0.0816p as=0.0816p pd=1.16u ps=1.16u
    I_MXI1_I132_I33_MP0 (I1_I132_G1_0n I1_I132_G1_0 VDD VDD) gpdk090_pmos1v w=0.24u l=0.1u ad=0.0816p as=0.0816p pd=1.16u ps=1.16u
    I_MXI1_I145_MP0 (I1_dm4 I1_dmn4 VDD VDD) gpdk090_pmos1v w=0.24u l=0.1u ad=0.0816p as=0.0816p pd=1.16u ps=1.16u
    I_MXI1_I143_MP0 (I1_dm3 I1_dmn3 VDD VDD) gpdk090_pmos1v w=0.24u l=0.1u ad=0.0816p as=0.0816p pd=1.16u ps=1.16u
    I_MXI1_I141_MP0 (I1_dm2 I1_dmn2 VDD VDD) gpdk090_pmos1v w=0.24u l=0.1u ad=0.0816p as=0.0816p pd=1.16u ps=1.16u
    I_MXI1_I139_MP0 (I1_dm1 I1_dmn1 VDD VDD) gpdk090_pmos1v w=0.24u l=0.1u ad=0.0816p as=0.0816p pd=1.16u ps=1.16u
    I_MXI1_I132_I18_MP0 (I1_I132_G0_0n I1_I132_G0_0 VDD VDD) gpdk090_pmos1v w=0.24u l=0.1u ad=0.0816p as=0.0816p pd=1.16u ps=1.16u
    I_MXI1_I137_MP0 (I1_dm0 I1_dmn0 VDD VDD) gpdk090_pmos1v w=0.24u l=0.1u ad=0.0816p as=0.0816p pd=1.16u ps=1.16u
    I_MXI1_I37_MP0 (I1_nbk6 I1_nbkn6 VDD VDD) gpdk090_pmos1v w=0.24u l=0.1u ad=0.0816p as=0.0816p pd=1.16u ps=1.16u
    I_MXI2_I4_I17_MP0 (C I2_I4_cn VDD VDD) gpdk090_pmos1v w=0.24u l=0.1u ad=0.0816p as=0.0816p pd=1.16u ps=1.16u
    I_MXI2_I1_I8_I33_MP0 (I2_I1_I8_G1_0n I2_I1_I8_G1_0 VDD VDD) gpdk090_pmos1v w=0.24u l=0.1u ad=0.0816p as=0.0816p pd=1.16u ps=1.16u
    I_MXI1_I132_I16_MP0 (I1_I132_cinn I1_qu1 VDD VDD) gpdk090_pmos1v w=0.24u l=0.1u ad=0.0816p as=0.0816p pd=1.16u ps=1.16u
    I_MXI1_I34_MP0 (I1_nbk5 I1_nbkn5 VDD VDD) gpdk090_pmos1v w=0.24u l=0.1u ad=0.0816p as=0.0816p pd=1.16u ps=1.16u
    I_MXI1_I135_MP0 (DIVQ_0 I1_p7_8 VDD VDD) gpdk090_pmos1v w=0.24u l=0.1u ad=0.0816p as=0.0816p pd=1.16u ps=1.16u
    I_MXI1_I156_MP0 (I1_nqk1 I1_nqkn1 VDD VDD) gpdk090_pmos1v w=0.24u l=0.1u ad=0.0816p as=0.0816p pd=1.16u ps=1.16u
    I_MXI2_I4_I23_MP0 (DZ I2_I4_dzn VDD VDD) gpdk090_pmos1v w=0.24u l=0.1u ad=0.0816p as=0.0816p pd=1.16u ps=1.16u
    I_MXI2_I1_I8_I16_MP0 (I2_I1_I8_cinn OP_0 VDD VDD) gpdk090_pmos1v w=0.24u l=0.1u ad=0.0816p as=0.0816p pd=1.16u ps=1.16u
    I_MXI2_I1_I8_I18_MP0 (I2_I1_I8_G0_0n I2_I1_I8_G0_0 VDD VDD) gpdk090_pmos1v w=0.24u l=0.1u ad=0.0816p as=0.0816p pd=1.16u ps=1.16u
    I_MXI1_I120_I33_MP0 (I1_I120_G1_0n I1_I120_G1_0 VDD VDD) gpdk090_pmos1v w=0.24u l=0.1u ad=0.0816p as=0.0816p pd=1.16u ps=1.16u
    I_MXI1_I120_I18_MP0 (I1_I120_G0_0n I1_I120_G0_0 VDD VDD) gpdk090_pmos1v w=0.24u l=0.1u ad=0.0816p as=0.0816p pd=1.16u ps=1.16u
    I_MXI1_I120_I16_MP0 (I1_I120_cinn I1_qu2 VDD VDD) gpdk090_pmos1v w=0.24u l=0.1u ad=0.0816p as=0.0816p pd=1.16u ps=1.16u
    I_MXI1_I201_MP0 (I1_sqn I1_sq VDD VDD) gpdk090_pmos1v w=0.24u l=0.1u ad=0.0816p as=0.0816p pd=1.16u ps=1.16u
    I_MXI1_I31_MP0 (I1_nbk4 I1_nbkn4 VDD VDD) gpdk090_pmos1v w=0.24u l=0.1u ad=0.0816p as=0.0816p pd=1.16u ps=1.16u
    I_MXI1_I159_MP0 (I1_nqk2 I1_nqkn2 VDD VDD) gpdk090_pmos1v w=0.24u l=0.1u ad=0.0816p as=0.0816p pd=1.16u ps=1.16u
    I_MXI1_I28_MP0 (I1_nbk3 I1_nbkn3 VDD VDD) gpdk090_pmos1v w=0.24u l=0.1u ad=0.0816p as=0.0816p pd=1.16u ps=1.16u
    I_MXI2_I2_I5_MP0 (I2_NOT_0 A_0 VDD VDD) gpdk090_pmos1v w=0.24u l=0.1u ad=0.0816p as=0.0816p pd=1.16u ps=1.16u
    I_MXI2_I2_I29_MP0 (I2_NOT_4 A_4 VDD VDD) gpdk090_pmos1v w=0.24u l=0.1u ad=0.0816p as=0.0816p pd=1.16u ps=1.16u
    I_MXI1_I108_I16_MP0 (I1_I108_cinn I1_qu3 VDD VDD) gpdk090_pmos1v w=0.24u l=0.1u ad=0.0816p as=0.0816p pd=1.16u ps=1.16u
    I_MXI1_I162_MP0 (I1_nqk3 I1_nqkn3 VDD VDD) gpdk090_pmos1v w=0.24u l=0.1u ad=0.0816p as=0.0816p pd=1.16u ps=1.16u
    I_MXI1_I2_MP0 (I1_nak1 I1_nakn1 VDD VDD) gpdk090_pmos1v w=0.24u l=0.1u ad=0.0816p as=0.0816p pd=1.16u ps=1.16u
    I_MXI1_I5_MP0 (I1_nak2 I1_nakn2 VDD VDD) gpdk090_pmos1v w=0.24u l=0.1u ad=0.0816p as=0.0816p pd=1.16u ps=1.16u
    I_MXI1_I8_MP0 (I1_nak3 I1_nakn3 VDD VDD) gpdk090_pmos1v w=0.24u l=0.1u ad=0.0816p as=0.0816p pd=1.16u ps=1.16u
    I_MXI1_I11_MP0 (I1_nak4 I1_nakn4 VDD VDD) gpdk090_pmos1v w=0.24u l=0.1u ad=0.0816p as=0.0816p pd=1.16u ps=1.16u
    I_MXI1_I14_MP0 (I1_nak5 I1_nakn5 VDD VDD) gpdk090_pmos1v w=0.24u l=0.1u ad=0.0816p as=0.0816p pd=1.16u ps=1.16u
    I_MXI1_I22_MP0 (I1_nbk1 I1_nbkn1 VDD VDD) gpdk090_pmos1v w=0.24u l=0.1u ad=0.0816p as=0.0816p pd=1.16u ps=1.16u
    I_MXI1_I25_MP0 (I1_nbk2 I1_nbkn2 VDD VDD) gpdk090_pmos1v w=0.24u l=0.1u ad=0.0816p as=0.0816p pd=1.16u ps=1.16u
    I_MXI2_I2_I1_MP0 (I2_AND_0 I2_I2_nand0 VDD VDD) gpdk090_pmos1v w=0.24u l=0.1u ad=0.0816p as=0.0816p pd=1.16u ps=1.16u
    I_MXI2_I2_I11_MP0 (I2_NOT_1 A_1 VDD VDD) gpdk090_pmos1v w=0.24u l=0.1u ad=0.0816p as=0.0816p pd=1.16u ps=1.16u
    I_MXI2_I2_I27_MP0 (I2_OR_4 I2_I2_nor4 VDD VDD) gpdk090_pmos1v w=0.24u l=0.1u ad=0.0816p as=0.0816p pd=1.16u ps=1.16u
    I_MXI2_I2_I25_MP0 (I2_AND_4 I2_I2_nand4 VDD VDD) gpdk090_pmos1v w=0.24u l=0.1u ad=0.0816p as=0.0816p pd=1.16u ps=1.16u
    I_MXI1_I96_I16_MP0 (I1_I96_cinn I1_qu4 VDD VDD) gpdk090_pmos1v w=0.24u l=0.1u ad=0.0816p as=0.0816p pd=1.16u ps=1.16u
    I_MXI1_I84_I16_MP0 (I1_I84_cinn I1_qu5 VDD VDD) gpdk090_pmos1v w=0.24u l=0.1u ad=0.0816p as=0.0816p pd=1.16u ps=1.16u
    I_MXI1_I165_MP0 (I1_nqk4 I1_nqkn4 VDD VDD) gpdk090_pmos1v w=0.24u l=0.1u ad=0.0816p as=0.0816p pd=1.16u ps=1.16u
    I_MXI1_I168_MP0 (I1_nqk5 I1_nqkn5 VDD VDD) gpdk090_pmos1v w=0.24u l=0.1u ad=0.0816p as=0.0816p pd=1.16u ps=1.16u
    I_MXI1_I171_MP0 (I1_nqk6 I1_nqkn6 VDD VDD) gpdk090_pmos1v w=0.24u l=0.1u ad=0.0816p as=0.0816p pd=1.16u ps=1.16u
    I_MXI1_I17_MP0 (I1_nak6 I1_nakn6 VDD VDD) gpdk090_pmos1v w=0.24u l=0.1u ad=0.0816p as=0.0816p pd=1.16u ps=1.16u
    I_MXI2_I2_I3_MP0 (I2_OR_0 I2_I2_nor0 VDD VDD) gpdk090_pmos1v w=0.24u l=0.1u ad=0.0816p as=0.0816p pd=1.16u ps=1.16u
    I_MXI2_I2_I9_MP0 (I2_OR_1 I2_I2_nor1 VDD VDD) gpdk090_pmos1v w=0.24u l=0.1u ad=0.0816p as=0.0816p pd=1.16u ps=1.16u
    I_MXI2_I2_I7_MP0 (I2_AND_1 I2_I2_nand1 VDD VDD) gpdk090_pmos1v w=0.24u l=0.1u ad=0.0816p as=0.0816p pd=1.16u ps=1.16u
    I_MXI2_I2_I17_MP0 (I2_NOT_2 A_2 VDD VDD) gpdk090_pmos1v w=0.24u l=0.1u ad=0.0816p as=0.0816p pd=1.16u ps=1.16u
    I_MXI2_I2_I13_MP0 (I2_AND_2 I2_I2_nand2 VDD VDD) gpdk090_pmos1v w=0.24u l=0.1u ad=0.0816p as=0.0816p pd=1.16u ps=1.16u
    I_MXI1_I108_I18_MP0 (I1_I108_G0_0n I1_I108_G0_0 VDD VDD) gpdk090_pmos1v w=0.24u l=0.1u ad=0.0816p as=0.0816p pd=1.16u ps=1.16u
    I_MXI1_I72_I16_MP0 (I1_I72_cinn I1_qu6 VDD VDD) gpdk090_pmos1v w=0.24u l=0.1u ad=0.0816p as=0.0816p pd=1.16u ps=1.16u
    I_MXI1_I60_I16_MP0 (I1_I60_cinn I1_qu7 VDD VDD) gpdk090_pmos1v w=0.24u l=0.1u ad=0.0816p as=0.0816p pd=1.16u ps=1.16u
    I_MXI1_I48_I16_MP0 (I1_I48_cinn VDD VDD VDD) gpdk090_pmos1v w=0.24u l=0.1u ad=0.0816p as=0.0816p pd=1.16u ps=1.16u
    I_MXI2_I2_I15_MP0 (I2_OR_2 I2_I2_nor2 VDD VDD) gpdk090_pmos1v w=0.24u l=0.1u ad=0.0816p as=0.0816p pd=1.16u ps=1.16u
    I_MXI1_I108_I33_MP0 (I1_I108_G1_0n I1_I108_G1_0 VDD VDD) gpdk090_pmos1v w=0.24u l=0.1u ad=0.0816p as=0.0816p pd=1.16u ps=1.16u
    I_MXI1_I84_I18_MP0 (I1_I84_G0_0n I1_I84_G0_0 VDD VDD) gpdk090_pmos1v w=0.24u l=0.1u ad=0.0816p as=0.0816p pd=1.16u ps=1.16u
    I_MXI1_I72_I18_MP0 (I1_I72_G0_0n I1_I72_G0_0 VDD VDD) gpdk090_pmos1v w=0.24u l=0.1u ad=0.0816p as=0.0816p pd=1.16u ps=1.16u
    I_MXI1_I48_I18_MP0 (I1_I48_G0_0n I1_I48_G0_0 VDD VDD) gpdk090_pmos1v w=0.24u l=0.1u ad=0.0816p as=0.0816p pd=1.16u ps=1.16u
    I_MXI1_I96_I18_MP0 (I1_I96_G0_0n I1_I96_G0_0 VDD VDD) gpdk090_pmos1v w=0.24u l=0.1u ad=0.0816p as=0.0816p pd=1.16u ps=1.16u
    I_MXI1_I60_I18_MP0 (I1_I60_G0_0n I1_I60_G0_0 VDD VDD) gpdk090_pmos1v w=0.24u l=0.1u ad=0.0816p as=0.0816p pd=1.16u ps=1.16u
    I_MXI1_I48_I33_MP0 (I1_I48_G1_0n I1_I48_G1_0 VDD VDD) gpdk090_pmos1v w=0.24u l=0.1u ad=0.0816p as=0.0816p pd=1.16u ps=1.16u
    I_MXI1_I84_I33_MP0 (I1_I84_G1_0n I1_I84_G1_0 VDD VDD) gpdk090_pmos1v w=0.24u l=0.1u ad=0.0816p as=0.0816p pd=1.16u ps=1.16u
    I_MXI1_I96_I33_MP0 (I1_I96_G1_0n I1_I96_G1_0 VDD VDD) gpdk090_pmos1v w=0.24u l=0.1u ad=0.0816p as=0.0816p pd=1.16u ps=1.16u
    I_MXI1_I72_I33_MP0 (I1_I72_G1_0n I1_I72_G1_0 VDD VDD) gpdk090_pmos1v w=0.24u l=0.1u ad=0.0816p as=0.0816p pd=1.16u ps=1.16u
    I_MXI1_I60_I33_MP0 (I1_I60_G1_0n I1_I60_G1_0 VDD VDD) gpdk090_pmos1v w=0.24u l=0.1u ad=0.0816p as=0.0816p pd=1.16u ps=1.16u
    I_MXI0_I33_MP9 (XI0_I33_ap1 B_6 VDD VDD) gpdk090_pmos1v w=0.48u l=0.1u ad=0.1056p as=0.1632p pd=0.92u ps=1.64u
    I_MXI0_I33_MP11 (I0_one3 XI0_I33_aan XI0_I33_ap1 VDD) gpdk090_pmos1v w=0.48u l=0.1u ad=0.1056p as=0.1056p pd=0.92u ps=0.92u
    I_MXI0_I33_MP12 (XI0_I33_ap1 XI0_I33_abn I0_one3 VDD) gpdk090_pmos1v w=0.48u l=0.1u ad=0.1056p as=0.1056p pd=0.92u ps=0.92u
    I_MXI0_I33_MP10 (VDD B_5 XI0_I33_ap1 VDD) gpdk090_pmos1v w=0.48u l=0.1u ad=0.1632p as=0.1056p pd=1.64u ps=0.92u
    I_MXI0_I33_MP2 (VDD B_6 XI0_I33_aan VDD) gpdk090_pmos1v w=0.24u l=0.1u ad=0.0816p as=0.0816p pd=1.16u ps=1.16u
    I_MXI0_I33_MP4 (XI0_I33_abn B_5 VDD VDD) gpdk090_pmos1v w=0.24u l=0.1u ad=0.0816p as=0.0816p pd=1.16u ps=1.16u
    I_MXI0_I33_MP16 (XI0_I33_bbn B_6 VDD VDD) gpdk090_pmos1v w=0.24u l=0.1u ad=0.0816p as=0.0936p pd=1.16u ps=0.92u
    I_MXI0_I33_MP14 (XI0_I33_ban B_7 VDD VDD) gpdk090_pmos1v w=0.24u l=0.1u ad=0.0816p as=0.0816p pd=1.16u ps=1.16u
    I_MXI0_I33_MP23 (XI0_I33_e XI0_I33_ban XI0_I33_bp1 VDD) gpdk090_pmos1v w=0.48u l=0.1u ad=0.1056p as=0.1632p pd=0.92u ps=1.64u
    I_MXI0_I33_MP24 (XI0_I33_bp1 B_6 XI0_I33_e VDD) gpdk090_pmos1v w=0.48u l=0.1u ad=0.1056p as=0.1056p pd=0.92u ps=0.92u
    I_MXI0_I33_MP22 (VDD XI0_I33_bbn XI0_I33_bp1 VDD) gpdk090_pmos1v w=0.48u l=0.1u ad=0.1056p as=0.1056p pd=0.92u ps=0.92u
    I_MXI0_I33_MP21 (XI0_I33_bp1 B_7 VDD VDD) gpdk090_pmos1v w=0.48u l=0.1u ad=0.1632p as=0.1056p pd=1.64u ps=0.92u
    I_MXI0_I33_MP28 (XI0_I33_cp I0_one3 I0_two3 VDD) gpdk090_pmos1v w=0.48u l=0.1u ad=0.1056p as=0.1632p pd=0.92u ps=1.64u
    I_MXI0_I33_MP27 (VDD XI0_I33_e XI0_I33_cp VDD) gpdk090_pmos1v w=0.48u l=0.1u ad=0.0936p as=0.1056p pd=0.92u ps=0.92u
    I_MXI0_I22_MP9 (XI0_I22_ap1 B_4 VDD VDD) gpdk090_pmos1v w=0.48u l=0.1u ad=0.1056p as=0.1632p pd=0.92u ps=1.64u
    I_MXI0_I22_MP11 (I0_one2 XI0_I22_aan XI0_I22_ap1 VDD) gpdk090_pmos1v w=0.48u l=0.1u ad=0.1056p as=0.1056p pd=0.92u ps=0.92u
    I_MXI0_I22_MP12 (XI0_I22_ap1 XI0_I22_abn I0_one2 VDD) gpdk090_pmos1v w=0.48u l=0.1u ad=0.1056p as=0.1056p pd=0.92u ps=0.92u
    I_MXI0_I22_MP10 (VDD B_3 XI0_I22_ap1 VDD) gpdk090_pmos1v w=0.48u l=0.1u ad=0.1632p as=0.1056p pd=1.64u ps=0.92u
    I_MXI0_I22_MP2 (VDD B_4 XI0_I22_aan VDD) gpdk090_pmos1v w=0.24u l=0.1u ad=0.0816p as=0.0816p pd=1.16u ps=1.16u
    I_MXI0_I22_MP4 (XI0_I22_abn B_3 VDD VDD) gpdk090_pmos1v w=0.24u l=0.1u ad=0.0816p as=0.0816p pd=1.16u ps=1.16u
    I_MXI0_I22_MP16 (XI0_I22_bbn B_4 VDD VDD) gpdk090_pmos1v w=0.24u l=0.1u ad=0.0816p as=0.0936p pd=1.16u ps=0.92u
    I_MXI0_I22_MP14 (XI0_I22_ban B_5 VDD VDD) gpdk090_pmos1v w=0.24u l=0.1u ad=0.0816p as=0.0816p pd=1.16u ps=1.16u
    I_MXI0_I22_MP23 (XI0_I22_e XI0_I22_ban XI0_I22_bp1 VDD) gpdk090_pmos1v w=0.48u l=0.1u ad=0.1056p as=0.1632p pd=0.92u ps=1.64u
    I_MXI0_I22_MP24 (XI0_I22_bp1 B_4 XI0_I22_e VDD) gpdk090_pmos1v w=0.48u l=0.1u ad=0.1056p as=0.1056p pd=0.92u ps=0.92u
    I_MXI0_I22_MP22 (VDD XI0_I22_bbn XI0_I22_bp1 VDD) gpdk090_pmos1v w=0.48u l=0.1u ad=0.1056p as=0.1056p pd=0.92u ps=0.92u
    I_MXI0_I22_MP21 (XI0_I22_bp1 B_5 VDD VDD) gpdk090_pmos1v w=0.48u l=0.1u ad=0.1632p as=0.1056p pd=1.64u ps=0.92u
    I_MXI0_I22_MP28 (XI0_I22_cp I0_one2 I0_two2 VDD) gpdk090_pmos1v w=0.48u l=0.1u ad=0.1056p as=0.1632p pd=0.92u ps=1.64u
    I_MXI0_I22_MP27 (VDD XI0_I22_e XI0_I22_cp VDD) gpdk090_pmos1v w=0.48u l=0.1u ad=0.0936p as=0.1056p pd=0.92u ps=0.92u
    I_MXI0_I11_MP9 (XI0_I11_ap1 B_2 VDD VDD) gpdk090_pmos1v w=0.48u l=0.1u ad=0.1056p as=0.1632p pd=0.92u ps=1.64u
    I_MXI0_I11_MP11 (I0_one1 XI0_I11_aan XI0_I11_ap1 VDD) gpdk090_pmos1v w=0.48u l=0.1u ad=0.1056p as=0.1056p pd=0.92u ps=0.92u
    I_MXI0_I11_MP12 (XI0_I11_ap1 XI0_I11_abn I0_one1 VDD) gpdk090_pmos1v w=0.48u l=0.1u ad=0.1056p as=0.1056p pd=0.92u ps=0.92u
    I_MXI0_I11_MP10 (VDD B_1 XI0_I11_ap1 VDD) gpdk090_pmos1v w=0.48u l=0.1u ad=0.1632p as=0.1056p pd=1.64u ps=0.92u
    I_MXI0_I11_MP2 (VDD B_2 XI0_I11_aan VDD) gpdk090_pmos1v w=0.24u l=0.1u ad=0.0816p as=0.0816p pd=1.16u ps=1.16u
    I_MXI0_I11_MP4 (XI0_I11_abn B_1 VDD VDD) gpdk090_pmos1v w=0.24u l=0.1u ad=0.0816p as=0.0816p pd=1.16u ps=1.16u
    I_MXI0_I11_MP16 (XI0_I11_bbn B_2 VDD VDD) gpdk090_pmos1v w=0.24u l=0.1u ad=0.0816p as=0.0936p pd=1.16u ps=0.92u
    I_MXI0_I11_MP14 (XI0_I11_ban B_3 VDD VDD) gpdk090_pmos1v w=0.24u l=0.1u ad=0.0816p as=0.0816p pd=1.16u ps=1.16u
    I_MXI0_I11_MP23 (XI0_I11_e XI0_I11_ban XI0_I11_bp1 VDD) gpdk090_pmos1v w=0.48u l=0.1u ad=0.1056p as=0.1632p pd=0.92u ps=1.64u
    I_MXI0_I11_MP24 (XI0_I11_bp1 B_2 XI0_I11_e VDD) gpdk090_pmos1v w=0.48u l=0.1u ad=0.1056p as=0.1056p pd=0.92u ps=0.92u
    I_MXI0_I11_MP22 (VDD XI0_I11_bbn XI0_I11_bp1 VDD) gpdk090_pmos1v w=0.48u l=0.1u ad=0.1056p as=0.1056p pd=0.92u ps=0.92u
    I_MXI0_I11_MP21 (XI0_I11_bp1 B_3 VDD VDD) gpdk090_pmos1v w=0.48u l=0.1u ad=0.1632p as=0.1056p pd=1.64u ps=0.92u
    I_MXI0_I11_MP28 (XI0_I11_cp I0_one1 I0_two1 VDD) gpdk090_pmos1v w=0.48u l=0.1u ad=0.1056p as=0.1632p pd=0.92u ps=1.64u
    I_MXI0_I11_MP27 (VDD XI0_I11_e XI0_I11_cp VDD) gpdk090_pmos1v w=0.48u l=0.1u ad=0.0936p as=0.1056p pd=0.92u ps=0.92u
    I_MXI0_I0_MP9 (XI0_I0_ap1 B_0 VDD VDD) gpdk090_pmos1v w=0.48u l=0.1u ad=0.1056p as=0.1632p pd=0.92u ps=1.64u
    I_MXI0_I0_MP11 (I0_one0 XI0_I0_aan XI0_I0_ap1 VDD) gpdk090_pmos1v w=0.48u l=0.1u ad=0.1056p as=0.1056p pd=0.92u ps=0.92u
    I_MXI0_I0_MP12 (XI0_I0_ap1 XI0_I0_abn I0_one0 VDD) gpdk090_pmos1v w=0.48u l=0.1u ad=0.1056p as=0.1056p pd=0.92u ps=0.92u
    I_MXI0_I0_MP10 (VDD VSS XI0_I0_ap1 VDD) gpdk090_pmos1v w=0.48u l=0.1u ad=0.1632p as=0.1056p pd=1.64u ps=0.92u
    I_MXI0_I0_MP2 (VDD B_0 XI0_I0_aan VDD) gpdk090_pmos1v w=0.24u l=0.1u ad=0.0816p as=0.0816p pd=1.16u ps=1.16u
    I_MXI0_I0_MP4 (XI0_I0_abn VSS VDD VDD) gpdk090_pmos1v w=0.24u l=0.1u ad=0.0816p as=0.0816p pd=1.16u ps=1.16u
    I_MXI0_I0_MP16 (XI0_I0_bbn B_0 VDD VDD) gpdk090_pmos1v w=0.24u l=0.1u ad=0.0816p as=0.0936p pd=1.16u ps=0.92u
    I_MXI0_I0_MP14 (XI0_I0_ban B_1 VDD VDD) gpdk090_pmos1v w=0.24u l=0.1u ad=0.0816p as=0.0816p pd=1.16u ps=1.16u
    I_MXI0_I0_MP23 (XI0_I0_e XI0_I0_ban XI0_I0_bp1 VDD) gpdk090_pmos1v w=0.48u l=0.1u ad=0.1056p as=0.1632p pd=0.92u ps=1.64u
    I_MXI0_I0_MP24 (XI0_I0_bp1 B_0 XI0_I0_e VDD) gpdk090_pmos1v w=0.48u l=0.1u ad=0.1056p as=0.1056p pd=0.92u ps=0.92u
    I_MXI0_I0_MP22 (VDD XI0_I0_bbn XI0_I0_bp1 VDD) gpdk090_pmos1v w=0.48u l=0.1u ad=0.1056p as=0.1056p pd=0.92u ps=0.92u
    I_MXI0_I0_MP21 (XI0_I0_bp1 B_1 VDD VDD) gpdk090_pmos1v w=0.48u l=0.1u ad=0.1632p as=0.1056p pd=1.64u ps=0.92u
    I_MXI0_I0_MP28 (XI0_I0_cp I0_one0 I0_two0 VDD) gpdk090_pmos1v w=0.48u l=0.1u ad=0.1056p as=0.1632p pd=0.92u ps=1.64u
    I_MXI0_I0_MP27 (VDD XI0_I0_e XI0_I0_cp VDD) gpdk090_pmos1v w=0.48u l=0.1u ad=0.0936p as=0.1056p pd=0.92u ps=0.92u
    I_MXI0_I77_I41_MP1 (VDD I0_I77_G3_0n XI0_I77_I41_Bn VDD) gpdk090_pmos1v w=0.24u l=0.1u ad=0.0816p as=0.0816p pd=1.16u ps=1.16u
    I_MXI0_I77_I41_MP5 (MULP_12 XI0_I77_I41_Bn XI0_I77_I41_p1 VDD) gpdk090_pmos1v w=0.48u l=0.1u ad=0.1056p as=0.1632p pd=0.92u ps=1.64u
    I_MXI0_I77_I41_MP4 (XI0_I77_I41_p1 XI0_I77_I41_An MULP_12 VDD) gpdk090_pmos1v w=0.48u l=0.1u ad=0.1056p as=0.1056p pd=0.92u ps=0.92u
    I_MXI0_I77_I41_MP2 (VDD I0_I77_pn4 XI0_I77_I41_p1 VDD) gpdk090_pmos1v w=0.48u l=0.1u ad=0.1056p as=0.1056p pd=0.92u ps=0.92u
    I_MXI0_I77_I41_MP3 (XI0_I77_I41_p1 I0_I77_G3_0n VDD VDD) gpdk090_pmos1v w=0.48u l=0.1u ad=0.1632p as=0.1056p pd=1.64u ps=0.92u
    I_MXI0_I77_I41_MP0 (VDD I0_I77_pn4 XI0_I77_I41_An VDD) gpdk090_pmos1v w=0.24u l=0.1u ad=0.0816p as=0.0816p pd=1.16u ps=1.16u
    I_MXI1_I152_I41_MP1 (VDD I1_I152_G3_0n XI1_I152_I41_Bn VDD) gpdk090_pmos1v w=0.24u l=0.1u ad=0.0816p as=0.0816p pd=1.16u ps=1.16u
    I_MXI1_I152_I41_MP5 (I1_ru4 XI1_I152_I41_Bn XI1_I152_I41_p1 VDD) gpdk090_pmos1v w=0.48u l=0.1u ad=0.1056p as=0.1632p pd=0.92u ps=1.64u
    I_MXI1_I152_I41_MP4 (XI1_I152_I41_p1 XI1_I152_I41_An I1_ru4 VDD) gpdk090_pmos1v w=0.48u l=0.1u ad=0.1056p as=0.1056p pd=0.92u ps=0.92u
    I_MXI1_I152_I41_MP2 (VDD I1_I152_pn4 XI1_I152_I41_p1 VDD) gpdk090_pmos1v w=0.48u l=0.1u ad=0.1056p as=0.1056p pd=0.92u ps=0.92u
    I_MXI1_I152_I41_MP3 (XI1_I152_I41_p1 I1_I152_G3_0n VDD VDD) gpdk090_pmos1v w=0.48u l=0.1u ad=0.1632p as=0.1056p pd=1.64u ps=0.92u
    I_MXI1_I152_I41_MP0 (VDD I1_I152_pn4 XI1_I152_I41_An VDD) gpdk090_pmos1v w=0.24u l=0.1u ad=0.0816p as=0.0816p pd=1.16u ps=1.16u
    I_MXI0_I77_I40_MP1 (VDD I0_I77_G2_0n XI0_I77_I40_Bn VDD) gpdk090_pmos1v w=0.24u l=0.1u ad=0.0816p as=0.0816p pd=1.16u ps=1.16u
    I_MXI0_I77_I40_MP5 (MULP_11 XI0_I77_I40_Bn XI0_I77_I40_p1 VDD) gpdk090_pmos1v w=0.48u l=0.1u ad=0.1056p as=0.1632p pd=0.92u ps=1.64u
    I_MXI0_I77_I40_MP4 (XI0_I77_I40_p1 XI0_I77_I40_An MULP_11 VDD) gpdk090_pmos1v w=0.48u l=0.1u ad=0.1056p as=0.1056p pd=0.92u ps=0.92u
    I_MXI0_I77_I40_MP2 (VDD I0_I77_pn3 XI0_I77_I40_p1 VDD) gpdk090_pmos1v w=0.48u l=0.1u ad=0.1056p as=0.1056p pd=0.92u ps=0.92u
    I_MXI0_I77_I40_MP3 (XI0_I77_I40_p1 I0_I77_G2_0n VDD VDD) gpdk090_pmos1v w=0.48u l=0.1u ad=0.1632p as=0.1056p pd=1.64u ps=0.92u
    I_MXI0_I77_I40_MP0 (VDD I0_I77_pn3 XI0_I77_I40_An VDD) gpdk090_pmos1v w=0.24u l=0.1u ad=0.0816p as=0.0816p pd=1.16u ps=1.16u
    I_MXI2_I2_I46_MP1 (VDD B_7 XI2_I2_I46_Bn VDD) gpdk090_pmos1v w=0.24u l=0.1u ad=0.0816p as=0.0816p pd=1.16u ps=1.16u
    I_MXI2_I2_I46_MP5 (I2_XOR_7 XI2_I2_I46_Bn XI2_I2_I46_p1 VDD) gpdk090_pmos1v w=0.48u l=0.1u ad=0.1056p as=0.1632p pd=0.92u ps=1.64u
    I_MXI2_I2_I46_MP4 (XI2_I2_I46_p1 XI2_I2_I46_An I2_XOR_7 VDD) gpdk090_pmos1v w=0.48u l=0.1u ad=0.1056p as=0.1056p pd=0.92u ps=0.92u
    I_MXI2_I2_I46_MP2 (VDD A_7 XI2_I2_I46_p1 VDD) gpdk090_pmos1v w=0.48u l=0.1u ad=0.1056p as=0.1056p pd=0.92u ps=0.92u
    I_MXI2_I2_I46_MP3 (XI2_I2_I46_p1 B_7 VDD VDD) gpdk090_pmos1v w=0.48u l=0.1u ad=0.1632p as=0.1056p pd=1.64u ps=0.92u
    I_MXI2_I2_I46_MP0 (VDD A_7 XI2_I2_I46_An VDD) gpdk090_pmos1v w=0.24u l=0.1u ad=0.0816p as=0.0816p pd=1.16u ps=1.16u
    I_MXI2_I2_I34_MP1 (VDD B_5 XI2_I2_I34_Bn VDD) gpdk090_pmos1v w=0.24u l=0.1u ad=0.0816p as=0.0816p pd=1.16u ps=1.16u
    I_MXI2_I2_I34_MP5 (I2_XOR_5 XI2_I2_I34_Bn XI2_I2_I34_p1 VDD) gpdk090_pmos1v w=0.48u l=0.1u ad=0.1056p as=0.1632p pd=0.92u ps=1.64u
    I_MXI2_I2_I34_MP4 (XI2_I2_I34_p1 XI2_I2_I34_An I2_XOR_5 VDD) gpdk090_pmos1v w=0.48u l=0.1u ad=0.1056p as=0.1056p pd=0.92u ps=0.92u
    I_MXI2_I2_I34_MP2 (VDD A_5 XI2_I2_I34_p1 VDD) gpdk090_pmos1v w=0.48u l=0.1u ad=0.1056p as=0.1056p pd=0.92u ps=0.92u
    I_MXI2_I2_I34_MP3 (XI2_I2_I34_p1 B_5 VDD VDD) gpdk090_pmos1v w=0.48u l=0.1u ad=0.1632p as=0.1056p pd=1.64u ps=0.92u
    I_MXI2_I2_I34_MP0 (VDD A_5 XI2_I2_I34_An VDD) gpdk090_pmos1v w=0.24u l=0.1u ad=0.0816p as=0.0816p pd=1.16u ps=1.16u
    I_MXI1_I152_I40_MP1 (VDD I1_I152_G2_0n XI1_I152_I40_Bn VDD) gpdk090_pmos1v w=0.24u l=0.1u ad=0.0816p as=0.0816p pd=1.16u ps=1.16u
    I_MXI1_I152_I40_MP5 (I1_ru3 XI1_I152_I40_Bn XI1_I152_I40_p1 VDD) gpdk090_pmos1v w=0.48u l=0.1u ad=0.1056p as=0.1632p pd=0.92u ps=1.64u
    I_MXI1_I152_I40_MP4 (XI1_I152_I40_p1 XI1_I152_I40_An I1_ru3 VDD) gpdk090_pmos1v w=0.48u l=0.1u ad=0.1056p as=0.1056p pd=0.92u ps=0.92u
    I_MXI1_I152_I40_MP2 (VDD I1_I152_pn3 XI1_I152_I40_p1 VDD) gpdk090_pmos1v w=0.48u l=0.1u ad=0.1056p as=0.1056p pd=0.92u ps=0.92u
    I_MXI1_I152_I40_MP3 (XI1_I152_I40_p1 I1_I152_G2_0n VDD VDD) gpdk090_pmos1v w=0.48u l=0.1u ad=0.1632p as=0.1056p pd=1.64u ps=0.92u
    I_MXI1_I152_I40_MP0 (VDD I1_I152_pn3 XI1_I152_I40_An VDD) gpdk090_pmos1v w=0.24u l=0.1u ad=0.0816p as=0.0816p pd=1.16u ps=1.16u
    I_MXI2_I1_I7_MP1 (VDD OP_0 XI2_I1_I7_Bn VDD) gpdk090_pmos1v w=0.24u l=0.1u ad=0.0816p as=0.0816p pd=1.16u ps=1.16u
    I_MXI2_I1_I7_MP5 (I2_I1_bx7 XI2_I1_I7_Bn XI2_I1_I7_p1 VDD) gpdk090_pmos1v w=0.48u l=0.1u ad=0.1056p as=0.1632p pd=0.92u ps=1.64u
    I_MXI2_I1_I7_MP4 (XI2_I1_I7_p1 XI2_I1_I7_An I2_I1_bx7 VDD) gpdk090_pmos1v w=0.48u l=0.1u ad=0.1056p as=0.1056p pd=0.92u ps=0.92u
    I_MXI2_I1_I7_MP2 (VDD B_7 XI2_I1_I7_p1 VDD) gpdk090_pmos1v w=0.48u l=0.1u ad=0.1056p as=0.1056p pd=0.92u ps=0.92u
    I_MXI2_I1_I7_MP3 (XI2_I1_I7_p1 OP_0 VDD VDD) gpdk090_pmos1v w=0.48u l=0.1u ad=0.1632p as=0.1056p pd=1.64u ps=0.92u
    I_MXI2_I1_I7_MP0 (VDD B_7 XI2_I1_I7_An VDD) gpdk090_pmos1v w=0.24u l=0.1u ad=0.0816p as=0.0816p pd=1.16u ps=1.16u
    I_MXI2_I2_I40_MP1 (VDD B_6 XI2_I2_I40_Bn VDD) gpdk090_pmos1v w=0.24u l=0.1u ad=0.0816p as=0.0816p pd=1.16u ps=1.16u
    I_MXI2_I2_I40_MP5 (I2_XOR_6 XI2_I2_I40_Bn XI2_I2_I40_p1 VDD) gpdk090_pmos1v w=0.48u l=0.1u ad=0.1056p as=0.1632p pd=0.92u ps=1.64u
    I_MXI2_I2_I40_MP4 (XI2_I2_I40_p1 XI2_I2_I40_An I2_XOR_6 VDD) gpdk090_pmos1v w=0.48u l=0.1u ad=0.1056p as=0.1056p pd=0.92u ps=0.92u
    I_MXI2_I2_I40_MP2 (VDD A_6 XI2_I2_I40_p1 VDD) gpdk090_pmos1v w=0.48u l=0.1u ad=0.1056p as=0.1056p pd=0.92u ps=0.92u
    I_MXI2_I2_I40_MP3 (XI2_I2_I40_p1 B_6 VDD VDD) gpdk090_pmos1v w=0.48u l=0.1u ad=0.1632p as=0.1056p pd=1.64u ps=0.92u
    I_MXI2_I2_I40_MP0 (VDD A_6 XI2_I2_I40_An VDD) gpdk090_pmos1v w=0.24u l=0.1u ad=0.0816p as=0.0816p pd=1.16u ps=1.16u
    I_MXI2_I1_I6_MP1 (VDD OP_0 XI2_I1_I6_Bn VDD) gpdk090_pmos1v w=0.24u l=0.1u ad=0.0816p as=0.0816p pd=1.16u ps=1.16u
    I_MXI2_I1_I6_MP5 (I2_I1_bx6 XI2_I1_I6_Bn XI2_I1_I6_p1 VDD) gpdk090_pmos1v w=0.48u l=0.1u ad=0.1056p as=0.1632p pd=0.92u ps=1.64u
    I_MXI2_I1_I6_MP4 (XI2_I1_I6_p1 XI2_I1_I6_An I2_I1_bx6 VDD) gpdk090_pmos1v w=0.48u l=0.1u ad=0.1056p as=0.1056p pd=0.92u ps=0.92u
    I_MXI2_I1_I6_MP2 (VDD B_6 XI2_I1_I6_p1 VDD) gpdk090_pmos1v w=0.48u l=0.1u ad=0.1056p as=0.1056p pd=0.92u ps=0.92u
    I_MXI2_I1_I6_MP3 (XI2_I1_I6_p1 OP_0 VDD VDD) gpdk090_pmos1v w=0.48u l=0.1u ad=0.1632p as=0.1056p pd=1.64u ps=0.92u
    I_MXI2_I1_I6_MP0 (VDD B_6 XI2_I1_I6_An VDD) gpdk090_pmos1v w=0.24u l=0.1u ad=0.0816p as=0.0816p pd=1.16u ps=1.16u
    I_MXI2_I2_I22_MP1 (VDD B_3 XI2_I2_I22_Bn VDD) gpdk090_pmos1v w=0.24u l=0.1u ad=0.0816p as=0.0816p pd=1.16u ps=1.16u
    I_MXI2_I2_I22_MP5 (I2_XOR_3 XI2_I2_I22_Bn XI2_I2_I22_p1 VDD) gpdk090_pmos1v w=0.48u l=0.1u ad=0.1056p as=0.1632p pd=0.92u ps=1.64u
    I_MXI2_I2_I22_MP4 (XI2_I2_I22_p1 XI2_I2_I22_An I2_XOR_3 VDD) gpdk090_pmos1v w=0.48u l=0.1u ad=0.1056p as=0.1056p pd=0.92u ps=0.92u
    I_MXI2_I2_I22_MP2 (VDD A_3 XI2_I2_I22_p1 VDD) gpdk090_pmos1v w=0.48u l=0.1u ad=0.1056p as=0.1056p pd=0.92u ps=0.92u
    I_MXI2_I2_I22_MP3 (XI2_I2_I22_p1 B_3 VDD VDD) gpdk090_pmos1v w=0.48u l=0.1u ad=0.1632p as=0.1056p pd=1.64u ps=0.92u
    I_MXI2_I2_I22_MP0 (VDD A_3 XI2_I2_I22_An VDD) gpdk090_pmos1v w=0.24u l=0.1u ad=0.0816p as=0.0816p pd=1.16u ps=1.16u
    I_MXI2_I1_I5_MP1 (VDD OP_0 XI2_I1_I5_Bn VDD) gpdk090_pmos1v w=0.24u l=0.1u ad=0.0816p as=0.0816p pd=1.16u ps=1.16u
    I_MXI2_I1_I5_MP5 (I2_I1_bx5 XI2_I1_I5_Bn XI2_I1_I5_p1 VDD) gpdk090_pmos1v w=0.48u l=0.1u ad=0.1056p as=0.1632p pd=0.92u ps=1.64u
    I_MXI2_I1_I5_MP4 (XI2_I1_I5_p1 XI2_I1_I5_An I2_I1_bx5 VDD) gpdk090_pmos1v w=0.48u l=0.1u ad=0.1056p as=0.1056p pd=0.92u ps=0.92u
    I_MXI2_I1_I5_MP2 (VDD B_5 XI2_I1_I5_p1 VDD) gpdk090_pmos1v w=0.48u l=0.1u ad=0.1056p as=0.1056p pd=0.92u ps=0.92u
    I_MXI2_I1_I5_MP3 (XI2_I1_I5_p1 OP_0 VDD VDD) gpdk090_pmos1v w=0.48u l=0.1u ad=0.1632p as=0.1056p pd=1.64u ps=0.92u
    I_MXI2_I1_I5_MP0 (VDD B_5 XI2_I1_I5_An VDD) gpdk090_pmos1v w=0.24u l=0.1u ad=0.0816p as=0.0816p pd=1.16u ps=1.16u
    I_MXI1_I132_I41_MP1 (VDD I1_I132_G3_0n XI1_I132_I41_Bn VDD) gpdk090_pmos1v w=0.24u l=0.1u ad=0.0816p as=0.0816p pd=1.16u ps=1.16u
    I_MXI1_I132_I41_MP5 (I1_p7_4 XI1_I132_I41_Bn XI1_I132_I41_p1 VDD) gpdk090_pmos1v w=0.48u l=0.1u ad=0.1056p as=0.1632p pd=0.92u ps=1.64u
    I_MXI1_I132_I41_MP4 (XI1_I132_I41_p1 XI1_I132_I41_An I1_p7_4 VDD) gpdk090_pmos1v w=0.48u l=0.1u ad=0.1056p as=0.1056p pd=0.92u ps=0.92u
    I_MXI1_I132_I41_MP2 (VDD I1_I132_pn4 XI1_I132_I41_p1 VDD) gpdk090_pmos1v w=0.48u l=0.1u ad=0.1056p as=0.1056p pd=0.92u ps=0.92u
    I_MXI1_I132_I41_MP3 (XI1_I132_I41_p1 I1_I132_G3_0n VDD VDD) gpdk090_pmos1v w=0.48u l=0.1u ad=0.1632p as=0.1056p pd=1.64u ps=0.92u
    I_MXI1_I132_I41_MP0 (VDD I1_I132_pn4 XI1_I132_I41_An VDD) gpdk090_pmos1v w=0.24u l=0.1u ad=0.0816p as=0.0816p pd=1.16u ps=1.16u
    I_MXI1_I132_I40_MP1 (VDD I1_I132_G2_0n XI1_I132_I40_Bn VDD) gpdk090_pmos1v w=0.24u l=0.1u ad=0.0816p as=0.0816p pd=1.16u ps=1.16u
    I_MXI1_I132_I40_MP5 (I1_p7_3 XI1_I132_I40_Bn XI1_I132_I40_p1 VDD) gpdk090_pmos1v w=0.48u l=0.1u ad=0.1056p as=0.1632p pd=0.92u ps=1.64u
    I_MXI1_I132_I40_MP4 (XI1_I132_I40_p1 XI1_I132_I40_An I1_p7_3 VDD) gpdk090_pmos1v w=0.48u l=0.1u ad=0.1056p as=0.1056p pd=0.92u ps=0.92u
    I_MXI1_I132_I40_MP2 (VDD I1_I132_pn3 XI1_I132_I40_p1 VDD) gpdk090_pmos1v w=0.48u l=0.1u ad=0.1056p as=0.1056p pd=0.92u ps=0.92u
    I_MXI1_I132_I40_MP3 (XI1_I132_I40_p1 I1_I132_G2_0n VDD VDD) gpdk090_pmos1v w=0.48u l=0.1u ad=0.1632p as=0.1056p pd=1.64u ps=0.92u
    I_MXI1_I132_I40_MP0 (VDD I1_I132_pn3 XI1_I132_I40_An VDD) gpdk090_pmos1v w=0.24u l=0.1u ad=0.0816p as=0.0816p pd=1.16u ps=1.16u
    I_MXI2_I1_I3_MP1 (VDD OP_0 XI2_I1_I3_Bn VDD) gpdk090_pmos1v w=0.24u l=0.1u ad=0.0816p as=0.0816p pd=1.16u ps=1.16u
    I_MXI2_I1_I3_MP5 (I2_I1_bx3 XI2_I1_I3_Bn XI2_I1_I3_p1 VDD) gpdk090_pmos1v w=0.48u l=0.1u ad=0.1056p as=0.1632p pd=0.92u ps=1.64u
    I_MXI2_I1_I3_MP4 (XI2_I1_I3_p1 XI2_I1_I3_An I2_I1_bx3 VDD) gpdk090_pmos1v w=0.48u l=0.1u ad=0.1056p as=0.1056p pd=0.92u ps=0.92u
    I_MXI2_I1_I3_MP2 (VDD B_3 XI2_I1_I3_p1 VDD) gpdk090_pmos1v w=0.48u l=0.1u ad=0.1056p as=0.1056p pd=0.92u ps=0.92u
    I_MXI2_I1_I3_MP3 (XI2_I1_I3_p1 OP_0 VDD VDD) gpdk090_pmos1v w=0.48u l=0.1u ad=0.1632p as=0.1056p pd=1.64u ps=0.92u
    I_MXI2_I1_I3_MP0 (VDD B_3 XI2_I1_I3_An VDD) gpdk090_pmos1v w=0.24u l=0.1u ad=0.0816p as=0.0816p pd=1.16u ps=1.16u
    I_MXI1_I131_MP1 (VDD I1_qu1 XI1_I131_Bn VDD) gpdk090_pmos1v w=0.24u l=0.1u ad=0.0816p as=0.0816p pd=1.16u ps=1.16u
    I_MXI1_I131_MP5 (I1_b7_7 XI1_I131_Bn XI1_I131_p1 VDD) gpdk090_pmos1v w=0.48u l=0.1u ad=0.1056p as=0.1632p pd=0.92u ps=1.64u
    I_MXI1_I131_MP4 (XI1_I131_p1 XI1_I131_An I1_b7_7 VDD) gpdk090_pmos1v w=0.48u l=0.1u ad=0.1056p as=0.1056p pd=0.92u ps=0.92u
    I_MXI1_I131_MP2 (VDD I1_dd7 XI1_I131_p1 VDD) gpdk090_pmos1v w=0.48u l=0.1u ad=0.1056p as=0.1056p pd=0.92u ps=0.92u
    I_MXI1_I131_MP3 (XI1_I131_p1 I1_qu1 VDD VDD) gpdk090_pmos1v w=0.48u l=0.1u ad=0.1632p as=0.1056p pd=1.64u ps=0.92u
    I_MXI1_I131_MP0 (VDD I1_dd7 XI1_I131_An VDD) gpdk090_pmos1v w=0.24u l=0.1u ad=0.0816p as=0.0816p pd=1.16u ps=1.16u
    I_MXI1_I134_MP1 (VDD I1_c7_8 XI1_I134_Bn VDD) gpdk090_pmos1v w=0.24u l=0.1u ad=0.0816p as=0.0816p pd=1.16u ps=1.16u
    I_MXI1_I134_MP5 (I1_p7_8 XI1_I134_Bn XI1_I134_p1 VDD) gpdk090_pmos1v w=0.48u l=0.1u ad=0.1056p as=0.1632p pd=0.92u ps=1.64u
    I_MXI1_I134_MP4 (XI1_I134_p1 XI1_I134_An I1_p7_8 VDD) gpdk090_pmos1v w=0.48u l=0.1u ad=0.1056p as=0.1056p pd=0.92u ps=0.92u
    I_MXI1_I134_MP2 (VDD I1_h7 XI1_I134_p1 VDD) gpdk090_pmos1v w=0.48u l=0.1u ad=0.1056p as=0.1056p pd=0.92u ps=0.92u
    I_MXI1_I134_MP3 (XI1_I134_p1 I1_c7_8 VDD VDD) gpdk090_pmos1v w=0.48u l=0.1u ad=0.1632p as=0.1056p pd=1.64u ps=0.92u
    I_MXI1_I134_MP0 (VDD I1_h7 XI1_I134_An VDD) gpdk090_pmos1v w=0.24u l=0.1u ad=0.0816p as=0.0816p pd=1.16u ps=1.16u
    I_MXI2_I4_I18_MP1 (VDD I2_C8 XI2_I4_I18_Bn VDD) gpdk090_pmos1v w=0.24u l=0.1u ad=0.0816p as=0.0816p pd=1.16u ps=1.16u
    I_MXI2_I4_I18_MP5 (I2_I4_ovf XI2_I4_I18_Bn XI2_I4_I18_p1 VDD) gpdk090_pmos1v w=0.48u l=0.1u ad=0.1056p as=0.1632p pd=0.92u ps=1.64u
    I_MXI2_I4_I18_MP4 (XI2_I4_I18_p1 XI2_I4_I18_An I2_I4_ovf VDD) gpdk090_pmos1v w=0.48u l=0.1u ad=0.1056p as=0.1056p pd=0.92u ps=0.92u
    I_MXI2_I4_I18_MP2 (VDD I2_C7 XI2_I4_I18_p1 VDD) gpdk090_pmos1v w=0.48u l=0.1u ad=0.1056p as=0.1056p pd=0.92u ps=0.92u
    I_MXI2_I4_I18_MP3 (XI2_I4_I18_p1 I2_C8 VDD VDD) gpdk090_pmos1v w=0.48u l=0.1u ad=0.1632p as=0.1056p pd=1.64u ps=0.92u
    I_MXI2_I4_I18_MP0 (VDD I2_C7 XI2_I4_I18_An VDD) gpdk090_pmos1v w=0.24u l=0.1u ad=0.0816p as=0.0816p pd=1.16u ps=1.16u
    I_MXI1_I124_MP1 (VDD I1_qu1 XI1_I124_Bn VDD) gpdk090_pmos1v w=0.24u l=0.1u ad=0.0816p as=0.0816p pd=1.16u ps=1.16u
    I_MXI1_I124_MP5 (I1_b7_0 XI1_I124_Bn XI1_I124_p1 VDD) gpdk090_pmos1v w=0.48u l=0.1u ad=0.1056p as=0.1632p pd=0.92u ps=1.64u
    I_MXI1_I124_MP4 (XI1_I124_p1 XI1_I124_An I1_b7_0 VDD) gpdk090_pmos1v w=0.48u l=0.1u ad=0.1056p as=0.1056p pd=0.92u ps=0.92u
    I_MXI1_I124_MP2 (VDD B_0 XI1_I124_p1 VDD) gpdk090_pmos1v w=0.48u l=0.1u ad=0.1056p as=0.1056p pd=0.92u ps=0.92u
    I_MXI1_I124_MP3 (XI1_I124_p1 I1_qu1 VDD VDD) gpdk090_pmos1v w=0.48u l=0.1u ad=0.1632p as=0.1056p pd=1.64u ps=0.92u
    I_MXI1_I124_MP0 (VDD B_0 XI1_I124_An VDD) gpdk090_pmos1v w=0.24u l=0.1u ad=0.0816p as=0.0816p pd=1.16u ps=1.16u
    I_MXI2_I1_I8_I41_MP1 (VDD I2_I1_I8_G3_0n XI2_I1_I8_I41_Bn VDD) gpdk090_pmos1v w=0.24u l=0.1u ad=0.0816p as=0.0816p pd=1.16u ps=1.16u
    I_MXI2_I1_I8_I41_MP5 (I2_S_4 XI2_I1_I8_I41_Bn XI2_I1_I8_I41_p1 VDD) gpdk090_pmos1v w=0.48u l=0.1u ad=0.1056p as=0.1632p pd=0.92u ps=1.64u
    I_MXI2_I1_I8_I41_MP4 (XI2_I1_I8_I41_p1 XI2_I1_I8_I41_An I2_S_4 VDD) gpdk090_pmos1v w=0.48u l=0.1u ad=0.1056p as=0.1056p pd=0.92u ps=0.92u
    I_MXI2_I1_I8_I41_MP2 (VDD I2_I1_I8_pn4 XI2_I1_I8_I41_p1 VDD) gpdk090_pmos1v w=0.48u l=0.1u ad=0.1056p as=0.1056p pd=0.92u ps=0.92u
    I_MXI2_I1_I8_I41_MP3 (XI2_I1_I8_I41_p1 I2_I1_I8_G3_0n VDD VDD) gpdk090_pmos1v w=0.48u l=0.1u ad=0.1632p as=0.1056p pd=1.64u ps=0.92u
    I_MXI2_I1_I8_I41_MP0 (VDD I2_I1_I8_pn4 XI2_I1_I8_I41_An VDD) gpdk090_pmos1v w=0.24u l=0.1u ad=0.0816p as=0.0816p pd=1.16u ps=1.16u
    I_MXI2_I1_I8_I40_MP1 (VDD I2_I1_I8_G2_0n XI2_I1_I8_I40_Bn VDD) gpdk090_pmos1v w=0.24u l=0.1u ad=0.0816p as=0.0816p pd=1.16u ps=1.16u
    I_MXI2_I1_I8_I40_MP5 (I2_S_3 XI2_I1_I8_I40_Bn XI2_I1_I8_I40_p1 VDD) gpdk090_pmos1v w=0.48u l=0.1u ad=0.1056p as=0.1632p pd=0.92u ps=1.64u
    I_MXI2_I1_I8_I40_MP4 (XI2_I1_I8_I40_p1 XI2_I1_I8_I40_An I2_S_3 VDD) gpdk090_pmos1v w=0.48u l=0.1u ad=0.1056p as=0.1056p pd=0.92u ps=0.92u
    I_MXI2_I1_I8_I40_MP2 (VDD I2_I1_I8_pn3 XI2_I1_I8_I40_p1 VDD) gpdk090_pmos1v w=0.48u l=0.1u ad=0.1056p as=0.1056p pd=0.92u ps=0.92u
    I_MXI2_I1_I8_I40_MP3 (XI2_I1_I8_I40_p1 I2_I1_I8_G2_0n VDD VDD) gpdk090_pmos1v w=0.48u l=0.1u ad=0.1632p as=0.1056p pd=1.64u ps=0.92u
    I_MXI2_I1_I8_I40_MP0 (VDD I2_I1_I8_pn3 XI2_I1_I8_I40_An VDD) gpdk090_pmos1v w=0.24u l=0.1u ad=0.0816p as=0.0816p pd=1.16u ps=1.16u
    I_MXI2_I1_I4_MP1 (VDD OP_0 XI2_I1_I4_Bn VDD) gpdk090_pmos1v w=0.24u l=0.1u ad=0.0816p as=0.0816p pd=1.16u ps=1.16u
    I_MXI2_I1_I4_MP5 (I2_I1_bx4 XI2_I1_I4_Bn XI2_I1_I4_p1 VDD) gpdk090_pmos1v w=0.48u l=0.1u ad=0.1056p as=0.1632p pd=0.92u ps=1.64u
    I_MXI2_I1_I4_MP4 (XI2_I1_I4_p1 XI2_I1_I4_An I2_I1_bx4 VDD) gpdk090_pmos1v w=0.48u l=0.1u ad=0.1056p as=0.1056p pd=0.92u ps=0.92u
    I_MXI2_I1_I4_MP2 (VDD B_4 XI2_I1_I4_p1 VDD) gpdk090_pmos1v w=0.48u l=0.1u ad=0.1056p as=0.1056p pd=0.92u ps=0.92u
    I_MXI2_I1_I4_MP3 (XI2_I1_I4_p1 OP_0 VDD VDD) gpdk090_pmos1v w=0.48u l=0.1u ad=0.1632p as=0.1056p pd=1.64u ps=0.92u
    I_MXI2_I1_I4_MP0 (VDD B_4 XI2_I1_I4_An VDD) gpdk090_pmos1v w=0.24u l=0.1u ad=0.0816p as=0.0816p pd=1.16u ps=1.16u
    I_MXI1_I133_MP1 (VDD I1_qu1 XI1_I133_Bn VDD) gpdk090_pmos1v w=0.24u l=0.1u ad=0.0816p as=0.0816p pd=1.16u ps=1.16u
    I_MXI1_I133_MP5 (I1_h7 XI1_I133_Bn XI1_I133_p1 VDD) gpdk090_pmos1v w=0.48u l=0.1u ad=0.1056p as=0.1632p pd=0.92u ps=1.64u
    I_MXI1_I133_MP4 (XI1_I133_p1 XI1_I133_An I1_h7 VDD) gpdk090_pmos1v w=0.48u l=0.1u ad=0.1056p as=0.1056p pd=0.92u ps=0.92u
    I_MXI1_I133_MP2 (VDD I1_p6_7 XI1_I133_p1 VDD) gpdk090_pmos1v w=0.48u l=0.1u ad=0.1056p as=0.1056p pd=0.92u ps=0.92u
    I_MXI1_I133_MP3 (XI1_I133_p1 I1_qu1 VDD VDD) gpdk090_pmos1v w=0.48u l=0.1u ad=0.1632p as=0.1056p pd=1.64u ps=0.92u
    I_MXI1_I133_MP0 (VDD I1_p6_7 XI1_I133_An VDD) gpdk090_pmos1v w=0.24u l=0.1u ad=0.0816p as=0.0816p pd=1.16u ps=1.16u
    I_MXI1_I130_MP1 (VDD I1_qu1 XI1_I130_Bn VDD) gpdk090_pmos1v w=0.24u l=0.1u ad=0.0816p as=0.0816p pd=1.16u ps=1.16u
    I_MXI1_I130_MP5 (I1_b7_6 XI1_I130_Bn XI1_I130_p1 VDD) gpdk090_pmos1v w=0.48u l=0.1u ad=0.1056p as=0.1632p pd=0.92u ps=1.64u
    I_MXI1_I130_MP4 (XI1_I130_p1 XI1_I130_An I1_b7_6 VDD) gpdk090_pmos1v w=0.48u l=0.1u ad=0.1056p as=0.1056p pd=0.92u ps=0.92u
    I_MXI1_I130_MP2 (VDD I1_dd6 XI1_I130_p1 VDD) gpdk090_pmos1v w=0.48u l=0.1u ad=0.1056p as=0.1056p pd=0.92u ps=0.92u
    I_MXI1_I130_MP3 (XI1_I130_p1 I1_qu1 VDD VDD) gpdk090_pmos1v w=0.48u l=0.1u ad=0.1632p as=0.1056p pd=1.64u ps=0.92u
    I_MXI1_I130_MP0 (VDD I1_dd6 XI1_I130_An VDD) gpdk090_pmos1v w=0.24u l=0.1u ad=0.0816p as=0.0816p pd=1.16u ps=1.16u
    I_MXI1_I129_MP1 (VDD I1_qu1 XI1_I129_Bn VDD) gpdk090_pmos1v w=0.24u l=0.1u ad=0.0816p as=0.0816p pd=1.16u ps=1.16u
    I_MXI1_I129_MP5 (I1_b7_5 XI1_I129_Bn XI1_I129_p1 VDD) gpdk090_pmos1v w=0.48u l=0.1u ad=0.1056p as=0.1632p pd=0.92u ps=1.64u
    I_MXI1_I129_MP4 (XI1_I129_p1 XI1_I129_An I1_b7_5 VDD) gpdk090_pmos1v w=0.48u l=0.1u ad=0.1056p as=0.1056p pd=0.92u ps=0.92u
    I_MXI1_I129_MP2 (VDD I1_dd5 XI1_I129_p1 VDD) gpdk090_pmos1v w=0.48u l=0.1u ad=0.1056p as=0.1056p pd=0.92u ps=0.92u
    I_MXI1_I129_MP3 (XI1_I129_p1 I1_qu1 VDD VDD) gpdk090_pmos1v w=0.48u l=0.1u ad=0.1632p as=0.1056p pd=1.64u ps=0.92u
    I_MXI1_I129_MP0 (VDD I1_dd5 XI1_I129_An VDD) gpdk090_pmos1v w=0.24u l=0.1u ad=0.0816p as=0.0816p pd=1.16u ps=1.16u
    I_MXI1_I128_MP1 (VDD I1_qu1 XI1_I128_Bn VDD) gpdk090_pmos1v w=0.24u l=0.1u ad=0.0816p as=0.0816p pd=1.16u ps=1.16u
    I_MXI1_I128_MP5 (I1_b7_4 XI1_I128_Bn XI1_I128_p1 VDD) gpdk090_pmos1v w=0.48u l=0.1u ad=0.1056p as=0.1632p pd=0.92u ps=1.64u
    I_MXI1_I128_MP4 (XI1_I128_p1 XI1_I128_An I1_b7_4 VDD) gpdk090_pmos1v w=0.48u l=0.1u ad=0.1056p as=0.1056p pd=0.92u ps=0.92u
    I_MXI1_I128_MP2 (VDD I1_dd4 XI1_I128_p1 VDD) gpdk090_pmos1v w=0.48u l=0.1u ad=0.1056p as=0.1056p pd=0.92u ps=0.92u
    I_MXI1_I128_MP3 (XI1_I128_p1 I1_qu1 VDD VDD) gpdk090_pmos1v w=0.48u l=0.1u ad=0.1632p as=0.1056p pd=1.64u ps=0.92u
    I_MXI1_I128_MP0 (VDD I1_dd4 XI1_I128_An VDD) gpdk090_pmos1v w=0.24u l=0.1u ad=0.0816p as=0.0816p pd=1.16u ps=1.16u
    I_MXI1_I127_MP1 (VDD I1_qu1 XI1_I127_Bn VDD) gpdk090_pmos1v w=0.24u l=0.1u ad=0.0816p as=0.0816p pd=1.16u ps=1.16u
    I_MXI1_I127_MP5 (I1_b7_3 XI1_I127_Bn XI1_I127_p1 VDD) gpdk090_pmos1v w=0.48u l=0.1u ad=0.1056p as=0.1632p pd=0.92u ps=1.64u
    I_MXI1_I127_MP4 (XI1_I127_p1 XI1_I127_An I1_b7_3 VDD) gpdk090_pmos1v w=0.48u l=0.1u ad=0.1056p as=0.1056p pd=0.92u ps=0.92u
    I_MXI1_I127_MP2 (VDD I1_dd3 XI1_I127_p1 VDD) gpdk090_pmos1v w=0.48u l=0.1u ad=0.1056p as=0.1056p pd=0.92u ps=0.92u
    I_MXI1_I127_MP3 (XI1_I127_p1 I1_qu1 VDD VDD) gpdk090_pmos1v w=0.48u l=0.1u ad=0.1632p as=0.1056p pd=1.64u ps=0.92u
    I_MXI1_I127_MP0 (VDD I1_dd3 XI1_I127_An VDD) gpdk090_pmos1v w=0.24u l=0.1u ad=0.0816p as=0.0816p pd=1.16u ps=1.16u
    I_MXI1_I126_MP1 (VDD I1_qu1 XI1_I126_Bn VDD) gpdk090_pmos1v w=0.24u l=0.1u ad=0.0816p as=0.0816p pd=1.16u ps=1.16u
    I_MXI1_I126_MP5 (I1_b7_2 XI1_I126_Bn XI1_I126_p1 VDD) gpdk090_pmos1v w=0.48u l=0.1u ad=0.1056p as=0.1632p pd=0.92u ps=1.64u
    I_MXI1_I126_MP4 (XI1_I126_p1 XI1_I126_An I1_b7_2 VDD) gpdk090_pmos1v w=0.48u l=0.1u ad=0.1056p as=0.1056p pd=0.92u ps=0.92u
    I_MXI1_I126_MP2 (VDD I1_dd2 XI1_I126_p1 VDD) gpdk090_pmos1v w=0.48u l=0.1u ad=0.1056p as=0.1056p pd=0.92u ps=0.92u
    I_MXI1_I126_MP3 (XI1_I126_p1 I1_qu1 VDD VDD) gpdk090_pmos1v w=0.48u l=0.1u ad=0.1632p as=0.1056p pd=1.64u ps=0.92u
    I_MXI1_I126_MP0 (VDD I1_dd2 XI1_I126_An VDD) gpdk090_pmos1v w=0.24u l=0.1u ad=0.0816p as=0.0816p pd=1.16u ps=1.16u
    I_MXI1_I125_MP1 (VDD I1_qu1 XI1_I125_Bn VDD) gpdk090_pmos1v w=0.24u l=0.1u ad=0.0816p as=0.0816p pd=1.16u ps=1.16u
    I_MXI1_I125_MP5 (I1_b7_1 XI1_I125_Bn XI1_I125_p1 VDD) gpdk090_pmos1v w=0.48u l=0.1u ad=0.1056p as=0.1632p pd=0.92u ps=1.64u
    I_MXI1_I125_MP4 (XI1_I125_p1 XI1_I125_An I1_b7_1 VDD) gpdk090_pmos1v w=0.48u l=0.1u ad=0.1056p as=0.1056p pd=0.92u ps=0.92u
    I_MXI1_I125_MP2 (VDD I1_dd1 XI1_I125_p1 VDD) gpdk090_pmos1v w=0.48u l=0.1u ad=0.1056p as=0.1056p pd=0.92u ps=0.92u
    I_MXI1_I125_MP3 (XI1_I125_p1 I1_qu1 VDD VDD) gpdk090_pmos1v w=0.48u l=0.1u ad=0.1632p as=0.1056p pd=1.64u ps=0.92u
    I_MXI1_I125_MP0 (VDD I1_dd1 XI1_I125_An VDD) gpdk090_pmos1v w=0.24u l=0.1u ad=0.0816p as=0.0816p pd=1.16u ps=1.16u
    I_MXI2_I1_I0_MP1 (VDD OP_0 XI2_I1_I0_Bn VDD) gpdk090_pmos1v w=0.24u l=0.1u ad=0.0816p as=0.0816p pd=1.16u ps=1.16u
    I_MXI2_I1_I0_MP5 (I2_I1_bx0 XI2_I1_I0_Bn XI2_I1_I0_p1 VDD) gpdk090_pmos1v w=0.48u l=0.1u ad=0.1056p as=0.1632p pd=0.92u ps=1.64u
    I_MXI2_I1_I0_MP4 (XI2_I1_I0_p1 XI2_I1_I0_An I2_I1_bx0 VDD) gpdk090_pmos1v w=0.48u l=0.1u ad=0.1056p as=0.1056p pd=0.92u ps=0.92u
    I_MXI2_I1_I0_MP2 (VDD B_0 XI2_I1_I0_p1 VDD) gpdk090_pmos1v w=0.48u l=0.1u ad=0.1056p as=0.1056p pd=0.92u ps=0.92u
    I_MXI2_I1_I0_MP3 (XI2_I1_I0_p1 OP_0 VDD VDD) gpdk090_pmos1v w=0.48u l=0.1u ad=0.1632p as=0.1056p pd=1.64u ps=0.92u
    I_MXI2_I1_I0_MP0 (VDD B_0 XI2_I1_I0_An VDD) gpdk090_pmos1v w=0.24u l=0.1u ad=0.0816p as=0.0816p pd=1.16u ps=1.16u
    I_MXI1_I122_MP1 (VDD I1_c6_8 XI1_I122_Bn VDD) gpdk090_pmos1v w=0.24u l=0.1u ad=0.0816p as=0.0816p pd=1.16u ps=1.16u
    I_MXI1_I122_MP5 (I1_p6_8 XI1_I122_Bn XI1_I122_p1 VDD) gpdk090_pmos1v w=0.48u l=0.1u ad=0.1056p as=0.1632p pd=0.92u ps=1.64u
    I_MXI1_I122_MP4 (XI1_I122_p1 XI1_I122_An I1_p6_8 VDD) gpdk090_pmos1v w=0.48u l=0.1u ad=0.1056p as=0.1056p pd=0.92u ps=0.92u
    I_MXI1_I122_MP2 (VDD I1_h6 XI1_I122_p1 VDD) gpdk090_pmos1v w=0.48u l=0.1u ad=0.1056p as=0.1056p pd=0.92u ps=0.92u
    I_MXI1_I122_MP3 (XI1_I122_p1 I1_c6_8 VDD VDD) gpdk090_pmos1v w=0.48u l=0.1u ad=0.1632p as=0.1056p pd=1.64u ps=0.92u
    I_MXI1_I122_MP0 (VDD I1_h6 XI1_I122_An VDD) gpdk090_pmos1v w=0.24u l=0.1u ad=0.0816p as=0.0816p pd=1.16u ps=1.16u
    I_MXI1_I120_I41_MP1 (VDD I1_I120_G3_0n XI1_I120_I41_Bn VDD) gpdk090_pmos1v w=0.24u l=0.1u ad=0.0816p as=0.0816p pd=1.16u ps=1.16u
    I_MXI1_I120_I41_MP5 (I1_p6_4 XI1_I120_I41_Bn XI1_I120_I41_p1 VDD) gpdk090_pmos1v w=0.48u l=0.1u ad=0.1056p as=0.1632p pd=0.92u ps=1.64u
    I_MXI1_I120_I41_MP4 (XI1_I120_I41_p1 XI1_I120_I41_An I1_p6_4 VDD) gpdk090_pmos1v w=0.48u l=0.1u ad=0.1056p as=0.1056p pd=0.92u ps=0.92u
    I_MXI1_I120_I41_MP2 (VDD I1_I120_pn4 XI1_I120_I41_p1 VDD) gpdk090_pmos1v w=0.48u l=0.1u ad=0.1056p as=0.1056p pd=0.92u ps=0.92u
    I_MXI1_I120_I41_MP3 (XI1_I120_I41_p1 I1_I120_G3_0n VDD VDD) gpdk090_pmos1v w=0.48u l=0.1u ad=0.1632p as=0.1056p pd=1.64u ps=0.92u
    I_MXI1_I120_I41_MP0 (VDD I1_I120_pn4 XI1_I120_I41_An VDD) gpdk090_pmos1v w=0.24u l=0.1u ad=0.0816p as=0.0816p pd=1.16u ps=1.16u
    I_MXI1_I120_I40_MP1 (VDD I1_I120_G2_0n XI1_I120_I40_Bn VDD) gpdk090_pmos1v w=0.24u l=0.1u ad=0.0816p as=0.0816p pd=1.16u ps=1.16u
    I_MXI1_I120_I40_MP5 (I1_p6_3 XI1_I120_I40_Bn XI1_I120_I40_p1 VDD) gpdk090_pmos1v w=0.48u l=0.1u ad=0.1056p as=0.1632p pd=0.92u ps=1.64u
    I_MXI1_I120_I40_MP4 (XI1_I120_I40_p1 XI1_I120_I40_An I1_p6_3 VDD) gpdk090_pmos1v w=0.48u l=0.1u ad=0.1056p as=0.1056p pd=0.92u ps=0.92u
    I_MXI1_I120_I40_MP2 (VDD I1_I120_pn3 XI1_I120_I40_p1 VDD) gpdk090_pmos1v w=0.48u l=0.1u ad=0.1056p as=0.1056p pd=0.92u ps=0.92u
    I_MXI1_I120_I40_MP3 (XI1_I120_I40_p1 I1_I120_G2_0n VDD VDD) gpdk090_pmos1v w=0.48u l=0.1u ad=0.1632p as=0.1056p pd=1.64u ps=0.92u
    I_MXI1_I120_I40_MP0 (VDD I1_I120_pn3 XI1_I120_I40_An VDD) gpdk090_pmos1v w=0.24u l=0.1u ad=0.0816p as=0.0816p pd=1.16u ps=1.16u
    I_MXI2_I1_I1_MP1 (VDD OP_0 XI2_I1_I1_Bn VDD) gpdk090_pmos1v w=0.24u l=0.1u ad=0.0816p as=0.0816p pd=1.16u ps=1.16u
    I_MXI2_I1_I1_MP5 (I2_I1_bx1 XI2_I1_I1_Bn XI2_I1_I1_p1 VDD) gpdk090_pmos1v w=0.48u l=0.1u ad=0.1056p as=0.1632p pd=0.92u ps=1.64u
    I_MXI2_I1_I1_MP4 (XI2_I1_I1_p1 XI2_I1_I1_An I2_I1_bx1 VDD) gpdk090_pmos1v w=0.48u l=0.1u ad=0.1056p as=0.1056p pd=0.92u ps=0.92u
    I_MXI2_I1_I1_MP2 (VDD B_1 XI2_I1_I1_p1 VDD) gpdk090_pmos1v w=0.48u l=0.1u ad=0.1056p as=0.1056p pd=0.92u ps=0.92u
    I_MXI2_I1_I1_MP3 (XI2_I1_I1_p1 OP_0 VDD VDD) gpdk090_pmos1v w=0.48u l=0.1u ad=0.1632p as=0.1056p pd=1.64u ps=0.92u
    I_MXI2_I1_I1_MP0 (VDD B_1 XI2_I1_I1_An VDD) gpdk090_pmos1v w=0.24u l=0.1u ad=0.0816p as=0.0816p pd=1.16u ps=1.16u
    I_MXI2_I2_I28_MP1 (VDD B_4 XI2_I2_I28_Bn VDD) gpdk090_pmos1v w=0.24u l=0.1u ad=0.0816p as=0.0816p pd=1.16u ps=1.16u
    I_MXI2_I2_I28_MP5 (I2_XOR_4 XI2_I2_I28_Bn XI2_I2_I28_p1 VDD) gpdk090_pmos1v w=0.48u l=0.1u ad=0.1056p as=0.1632p pd=0.92u ps=1.64u
    I_MXI2_I2_I28_MP4 (XI2_I2_I28_p1 XI2_I2_I28_An I2_XOR_4 VDD) gpdk090_pmos1v w=0.48u l=0.1u ad=0.1056p as=0.1056p pd=0.92u ps=0.92u
    I_MXI2_I2_I28_MP2 (VDD A_4 XI2_I2_I28_p1 VDD) gpdk090_pmos1v w=0.48u l=0.1u ad=0.1056p as=0.1056p pd=0.92u ps=0.92u
    I_MXI2_I2_I28_MP3 (XI2_I2_I28_p1 B_4 VDD VDD) gpdk090_pmos1v w=0.48u l=0.1u ad=0.1632p as=0.1056p pd=1.64u ps=0.92u
    I_MXI2_I2_I28_MP0 (VDD A_4 XI2_I2_I28_An VDD) gpdk090_pmos1v w=0.24u l=0.1u ad=0.0816p as=0.0816p pd=1.16u ps=1.16u
    I_MXI2_I1_I2_MP1 (VDD OP_0 XI2_I1_I2_Bn VDD) gpdk090_pmos1v w=0.24u l=0.1u ad=0.0816p as=0.0816p pd=1.16u ps=1.16u
    I_MXI2_I1_I2_MP5 (I2_I1_bx2 XI2_I1_I2_Bn XI2_I1_I2_p1 VDD) gpdk090_pmos1v w=0.48u l=0.1u ad=0.1056p as=0.1632p pd=0.92u ps=1.64u
    I_MXI2_I1_I2_MP4 (XI2_I1_I2_p1 XI2_I1_I2_An I2_I1_bx2 VDD) gpdk090_pmos1v w=0.48u l=0.1u ad=0.1056p as=0.1056p pd=0.92u ps=0.92u
    I_MXI2_I1_I2_MP2 (VDD B_2 XI2_I1_I2_p1 VDD) gpdk090_pmos1v w=0.48u l=0.1u ad=0.1056p as=0.1056p pd=0.92u ps=0.92u
    I_MXI2_I1_I2_MP3 (XI2_I1_I2_p1 OP_0 VDD VDD) gpdk090_pmos1v w=0.48u l=0.1u ad=0.1632p as=0.1056p pd=1.64u ps=0.92u
    I_MXI2_I1_I2_MP0 (VDD B_2 XI2_I1_I2_An VDD) gpdk090_pmos1v w=0.24u l=0.1u ad=0.0816p as=0.0816p pd=1.16u ps=1.16u
    I_MXI1_I114_MP1 (VDD I1_qu2 XI1_I114_Bn VDD) gpdk090_pmos1v w=0.24u l=0.1u ad=0.0816p as=0.0816p pd=1.16u ps=1.16u
    I_MXI1_I114_MP5 (I1_b6_2 XI1_I114_Bn XI1_I114_p1 VDD) gpdk090_pmos1v w=0.48u l=0.1u ad=0.1056p as=0.1632p pd=0.92u ps=1.64u
    I_MXI1_I114_MP4 (XI1_I114_p1 XI1_I114_An I1_b6_2 VDD) gpdk090_pmos1v w=0.48u l=0.1u ad=0.1056p as=0.1056p pd=0.92u ps=0.92u
    I_MXI1_I114_MP2 (VDD I1_dd2 XI1_I114_p1 VDD) gpdk090_pmos1v w=0.48u l=0.1u ad=0.1056p as=0.1056p pd=0.92u ps=0.92u
    I_MXI1_I114_MP3 (XI1_I114_p1 I1_qu2 VDD VDD) gpdk090_pmos1v w=0.48u l=0.1u ad=0.1632p as=0.1056p pd=1.64u ps=0.92u
    I_MXI1_I114_MP0 (VDD I1_dd2 XI1_I114_An VDD) gpdk090_pmos1v w=0.24u l=0.1u ad=0.0816p as=0.0816p pd=1.16u ps=1.16u
    I_MXI1_I113_MP1 (VDD I1_qu2 XI1_I113_Bn VDD) gpdk090_pmos1v w=0.24u l=0.1u ad=0.0816p as=0.0816p pd=1.16u ps=1.16u
    I_MXI1_I113_MP5 (I1_b6_1 XI1_I113_Bn XI1_I113_p1 VDD) gpdk090_pmos1v w=0.48u l=0.1u ad=0.1056p as=0.1632p pd=0.92u ps=1.64u
    I_MXI1_I113_MP4 (XI1_I113_p1 XI1_I113_An I1_b6_1 VDD) gpdk090_pmos1v w=0.48u l=0.1u ad=0.1056p as=0.1056p pd=0.92u ps=0.92u
    I_MXI1_I113_MP2 (VDD I1_dd1 XI1_I113_p1 VDD) gpdk090_pmos1v w=0.48u l=0.1u ad=0.1056p as=0.1056p pd=0.92u ps=0.92u
    I_MXI1_I113_MP3 (XI1_I113_p1 I1_qu2 VDD VDD) gpdk090_pmos1v w=0.48u l=0.1u ad=0.1632p as=0.1056p pd=1.64u ps=0.92u
    I_MXI1_I113_MP0 (VDD I1_dd1 XI1_I113_An VDD) gpdk090_pmos1v w=0.24u l=0.1u ad=0.0816p as=0.0816p pd=1.16u ps=1.16u
    I_MXI1_I112_MP1 (VDD I1_qu2 XI1_I112_Bn VDD) gpdk090_pmos1v w=0.24u l=0.1u ad=0.0816p as=0.0816p pd=1.16u ps=1.16u
    I_MXI1_I112_MP5 (I1_b6_0 XI1_I112_Bn XI1_I112_p1 VDD) gpdk090_pmos1v w=0.48u l=0.1u ad=0.1056p as=0.1632p pd=0.92u ps=1.64u
    I_MXI1_I112_MP4 (XI1_I112_p1 XI1_I112_An I1_b6_0 VDD) gpdk090_pmos1v w=0.48u l=0.1u ad=0.1056p as=0.1056p pd=0.92u ps=0.92u
    I_MXI1_I112_MP2 (VDD B_0 XI1_I112_p1 VDD) gpdk090_pmos1v w=0.48u l=0.1u ad=0.1056p as=0.1056p pd=0.92u ps=0.92u
    I_MXI1_I112_MP3 (XI1_I112_p1 I1_qu2 VDD VDD) gpdk090_pmos1v w=0.48u l=0.1u ad=0.1632p as=0.1056p pd=1.64u ps=0.92u
    I_MXI1_I112_MP0 (VDD B_0 XI1_I112_An VDD) gpdk090_pmos1v w=0.24u l=0.1u ad=0.0816p as=0.0816p pd=1.16u ps=1.16u
    I_MXI2_I2_I10_MP1 (VDD B_1 XI2_I2_I10_Bn VDD) gpdk090_pmos1v w=0.24u l=0.1u ad=0.0816p as=0.0816p pd=1.16u ps=1.16u
    I_MXI2_I2_I10_MP5 (I2_XOR_1 XI2_I2_I10_Bn XI2_I2_I10_p1 VDD) gpdk090_pmos1v w=0.48u l=0.1u ad=0.1056p as=0.1632p pd=0.92u ps=1.64u
    I_MXI2_I2_I10_MP4 (XI2_I2_I10_p1 XI2_I2_I10_An I2_XOR_1 VDD) gpdk090_pmos1v w=0.48u l=0.1u ad=0.1056p as=0.1056p pd=0.92u ps=0.92u
    I_MXI2_I2_I10_MP2 (VDD A_1 XI2_I2_I10_p1 VDD) gpdk090_pmos1v w=0.48u l=0.1u ad=0.1056p as=0.1056p pd=0.92u ps=0.92u
    I_MXI2_I2_I10_MP3 (XI2_I2_I10_p1 B_1 VDD VDD) gpdk090_pmos1v w=0.48u l=0.1u ad=0.1632p as=0.1056p pd=1.64u ps=0.92u
    I_MXI2_I2_I10_MP0 (VDD A_1 XI2_I2_I10_An VDD) gpdk090_pmos1v w=0.24u l=0.1u ad=0.0816p as=0.0816p pd=1.16u ps=1.16u
    I_MXI1_I116_MP1 (VDD I1_qu2 XI1_I116_Bn VDD) gpdk090_pmos1v w=0.24u l=0.1u ad=0.0816p as=0.0816p pd=1.16u ps=1.16u
    I_MXI1_I116_MP5 (I1_b6_4 XI1_I116_Bn XI1_I116_p1 VDD) gpdk090_pmos1v w=0.48u l=0.1u ad=0.1056p as=0.1632p pd=0.92u ps=1.64u
    I_MXI1_I116_MP4 (XI1_I116_p1 XI1_I116_An I1_b6_4 VDD) gpdk090_pmos1v w=0.48u l=0.1u ad=0.1056p as=0.1056p pd=0.92u ps=0.92u
    I_MXI1_I116_MP2 (VDD I1_dd4 XI1_I116_p1 VDD) gpdk090_pmos1v w=0.48u l=0.1u ad=0.1056p as=0.1056p pd=0.92u ps=0.92u
    I_MXI1_I116_MP3 (XI1_I116_p1 I1_qu2 VDD VDD) gpdk090_pmos1v w=0.48u l=0.1u ad=0.1632p as=0.1056p pd=1.64u ps=0.92u
    I_MXI1_I116_MP0 (VDD I1_dd4 XI1_I116_An VDD) gpdk090_pmos1v w=0.24u l=0.1u ad=0.0816p as=0.0816p pd=1.16u ps=1.16u
    I_MXI1_I115_MP1 (VDD I1_qu2 XI1_I115_Bn VDD) gpdk090_pmos1v w=0.24u l=0.1u ad=0.0816p as=0.0816p pd=1.16u ps=1.16u
    I_MXI1_I115_MP5 (I1_b6_3 XI1_I115_Bn XI1_I115_p1 VDD) gpdk090_pmos1v w=0.48u l=0.1u ad=0.1056p as=0.1632p pd=0.92u ps=1.64u
    I_MXI1_I115_MP4 (XI1_I115_p1 XI1_I115_An I1_b6_3 VDD) gpdk090_pmos1v w=0.48u l=0.1u ad=0.1056p as=0.1056p pd=0.92u ps=0.92u
    I_MXI1_I115_MP2 (VDD I1_dd3 XI1_I115_p1 VDD) gpdk090_pmos1v w=0.48u l=0.1u ad=0.1056p as=0.1056p pd=0.92u ps=0.92u
    I_MXI1_I115_MP3 (XI1_I115_p1 I1_qu2 VDD VDD) gpdk090_pmos1v w=0.48u l=0.1u ad=0.1632p as=0.1056p pd=1.64u ps=0.92u
    I_MXI1_I115_MP0 (VDD I1_dd3 XI1_I115_An VDD) gpdk090_pmos1v w=0.24u l=0.1u ad=0.0816p as=0.0816p pd=1.16u ps=1.16u
    I_MXI1_I100_MP1 (VDD I1_qu3 XI1_I100_Bn VDD) gpdk090_pmos1v w=0.24u l=0.1u ad=0.0816p as=0.0816p pd=1.16u ps=1.16u
    I_MXI1_I100_MP5 (I1_b5_0 XI1_I100_Bn XI1_I100_p1 VDD) gpdk090_pmos1v w=0.48u l=0.1u ad=0.1056p as=0.1632p pd=0.92u ps=1.64u
    I_MXI1_I100_MP4 (XI1_I100_p1 XI1_I100_An I1_b5_0 VDD) gpdk090_pmos1v w=0.48u l=0.1u ad=0.1056p as=0.1056p pd=0.92u ps=0.92u
    I_MXI1_I100_MP2 (VDD B_0 XI1_I100_p1 VDD) gpdk090_pmos1v w=0.48u l=0.1u ad=0.1056p as=0.1056p pd=0.92u ps=0.92u
    I_MXI1_I100_MP3 (XI1_I100_p1 I1_qu3 VDD VDD) gpdk090_pmos1v w=0.48u l=0.1u ad=0.1632p as=0.1056p pd=1.64u ps=0.92u
    I_MXI1_I100_MP0 (VDD B_0 XI1_I100_An VDD) gpdk090_pmos1v w=0.24u l=0.1u ad=0.0816p as=0.0816p pd=1.16u ps=1.16u
    I_MXI1_I153_MP1 (VDD B_7 XI1_I153_Bn VDD) gpdk090_pmos1v w=0.24u l=0.1u ad=0.0816p as=0.0816p pd=1.16u ps=1.16u
    I_MXI1_I153_MP5 (I1_sq XI1_I153_Bn XI1_I153_p1 VDD) gpdk090_pmos1v w=0.48u l=0.1u ad=0.1056p as=0.1632p pd=0.92u ps=1.64u
    I_MXI1_I153_MP4 (XI1_I153_p1 XI1_I153_An I1_sq VDD) gpdk090_pmos1v w=0.48u l=0.1u ad=0.1056p as=0.1056p pd=0.92u ps=0.92u
    I_MXI1_I153_MP2 (VDD A_7 XI1_I153_p1 VDD) gpdk090_pmos1v w=0.48u l=0.1u ad=0.1056p as=0.1056p pd=0.92u ps=0.92u
    I_MXI1_I153_MP3 (XI1_I153_p1 B_7 VDD VDD) gpdk090_pmos1v w=0.48u l=0.1u ad=0.1632p as=0.1056p pd=1.64u ps=0.92u
    I_MXI1_I153_MP0 (VDD A_7 XI1_I153_An VDD) gpdk090_pmos1v w=0.24u l=0.1u ad=0.0816p as=0.0816p pd=1.16u ps=1.16u
    I_MXI2_I2_I4_MP1 (VDD B_0 XI2_I2_I4_Bn VDD) gpdk090_pmos1v w=0.24u l=0.1u ad=0.0816p as=0.0816p pd=1.16u ps=1.16u
    I_MXI2_I2_I4_MP5 (I2_XOR_0 XI2_I2_I4_Bn XI2_I2_I4_p1 VDD) gpdk090_pmos1v w=0.48u l=0.1u ad=0.1056p as=0.1632p pd=0.92u ps=1.64u
    I_MXI2_I2_I4_MP4 (XI2_I2_I4_p1 XI2_I2_I4_An I2_XOR_0 VDD) gpdk090_pmos1v w=0.48u l=0.1u ad=0.1056p as=0.1056p pd=0.92u ps=0.92u
    I_MXI2_I2_I4_MP2 (VDD A_0 XI2_I2_I4_p1 VDD) gpdk090_pmos1v w=0.48u l=0.1u ad=0.1056p as=0.1056p pd=0.92u ps=0.92u
    I_MXI2_I2_I4_MP3 (XI2_I2_I4_p1 B_0 VDD VDD) gpdk090_pmos1v w=0.48u l=0.1u ad=0.1632p as=0.1056p pd=1.64u ps=0.92u
    I_MXI2_I2_I4_MP0 (VDD A_0 XI2_I2_I4_An VDD) gpdk090_pmos1v w=0.24u l=0.1u ad=0.0816p as=0.0816p pd=1.16u ps=1.16u
    I_MXI1_I119_MP1 (VDD I1_qu2 XI1_I119_Bn VDD) gpdk090_pmos1v w=0.24u l=0.1u ad=0.0816p as=0.0816p pd=1.16u ps=1.16u
    I_MXI1_I119_MP5 (I1_b6_7 XI1_I119_Bn XI1_I119_p1 VDD) gpdk090_pmos1v w=0.48u l=0.1u ad=0.1056p as=0.1632p pd=0.92u ps=1.64u
    I_MXI1_I119_MP4 (XI1_I119_p1 XI1_I119_An I1_b6_7 VDD) gpdk090_pmos1v w=0.48u l=0.1u ad=0.1056p as=0.1056p pd=0.92u ps=0.92u
    I_MXI1_I119_MP2 (VDD I1_dd7 XI1_I119_p1 VDD) gpdk090_pmos1v w=0.48u l=0.1u ad=0.1056p as=0.1056p pd=0.92u ps=0.92u
    I_MXI1_I119_MP3 (XI1_I119_p1 I1_qu2 VDD VDD) gpdk090_pmos1v w=0.48u l=0.1u ad=0.1632p as=0.1056p pd=1.64u ps=0.92u
    I_MXI1_I119_MP0 (VDD I1_dd7 XI1_I119_An VDD) gpdk090_pmos1v w=0.24u l=0.1u ad=0.0816p as=0.0816p pd=1.16u ps=1.16u
    I_MXI1_I118_MP1 (VDD I1_qu2 XI1_I118_Bn VDD) gpdk090_pmos1v w=0.24u l=0.1u ad=0.0816p as=0.0816p pd=1.16u ps=1.16u
    I_MXI1_I118_MP5 (I1_b6_6 XI1_I118_Bn XI1_I118_p1 VDD) gpdk090_pmos1v w=0.48u l=0.1u ad=0.1056p as=0.1632p pd=0.92u ps=1.64u
    I_MXI1_I118_MP4 (XI1_I118_p1 XI1_I118_An I1_b6_6 VDD) gpdk090_pmos1v w=0.48u l=0.1u ad=0.1056p as=0.1056p pd=0.92u ps=0.92u
    I_MXI1_I118_MP2 (VDD I1_dd6 XI1_I118_p1 VDD) gpdk090_pmos1v w=0.48u l=0.1u ad=0.1056p as=0.1056p pd=0.92u ps=0.92u
    I_MXI1_I118_MP3 (XI1_I118_p1 I1_qu2 VDD VDD) gpdk090_pmos1v w=0.48u l=0.1u ad=0.1632p as=0.1056p pd=1.64u ps=0.92u
    I_MXI1_I118_MP0 (VDD I1_dd6 XI1_I118_An VDD) gpdk090_pmos1v w=0.24u l=0.1u ad=0.0816p as=0.0816p pd=1.16u ps=1.16u
    I_MXI1_I117_MP1 (VDD I1_qu2 XI1_I117_Bn VDD) gpdk090_pmos1v w=0.24u l=0.1u ad=0.0816p as=0.0816p pd=1.16u ps=1.16u
    I_MXI1_I117_MP5 (I1_b6_5 XI1_I117_Bn XI1_I117_p1 VDD) gpdk090_pmos1v w=0.48u l=0.1u ad=0.1056p as=0.1632p pd=0.92u ps=1.64u
    I_MXI1_I117_MP4 (XI1_I117_p1 XI1_I117_An I1_b6_5 VDD) gpdk090_pmos1v w=0.48u l=0.1u ad=0.1056p as=0.1056p pd=0.92u ps=0.92u
    I_MXI1_I117_MP2 (VDD I1_dd5 XI1_I117_p1 VDD) gpdk090_pmos1v w=0.48u l=0.1u ad=0.1056p as=0.1056p pd=0.92u ps=0.92u
    I_MXI1_I117_MP3 (XI1_I117_p1 I1_qu2 VDD VDD) gpdk090_pmos1v w=0.48u l=0.1u ad=0.1632p as=0.1056p pd=1.64u ps=0.92u
    I_MXI1_I117_MP0 (VDD I1_dd5 XI1_I117_An VDD) gpdk090_pmos1v w=0.24u l=0.1u ad=0.0816p as=0.0816p pd=1.16u ps=1.16u
    I_MXI1_I108_I40_MP1 (VDD I1_I108_G2_0n XI1_I108_I40_Bn VDD) gpdk090_pmos1v w=0.24u l=0.1u ad=0.0816p as=0.0816p pd=1.16u ps=1.16u
    I_MXI1_I108_I40_MP5 (I1_p5_3 XI1_I108_I40_Bn XI1_I108_I40_p1 VDD) gpdk090_pmos1v w=0.48u l=0.1u ad=0.1056p as=0.1632p pd=0.92u ps=1.64u
    I_MXI1_I108_I40_MP4 (XI1_I108_I40_p1 XI1_I108_I40_An I1_p5_3 VDD) gpdk090_pmos1v w=0.48u l=0.1u ad=0.1056p as=0.1056p pd=0.92u ps=0.92u
    I_MXI1_I108_I40_MP2 (VDD I1_I108_pn3 XI1_I108_I40_p1 VDD) gpdk090_pmos1v w=0.48u l=0.1u ad=0.1056p as=0.1056p pd=0.92u ps=0.92u
    I_MXI1_I108_I40_MP3 (XI1_I108_I40_p1 I1_I108_G2_0n VDD VDD) gpdk090_pmos1v w=0.48u l=0.1u ad=0.1632p as=0.1056p pd=1.64u ps=0.92u
    I_MXI1_I108_I40_MP0 (VDD I1_I108_pn3 XI1_I108_I40_An VDD) gpdk090_pmos1v w=0.24u l=0.1u ad=0.0816p as=0.0816p pd=1.16u ps=1.16u
    I_MXI1_I101_MP1 (VDD I1_qu3 XI1_I101_Bn VDD) gpdk090_pmos1v w=0.24u l=0.1u ad=0.0816p as=0.0816p pd=1.16u ps=1.16u
    I_MXI1_I101_MP5 (I1_b5_1 XI1_I101_Bn XI1_I101_p1 VDD) gpdk090_pmos1v w=0.48u l=0.1u ad=0.1056p as=0.1632p pd=0.92u ps=1.64u
    I_MXI1_I101_MP4 (XI1_I101_p1 XI1_I101_An I1_b5_1 VDD) gpdk090_pmos1v w=0.48u l=0.1u ad=0.1056p as=0.1056p pd=0.92u ps=0.92u
    I_MXI1_I101_MP2 (VDD I1_dd1 XI1_I101_p1 VDD) gpdk090_pmos1v w=0.48u l=0.1u ad=0.1056p as=0.1056p pd=0.92u ps=0.92u
    I_MXI1_I101_MP3 (XI1_I101_p1 I1_qu3 VDD VDD) gpdk090_pmos1v w=0.48u l=0.1u ad=0.1632p as=0.1056p pd=1.64u ps=0.92u
    I_MXI1_I101_MP0 (VDD I1_dd1 XI1_I101_An VDD) gpdk090_pmos1v w=0.24u l=0.1u ad=0.0816p as=0.0816p pd=1.16u ps=1.16u
    I_MXI1_I64_MP1 (VDD I1_qu6 XI1_I64_Bn VDD) gpdk090_pmos1v w=0.24u l=0.1u ad=0.0816p as=0.0816p pd=1.16u ps=1.16u
    I_MXI1_I64_MP5 (I1_b2_0 XI1_I64_Bn XI1_I64_p1 VDD) gpdk090_pmos1v w=0.48u l=0.1u ad=0.1056p as=0.1632p pd=0.92u ps=1.64u
    I_MXI1_I64_MP4 (XI1_I64_p1 XI1_I64_An I1_b2_0 VDD) gpdk090_pmos1v w=0.48u l=0.1u ad=0.1056p as=0.1056p pd=0.92u ps=0.92u
    I_MXI1_I64_MP2 (VDD B_0 XI1_I64_p1 VDD) gpdk090_pmos1v w=0.48u l=0.1u ad=0.1056p as=0.1056p pd=0.92u ps=0.92u
    I_MXI1_I64_MP3 (XI1_I64_p1 I1_qu6 VDD VDD) gpdk090_pmos1v w=0.48u l=0.1u ad=0.1632p as=0.1056p pd=1.64u ps=0.92u
    I_MXI1_I64_MP0 (VDD B_0 XI1_I64_An VDD) gpdk090_pmos1v w=0.24u l=0.1u ad=0.0816p as=0.0816p pd=1.16u ps=1.16u
    I_MXI1_I52_MP1 (VDD I1_qu7 XI1_I52_Bn VDD) gpdk090_pmos1v w=0.24u l=0.1u ad=0.0816p as=0.0816p pd=1.16u ps=1.16u
    I_MXI1_I52_MP5 (I1_b1_0 XI1_I52_Bn XI1_I52_p1 VDD) gpdk090_pmos1v w=0.48u l=0.1u ad=0.1056p as=0.1632p pd=0.92u ps=1.64u
    I_MXI1_I52_MP4 (XI1_I52_p1 XI1_I52_An I1_b1_0 VDD) gpdk090_pmos1v w=0.48u l=0.1u ad=0.1056p as=0.1056p pd=0.92u ps=0.92u
    I_MXI1_I52_MP2 (VDD B_0 XI1_I52_p1 VDD) gpdk090_pmos1v w=0.48u l=0.1u ad=0.1056p as=0.1056p pd=0.92u ps=0.92u
    I_MXI1_I52_MP3 (XI1_I52_p1 I1_qu7 VDD VDD) gpdk090_pmos1v w=0.48u l=0.1u ad=0.1632p as=0.1056p pd=1.64u ps=0.92u
    I_MXI1_I52_MP0 (VDD B_0 XI1_I52_An VDD) gpdk090_pmos1v w=0.24u l=0.1u ad=0.0816p as=0.0816p pd=1.16u ps=1.16u
    I_MXI1_I40_MP1 (VDD VDD XI1_I40_Bn VDD) gpdk090_pmos1v w=0.24u l=0.1u ad=0.0816p as=0.0816p pd=1.16u ps=1.16u
    I_MXI1_I40_MP5 (I1_b0_0 XI1_I40_Bn XI1_I40_p1 VDD) gpdk090_pmos1v w=0.48u l=0.1u ad=0.1056p as=0.1632p pd=0.92u ps=1.64u
    I_MXI1_I40_MP4 (XI1_I40_p1 XI1_I40_An I1_b0_0 VDD) gpdk090_pmos1v w=0.48u l=0.1u ad=0.1056p as=0.1056p pd=0.92u ps=0.92u
    I_MXI1_I40_MP2 (VDD B_0 XI1_I40_p1 VDD) gpdk090_pmos1v w=0.48u l=0.1u ad=0.1056p as=0.1056p pd=0.92u ps=0.92u
    I_MXI1_I40_MP3 (XI1_I40_p1 VDD VDD VDD) gpdk090_pmos1v w=0.48u l=0.1u ad=0.1632p as=0.1056p pd=1.64u ps=0.92u
    I_MXI1_I40_MP0 (VDD B_0 XI1_I40_An VDD) gpdk090_pmos1v w=0.24u l=0.1u ad=0.0816p as=0.0816p pd=1.16u ps=1.16u
    I_MXI2_I2_I16_MP1 (VDD B_2 XI2_I2_I16_Bn VDD) gpdk090_pmos1v w=0.24u l=0.1u ad=0.0816p as=0.0816p pd=1.16u ps=1.16u
    I_MXI2_I2_I16_MP5 (I2_XOR_2 XI2_I2_I16_Bn XI2_I2_I16_p1 VDD) gpdk090_pmos1v w=0.48u l=0.1u ad=0.1056p as=0.1632p pd=0.92u ps=1.64u
    I_MXI2_I2_I16_MP4 (XI2_I2_I16_p1 XI2_I2_I16_An I2_XOR_2 VDD) gpdk090_pmos1v w=0.48u l=0.1u ad=0.1056p as=0.1056p pd=0.92u ps=0.92u
    I_MXI2_I2_I16_MP2 (VDD A_2 XI2_I2_I16_p1 VDD) gpdk090_pmos1v w=0.48u l=0.1u ad=0.1056p as=0.1056p pd=0.92u ps=0.92u
    I_MXI2_I2_I16_MP3 (XI2_I2_I16_p1 B_2 VDD VDD) gpdk090_pmos1v w=0.48u l=0.1u ad=0.1632p as=0.1056p pd=1.64u ps=0.92u
    I_MXI2_I2_I16_MP0 (VDD A_2 XI2_I2_I16_An VDD) gpdk090_pmos1v w=0.24u l=0.1u ad=0.0816p as=0.0816p pd=1.16u ps=1.16u
    I_MXI1_I121_MP1 (VDD I1_qu2 XI1_I121_Bn VDD) gpdk090_pmos1v w=0.24u l=0.1u ad=0.0816p as=0.0816p pd=1.16u ps=1.16u
    I_MXI1_I121_MP5 (I1_h6 XI1_I121_Bn XI1_I121_p1 VDD) gpdk090_pmos1v w=0.48u l=0.1u ad=0.1056p as=0.1632p pd=0.92u ps=1.64u
    I_MXI1_I121_MP4 (XI1_I121_p1 XI1_I121_An I1_h6 VDD) gpdk090_pmos1v w=0.48u l=0.1u ad=0.1056p as=0.1056p pd=0.92u ps=0.92u
    I_MXI1_I121_MP2 (VDD I1_p5_7 XI1_I121_p1 VDD) gpdk090_pmos1v w=0.48u l=0.1u ad=0.1056p as=0.1056p pd=0.92u ps=0.92u
    I_MXI1_I121_MP3 (XI1_I121_p1 I1_qu2 VDD VDD) gpdk090_pmos1v w=0.48u l=0.1u ad=0.1632p as=0.1056p pd=1.64u ps=0.92u
    I_MXI1_I121_MP0 (VDD I1_p5_7 XI1_I121_An VDD) gpdk090_pmos1v w=0.24u l=0.1u ad=0.0816p as=0.0816p pd=1.16u ps=1.16u
    I_MXI1_I108_I41_MP1 (VDD I1_I108_G3_0n XI1_I108_I41_Bn VDD) gpdk090_pmos1v w=0.24u l=0.1u ad=0.0816p as=0.0816p pd=1.16u ps=1.16u
    I_MXI1_I108_I41_MP5 (I1_p5_4 XI1_I108_I41_Bn XI1_I108_I41_p1 VDD) gpdk090_pmos1v w=0.48u l=0.1u ad=0.1056p as=0.1632p pd=0.92u ps=1.64u
    I_MXI1_I108_I41_MP4 (XI1_I108_I41_p1 XI1_I108_I41_An I1_p5_4 VDD) gpdk090_pmos1v w=0.48u l=0.1u ad=0.1056p as=0.1056p pd=0.92u ps=0.92u
    I_MXI1_I108_I41_MP2 (VDD I1_I108_pn4 XI1_I108_I41_p1 VDD) gpdk090_pmos1v w=0.48u l=0.1u ad=0.1056p as=0.1056p pd=0.92u ps=0.92u
    I_MXI1_I108_I41_MP3 (XI1_I108_I41_p1 I1_I108_G3_0n VDD VDD) gpdk090_pmos1v w=0.48u l=0.1u ad=0.1632p as=0.1056p pd=1.64u ps=0.92u
    I_MXI1_I108_I41_MP0 (VDD I1_I108_pn4 XI1_I108_I41_An VDD) gpdk090_pmos1v w=0.24u l=0.1u ad=0.0816p as=0.0816p pd=1.16u ps=1.16u
    I_MXI1_I102_MP1 (VDD I1_qu3 XI1_I102_Bn VDD) gpdk090_pmos1v w=0.24u l=0.1u ad=0.0816p as=0.0816p pd=1.16u ps=1.16u
    I_MXI1_I102_MP5 (I1_b5_2 XI1_I102_Bn XI1_I102_p1 VDD) gpdk090_pmos1v w=0.48u l=0.1u ad=0.1056p as=0.1632p pd=0.92u ps=1.64u
    I_MXI1_I102_MP4 (XI1_I102_p1 XI1_I102_An I1_b5_2 VDD) gpdk090_pmos1v w=0.48u l=0.1u ad=0.1056p as=0.1056p pd=0.92u ps=0.92u
    I_MXI1_I102_MP2 (VDD I1_dd2 XI1_I102_p1 VDD) gpdk090_pmos1v w=0.48u l=0.1u ad=0.1056p as=0.1056p pd=0.92u ps=0.92u
    I_MXI1_I102_MP3 (XI1_I102_p1 I1_qu3 VDD VDD) gpdk090_pmos1v w=0.48u l=0.1u ad=0.1632p as=0.1056p pd=1.64u ps=0.92u
    I_MXI1_I102_MP0 (VDD I1_dd2 XI1_I102_An VDD) gpdk090_pmos1v w=0.24u l=0.1u ad=0.0816p as=0.0816p pd=1.16u ps=1.16u
    I_MXI1_I90_MP1 (VDD I1_qu4 XI1_I90_Bn VDD) gpdk090_pmos1v w=0.24u l=0.1u ad=0.0816p as=0.0816p pd=1.16u ps=1.16u
    I_MXI1_I90_MP5 (I1_b4_2 XI1_I90_Bn XI1_I90_p1 VDD) gpdk090_pmos1v w=0.48u l=0.1u ad=0.1056p as=0.1632p pd=0.92u ps=1.64u
    I_MXI1_I90_MP4 (XI1_I90_p1 XI1_I90_An I1_b4_2 VDD) gpdk090_pmos1v w=0.48u l=0.1u ad=0.1056p as=0.1056p pd=0.92u ps=0.92u
    I_MXI1_I90_MP2 (VDD I1_dd2 XI1_I90_p1 VDD) gpdk090_pmos1v w=0.48u l=0.1u ad=0.1056p as=0.1056p pd=0.92u ps=0.92u
    I_MXI1_I90_MP3 (XI1_I90_p1 I1_qu4 VDD VDD) gpdk090_pmos1v w=0.48u l=0.1u ad=0.1632p as=0.1056p pd=1.64u ps=0.92u
    I_MXI1_I90_MP0 (VDD I1_dd2 XI1_I90_An VDD) gpdk090_pmos1v w=0.24u l=0.1u ad=0.0816p as=0.0816p pd=1.16u ps=1.16u
    I_MXI1_I89_MP1 (VDD I1_qu4 XI1_I89_Bn VDD) gpdk090_pmos1v w=0.24u l=0.1u ad=0.0816p as=0.0816p pd=1.16u ps=1.16u
    I_MXI1_I89_MP5 (I1_b4_1 XI1_I89_Bn XI1_I89_p1 VDD) gpdk090_pmos1v w=0.48u l=0.1u ad=0.1056p as=0.1632p pd=0.92u ps=1.64u
    I_MXI1_I89_MP4 (XI1_I89_p1 XI1_I89_An I1_b4_1 VDD) gpdk090_pmos1v w=0.48u l=0.1u ad=0.1056p as=0.1056p pd=0.92u ps=0.92u
    I_MXI1_I89_MP2 (VDD I1_dd1 XI1_I89_p1 VDD) gpdk090_pmos1v w=0.48u l=0.1u ad=0.1056p as=0.1056p pd=0.92u ps=0.92u
    I_MXI1_I89_MP3 (XI1_I89_p1 I1_qu4 VDD VDD) gpdk090_pmos1v w=0.48u l=0.1u ad=0.1632p as=0.1056p pd=1.64u ps=0.92u
    I_MXI1_I89_MP0 (VDD I1_dd1 XI1_I89_An VDD) gpdk090_pmos1v w=0.24u l=0.1u ad=0.0816p as=0.0816p pd=1.16u ps=1.16u
    I_MXI1_I88_MP1 (VDD I1_qu4 XI1_I88_Bn VDD) gpdk090_pmos1v w=0.24u l=0.1u ad=0.0816p as=0.0816p pd=1.16u ps=1.16u
    I_MXI1_I88_MP5 (I1_b4_0 XI1_I88_Bn XI1_I88_p1 VDD) gpdk090_pmos1v w=0.48u l=0.1u ad=0.1056p as=0.1632p pd=0.92u ps=1.64u
    I_MXI1_I88_MP4 (XI1_I88_p1 XI1_I88_An I1_b4_0 VDD) gpdk090_pmos1v w=0.48u l=0.1u ad=0.1056p as=0.1056p pd=0.92u ps=0.92u
    I_MXI1_I88_MP2 (VDD B_0 XI1_I88_p1 VDD) gpdk090_pmos1v w=0.48u l=0.1u ad=0.1056p as=0.1056p pd=0.92u ps=0.92u
    I_MXI1_I88_MP3 (XI1_I88_p1 I1_qu4 VDD VDD) gpdk090_pmos1v w=0.48u l=0.1u ad=0.1632p as=0.1056p pd=1.64u ps=0.92u
    I_MXI1_I88_MP0 (VDD B_0 XI1_I88_An VDD) gpdk090_pmos1v w=0.24u l=0.1u ad=0.0816p as=0.0816p pd=1.16u ps=1.16u
    I_MXI1_I77_MP1 (VDD I1_qu5 XI1_I77_Bn VDD) gpdk090_pmos1v w=0.24u l=0.1u ad=0.0816p as=0.0816p pd=1.16u ps=1.16u
    I_MXI1_I77_MP5 (I1_b3_1 XI1_I77_Bn XI1_I77_p1 VDD) gpdk090_pmos1v w=0.48u l=0.1u ad=0.1056p as=0.1632p pd=0.92u ps=1.64u
    I_MXI1_I77_MP4 (XI1_I77_p1 XI1_I77_An I1_b3_1 VDD) gpdk090_pmos1v w=0.48u l=0.1u ad=0.1056p as=0.1056p pd=0.92u ps=0.92u
    I_MXI1_I77_MP2 (VDD I1_dd1 XI1_I77_p1 VDD) gpdk090_pmos1v w=0.48u l=0.1u ad=0.1056p as=0.1056p pd=0.92u ps=0.92u
    I_MXI1_I77_MP3 (XI1_I77_p1 I1_qu5 VDD VDD) gpdk090_pmos1v w=0.48u l=0.1u ad=0.1632p as=0.1056p pd=1.64u ps=0.92u
    I_MXI1_I77_MP0 (VDD I1_dd1 XI1_I77_An VDD) gpdk090_pmos1v w=0.24u l=0.1u ad=0.0816p as=0.0816p pd=1.16u ps=1.16u
    I_MXI1_I78_MP1 (VDD I1_qu5 XI1_I78_Bn VDD) gpdk090_pmos1v w=0.24u l=0.1u ad=0.0816p as=0.0816p pd=1.16u ps=1.16u
    I_MXI1_I78_MP5 (I1_b3_2 XI1_I78_Bn XI1_I78_p1 VDD) gpdk090_pmos1v w=0.48u l=0.1u ad=0.1056p as=0.1632p pd=0.92u ps=1.64u
    I_MXI1_I78_MP4 (XI1_I78_p1 XI1_I78_An I1_b3_2 VDD) gpdk090_pmos1v w=0.48u l=0.1u ad=0.1056p as=0.1056p pd=0.92u ps=0.92u
    I_MXI1_I78_MP2 (VDD I1_dd2 XI1_I78_p1 VDD) gpdk090_pmos1v w=0.48u l=0.1u ad=0.1056p as=0.1056p pd=0.92u ps=0.92u
    I_MXI1_I78_MP3 (XI1_I78_p1 I1_qu5 VDD VDD) gpdk090_pmos1v w=0.48u l=0.1u ad=0.1632p as=0.1056p pd=1.64u ps=0.92u
    I_MXI1_I78_MP0 (VDD I1_dd2 XI1_I78_An VDD) gpdk090_pmos1v w=0.24u l=0.1u ad=0.0816p as=0.0816p pd=1.16u ps=1.16u
    I_MXI1_I76_MP1 (VDD I1_qu5 XI1_I76_Bn VDD) gpdk090_pmos1v w=0.24u l=0.1u ad=0.0816p as=0.0816p pd=1.16u ps=1.16u
    I_MXI1_I76_MP5 (I1_b3_0 XI1_I76_Bn XI1_I76_p1 VDD) gpdk090_pmos1v w=0.48u l=0.1u ad=0.1056p as=0.1632p pd=0.92u ps=1.64u
    I_MXI1_I76_MP4 (XI1_I76_p1 XI1_I76_An I1_b3_0 VDD) gpdk090_pmos1v w=0.48u l=0.1u ad=0.1056p as=0.1056p pd=0.92u ps=0.92u
    I_MXI1_I76_MP2 (VDD B_0 XI1_I76_p1 VDD) gpdk090_pmos1v w=0.48u l=0.1u ad=0.1056p as=0.1056p pd=0.92u ps=0.92u
    I_MXI1_I76_MP3 (XI1_I76_p1 I1_qu5 VDD VDD) gpdk090_pmos1v w=0.48u l=0.1u ad=0.1632p as=0.1056p pd=1.64u ps=0.92u
    I_MXI1_I76_MP0 (VDD B_0 XI1_I76_An VDD) gpdk090_pmos1v w=0.24u l=0.1u ad=0.0816p as=0.0816p pd=1.16u ps=1.16u
    I_MXI1_I65_MP1 (VDD I1_qu6 XI1_I65_Bn VDD) gpdk090_pmos1v w=0.24u l=0.1u ad=0.0816p as=0.0816p pd=1.16u ps=1.16u
    I_MXI1_I65_MP5 (I1_b2_1 XI1_I65_Bn XI1_I65_p1 VDD) gpdk090_pmos1v w=0.48u l=0.1u ad=0.1056p as=0.1632p pd=0.92u ps=1.64u
    I_MXI1_I65_MP4 (XI1_I65_p1 XI1_I65_An I1_b2_1 VDD) gpdk090_pmos1v w=0.48u l=0.1u ad=0.1056p as=0.1056p pd=0.92u ps=0.92u
    I_MXI1_I65_MP2 (VDD I1_dd1 XI1_I65_p1 VDD) gpdk090_pmos1v w=0.48u l=0.1u ad=0.1056p as=0.1056p pd=0.92u ps=0.92u
    I_MXI1_I65_MP3 (XI1_I65_p1 I1_qu6 VDD VDD) gpdk090_pmos1v w=0.48u l=0.1u ad=0.1632p as=0.1056p pd=1.64u ps=0.92u
    I_MXI1_I65_MP0 (VDD I1_dd1 XI1_I65_An VDD) gpdk090_pmos1v w=0.24u l=0.1u ad=0.0816p as=0.0816p pd=1.16u ps=1.16u
    I_MXI1_I66_MP1 (VDD I1_qu6 XI1_I66_Bn VDD) gpdk090_pmos1v w=0.24u l=0.1u ad=0.0816p as=0.0816p pd=1.16u ps=1.16u
    I_MXI1_I66_MP5 (I1_b2_2 XI1_I66_Bn XI1_I66_p1 VDD) gpdk090_pmos1v w=0.48u l=0.1u ad=0.1056p as=0.1632p pd=0.92u ps=1.64u
    I_MXI1_I66_MP4 (XI1_I66_p1 XI1_I66_An I1_b2_2 VDD) gpdk090_pmos1v w=0.48u l=0.1u ad=0.1056p as=0.1056p pd=0.92u ps=0.92u
    I_MXI1_I66_MP2 (VDD I1_dd2 XI1_I66_p1 VDD) gpdk090_pmos1v w=0.48u l=0.1u ad=0.1056p as=0.1056p pd=0.92u ps=0.92u
    I_MXI1_I66_MP3 (XI1_I66_p1 I1_qu6 VDD VDD) gpdk090_pmos1v w=0.48u l=0.1u ad=0.1632p as=0.1056p pd=1.64u ps=0.92u
    I_MXI1_I66_MP0 (VDD I1_dd2 XI1_I66_An VDD) gpdk090_pmos1v w=0.24u l=0.1u ad=0.0816p as=0.0816p pd=1.16u ps=1.16u
    I_MXI1_I53_MP1 (VDD I1_qu7 XI1_I53_Bn VDD) gpdk090_pmos1v w=0.24u l=0.1u ad=0.0816p as=0.0816p pd=1.16u ps=1.16u
    I_MXI1_I53_MP5 (I1_b1_1 XI1_I53_Bn XI1_I53_p1 VDD) gpdk090_pmos1v w=0.48u l=0.1u ad=0.1056p as=0.1632p pd=0.92u ps=1.64u
    I_MXI1_I53_MP4 (XI1_I53_p1 XI1_I53_An I1_b1_1 VDD) gpdk090_pmos1v w=0.48u l=0.1u ad=0.1056p as=0.1056p pd=0.92u ps=0.92u
    I_MXI1_I53_MP2 (VDD I1_dd1 XI1_I53_p1 VDD) gpdk090_pmos1v w=0.48u l=0.1u ad=0.1056p as=0.1056p pd=0.92u ps=0.92u
    I_MXI1_I53_MP3 (XI1_I53_p1 I1_qu7 VDD VDD) gpdk090_pmos1v w=0.48u l=0.1u ad=0.1632p as=0.1056p pd=1.64u ps=0.92u
    I_MXI1_I53_MP0 (VDD I1_dd1 XI1_I53_An VDD) gpdk090_pmos1v w=0.24u l=0.1u ad=0.0816p as=0.0816p pd=1.16u ps=1.16u
    I_MXI1_I54_MP1 (VDD I1_qu7 XI1_I54_Bn VDD) gpdk090_pmos1v w=0.24u l=0.1u ad=0.0816p as=0.0816p pd=1.16u ps=1.16u
    I_MXI1_I54_MP5 (I1_b1_2 XI1_I54_Bn XI1_I54_p1 VDD) gpdk090_pmos1v w=0.48u l=0.1u ad=0.1056p as=0.1632p pd=0.92u ps=1.64u
    I_MXI1_I54_MP4 (XI1_I54_p1 XI1_I54_An I1_b1_2 VDD) gpdk090_pmos1v w=0.48u l=0.1u ad=0.1056p as=0.1056p pd=0.92u ps=0.92u
    I_MXI1_I54_MP2 (VDD I1_dd2 XI1_I54_p1 VDD) gpdk090_pmos1v w=0.48u l=0.1u ad=0.1056p as=0.1056p pd=0.92u ps=0.92u
    I_MXI1_I54_MP3 (XI1_I54_p1 I1_qu7 VDD VDD) gpdk090_pmos1v w=0.48u l=0.1u ad=0.1632p as=0.1056p pd=1.64u ps=0.92u
    I_MXI1_I54_MP0 (VDD I1_dd2 XI1_I54_An VDD) gpdk090_pmos1v w=0.24u l=0.1u ad=0.0816p as=0.0816p pd=1.16u ps=1.16u
    I_MXI1_I43_MP1 (VDD VDD XI1_I43_Bn VDD) gpdk090_pmos1v w=0.24u l=0.1u ad=0.0816p as=0.0816p pd=1.16u ps=1.16u
    I_MXI1_I43_MP5 (I1_b0_3 XI1_I43_Bn XI1_I43_p1 VDD) gpdk090_pmos1v w=0.48u l=0.1u ad=0.1056p as=0.1632p pd=0.92u ps=1.64u
    I_MXI1_I43_MP4 (XI1_I43_p1 XI1_I43_An I1_b0_3 VDD) gpdk090_pmos1v w=0.48u l=0.1u ad=0.1056p as=0.1056p pd=0.92u ps=0.92u
    I_MXI1_I43_MP2 (VDD I1_dd3 XI1_I43_p1 VDD) gpdk090_pmos1v w=0.48u l=0.1u ad=0.1056p as=0.1056p pd=0.92u ps=0.92u
    I_MXI1_I43_MP3 (XI1_I43_p1 VDD VDD VDD) gpdk090_pmos1v w=0.48u l=0.1u ad=0.1632p as=0.1056p pd=1.64u ps=0.92u
    I_MXI1_I43_MP0 (VDD I1_dd3 XI1_I43_An VDD) gpdk090_pmos1v w=0.24u l=0.1u ad=0.0816p as=0.0816p pd=1.16u ps=1.16u
    I_MXI1_I41_MP1 (VDD VDD XI1_I41_Bn VDD) gpdk090_pmos1v w=0.24u l=0.1u ad=0.0816p as=0.0816p pd=1.16u ps=1.16u
    I_MXI1_I41_MP5 (I1_b0_1 XI1_I41_Bn XI1_I41_p1 VDD) gpdk090_pmos1v w=0.48u l=0.1u ad=0.1056p as=0.1632p pd=0.92u ps=1.64u
    I_MXI1_I41_MP4 (XI1_I41_p1 XI1_I41_An I1_b0_1 VDD) gpdk090_pmos1v w=0.48u l=0.1u ad=0.1056p as=0.1056p pd=0.92u ps=0.92u
    I_MXI1_I41_MP2 (VDD I1_dd1 XI1_I41_p1 VDD) gpdk090_pmos1v w=0.48u l=0.1u ad=0.1056p as=0.1056p pd=0.92u ps=0.92u
    I_MXI1_I41_MP3 (XI1_I41_p1 VDD VDD VDD) gpdk090_pmos1v w=0.48u l=0.1u ad=0.1632p as=0.1056p pd=1.64u ps=0.92u
    I_MXI1_I41_MP0 (VDD I1_dd1 XI1_I41_An VDD) gpdk090_pmos1v w=0.24u l=0.1u ad=0.0816p as=0.0816p pd=1.16u ps=1.16u
    I_MXI1_I42_MP1 (VDD VDD XI1_I42_Bn VDD) gpdk090_pmos1v w=0.24u l=0.1u ad=0.0816p as=0.0816p pd=1.16u ps=1.16u
    I_MXI1_I42_MP5 (I1_b0_2 XI1_I42_Bn XI1_I42_p1 VDD) gpdk090_pmos1v w=0.48u l=0.1u ad=0.1056p as=0.1632p pd=0.92u ps=1.64u
    I_MXI1_I42_MP4 (XI1_I42_p1 XI1_I42_An I1_b0_2 VDD) gpdk090_pmos1v w=0.48u l=0.1u ad=0.1056p as=0.1056p pd=0.92u ps=0.92u
    I_MXI1_I42_MP2 (VDD I1_dd2 XI1_I42_p1 VDD) gpdk090_pmos1v w=0.48u l=0.1u ad=0.1056p as=0.1056p pd=0.92u ps=0.92u
    I_MXI1_I42_MP3 (XI1_I42_p1 VDD VDD VDD) gpdk090_pmos1v w=0.48u l=0.1u ad=0.1632p as=0.1056p pd=1.64u ps=0.92u
    I_MXI1_I42_MP0 (VDD I1_dd2 XI1_I42_An VDD) gpdk090_pmos1v w=0.24u l=0.1u ad=0.0816p as=0.0816p pd=1.16u ps=1.16u
    I_MXI1_I103_MP1 (VDD I1_qu3 XI1_I103_Bn VDD) gpdk090_pmos1v w=0.24u l=0.1u ad=0.0816p as=0.0816p pd=1.16u ps=1.16u
    I_MXI1_I103_MP5 (I1_b5_3 XI1_I103_Bn XI1_I103_p1 VDD) gpdk090_pmos1v w=0.48u l=0.1u ad=0.1056p as=0.1632p pd=0.92u ps=1.64u
    I_MXI1_I103_MP4 (XI1_I103_p1 XI1_I103_An I1_b5_3 VDD) gpdk090_pmos1v w=0.48u l=0.1u ad=0.1056p as=0.1056p pd=0.92u ps=0.92u
    I_MXI1_I103_MP2 (VDD I1_dd3 XI1_I103_p1 VDD) gpdk090_pmos1v w=0.48u l=0.1u ad=0.1056p as=0.1056p pd=0.92u ps=0.92u
    I_MXI1_I103_MP3 (XI1_I103_p1 I1_qu3 VDD VDD) gpdk090_pmos1v w=0.48u l=0.1u ad=0.1632p as=0.1056p pd=1.64u ps=0.92u
    I_MXI1_I103_MP0 (VDD I1_dd3 XI1_I103_An VDD) gpdk090_pmos1v w=0.24u l=0.1u ad=0.0816p as=0.0816p pd=1.16u ps=1.16u
    I_MXI1_I91_MP1 (VDD I1_qu4 XI1_I91_Bn VDD) gpdk090_pmos1v w=0.24u l=0.1u ad=0.0816p as=0.0816p pd=1.16u ps=1.16u
    I_MXI1_I91_MP5 (I1_b4_3 XI1_I91_Bn XI1_I91_p1 VDD) gpdk090_pmos1v w=0.48u l=0.1u ad=0.1056p as=0.1632p pd=0.92u ps=1.64u
    I_MXI1_I91_MP4 (XI1_I91_p1 XI1_I91_An I1_b4_3 VDD) gpdk090_pmos1v w=0.48u l=0.1u ad=0.1056p as=0.1056p pd=0.92u ps=0.92u
    I_MXI1_I91_MP2 (VDD I1_dd3 XI1_I91_p1 VDD) gpdk090_pmos1v w=0.48u l=0.1u ad=0.1056p as=0.1056p pd=0.92u ps=0.92u
    I_MXI1_I91_MP3 (XI1_I91_p1 I1_qu4 VDD VDD) gpdk090_pmos1v w=0.48u l=0.1u ad=0.1632p as=0.1056p pd=1.64u ps=0.92u
    I_MXI1_I91_MP0 (VDD I1_dd3 XI1_I91_An VDD) gpdk090_pmos1v w=0.24u l=0.1u ad=0.0816p as=0.0816p pd=1.16u ps=1.16u
    I_MXI1_I79_MP1 (VDD I1_qu5 XI1_I79_Bn VDD) gpdk090_pmos1v w=0.24u l=0.1u ad=0.0816p as=0.0816p pd=1.16u ps=1.16u
    I_MXI1_I79_MP5 (I1_b3_3 XI1_I79_Bn XI1_I79_p1 VDD) gpdk090_pmos1v w=0.48u l=0.1u ad=0.1056p as=0.1632p pd=0.92u ps=1.64u
    I_MXI1_I79_MP4 (XI1_I79_p1 XI1_I79_An I1_b3_3 VDD) gpdk090_pmos1v w=0.48u l=0.1u ad=0.1056p as=0.1056p pd=0.92u ps=0.92u
    I_MXI1_I79_MP2 (VDD I1_dd3 XI1_I79_p1 VDD) gpdk090_pmos1v w=0.48u l=0.1u ad=0.1056p as=0.1056p pd=0.92u ps=0.92u
    I_MXI1_I79_MP3 (XI1_I79_p1 I1_qu5 VDD VDD) gpdk090_pmos1v w=0.48u l=0.1u ad=0.1632p as=0.1056p pd=1.64u ps=0.92u
    I_MXI1_I79_MP0 (VDD I1_dd3 XI1_I79_An VDD) gpdk090_pmos1v w=0.24u l=0.1u ad=0.0816p as=0.0816p pd=1.16u ps=1.16u
    I_MXI1_I67_MP1 (VDD I1_qu6 XI1_I67_Bn VDD) gpdk090_pmos1v w=0.24u l=0.1u ad=0.0816p as=0.0816p pd=1.16u ps=1.16u
    I_MXI1_I67_MP5 (I1_b2_3 XI1_I67_Bn XI1_I67_p1 VDD) gpdk090_pmos1v w=0.48u l=0.1u ad=0.1056p as=0.1632p pd=0.92u ps=1.64u
    I_MXI1_I67_MP4 (XI1_I67_p1 XI1_I67_An I1_b2_3 VDD) gpdk090_pmos1v w=0.48u l=0.1u ad=0.1056p as=0.1056p pd=0.92u ps=0.92u
    I_MXI1_I67_MP2 (VDD I1_dd3 XI1_I67_p1 VDD) gpdk090_pmos1v w=0.48u l=0.1u ad=0.1056p as=0.1056p pd=0.92u ps=0.92u
    I_MXI1_I67_MP3 (XI1_I67_p1 I1_qu6 VDD VDD) gpdk090_pmos1v w=0.48u l=0.1u ad=0.1632p as=0.1056p pd=1.64u ps=0.92u
    I_MXI1_I67_MP0 (VDD I1_dd3 XI1_I67_An VDD) gpdk090_pmos1v w=0.24u l=0.1u ad=0.0816p as=0.0816p pd=1.16u ps=1.16u
    I_MXI1_I55_MP1 (VDD I1_qu7 XI1_I55_Bn VDD) gpdk090_pmos1v w=0.24u l=0.1u ad=0.0816p as=0.0816p pd=1.16u ps=1.16u
    I_MXI1_I55_MP5 (I1_b1_3 XI1_I55_Bn XI1_I55_p1 VDD) gpdk090_pmos1v w=0.48u l=0.1u ad=0.1056p as=0.1632p pd=0.92u ps=1.64u
    I_MXI1_I55_MP4 (XI1_I55_p1 XI1_I55_An I1_b1_3 VDD) gpdk090_pmos1v w=0.48u l=0.1u ad=0.1056p as=0.1056p pd=0.92u ps=0.92u
    I_MXI1_I55_MP2 (VDD I1_dd3 XI1_I55_p1 VDD) gpdk090_pmos1v w=0.48u l=0.1u ad=0.1056p as=0.1056p pd=0.92u ps=0.92u
    I_MXI1_I55_MP3 (XI1_I55_p1 I1_qu7 VDD VDD) gpdk090_pmos1v w=0.48u l=0.1u ad=0.1632p as=0.1056p pd=1.64u ps=0.92u
    I_MXI1_I55_MP0 (VDD I1_dd3 XI1_I55_An VDD) gpdk090_pmos1v w=0.24u l=0.1u ad=0.0816p as=0.0816p pd=1.16u ps=1.16u
    I_MXI1_I104_MP1 (VDD I1_qu3 XI1_I104_Bn VDD) gpdk090_pmos1v w=0.24u l=0.1u ad=0.0816p as=0.0816p pd=1.16u ps=1.16u
    I_MXI1_I104_MP5 (I1_b5_4 XI1_I104_Bn XI1_I104_p1 VDD) gpdk090_pmos1v w=0.48u l=0.1u ad=0.1056p as=0.1632p pd=0.92u ps=1.64u
    I_MXI1_I104_MP4 (XI1_I104_p1 XI1_I104_An I1_b5_4 VDD) gpdk090_pmos1v w=0.48u l=0.1u ad=0.1056p as=0.1056p pd=0.92u ps=0.92u
    I_MXI1_I104_MP2 (VDD I1_dd4 XI1_I104_p1 VDD) gpdk090_pmos1v w=0.48u l=0.1u ad=0.1056p as=0.1056p pd=0.92u ps=0.92u
    I_MXI1_I104_MP3 (XI1_I104_p1 I1_qu3 VDD VDD) gpdk090_pmos1v w=0.48u l=0.1u ad=0.1632p as=0.1056p pd=1.64u ps=0.92u
    I_MXI1_I104_MP0 (VDD I1_dd4 XI1_I104_An VDD) gpdk090_pmos1v w=0.24u l=0.1u ad=0.0816p as=0.0816p pd=1.16u ps=1.16u
    I_MXI1_I96_I40_MP1 (VDD I1_I96_G2_0n XI1_I96_I40_Bn VDD) gpdk090_pmos1v w=0.24u l=0.1u ad=0.0816p as=0.0816p pd=1.16u ps=1.16u
    I_MXI1_I96_I40_MP5 (I1_p4_3 XI1_I96_I40_Bn XI1_I96_I40_p1 VDD) gpdk090_pmos1v w=0.48u l=0.1u ad=0.1056p as=0.1632p pd=0.92u ps=1.64u
    I_MXI1_I96_I40_MP4 (XI1_I96_I40_p1 XI1_I96_I40_An I1_p4_3 VDD) gpdk090_pmos1v w=0.48u l=0.1u ad=0.1056p as=0.1056p pd=0.92u ps=0.92u
    I_MXI1_I96_I40_MP2 (VDD I1_I96_pn3 XI1_I96_I40_p1 VDD) gpdk090_pmos1v w=0.48u l=0.1u ad=0.1056p as=0.1056p pd=0.92u ps=0.92u
    I_MXI1_I96_I40_MP3 (XI1_I96_I40_p1 I1_I96_G2_0n VDD VDD) gpdk090_pmos1v w=0.48u l=0.1u ad=0.1632p as=0.1056p pd=1.64u ps=0.92u
    I_MXI1_I96_I40_MP0 (VDD I1_I96_pn3 XI1_I96_I40_An VDD) gpdk090_pmos1v w=0.24u l=0.1u ad=0.0816p as=0.0816p pd=1.16u ps=1.16u
    I_MXI1_I80_MP1 (VDD I1_qu5 XI1_I80_Bn VDD) gpdk090_pmos1v w=0.24u l=0.1u ad=0.0816p as=0.0816p pd=1.16u ps=1.16u
    I_MXI1_I80_MP5 (I1_b3_4 XI1_I80_Bn XI1_I80_p1 VDD) gpdk090_pmos1v w=0.48u l=0.1u ad=0.1056p as=0.1632p pd=0.92u ps=1.64u
    I_MXI1_I80_MP4 (XI1_I80_p1 XI1_I80_An I1_b3_4 VDD) gpdk090_pmos1v w=0.48u l=0.1u ad=0.1056p as=0.1056p pd=0.92u ps=0.92u
    I_MXI1_I80_MP2 (VDD I1_dd4 XI1_I80_p1 VDD) gpdk090_pmos1v w=0.48u l=0.1u ad=0.1056p as=0.1056p pd=0.92u ps=0.92u
    I_MXI1_I80_MP3 (XI1_I80_p1 I1_qu5 VDD VDD) gpdk090_pmos1v w=0.48u l=0.1u ad=0.1632p as=0.1056p pd=1.64u ps=0.92u
    I_MXI1_I80_MP0 (VDD I1_dd4 XI1_I80_An VDD) gpdk090_pmos1v w=0.24u l=0.1u ad=0.0816p as=0.0816p pd=1.16u ps=1.16u
    I_MXI1_I68_MP1 (VDD I1_qu6 XI1_I68_Bn VDD) gpdk090_pmos1v w=0.24u l=0.1u ad=0.0816p as=0.0816p pd=1.16u ps=1.16u
    I_MXI1_I68_MP5 (I1_b2_4 XI1_I68_Bn XI1_I68_p1 VDD) gpdk090_pmos1v w=0.48u l=0.1u ad=0.1056p as=0.1632p pd=0.92u ps=1.64u
    I_MXI1_I68_MP4 (XI1_I68_p1 XI1_I68_An I1_b2_4 VDD) gpdk090_pmos1v w=0.48u l=0.1u ad=0.1056p as=0.1056p pd=0.92u ps=0.92u
    I_MXI1_I68_MP2 (VDD I1_dd4 XI1_I68_p1 VDD) gpdk090_pmos1v w=0.48u l=0.1u ad=0.1056p as=0.1056p pd=0.92u ps=0.92u
    I_MXI1_I68_MP3 (XI1_I68_p1 I1_qu6 VDD VDD) gpdk090_pmos1v w=0.48u l=0.1u ad=0.1632p as=0.1056p pd=1.64u ps=0.92u
    I_MXI1_I68_MP0 (VDD I1_dd4 XI1_I68_An VDD) gpdk090_pmos1v w=0.24u l=0.1u ad=0.0816p as=0.0816p pd=1.16u ps=1.16u
    I_MXI1_I44_MP1 (VDD VDD XI1_I44_Bn VDD) gpdk090_pmos1v w=0.24u l=0.1u ad=0.0816p as=0.0816p pd=1.16u ps=1.16u
    I_MXI1_I44_MP5 (I1_b0_4 XI1_I44_Bn XI1_I44_p1 VDD) gpdk090_pmos1v w=0.48u l=0.1u ad=0.1056p as=0.1632p pd=0.92u ps=1.64u
    I_MXI1_I44_MP4 (XI1_I44_p1 XI1_I44_An I1_b0_4 VDD) gpdk090_pmos1v w=0.48u l=0.1u ad=0.1056p as=0.1056p pd=0.92u ps=0.92u
    I_MXI1_I44_MP2 (VDD I1_dd4 XI1_I44_p1 VDD) gpdk090_pmos1v w=0.48u l=0.1u ad=0.1056p as=0.1056p pd=0.92u ps=0.92u
    I_MXI1_I44_MP3 (XI1_I44_p1 VDD VDD VDD) gpdk090_pmos1v w=0.48u l=0.1u ad=0.1632p as=0.1056p pd=1.64u ps=0.92u
    I_MXI1_I44_MP0 (VDD I1_dd4 XI1_I44_An VDD) gpdk090_pmos1v w=0.24u l=0.1u ad=0.0816p as=0.0816p pd=1.16u ps=1.16u
    I_MXI1_I56_MP1 (VDD I1_qu7 XI1_I56_Bn VDD) gpdk090_pmos1v w=0.24u l=0.1u ad=0.0816p as=0.0816p pd=1.16u ps=1.16u
    I_MXI1_I56_MP5 (I1_b1_4 XI1_I56_Bn XI1_I56_p1 VDD) gpdk090_pmos1v w=0.48u l=0.1u ad=0.1056p as=0.1632p pd=0.92u ps=1.64u
    I_MXI1_I56_MP4 (XI1_I56_p1 XI1_I56_An I1_b1_4 VDD) gpdk090_pmos1v w=0.48u l=0.1u ad=0.1056p as=0.1056p pd=0.92u ps=0.92u
    I_MXI1_I56_MP2 (VDD I1_dd4 XI1_I56_p1 VDD) gpdk090_pmos1v w=0.48u l=0.1u ad=0.1056p as=0.1056p pd=0.92u ps=0.92u
    I_MXI1_I56_MP3 (XI1_I56_p1 I1_qu7 VDD VDD) gpdk090_pmos1v w=0.48u l=0.1u ad=0.1632p as=0.1056p pd=1.64u ps=0.92u
    I_MXI1_I56_MP0 (VDD I1_dd4 XI1_I56_An VDD) gpdk090_pmos1v w=0.24u l=0.1u ad=0.0816p as=0.0816p pd=1.16u ps=1.16u
    I_MXI1_I110_MP1 (VDD I1_c5_8 XI1_I110_Bn VDD) gpdk090_pmos1v w=0.24u l=0.1u ad=0.0816p as=0.0816p pd=1.16u ps=1.16u
    I_MXI1_I110_MP5 (I1_p5_8 XI1_I110_Bn XI1_I110_p1 VDD) gpdk090_pmos1v w=0.48u l=0.1u ad=0.1056p as=0.1632p pd=0.92u ps=1.64u
    I_MXI1_I110_MP4 (XI1_I110_p1 XI1_I110_An I1_p5_8 VDD) gpdk090_pmos1v w=0.48u l=0.1u ad=0.1056p as=0.1056p pd=0.92u ps=0.92u
    I_MXI1_I110_MP2 (VDD I1_h5 XI1_I110_p1 VDD) gpdk090_pmos1v w=0.48u l=0.1u ad=0.1056p as=0.1056p pd=0.92u ps=0.92u
    I_MXI1_I110_MP3 (XI1_I110_p1 I1_c5_8 VDD VDD) gpdk090_pmos1v w=0.48u l=0.1u ad=0.1632p as=0.1056p pd=1.64u ps=0.92u
    I_MXI1_I110_MP0 (VDD I1_h5 XI1_I110_An VDD) gpdk090_pmos1v w=0.24u l=0.1u ad=0.0816p as=0.0816p pd=1.16u ps=1.16u
    I_MXI1_I96_I41_MP1 (VDD I1_I96_G3_0n XI1_I96_I41_Bn VDD) gpdk090_pmos1v w=0.24u l=0.1u ad=0.0816p as=0.0816p pd=1.16u ps=1.16u
    I_MXI1_I96_I41_MP5 (I1_p4_4 XI1_I96_I41_Bn XI1_I96_I41_p1 VDD) gpdk090_pmos1v w=0.48u l=0.1u ad=0.1056p as=0.1632p pd=0.92u ps=1.64u
    I_MXI1_I96_I41_MP4 (XI1_I96_I41_p1 XI1_I96_I41_An I1_p4_4 VDD) gpdk090_pmos1v w=0.48u l=0.1u ad=0.1056p as=0.1056p pd=0.92u ps=0.92u
    I_MXI1_I96_I41_MP2 (VDD I1_I96_pn4 XI1_I96_I41_p1 VDD) gpdk090_pmos1v w=0.48u l=0.1u ad=0.1056p as=0.1056p pd=0.92u ps=0.92u
    I_MXI1_I96_I41_MP3 (XI1_I96_I41_p1 I1_I96_G3_0n VDD VDD) gpdk090_pmos1v w=0.48u l=0.1u ad=0.1632p as=0.1056p pd=1.64u ps=0.92u
    I_MXI1_I96_I41_MP0 (VDD I1_I96_pn4 XI1_I96_I41_An VDD) gpdk090_pmos1v w=0.24u l=0.1u ad=0.0816p as=0.0816p pd=1.16u ps=1.16u
    I_MXI1_I92_MP1 (VDD I1_qu4 XI1_I92_Bn VDD) gpdk090_pmos1v w=0.24u l=0.1u ad=0.0816p as=0.0816p pd=1.16u ps=1.16u
    I_MXI1_I92_MP5 (I1_b4_4 XI1_I92_Bn XI1_I92_p1 VDD) gpdk090_pmos1v w=0.48u l=0.1u ad=0.1056p as=0.1632p pd=0.92u ps=1.64u
    I_MXI1_I92_MP4 (XI1_I92_p1 XI1_I92_An I1_b4_4 VDD) gpdk090_pmos1v w=0.48u l=0.1u ad=0.1056p as=0.1056p pd=0.92u ps=0.92u
    I_MXI1_I92_MP2 (VDD I1_dd4 XI1_I92_p1 VDD) gpdk090_pmos1v w=0.48u l=0.1u ad=0.1056p as=0.1056p pd=0.92u ps=0.92u
    I_MXI1_I92_MP3 (XI1_I92_p1 I1_qu4 VDD VDD) gpdk090_pmos1v w=0.48u l=0.1u ad=0.1632p as=0.1056p pd=1.64u ps=0.92u
    I_MXI1_I92_MP0 (VDD I1_dd4 XI1_I92_An VDD) gpdk090_pmos1v w=0.24u l=0.1u ad=0.0816p as=0.0816p pd=1.16u ps=1.16u
    I_MXI1_I84_I40_MP1 (VDD I1_I84_G2_0n XI1_I84_I40_Bn VDD) gpdk090_pmos1v w=0.24u l=0.1u ad=0.0816p as=0.0816p pd=1.16u ps=1.16u
    I_MXI1_I84_I40_MP5 (I1_p3_3 XI1_I84_I40_Bn XI1_I84_I40_p1 VDD) gpdk090_pmos1v w=0.48u l=0.1u ad=0.1056p as=0.1632p pd=0.92u ps=1.64u
    I_MXI1_I84_I40_MP4 (XI1_I84_I40_p1 XI1_I84_I40_An I1_p3_3 VDD) gpdk090_pmos1v w=0.48u l=0.1u ad=0.1056p as=0.1056p pd=0.92u ps=0.92u
    I_MXI1_I84_I40_MP2 (VDD I1_I84_pn3 XI1_I84_I40_p1 VDD) gpdk090_pmos1v w=0.48u l=0.1u ad=0.1056p as=0.1056p pd=0.92u ps=0.92u
    I_MXI1_I84_I40_MP3 (XI1_I84_I40_p1 I1_I84_G2_0n VDD VDD) gpdk090_pmos1v w=0.48u l=0.1u ad=0.1632p as=0.1056p pd=1.64u ps=0.92u
    I_MXI1_I84_I40_MP0 (VDD I1_I84_pn3 XI1_I84_I40_An VDD) gpdk090_pmos1v w=0.24u l=0.1u ad=0.0816p as=0.0816p pd=1.16u ps=1.16u
    I_MXI1_I72_I40_MP1 (VDD I1_I72_G2_0n XI1_I72_I40_Bn VDD) gpdk090_pmos1v w=0.24u l=0.1u ad=0.0816p as=0.0816p pd=1.16u ps=1.16u
    I_MXI1_I72_I40_MP5 (I1_p2_3 XI1_I72_I40_Bn XI1_I72_I40_p1 VDD) gpdk090_pmos1v w=0.48u l=0.1u ad=0.1056p as=0.1632p pd=0.92u ps=1.64u
    I_MXI1_I72_I40_MP4 (XI1_I72_I40_p1 XI1_I72_I40_An I1_p2_3 VDD) gpdk090_pmos1v w=0.48u l=0.1u ad=0.1056p as=0.1056p pd=0.92u ps=0.92u
    I_MXI1_I72_I40_MP2 (VDD I1_I72_pn3 XI1_I72_I40_p1 VDD) gpdk090_pmos1v w=0.48u l=0.1u ad=0.1056p as=0.1056p pd=0.92u ps=0.92u
    I_MXI1_I72_I40_MP3 (XI1_I72_I40_p1 I1_I72_G2_0n VDD VDD) gpdk090_pmos1v w=0.48u l=0.1u ad=0.1632p as=0.1056p pd=1.64u ps=0.92u
    I_MXI1_I72_I40_MP0 (VDD I1_I72_pn3 XI1_I72_I40_An VDD) gpdk090_pmos1v w=0.24u l=0.1u ad=0.0816p as=0.0816p pd=1.16u ps=1.16u
    I_MXI1_I69_MP1 (VDD I1_qu6 XI1_I69_Bn VDD) gpdk090_pmos1v w=0.24u l=0.1u ad=0.0816p as=0.0816p pd=1.16u ps=1.16u
    I_MXI1_I69_MP5 (I1_b2_5 XI1_I69_Bn XI1_I69_p1 VDD) gpdk090_pmos1v w=0.48u l=0.1u ad=0.1056p as=0.1632p pd=0.92u ps=1.64u
    I_MXI1_I69_MP4 (XI1_I69_p1 XI1_I69_An I1_b2_5 VDD) gpdk090_pmos1v w=0.48u l=0.1u ad=0.1056p as=0.1056p pd=0.92u ps=0.92u
    I_MXI1_I69_MP2 (VDD I1_dd5 XI1_I69_p1 VDD) gpdk090_pmos1v w=0.48u l=0.1u ad=0.1056p as=0.1056p pd=0.92u ps=0.92u
    I_MXI1_I69_MP3 (XI1_I69_p1 I1_qu6 VDD VDD) gpdk090_pmos1v w=0.48u l=0.1u ad=0.1632p as=0.1056p pd=1.64u ps=0.92u
    I_MXI1_I69_MP0 (VDD I1_dd5 XI1_I69_An VDD) gpdk090_pmos1v w=0.24u l=0.1u ad=0.0816p as=0.0816p pd=1.16u ps=1.16u
    I_MXI1_I60_I40_MP1 (VDD I1_I60_G2_0n XI1_I60_I40_Bn VDD) gpdk090_pmos1v w=0.24u l=0.1u ad=0.0816p as=0.0816p pd=1.16u ps=1.16u
    I_MXI1_I60_I40_MP5 (I1_p1_3 XI1_I60_I40_Bn XI1_I60_I40_p1 VDD) gpdk090_pmos1v w=0.48u l=0.1u ad=0.1056p as=0.1632p pd=0.92u ps=1.64u
    I_MXI1_I60_I40_MP4 (XI1_I60_I40_p1 XI1_I60_I40_An I1_p1_3 VDD) gpdk090_pmos1v w=0.48u l=0.1u ad=0.1056p as=0.1056p pd=0.92u ps=0.92u
    I_MXI1_I60_I40_MP2 (VDD I1_I60_pn3 XI1_I60_I40_p1 VDD) gpdk090_pmos1v w=0.48u l=0.1u ad=0.1056p as=0.1056p pd=0.92u ps=0.92u
    I_MXI1_I60_I40_MP3 (XI1_I60_I40_p1 I1_I60_G2_0n VDD VDD) gpdk090_pmos1v w=0.48u l=0.1u ad=0.1632p as=0.1056p pd=1.64u ps=0.92u
    I_MXI1_I60_I40_MP0 (VDD I1_I60_pn3 XI1_I60_I40_An VDD) gpdk090_pmos1v w=0.24u l=0.1u ad=0.0816p as=0.0816p pd=1.16u ps=1.16u
    I_MXI1_I57_MP1 (VDD I1_qu7 XI1_I57_Bn VDD) gpdk090_pmos1v w=0.24u l=0.1u ad=0.0816p as=0.0816p pd=1.16u ps=1.16u
    I_MXI1_I57_MP5 (I1_b1_5 XI1_I57_Bn XI1_I57_p1 VDD) gpdk090_pmos1v w=0.48u l=0.1u ad=0.1056p as=0.1632p pd=0.92u ps=1.64u
    I_MXI1_I57_MP4 (XI1_I57_p1 XI1_I57_An I1_b1_5 VDD) gpdk090_pmos1v w=0.48u l=0.1u ad=0.1056p as=0.1056p pd=0.92u ps=0.92u
    I_MXI1_I57_MP2 (VDD I1_dd5 XI1_I57_p1 VDD) gpdk090_pmos1v w=0.48u l=0.1u ad=0.1056p as=0.1056p pd=0.92u ps=0.92u
    I_MXI1_I57_MP3 (XI1_I57_p1 I1_qu7 VDD VDD) gpdk090_pmos1v w=0.48u l=0.1u ad=0.1632p as=0.1056p pd=1.64u ps=0.92u
    I_MXI1_I57_MP0 (VDD I1_dd5 XI1_I57_An VDD) gpdk090_pmos1v w=0.24u l=0.1u ad=0.0816p as=0.0816p pd=1.16u ps=1.16u
    I_MXI1_I48_I40_MP1 (VDD I1_I48_G2_0n XI1_I48_I40_Bn VDD) gpdk090_pmos1v w=0.24u l=0.1u ad=0.0816p as=0.0816p pd=1.16u ps=1.16u
    I_MXI1_I48_I40_MP5 (I1_p0_3 XI1_I48_I40_Bn XI1_I48_I40_p1 VDD) gpdk090_pmos1v w=0.48u l=0.1u ad=0.1056p as=0.1632p pd=0.92u ps=1.64u
    I_MXI1_I48_I40_MP4 (XI1_I48_I40_p1 XI1_I48_I40_An I1_p0_3 VDD) gpdk090_pmos1v w=0.48u l=0.1u ad=0.1056p as=0.1056p pd=0.92u ps=0.92u
    I_MXI1_I48_I40_MP2 (VDD I1_I48_pn3 XI1_I48_I40_p1 VDD) gpdk090_pmos1v w=0.48u l=0.1u ad=0.1056p as=0.1056p pd=0.92u ps=0.92u
    I_MXI1_I48_I40_MP3 (XI1_I48_I40_p1 I1_I48_G2_0n VDD VDD) gpdk090_pmos1v w=0.48u l=0.1u ad=0.1632p as=0.1056p pd=1.64u ps=0.92u
    I_MXI1_I48_I40_MP0 (VDD I1_I48_pn3 XI1_I48_I40_An VDD) gpdk090_pmos1v w=0.24u l=0.1u ad=0.0816p as=0.0816p pd=1.16u ps=1.16u
    I_MXI1_I105_MP1 (VDD I1_qu3 XI1_I105_Bn VDD) gpdk090_pmos1v w=0.24u l=0.1u ad=0.0816p as=0.0816p pd=1.16u ps=1.16u
    I_MXI1_I105_MP5 (I1_b5_5 XI1_I105_Bn XI1_I105_p1 VDD) gpdk090_pmos1v w=0.48u l=0.1u ad=0.1056p as=0.1632p pd=0.92u ps=1.64u
    I_MXI1_I105_MP4 (XI1_I105_p1 XI1_I105_An I1_b5_5 VDD) gpdk090_pmos1v w=0.48u l=0.1u ad=0.1056p as=0.1056p pd=0.92u ps=0.92u
    I_MXI1_I105_MP2 (VDD I1_dd5 XI1_I105_p1 VDD) gpdk090_pmos1v w=0.48u l=0.1u ad=0.1056p as=0.1056p pd=0.92u ps=0.92u
    I_MXI1_I105_MP3 (XI1_I105_p1 I1_qu3 VDD VDD) gpdk090_pmos1v w=0.48u l=0.1u ad=0.1632p as=0.1056p pd=1.64u ps=0.92u
    I_MXI1_I105_MP0 (VDD I1_dd5 XI1_I105_An VDD) gpdk090_pmos1v w=0.24u l=0.1u ad=0.0816p as=0.0816p pd=1.16u ps=1.16u
    I_MXI1_I93_MP1 (VDD I1_qu4 XI1_I93_Bn VDD) gpdk090_pmos1v w=0.24u l=0.1u ad=0.0816p as=0.0816p pd=1.16u ps=1.16u
    I_MXI1_I93_MP5 (I1_b4_5 XI1_I93_Bn XI1_I93_p1 VDD) gpdk090_pmos1v w=0.48u l=0.1u ad=0.1056p as=0.1632p pd=0.92u ps=1.64u
    I_MXI1_I93_MP4 (XI1_I93_p1 XI1_I93_An I1_b4_5 VDD) gpdk090_pmos1v w=0.48u l=0.1u ad=0.1056p as=0.1056p pd=0.92u ps=0.92u
    I_MXI1_I93_MP2 (VDD I1_dd5 XI1_I93_p1 VDD) gpdk090_pmos1v w=0.48u l=0.1u ad=0.1056p as=0.1056p pd=0.92u ps=0.92u
    I_MXI1_I93_MP3 (XI1_I93_p1 I1_qu4 VDD VDD) gpdk090_pmos1v w=0.48u l=0.1u ad=0.1632p as=0.1056p pd=1.64u ps=0.92u
    I_MXI1_I93_MP0 (VDD I1_dd5 XI1_I93_An VDD) gpdk090_pmos1v w=0.24u l=0.1u ad=0.0816p as=0.0816p pd=1.16u ps=1.16u
    I_MXI1_I81_MP1 (VDD I1_qu5 XI1_I81_Bn VDD) gpdk090_pmos1v w=0.24u l=0.1u ad=0.0816p as=0.0816p pd=1.16u ps=1.16u
    I_MXI1_I81_MP5 (I1_b3_5 XI1_I81_Bn XI1_I81_p1 VDD) gpdk090_pmos1v w=0.48u l=0.1u ad=0.1056p as=0.1632p pd=0.92u ps=1.64u
    I_MXI1_I81_MP4 (XI1_I81_p1 XI1_I81_An I1_b3_5 VDD) gpdk090_pmos1v w=0.48u l=0.1u ad=0.1056p as=0.1056p pd=0.92u ps=0.92u
    I_MXI1_I81_MP2 (VDD I1_dd5 XI1_I81_p1 VDD) gpdk090_pmos1v w=0.48u l=0.1u ad=0.1056p as=0.1056p pd=0.92u ps=0.92u
    I_MXI1_I81_MP3 (XI1_I81_p1 I1_qu5 VDD VDD) gpdk090_pmos1v w=0.48u l=0.1u ad=0.1632p as=0.1056p pd=1.64u ps=0.92u
    I_MXI1_I81_MP0 (VDD I1_dd5 XI1_I81_An VDD) gpdk090_pmos1v w=0.24u l=0.1u ad=0.0816p as=0.0816p pd=1.16u ps=1.16u
    I_MXI1_I72_I41_MP1 (VDD I1_I72_G3_0n XI1_I72_I41_Bn VDD) gpdk090_pmos1v w=0.24u l=0.1u ad=0.0816p as=0.0816p pd=1.16u ps=1.16u
    I_MXI1_I72_I41_MP5 (I1_p2_4 XI1_I72_I41_Bn XI1_I72_I41_p1 VDD) gpdk090_pmos1v w=0.48u l=0.1u ad=0.1056p as=0.1632p pd=0.92u ps=1.64u
    I_MXI1_I72_I41_MP4 (XI1_I72_I41_p1 XI1_I72_I41_An I1_p2_4 VDD) gpdk090_pmos1v w=0.48u l=0.1u ad=0.1056p as=0.1056p pd=0.92u ps=0.92u
    I_MXI1_I72_I41_MP2 (VDD I1_I72_pn4 XI1_I72_I41_p1 VDD) gpdk090_pmos1v w=0.48u l=0.1u ad=0.1056p as=0.1056p pd=0.92u ps=0.92u
    I_MXI1_I72_I41_MP3 (XI1_I72_I41_p1 I1_I72_G3_0n VDD VDD) gpdk090_pmos1v w=0.48u l=0.1u ad=0.1632p as=0.1056p pd=1.64u ps=0.92u
    I_MXI1_I72_I41_MP0 (VDD I1_I72_pn4 XI1_I72_I41_An VDD) gpdk090_pmos1v w=0.24u l=0.1u ad=0.0816p as=0.0816p pd=1.16u ps=1.16u
    I_MXI1_I60_I41_MP1 (VDD I1_I60_G3_0n XI1_I60_I41_Bn VDD) gpdk090_pmos1v w=0.24u l=0.1u ad=0.0816p as=0.0816p pd=1.16u ps=1.16u
    I_MXI1_I60_I41_MP5 (I1_p1_4 XI1_I60_I41_Bn XI1_I60_I41_p1 VDD) gpdk090_pmos1v w=0.48u l=0.1u ad=0.1056p as=0.1632p pd=0.92u ps=1.64u
    I_MXI1_I60_I41_MP4 (XI1_I60_I41_p1 XI1_I60_I41_An I1_p1_4 VDD) gpdk090_pmos1v w=0.48u l=0.1u ad=0.1056p as=0.1056p pd=0.92u ps=0.92u
    I_MXI1_I60_I41_MP2 (VDD I1_I60_pn4 XI1_I60_I41_p1 VDD) gpdk090_pmos1v w=0.48u l=0.1u ad=0.1056p as=0.1056p pd=0.92u ps=0.92u
    I_MXI1_I60_I41_MP3 (XI1_I60_I41_p1 I1_I60_G3_0n VDD VDD) gpdk090_pmos1v w=0.48u l=0.1u ad=0.1632p as=0.1056p pd=1.64u ps=0.92u
    I_MXI1_I60_I41_MP0 (VDD I1_I60_pn4 XI1_I60_I41_An VDD) gpdk090_pmos1v w=0.24u l=0.1u ad=0.0816p as=0.0816p pd=1.16u ps=1.16u
    I_MXI1_I45_MP1 (VDD VDD XI1_I45_Bn VDD) gpdk090_pmos1v w=0.24u l=0.1u ad=0.0816p as=0.0816p pd=1.16u ps=1.16u
    I_MXI1_I45_MP5 (I1_b0_5 XI1_I45_Bn XI1_I45_p1 VDD) gpdk090_pmos1v w=0.48u l=0.1u ad=0.1056p as=0.1632p pd=0.92u ps=1.64u
    I_MXI1_I45_MP4 (XI1_I45_p1 XI1_I45_An I1_b0_5 VDD) gpdk090_pmos1v w=0.48u l=0.1u ad=0.1056p as=0.1056p pd=0.92u ps=0.92u
    I_MXI1_I45_MP2 (VDD I1_dd5 XI1_I45_p1 VDD) gpdk090_pmos1v w=0.48u l=0.1u ad=0.1056p as=0.1056p pd=0.92u ps=0.92u
    I_MXI1_I45_MP3 (XI1_I45_p1 VDD VDD VDD) gpdk090_pmos1v w=0.48u l=0.1u ad=0.1632p as=0.1056p pd=1.64u ps=0.92u
    I_MXI1_I45_MP0 (VDD I1_dd5 XI1_I45_An VDD) gpdk090_pmos1v w=0.24u l=0.1u ad=0.0816p as=0.0816p pd=1.16u ps=1.16u
    I_MXI1_I48_I41_MP1 (VDD I1_I48_G3_0n XI1_I48_I41_Bn VDD) gpdk090_pmos1v w=0.24u l=0.1u ad=0.0816p as=0.0816p pd=1.16u ps=1.16u
    I_MXI1_I48_I41_MP5 (I1_p0_4 XI1_I48_I41_Bn XI1_I48_I41_p1 VDD) gpdk090_pmos1v w=0.48u l=0.1u ad=0.1056p as=0.1632p pd=0.92u ps=1.64u
    I_MXI1_I48_I41_MP4 (XI1_I48_I41_p1 XI1_I48_I41_An I1_p0_4 VDD) gpdk090_pmos1v w=0.48u l=0.1u ad=0.1056p as=0.1056p pd=0.92u ps=0.92u
    I_MXI1_I48_I41_MP2 (VDD I1_I48_pn4 XI1_I48_I41_p1 VDD) gpdk090_pmos1v w=0.48u l=0.1u ad=0.1056p as=0.1056p pd=0.92u ps=0.92u
    I_MXI1_I48_I41_MP3 (XI1_I48_I41_p1 I1_I48_G3_0n VDD VDD) gpdk090_pmos1v w=0.48u l=0.1u ad=0.1632p as=0.1056p pd=1.64u ps=0.92u
    I_MXI1_I48_I41_MP0 (VDD I1_I48_pn4 XI1_I48_I41_An VDD) gpdk090_pmos1v w=0.24u l=0.1u ad=0.0816p as=0.0816p pd=1.16u ps=1.16u
    I_MXI1_I106_MP1 (VDD I1_qu3 XI1_I106_Bn VDD) gpdk090_pmos1v w=0.24u l=0.1u ad=0.0816p as=0.0816p pd=1.16u ps=1.16u
    I_MXI1_I106_MP5 (I1_b5_6 XI1_I106_Bn XI1_I106_p1 VDD) gpdk090_pmos1v w=0.48u l=0.1u ad=0.1056p as=0.1632p pd=0.92u ps=1.64u
    I_MXI1_I106_MP4 (XI1_I106_p1 XI1_I106_An I1_b5_6 VDD) gpdk090_pmos1v w=0.48u l=0.1u ad=0.1056p as=0.1056p pd=0.92u ps=0.92u
    I_MXI1_I106_MP2 (VDD I1_dd6 XI1_I106_p1 VDD) gpdk090_pmos1v w=0.48u l=0.1u ad=0.1056p as=0.1056p pd=0.92u ps=0.92u
    I_MXI1_I106_MP3 (XI1_I106_p1 I1_qu3 VDD VDD) gpdk090_pmos1v w=0.48u l=0.1u ad=0.1632p as=0.1056p pd=1.64u ps=0.92u
    I_MXI1_I106_MP0 (VDD I1_dd6 XI1_I106_An VDD) gpdk090_pmos1v w=0.24u l=0.1u ad=0.0816p as=0.0816p pd=1.16u ps=1.16u
    I_MXI1_I109_MP1 (VDD I1_qu3 XI1_I109_Bn VDD) gpdk090_pmos1v w=0.24u l=0.1u ad=0.0816p as=0.0816p pd=1.16u ps=1.16u
    I_MXI1_I109_MP5 (I1_h5 XI1_I109_Bn XI1_I109_p1 VDD) gpdk090_pmos1v w=0.48u l=0.1u ad=0.1056p as=0.1632p pd=0.92u ps=1.64u
    I_MXI1_I109_MP4 (XI1_I109_p1 XI1_I109_An I1_h5 VDD) gpdk090_pmos1v w=0.48u l=0.1u ad=0.1056p as=0.1056p pd=0.92u ps=0.92u
    I_MXI1_I109_MP2 (VDD I1_p4_7 XI1_I109_p1 VDD) gpdk090_pmos1v w=0.48u l=0.1u ad=0.1056p as=0.1056p pd=0.92u ps=0.92u
    I_MXI1_I109_MP3 (XI1_I109_p1 I1_qu3 VDD VDD) gpdk090_pmos1v w=0.48u l=0.1u ad=0.1632p as=0.1056p pd=1.64u ps=0.92u
    I_MXI1_I109_MP0 (VDD I1_p4_7 XI1_I109_An VDD) gpdk090_pmos1v w=0.24u l=0.1u ad=0.0816p as=0.0816p pd=1.16u ps=1.16u
    I_MXI1_I94_MP1 (VDD I1_qu4 XI1_I94_Bn VDD) gpdk090_pmos1v w=0.24u l=0.1u ad=0.0816p as=0.0816p pd=1.16u ps=1.16u
    I_MXI1_I94_MP5 (I1_b4_6 XI1_I94_Bn XI1_I94_p1 VDD) gpdk090_pmos1v w=0.48u l=0.1u ad=0.1056p as=0.1632p pd=0.92u ps=1.64u
    I_MXI1_I94_MP4 (XI1_I94_p1 XI1_I94_An I1_b4_6 VDD) gpdk090_pmos1v w=0.48u l=0.1u ad=0.1056p as=0.1056p pd=0.92u ps=0.92u
    I_MXI1_I94_MP2 (VDD I1_dd6 XI1_I94_p1 VDD) gpdk090_pmos1v w=0.48u l=0.1u ad=0.1056p as=0.1056p pd=0.92u ps=0.92u
    I_MXI1_I94_MP3 (XI1_I94_p1 I1_qu4 VDD VDD) gpdk090_pmos1v w=0.48u l=0.1u ad=0.1632p as=0.1056p pd=1.64u ps=0.92u
    I_MXI1_I94_MP0 (VDD I1_dd6 XI1_I94_An VDD) gpdk090_pmos1v w=0.24u l=0.1u ad=0.0816p as=0.0816p pd=1.16u ps=1.16u
    I_MXI1_I84_I41_MP1 (VDD I1_I84_G3_0n XI1_I84_I41_Bn VDD) gpdk090_pmos1v w=0.24u l=0.1u ad=0.0816p as=0.0816p pd=1.16u ps=1.16u
    I_MXI1_I84_I41_MP5 (I1_p3_4 XI1_I84_I41_Bn XI1_I84_I41_p1 VDD) gpdk090_pmos1v w=0.48u l=0.1u ad=0.1056p as=0.1632p pd=0.92u ps=1.64u
    I_MXI1_I84_I41_MP4 (XI1_I84_I41_p1 XI1_I84_I41_An I1_p3_4 VDD) gpdk090_pmos1v w=0.48u l=0.1u ad=0.1056p as=0.1056p pd=0.92u ps=0.92u
    I_MXI1_I84_I41_MP2 (VDD I1_I84_pn4 XI1_I84_I41_p1 VDD) gpdk090_pmos1v w=0.48u l=0.1u ad=0.1056p as=0.1056p pd=0.92u ps=0.92u
    I_MXI1_I84_I41_MP3 (XI1_I84_I41_p1 I1_I84_G3_0n VDD VDD) gpdk090_pmos1v w=0.48u l=0.1u ad=0.1632p as=0.1056p pd=1.64u ps=0.92u
    I_MXI1_I84_I41_MP0 (VDD I1_I84_pn4 XI1_I84_I41_An VDD) gpdk090_pmos1v w=0.24u l=0.1u ad=0.0816p as=0.0816p pd=1.16u ps=1.16u
    I_MXI1_I70_MP1 (VDD I1_qu6 XI1_I70_Bn VDD) gpdk090_pmos1v w=0.24u l=0.1u ad=0.0816p as=0.0816p pd=1.16u ps=1.16u
    I_MXI1_I70_MP5 (I1_b2_6 XI1_I70_Bn XI1_I70_p1 VDD) gpdk090_pmos1v w=0.48u l=0.1u ad=0.1056p as=0.1632p pd=0.92u ps=1.64u
    I_MXI1_I70_MP4 (XI1_I70_p1 XI1_I70_An I1_b2_6 VDD) gpdk090_pmos1v w=0.48u l=0.1u ad=0.1056p as=0.1056p pd=0.92u ps=0.92u
    I_MXI1_I70_MP2 (VDD I1_dd6 XI1_I70_p1 VDD) gpdk090_pmos1v w=0.48u l=0.1u ad=0.1056p as=0.1056p pd=0.92u ps=0.92u
    I_MXI1_I70_MP3 (XI1_I70_p1 I1_qu6 VDD VDD) gpdk090_pmos1v w=0.48u l=0.1u ad=0.1632p as=0.1056p pd=1.64u ps=0.92u
    I_MXI1_I70_MP0 (VDD I1_dd6 XI1_I70_An VDD) gpdk090_pmos1v w=0.24u l=0.1u ad=0.0816p as=0.0816p pd=1.16u ps=1.16u
    I_MXI1_I58_MP1 (VDD I1_qu7 XI1_I58_Bn VDD) gpdk090_pmos1v w=0.24u l=0.1u ad=0.0816p as=0.0816p pd=1.16u ps=1.16u
    I_MXI1_I58_MP5 (I1_b1_6 XI1_I58_Bn XI1_I58_p1 VDD) gpdk090_pmos1v w=0.48u l=0.1u ad=0.1056p as=0.1632p pd=0.92u ps=1.64u
    I_MXI1_I58_MP4 (XI1_I58_p1 XI1_I58_An I1_b1_6 VDD) gpdk090_pmos1v w=0.48u l=0.1u ad=0.1056p as=0.1056p pd=0.92u ps=0.92u
    I_MXI1_I58_MP2 (VDD I1_dd6 XI1_I58_p1 VDD) gpdk090_pmos1v w=0.48u l=0.1u ad=0.1056p as=0.1056p pd=0.92u ps=0.92u
    I_MXI1_I58_MP3 (XI1_I58_p1 I1_qu7 VDD VDD) gpdk090_pmos1v w=0.48u l=0.1u ad=0.1632p as=0.1056p pd=1.64u ps=0.92u
    I_MXI1_I58_MP0 (VDD I1_dd6 XI1_I58_An VDD) gpdk090_pmos1v w=0.24u l=0.1u ad=0.0816p as=0.0816p pd=1.16u ps=1.16u
    I_MXI1_I46_MP1 (VDD VDD XI1_I46_Bn VDD) gpdk090_pmos1v w=0.24u l=0.1u ad=0.0816p as=0.0816p pd=1.16u ps=1.16u
    I_MXI1_I46_MP5 (I1_b0_6 XI1_I46_Bn XI1_I46_p1 VDD) gpdk090_pmos1v w=0.48u l=0.1u ad=0.1056p as=0.1632p pd=0.92u ps=1.64u
    I_MXI1_I46_MP4 (XI1_I46_p1 XI1_I46_An I1_b0_6 VDD) gpdk090_pmos1v w=0.48u l=0.1u ad=0.1056p as=0.1056p pd=0.92u ps=0.92u
    I_MXI1_I46_MP2 (VDD I1_dd6 XI1_I46_p1 VDD) gpdk090_pmos1v w=0.48u l=0.1u ad=0.1056p as=0.1056p pd=0.92u ps=0.92u
    I_MXI1_I46_MP3 (XI1_I46_p1 VDD VDD VDD) gpdk090_pmos1v w=0.48u l=0.1u ad=0.1632p as=0.1056p pd=1.64u ps=0.92u
    I_MXI1_I46_MP0 (VDD I1_dd6 XI1_I46_An VDD) gpdk090_pmos1v w=0.24u l=0.1u ad=0.0816p as=0.0816p pd=1.16u ps=1.16u
    I_MXI1_I50_MP1 (VDD I1_c0_8 XI1_I50_Bn VDD) gpdk090_pmos1v w=0.24u l=0.1u ad=0.0816p as=0.0816p pd=1.16u ps=1.16u
    I_MXI1_I50_MP5 (I1_p0_8 XI1_I50_Bn XI1_I50_p1 VDD) gpdk090_pmos1v w=0.48u l=0.1u ad=0.1056p as=0.1632p pd=0.92u ps=1.64u
    I_MXI1_I50_MP4 (XI1_I50_p1 XI1_I50_An I1_p0_8 VDD) gpdk090_pmos1v w=0.48u l=0.1u ad=0.1056p as=0.1056p pd=0.92u ps=0.92u
    I_MXI1_I50_MP2 (VDD I1_h0 XI1_I50_p1 VDD) gpdk090_pmos1v w=0.48u l=0.1u ad=0.1056p as=0.1056p pd=0.92u ps=0.92u
    I_MXI1_I50_MP3 (XI1_I50_p1 I1_c0_8 VDD VDD) gpdk090_pmos1v w=0.48u l=0.1u ad=0.1632p as=0.1056p pd=1.64u ps=0.92u
    I_MXI1_I50_MP0 (VDD I1_h0 XI1_I50_An VDD) gpdk090_pmos1v w=0.24u l=0.1u ad=0.0816p as=0.0816p pd=1.16u ps=1.16u
    I_MXI1_I107_MP1 (VDD I1_qu3 XI1_I107_Bn VDD) gpdk090_pmos1v w=0.24u l=0.1u ad=0.0816p as=0.0816p pd=1.16u ps=1.16u
    I_MXI1_I107_MP5 (I1_b5_7 XI1_I107_Bn XI1_I107_p1 VDD) gpdk090_pmos1v w=0.48u l=0.1u ad=0.1056p as=0.1632p pd=0.92u ps=1.64u
    I_MXI1_I107_MP4 (XI1_I107_p1 XI1_I107_An I1_b5_7 VDD) gpdk090_pmos1v w=0.48u l=0.1u ad=0.1056p as=0.1056p pd=0.92u ps=0.92u
    I_MXI1_I107_MP2 (VDD I1_dd7 XI1_I107_p1 VDD) gpdk090_pmos1v w=0.48u l=0.1u ad=0.1056p as=0.1056p pd=0.92u ps=0.92u
    I_MXI1_I107_MP3 (XI1_I107_p1 I1_qu3 VDD VDD) gpdk090_pmos1v w=0.48u l=0.1u ad=0.1632p as=0.1056p pd=1.64u ps=0.92u
    I_MXI1_I107_MP0 (VDD I1_dd7 XI1_I107_An VDD) gpdk090_pmos1v w=0.24u l=0.1u ad=0.0816p as=0.0816p pd=1.16u ps=1.16u
    I_MXI1_I98_MP1 (VDD I1_c4_8 XI1_I98_Bn VDD) gpdk090_pmos1v w=0.24u l=0.1u ad=0.0816p as=0.0816p pd=1.16u ps=1.16u
    I_MXI1_I98_MP5 (I1_p4_8 XI1_I98_Bn XI1_I98_p1 VDD) gpdk090_pmos1v w=0.48u l=0.1u ad=0.1056p as=0.1632p pd=0.92u ps=1.64u
    I_MXI1_I98_MP4 (XI1_I98_p1 XI1_I98_An I1_p4_8 VDD) gpdk090_pmos1v w=0.48u l=0.1u ad=0.1056p as=0.1056p pd=0.92u ps=0.92u
    I_MXI1_I98_MP2 (VDD I1_h4 XI1_I98_p1 VDD) gpdk090_pmos1v w=0.48u l=0.1u ad=0.1056p as=0.1056p pd=0.92u ps=0.92u
    I_MXI1_I98_MP3 (XI1_I98_p1 I1_c4_8 VDD VDD) gpdk090_pmos1v w=0.48u l=0.1u ad=0.1632p as=0.1056p pd=1.64u ps=0.92u
    I_MXI1_I98_MP0 (VDD I1_h4 XI1_I98_An VDD) gpdk090_pmos1v w=0.24u l=0.1u ad=0.0816p as=0.0816p pd=1.16u ps=1.16u
    I_MXI1_I95_MP1 (VDD I1_qu4 XI1_I95_Bn VDD) gpdk090_pmos1v w=0.24u l=0.1u ad=0.0816p as=0.0816p pd=1.16u ps=1.16u
    I_MXI1_I95_MP5 (I1_b4_7 XI1_I95_Bn XI1_I95_p1 VDD) gpdk090_pmos1v w=0.48u l=0.1u ad=0.1056p as=0.1632p pd=0.92u ps=1.64u
    I_MXI1_I95_MP4 (XI1_I95_p1 XI1_I95_An I1_b4_7 VDD) gpdk090_pmos1v w=0.48u l=0.1u ad=0.1056p as=0.1056p pd=0.92u ps=0.92u
    I_MXI1_I95_MP2 (VDD I1_dd7 XI1_I95_p1 VDD) gpdk090_pmos1v w=0.48u l=0.1u ad=0.1056p as=0.1056p pd=0.92u ps=0.92u
    I_MXI1_I95_MP3 (XI1_I95_p1 I1_qu4 VDD VDD) gpdk090_pmos1v w=0.48u l=0.1u ad=0.1632p as=0.1056p pd=1.64u ps=0.92u
    I_MXI1_I95_MP0 (VDD I1_dd7 XI1_I95_An VDD) gpdk090_pmos1v w=0.24u l=0.1u ad=0.0816p as=0.0816p pd=1.16u ps=1.16u
    I_MXI1_I97_MP1 (VDD I1_qu4 XI1_I97_Bn VDD) gpdk090_pmos1v w=0.24u l=0.1u ad=0.0816p as=0.0816p pd=1.16u ps=1.16u
    I_MXI1_I97_MP5 (I1_h4 XI1_I97_Bn XI1_I97_p1 VDD) gpdk090_pmos1v w=0.48u l=0.1u ad=0.1056p as=0.1632p pd=0.92u ps=1.64u
    I_MXI1_I97_MP4 (XI1_I97_p1 XI1_I97_An I1_h4 VDD) gpdk090_pmos1v w=0.48u l=0.1u ad=0.1056p as=0.1056p pd=0.92u ps=0.92u
    I_MXI1_I97_MP2 (VDD I1_p3_7 XI1_I97_p1 VDD) gpdk090_pmos1v w=0.48u l=0.1u ad=0.1056p as=0.1056p pd=0.92u ps=0.92u
    I_MXI1_I97_MP3 (XI1_I97_p1 I1_qu4 VDD VDD) gpdk090_pmos1v w=0.48u l=0.1u ad=0.1632p as=0.1056p pd=1.64u ps=0.92u
    I_MXI1_I97_MP0 (VDD I1_p3_7 XI1_I97_An VDD) gpdk090_pmos1v w=0.24u l=0.1u ad=0.0816p as=0.0816p pd=1.16u ps=1.16u
    I_MXI1_I86_MP1 (VDD I1_c3_8 XI1_I86_Bn VDD) gpdk090_pmos1v w=0.24u l=0.1u ad=0.0816p as=0.0816p pd=1.16u ps=1.16u
    I_MXI1_I86_MP5 (I1_p3_8 XI1_I86_Bn XI1_I86_p1 VDD) gpdk090_pmos1v w=0.48u l=0.1u ad=0.1056p as=0.1632p pd=0.92u ps=1.64u
    I_MXI1_I86_MP4 (XI1_I86_p1 XI1_I86_An I1_p3_8 VDD) gpdk090_pmos1v w=0.48u l=0.1u ad=0.1056p as=0.1056p pd=0.92u ps=0.92u
    I_MXI1_I86_MP2 (VDD I1_h3 XI1_I86_p1 VDD) gpdk090_pmos1v w=0.48u l=0.1u ad=0.1056p as=0.1056p pd=0.92u ps=0.92u
    I_MXI1_I86_MP3 (XI1_I86_p1 I1_c3_8 VDD VDD) gpdk090_pmos1v w=0.48u l=0.1u ad=0.1632p as=0.1056p pd=1.64u ps=0.92u
    I_MXI1_I86_MP0 (VDD I1_h3 XI1_I86_An VDD) gpdk090_pmos1v w=0.24u l=0.1u ad=0.0816p as=0.0816p pd=1.16u ps=1.16u
    I_MXI1_I83_MP1 (VDD I1_qu5 XI1_I83_Bn VDD) gpdk090_pmos1v w=0.24u l=0.1u ad=0.0816p as=0.0816p pd=1.16u ps=1.16u
    I_MXI1_I83_MP5 (I1_b3_7 XI1_I83_Bn XI1_I83_p1 VDD) gpdk090_pmos1v w=0.48u l=0.1u ad=0.1056p as=0.1632p pd=0.92u ps=1.64u
    I_MXI1_I83_MP4 (XI1_I83_p1 XI1_I83_An I1_b3_7 VDD) gpdk090_pmos1v w=0.48u l=0.1u ad=0.1056p as=0.1056p pd=0.92u ps=0.92u
    I_MXI1_I83_MP2 (VDD I1_dd7 XI1_I83_p1 VDD) gpdk090_pmos1v w=0.48u l=0.1u ad=0.1056p as=0.1056p pd=0.92u ps=0.92u
    I_MXI1_I83_MP3 (XI1_I83_p1 I1_qu5 VDD VDD) gpdk090_pmos1v w=0.48u l=0.1u ad=0.1632p as=0.1056p pd=1.64u ps=0.92u
    I_MXI1_I83_MP0 (VDD I1_dd7 XI1_I83_An VDD) gpdk090_pmos1v w=0.24u l=0.1u ad=0.0816p as=0.0816p pd=1.16u ps=1.16u
    I_MXI1_I85_MP1 (VDD I1_qu5 XI1_I85_Bn VDD) gpdk090_pmos1v w=0.24u l=0.1u ad=0.0816p as=0.0816p pd=1.16u ps=1.16u
    I_MXI1_I85_MP5 (I1_h3 XI1_I85_Bn XI1_I85_p1 VDD) gpdk090_pmos1v w=0.48u l=0.1u ad=0.1056p as=0.1632p pd=0.92u ps=1.64u
    I_MXI1_I85_MP4 (XI1_I85_p1 XI1_I85_An I1_h3 VDD) gpdk090_pmos1v w=0.48u l=0.1u ad=0.1056p as=0.1056p pd=0.92u ps=0.92u
    I_MXI1_I85_MP2 (VDD I1_p2_7 XI1_I85_p1 VDD) gpdk090_pmos1v w=0.48u l=0.1u ad=0.1056p as=0.1056p pd=0.92u ps=0.92u
    I_MXI1_I85_MP3 (XI1_I85_p1 I1_qu5 VDD VDD) gpdk090_pmos1v w=0.48u l=0.1u ad=0.1632p as=0.1056p pd=1.64u ps=0.92u
    I_MXI1_I85_MP0 (VDD I1_p2_7 XI1_I85_An VDD) gpdk090_pmos1v w=0.24u l=0.1u ad=0.0816p as=0.0816p pd=1.16u ps=1.16u
    I_MXI1_I82_MP1 (VDD I1_qu5 XI1_I82_Bn VDD) gpdk090_pmos1v w=0.24u l=0.1u ad=0.0816p as=0.0816p pd=1.16u ps=1.16u
    I_MXI1_I82_MP5 (I1_b3_6 XI1_I82_Bn XI1_I82_p1 VDD) gpdk090_pmos1v w=0.48u l=0.1u ad=0.1056p as=0.1632p pd=0.92u ps=1.64u
    I_MXI1_I82_MP4 (XI1_I82_p1 XI1_I82_An I1_b3_6 VDD) gpdk090_pmos1v w=0.48u l=0.1u ad=0.1056p as=0.1056p pd=0.92u ps=0.92u
    I_MXI1_I82_MP2 (VDD I1_dd6 XI1_I82_p1 VDD) gpdk090_pmos1v w=0.48u l=0.1u ad=0.1056p as=0.1056p pd=0.92u ps=0.92u
    I_MXI1_I82_MP3 (XI1_I82_p1 I1_qu5 VDD VDD) gpdk090_pmos1v w=0.48u l=0.1u ad=0.1632p as=0.1056p pd=1.64u ps=0.92u
    I_MXI1_I82_MP0 (VDD I1_dd6 XI1_I82_An VDD) gpdk090_pmos1v w=0.24u l=0.1u ad=0.0816p as=0.0816p pd=1.16u ps=1.16u
    I_MXI1_I74_MP1 (VDD I1_c2_8 XI1_I74_Bn VDD) gpdk090_pmos1v w=0.24u l=0.1u ad=0.0816p as=0.0816p pd=1.16u ps=1.16u
    I_MXI1_I74_MP5 (I1_p2_8 XI1_I74_Bn XI1_I74_p1 VDD) gpdk090_pmos1v w=0.48u l=0.1u ad=0.1056p as=0.1632p pd=0.92u ps=1.64u
    I_MXI1_I74_MP4 (XI1_I74_p1 XI1_I74_An I1_p2_8 VDD) gpdk090_pmos1v w=0.48u l=0.1u ad=0.1056p as=0.1056p pd=0.92u ps=0.92u
    I_MXI1_I74_MP2 (VDD I1_h2 XI1_I74_p1 VDD) gpdk090_pmos1v w=0.48u l=0.1u ad=0.1056p as=0.1056p pd=0.92u ps=0.92u
    I_MXI1_I74_MP3 (XI1_I74_p1 I1_c2_8 VDD VDD) gpdk090_pmos1v w=0.48u l=0.1u ad=0.1632p as=0.1056p pd=1.64u ps=0.92u
    I_MXI1_I74_MP0 (VDD I1_h2 XI1_I74_An VDD) gpdk090_pmos1v w=0.24u l=0.1u ad=0.0816p as=0.0816p pd=1.16u ps=1.16u
    I_MXI1_I71_MP1 (VDD I1_qu6 XI1_I71_Bn VDD) gpdk090_pmos1v w=0.24u l=0.1u ad=0.0816p as=0.0816p pd=1.16u ps=1.16u
    I_MXI1_I71_MP5 (I1_b2_7 XI1_I71_Bn XI1_I71_p1 VDD) gpdk090_pmos1v w=0.48u l=0.1u ad=0.1056p as=0.1632p pd=0.92u ps=1.64u
    I_MXI1_I71_MP4 (XI1_I71_p1 XI1_I71_An I1_b2_7 VDD) gpdk090_pmos1v w=0.48u l=0.1u ad=0.1056p as=0.1056p pd=0.92u ps=0.92u
    I_MXI1_I71_MP2 (VDD I1_dd7 XI1_I71_p1 VDD) gpdk090_pmos1v w=0.48u l=0.1u ad=0.1056p as=0.1056p pd=0.92u ps=0.92u
    I_MXI1_I71_MP3 (XI1_I71_p1 I1_qu6 VDD VDD) gpdk090_pmos1v w=0.48u l=0.1u ad=0.1632p as=0.1056p pd=1.64u ps=0.92u
    I_MXI1_I71_MP0 (VDD I1_dd7 XI1_I71_An VDD) gpdk090_pmos1v w=0.24u l=0.1u ad=0.0816p as=0.0816p pd=1.16u ps=1.16u
    I_MXI1_I73_MP1 (VDD I1_qu6 XI1_I73_Bn VDD) gpdk090_pmos1v w=0.24u l=0.1u ad=0.0816p as=0.0816p pd=1.16u ps=1.16u
    I_MXI1_I73_MP5 (I1_h2 XI1_I73_Bn XI1_I73_p1 VDD) gpdk090_pmos1v w=0.48u l=0.1u ad=0.1056p as=0.1632p pd=0.92u ps=1.64u
    I_MXI1_I73_MP4 (XI1_I73_p1 XI1_I73_An I1_h2 VDD) gpdk090_pmos1v w=0.48u l=0.1u ad=0.1056p as=0.1056p pd=0.92u ps=0.92u
    I_MXI1_I73_MP2 (VDD I1_p1_7 XI1_I73_p1 VDD) gpdk090_pmos1v w=0.48u l=0.1u ad=0.1056p as=0.1056p pd=0.92u ps=0.92u
    I_MXI1_I73_MP3 (XI1_I73_p1 I1_qu6 VDD VDD) gpdk090_pmos1v w=0.48u l=0.1u ad=0.1632p as=0.1056p pd=1.64u ps=0.92u
    I_MXI1_I73_MP0 (VDD I1_p1_7 XI1_I73_An VDD) gpdk090_pmos1v w=0.24u l=0.1u ad=0.0816p as=0.0816p pd=1.16u ps=1.16u
    I_MXI1_I62_MP1 (VDD I1_c1_8 XI1_I62_Bn VDD) gpdk090_pmos1v w=0.24u l=0.1u ad=0.0816p as=0.0816p pd=1.16u ps=1.16u
    I_MXI1_I62_MP5 (I1_p1_8 XI1_I62_Bn XI1_I62_p1 VDD) gpdk090_pmos1v w=0.48u l=0.1u ad=0.1056p as=0.1632p pd=0.92u ps=1.64u
    I_MXI1_I62_MP4 (XI1_I62_p1 XI1_I62_An I1_p1_8 VDD) gpdk090_pmos1v w=0.48u l=0.1u ad=0.1056p as=0.1056p pd=0.92u ps=0.92u
    I_MXI1_I62_MP2 (VDD I1_h1 XI1_I62_p1 VDD) gpdk090_pmos1v w=0.48u l=0.1u ad=0.1056p as=0.1056p pd=0.92u ps=0.92u
    I_MXI1_I62_MP3 (XI1_I62_p1 I1_c1_8 VDD VDD) gpdk090_pmos1v w=0.48u l=0.1u ad=0.1632p as=0.1056p pd=1.64u ps=0.92u
    I_MXI1_I62_MP0 (VDD I1_h1 XI1_I62_An VDD) gpdk090_pmos1v w=0.24u l=0.1u ad=0.0816p as=0.0816p pd=1.16u ps=1.16u
    I_MXI1_I59_MP1 (VDD I1_qu7 XI1_I59_Bn VDD) gpdk090_pmos1v w=0.24u l=0.1u ad=0.0816p as=0.0816p pd=1.16u ps=1.16u
    I_MXI1_I59_MP5 (I1_b1_7 XI1_I59_Bn XI1_I59_p1 VDD) gpdk090_pmos1v w=0.48u l=0.1u ad=0.1056p as=0.1632p pd=0.92u ps=1.64u
    I_MXI1_I59_MP4 (XI1_I59_p1 XI1_I59_An I1_b1_7 VDD) gpdk090_pmos1v w=0.48u l=0.1u ad=0.1056p as=0.1056p pd=0.92u ps=0.92u
    I_MXI1_I59_MP2 (VDD I1_dd7 XI1_I59_p1 VDD) gpdk090_pmos1v w=0.48u l=0.1u ad=0.1056p as=0.1056p pd=0.92u ps=0.92u
    I_MXI1_I59_MP3 (XI1_I59_p1 I1_qu7 VDD VDD) gpdk090_pmos1v w=0.48u l=0.1u ad=0.1632p as=0.1056p pd=1.64u ps=0.92u
    I_MXI1_I59_MP0 (VDD I1_dd7 XI1_I59_An VDD) gpdk090_pmos1v w=0.24u l=0.1u ad=0.0816p as=0.0816p pd=1.16u ps=1.16u
    I_MXI1_I61_MP1 (VDD I1_qu7 XI1_I61_Bn VDD) gpdk090_pmos1v w=0.24u l=0.1u ad=0.0816p as=0.0816p pd=1.16u ps=1.16u
    I_MXI1_I61_MP5 (I1_h1 XI1_I61_Bn XI1_I61_p1 VDD) gpdk090_pmos1v w=0.48u l=0.1u ad=0.1056p as=0.1632p pd=0.92u ps=1.64u
    I_MXI1_I61_MP4 (XI1_I61_p1 XI1_I61_An I1_h1 VDD) gpdk090_pmos1v w=0.48u l=0.1u ad=0.1056p as=0.1056p pd=0.92u ps=0.92u
    I_MXI1_I61_MP2 (VDD I1_p0_7 XI1_I61_p1 VDD) gpdk090_pmos1v w=0.48u l=0.1u ad=0.1056p as=0.1056p pd=0.92u ps=0.92u
    I_MXI1_I61_MP3 (XI1_I61_p1 I1_qu7 VDD VDD) gpdk090_pmos1v w=0.48u l=0.1u ad=0.1632p as=0.1056p pd=1.64u ps=0.92u
    I_MXI1_I61_MP0 (VDD I1_p0_7 XI1_I61_An VDD) gpdk090_pmos1v w=0.24u l=0.1u ad=0.0816p as=0.0816p pd=1.16u ps=1.16u
    I_MXI1_I47_MP1 (VDD VDD XI1_I47_Bn VDD) gpdk090_pmos1v w=0.24u l=0.1u ad=0.0816p as=0.0816p pd=1.16u ps=1.16u
    I_MXI1_I47_MP5 (I1_b0_7 XI1_I47_Bn XI1_I47_p1 VDD) gpdk090_pmos1v w=0.48u l=0.1u ad=0.1056p as=0.1632p pd=0.92u ps=1.64u
    I_MXI1_I47_MP4 (XI1_I47_p1 XI1_I47_An I1_b0_7 VDD) gpdk090_pmos1v w=0.48u l=0.1u ad=0.1056p as=0.1056p pd=0.92u ps=0.92u
    I_MXI1_I47_MP2 (VDD I1_dd7 XI1_I47_p1 VDD) gpdk090_pmos1v w=0.48u l=0.1u ad=0.1056p as=0.1056p pd=0.92u ps=0.92u
    I_MXI1_I47_MP3 (XI1_I47_p1 VDD VDD VDD) gpdk090_pmos1v w=0.48u l=0.1u ad=0.1632p as=0.1056p pd=1.64u ps=0.92u
    I_MXI1_I47_MP0 (VDD I1_dd7 XI1_I47_An VDD) gpdk090_pmos1v w=0.24u l=0.1u ad=0.0816p as=0.0816p pd=1.16u ps=1.16u
    I_MXI1_I49_MP1 (VDD VDD XI1_I49_Bn VDD) gpdk090_pmos1v w=0.24u l=0.1u ad=0.0816p as=0.0816p pd=1.16u ps=1.16u
    I_MXI1_I49_MP5 (I1_h0 XI1_I49_Bn XI1_I49_p1 VDD) gpdk090_pmos1v w=0.48u l=0.1u ad=0.1056p as=0.1632p pd=0.92u ps=1.64u
    I_MXI1_I49_MP4 (XI1_I49_p1 XI1_I49_An I1_h0 VDD) gpdk090_pmos1v w=0.48u l=0.1u ad=0.1056p as=0.1056p pd=0.92u ps=0.92u
    I_MXI1_I49_MP2 (VDD VSS XI1_I49_p1 VDD) gpdk090_pmos1v w=0.48u l=0.1u ad=0.1056p as=0.1056p pd=0.92u ps=0.92u
    I_MXI1_I49_MP3 (XI1_I49_p1 VDD VDD VDD) gpdk090_pmos1v w=0.48u l=0.1u ad=0.1632p as=0.1056p pd=1.64u ps=0.92u
    I_MXI1_I49_MP0 (VDD VSS XI1_I49_An VDD) gpdk090_pmos1v w=0.24u l=0.1u ad=0.0816p as=0.0816p pd=1.16u ps=1.16u
    I_C1 (VDD VSS) capacitor c=6.109E-13
    I_C2 (A_0 VSS) capacitor c=3.102E-14
    I_C3 (A_1 VSS) capacitor c=2.820E-14
    I_C4 (A_2 VSS) capacitor c=2.948E-14
    I_C5 (A_3 VSS) capacitor c=2.340E-14
    I_C6 (A_4 VSS) capacitor c=2.814E-14
    I_C7 (A_5 VSS) capacitor c=2.509E-14
    I_C8 (A_6 VSS) capacitor c=2.579E-14
    I_C9 (A_7 VSS) capacitor c=4.618E-14
    I_C10 (B_0 VSS) capacitor c=2.938E-14
    I_C11 (B_1 VSS) capacitor c=2.783E-14
    I_C12 (B_2 VSS) capacitor c=1.725E-14
    I_C13 (B_3 VSS) capacitor c=3.786E-14
    I_C14 (B_4 VSS) capacitor c=1.719E-14
    I_C15 (B_5 VSS) capacitor c=3.422E-14
    I_C16 (B_6 VSS) capacitor c=1.446E-14
    I_C17 (B_7 VSS) capacitor c=3.256E-14
    I_C18 (C VSS) capacitor c=2.828E-15
    I_C19 (DZ VSS) capacitor c=2.507E-15
    I_C20 (OP_0 VSS) capacitor c=2.193E-14
    I_C21 (OP_1 VSS) capacitor c=3.690E-15
    I_C22 (OP_2 VSS) capacitor c=1.228E-15
    I_C23 (OP_3 VSS) capacitor c=1.361E-15
    I_C24 (V VSS) capacitor c=3.118E-15
    I_C25 (Y_0 VSS) capacitor c=3.336E-15
    I_C26 (Y_1 VSS) capacitor c=3.106E-15
    I_C27 (Y_10 VSS) capacitor c=2.698E-15
    I_C28 (Y_11 VSS) capacitor c=1.847E-15
    I_C29 (Y_12 VSS) capacitor c=1.780E-15
    I_C30 (Y_13 VSS) capacitor c=1.523E-15
    I_C31 (Y_14 VSS) capacitor c=1.596E-15
    I_C32 (Y_15 VSS) capacitor c=1.430E-15
    I_C33 (Y_2 VSS) capacitor c=2.426E-15
    I_C34 (Y_3 VSS) capacitor c=1.867E-15
    I_C35 (Y_4 VSS) capacitor c=2.839E-15
    I_C36 (Y_5 VSS) capacitor c=2.064E-15
    I_C37 (Y_6 VSS) capacitor c=3.396E-15
    I_C38 (Y_7 VSS) capacitor c=1.950E-15
    I_C39 (Y_8 VSS) capacitor c=5.038E-15
    I_C40 (Y_9 VSS) capacitor c=2.826E-15
    I_C41 (Z VSS) capacitor c=8.966E-16
    I_C42 (I1_h0 VSS) capacitor c=1.665E-15
    I_C43 (I1_dd7 VSS) capacitor c=3.175E-14
    I_C44 (I1_b0_7 VSS) capacitor c=2.512E-15
    I_C45 (I1_p0_7 VSS) capacitor c=1.832E-15
    I_C46 (I1_qu7 VSS) capacitor c=2.094E-14
    I_C47 (I1_h1 VSS) capacitor c=3.461E-15
    I_C48 (I1_b1_7 VSS) capacitor c=1.929E-15
    I_C49 (I1_c1_8 VSS) capacitor c=2.145E-15
    I_C50 (I1_p1_8 VSS) capacitor c=1.329E-15
    I_C51 (I1_p1_7 VSS) capacitor c=1.584E-15
    I_C52 (I1_qu6 VSS) capacitor c=1.960E-14
    I_C53 (I1_h2 VSS) capacitor c=2.700E-15
    I_C54 (I1_b2_7 VSS) capacitor c=2.150E-15
    I_C55 (I1_c2_8 VSS) capacitor c=2.036E-15
    I_C56 (I1_p2_8 VSS) capacitor c=1.833E-15
    I_C57 (I1_dd6 VSS) capacitor c=3.063E-14
    I_C58 (I1_qu5 VSS) capacitor c=1.956E-14
    I_C59 (I1_b3_6 VSS) capacitor c=2.729E-15
    I_C60 (I1_p2_7 VSS) capacitor c=2.191E-15
    I_C61 (I1_h3 VSS) capacitor c=2.930E-15
    I_C62 (I1_b3_7 VSS) capacitor c=2.383E-15
    I_C63 (I1_c3_8 VSS) capacitor c=2.190E-15
    I_C64 (I1_p3_8 VSS) capacitor c=1.232E-15
    I_C65 (I1_p3_7 VSS) capacitor c=2.483E-15
    I_C66 (I1_qu4 VSS) capacitor c=2.037E-14
    I_C67 (I1_h4 VSS) capacitor c=1.836E-15
    I_C68 (I1_b4_7 VSS) capacitor c=2.275E-15
    I_C69 (I1_c4_8 VSS) capacitor c=2.858E-15
    I_C70 (I1_p4_8 VSS) capacitor c=1.657E-15
    I_C71 (I1_qu3 VSS) capacitor c=2.206E-14
    I_C72 (I1_b5_7 VSS) capacitor c=1.966E-15
    I_C73 (I1_c0_8 VSS) capacitor c=2.108E-15
    I_C74 (I1_p0_8 VSS) capacitor c=1.608E-15
    I_C75 (I1_b0_6 VSS) capacitor c=2.720E-15
    I_C76 (I1_b1_6 VSS) capacitor c=1.998E-15
    I_C77 (I1_b2_6 VSS) capacitor c=2.438E-15
    I_C78 (I1_I84_pn4 VSS) capacitor c=4.053E-15
    I_C79 (I1_I84_G3_0n VSS) capacitor c=2.953E-15
    I_C80 (I1_p3_4 VSS) capacitor c=3.007E-15
    I_C81 (I1_b4_6 VSS) capacitor c=2.033E-15
    I_C82 (I1_p4_7 VSS) capacitor c=2.450E-15
    I_C83 (I1_h5 VSS) capacitor c=2.560E-15
    I_C84 (I1_b5_6 VSS) capacitor c=2.179E-15
    I_C85 (I1_I48_pn4 VSS) capacitor c=4.144E-15
    I_C86 (I1_I48_G3_0n VSS) capacitor c=3.240E-15
    I_C87 (I1_p0_4 VSS) capacitor c=4.393E-15
    I_C88 (I1_dd5 VSS) capacitor c=2.808E-14
    I_C89 (I1_b0_5 VSS) capacitor c=2.026E-15
    I_C90 (I1_I60_pn4 VSS) capacitor c=3.907E-15
    I_C91 (I1_I60_G3_0n VSS) capacitor c=3.063E-15
    I_C92 (I1_p1_4 VSS) capacitor c=2.988E-15
    I_C93 (I1_I72_pn4 VSS) capacitor c=5.571E-15
    I_C94 (I1_I72_G3_0n VSS) capacitor c=3.052E-15
    I_C95 (I1_p2_4 VSS) capacitor c=2.764E-15
    I_C96 (I1_b3_5 VSS) capacitor c=1.840E-15
    I_C97 (I1_b4_5 VSS) capacitor c=2.037E-15
    I_C98 (I1_b5_5 VSS) capacitor c=2.476E-15
    I_C99 (I1_I48_pn3 VSS) capacitor c=4.744E-15
    I_C100 (I1_I48_G2_0n VSS) capacitor c=3.101E-15
    I_C101 (I1_p0_3 VSS) capacitor c=2.617E-15
    I_C102 (I1_b1_5 VSS) capacitor c=2.169E-15
    I_C103 (I1_I60_pn3 VSS) capacitor c=3.900E-15
    I_C104 (I1_I60_G2_0n VSS) capacitor c=2.692E-15
    I_C105 (I1_p1_3 VSS) capacitor c=2.815E-15
    I_C106 (I1_b2_5 VSS) capacitor c=2.266E-15
    I_C107 (I1_I72_pn3 VSS) capacitor c=4.846E-15
    I_C108 (I1_I72_G2_0n VSS) capacitor c=3.193E-15
    I_C109 (I1_p2_3 VSS) capacitor c=2.425E-15
    I_C110 (I1_I84_pn3 VSS) capacitor c=4.729E-15
    I_C111 (I1_I84_G2_0n VSS) capacitor c=2.951E-15
    I_C112 (I1_p3_3 VSS) capacitor c=3.557E-15
    I_C113 (I1_dd4 VSS) capacitor c=2.139E-14
    I_C114 (I1_b4_4 VSS) capacitor c=2.289E-15
    I_C115 (I1_I96_pn4 VSS) capacitor c=5.234E-15
    I_C116 (I1_I96_G3_0n VSS) capacitor c=3.297E-15
    I_C117 (I1_p4_4 VSS) capacitor c=2.357E-15
    I_C118 (I1_c5_8 VSS) capacitor c=2.176E-15
    I_C119 (I1_p5_8 VSS) capacitor c=3.076E-15
    I_C120 (I1_b1_4 VSS) capacitor c=2.269E-15
    I_C121 (I1_b0_4 VSS) capacitor c=3.203E-15
    I_C122 (I1_b2_4 VSS) capacitor c=2.187E-15
    I_C123 (I1_b3_4 VSS) capacitor c=2.401E-15
    I_C124 (I1_I96_pn3 VSS) capacitor c=4.650E-15
    I_C125 (I1_I96_G2_0n VSS) capacitor c=2.989E-15
    I_C126 (I1_p4_3 VSS) capacitor c=2.460E-15
    I_C127 (I1_b5_4 VSS) capacitor c=1.858E-15
    I_C128 (I1_dd3 VSS) capacitor c=1.849E-14
    I_C129 (I1_b1_3 VSS) capacitor c=2.316E-15
    I_C130 (I1_b2_3 VSS) capacitor c=2.565E-15
    I_C131 (I1_b3_3 VSS) capacitor c=2.227E-15
    I_C132 (I1_b4_3 VSS) capacitor c=2.354E-15
    I_C133 (I1_b5_3 VSS) capacitor c=1.982E-15
    I_C134 (I1_dd2 VSS) capacitor c=2.040E-14
    I_C135 (I1_b0_2 VSS) capacitor c=2.204E-15
    I_C136 (I1_dd1 VSS) capacitor c=1.868E-14
    I_C137 (I1_b0_1 VSS) capacitor c=1.950E-15
    I_C138 (I1_b0_3 VSS) capacitor c=3.379E-15
    I_C139 (I1_b1_2 VSS) capacitor c=2.282E-15
    I_C140 (I1_b1_1 VSS) capacitor c=1.941E-15
    I_C141 (I1_b2_2 VSS) capacitor c=1.881E-15
    I_C142 (I1_b2_1 VSS) capacitor c=2.474E-15
    I_C143 (I1_b3_0 VSS) capacitor c=2.218E-15
    I_C144 (I1_b3_2 VSS) capacitor c=2.454E-15
    I_C145 (I1_b3_1 VSS) capacitor c=2.522E-15
    I_C146 (I1_b4_0 VSS) capacitor c=1.950E-15
    I_C147 (I1_b4_1 VSS) capacitor c=2.112E-15
    I_C148 (I1_b4_2 VSS) capacitor c=2.223E-15
    I_C149 (I1_b5_2 VSS) capacitor c=2.417E-15
    I_C150 (I1_I108_pn4 VSS) capacitor c=4.890E-15
    I_C151 (I1_I108_G3_0n VSS) capacitor c=3.447E-15
    I_C152 (I1_p5_4 VSS) capacitor c=2.586E-15
    I_C153 (I1_p5_7 VSS) capacitor c=1.700E-15
    I_C154 (I1_qu2 VSS) capacitor c=1.873E-14
    I_C155 (I1_h6 VSS) capacitor c=3.351E-15
    I_C156 (I2_XOR_2 VSS) capacitor c=1.006E-15
    I_C157 (I1_b0_0 VSS) capacitor c=2.953E-15
    I_C158 (I1_b1_0 VSS) capacitor c=2.622E-15
    I_C159 (I1_b2_0 VSS) capacitor c=1.991E-15
    I_C160 (I1_b5_1 VSS) capacitor c=2.568E-15
    I_C161 (I1_I108_pn3 VSS) capacitor c=3.866E-15
    I_C162 (I1_I108_G2_0n VSS) capacitor c=3.136E-15
    I_C163 (I1_p5_3 VSS) capacitor c=2.669E-15
    I_C164 (I1_b6_5 VSS) capacitor c=2.247E-15
    I_C165 (I1_b6_6 VSS) capacitor c=2.073E-15
    I_C166 (I1_b6_7 VSS) capacitor c=2.051E-15
    I_C167 (I2_XOR_0 VSS) capacitor c=1.317E-15
    I_C168 (I1_sq VSS) capacitor c=1.075E-14
    I_C169 (I1_b5_0 VSS) capacitor c=2.086E-15
    I_C170 (I1_b6_3 VSS) capacitor c=2.355E-15
    I_C171 (I1_b6_4 VSS) capacitor c=1.905E-15
    I_C172 (I2_XOR_1 VSS) capacitor c=1.255E-15
    I_C173 (I1_b6_0 VSS) capacitor c=2.084E-15
    I_C174 (I1_b6_1 VSS) capacitor c=2.477E-15
    I_C175 (I1_b6_2 VSS) capacitor c=1.982E-15
    I_C176 (I2_I1_bx2 VSS) capacitor c=2.174E-15
    I_C177 (I2_XOR_4 VSS) capacitor c=1.415E-15
    I_C178 (I2_I1_bx1 VSS) capacitor c=2.283E-15
    I_C179 (I1_I120_pn3 VSS) capacitor c=4.657E-15
    I_C180 (I1_I120_G2_0n VSS) capacitor c=2.450E-15
    I_C181 (I1_p6_3 VSS) capacitor c=3.016E-15
    I_C182 (I1_I120_pn4 VSS) capacitor c=4.290E-15
    I_C183 (I1_I120_G3_0n VSS) capacitor c=2.988E-15
    I_C184 (I1_p6_4 VSS) capacitor c=2.510E-15
    I_C185 (I1_c6_8 VSS) capacitor c=1.865E-15
    I_C186 (I1_p6_8 VSS) capacitor c=1.249E-15
    I_C187 (I2_I1_bx0 VSS) capacitor c=2.741E-15
    I_C188 (I1_qu1 VSS) capacitor c=2.007E-14
    I_C189 (I1_b7_1 VSS) capacitor c=2.615E-15
    I_C190 (I1_b7_2 VSS) capacitor c=2.142E-15
    I_C191 (I1_b7_3 VSS) capacitor c=2.456E-15
    I_C192 (I1_b7_4 VSS) capacitor c=2.238E-15
    I_C193 (I1_b7_5 VSS) capacitor c=2.089E-15
    I_C194 (I1_b7_6 VSS) capacitor c=2.070E-15
    I_C195 (I1_p6_7 VSS) capacitor c=1.654E-15
    I_C196 (I1_h7 VSS) capacitor c=2.275E-15
    I_C197 (I2_I1_bx4 VSS) capacitor c=2.609E-15
    I_C198 (I2_I1_I8_pn3 VSS) capacitor c=3.271E-15
    I_C199 (I2_I1_I8_G2_0n VSS) capacitor c=3.248E-15
    I_C200 (I2_S_3 VSS) capacitor c=2.326E-15
    I_C201 (I2_I1_I8_pn4 VSS) capacitor c=5.742E-15
    I_C202 (I2_I1_I8_G3_0n VSS) capacitor c=4.055E-15
    I_C203 (I2_S_4 VSS) capacitor c=1.516E-15
    I_C204 (I1_b7_0 VSS) capacitor c=2.243E-15
    I_C205 (I2_C7 VSS) capacitor c=4.402E-15
    I_C206 (I2_C8 VSS) capacitor c=2.698E-15
    I_C207 (I2_I4_ovf VSS) capacitor c=8.946E-16
    I_C208 (I1_c7_8 VSS) capacitor c=2.041E-15
    I_C209 (I1_p7_8 VSS) capacitor c=7.920E-15
    I_C210 (I1_b7_7 VSS) capacitor c=2.250E-15
    I_C211 (I2_I1_bx3 VSS) capacitor c=2.137E-15
    I_C212 (I1_I132_pn3 VSS) capacitor c=4.000E-15
    I_C213 (I1_I132_G2_0n VSS) capacitor c=2.937E-15
    I_C214 (I1_p7_3 VSS) capacitor c=2.032E-15
    I_C215 (I1_I132_pn4 VSS) capacitor c=5.027E-15
    I_C216 (I1_I132_G3_0n VSS) capacitor c=3.461E-15
    I_C217 (I1_p7_4 VSS) capacitor c=2.348E-15
    I_C218 (I2_I1_bx5 VSS) capacitor c=2.102E-15
    I_C219 (I2_XOR_3 VSS) capacitor c=9.702E-16
    I_C220 (I2_I1_bx6 VSS) capacitor c=2.457E-15
    I_C221 (I2_XOR_6 VSS) capacitor c=9.247E-16
    I_C222 (I2_I1_bx7 VSS) capacitor c=2.615E-15
    I_C223 (I1_I152_pn3 VSS) capacitor c=4.207E-15
    I_C224 (I1_I152_G2_0n VSS) capacitor c=3.159E-15
    I_C225 (I1_ru3 VSS) capacitor c=2.500E-15
    I_C226 (I2_XOR_5 VSS) capacitor c=1.143E-15
    I_C227 (I2_XOR_7 VSS) capacitor c=1.455E-15
    I_C228 (I0_I77_pn3 VSS) capacitor c=4.369E-15
    I_C229 (I0_I77_G2_0n VSS) capacitor c=2.524E-15
    I_C230 (MULP_11 VSS) capacitor c=1.708E-15
    I_C231 (I1_I152_pn4 VSS) capacitor c=4.395E-15
    I_C232 (I1_I152_G3_0n VSS) capacitor c=2.657E-15
    I_C233 (I1_ru4 VSS) capacitor c=2.344E-15
    I_C234 (I0_I77_pn4 VSS) capacitor c=4.809E-15
    I_C235 (I0_I77_G3_0n VSS) capacitor c=2.350E-15
    I_C236 (MULP_12 VSS) capacitor c=2.193E-15
    I_C237 (I0_one0 VSS) capacitor c=1.255E-14
    I_C238 (I0_two0 VSS) capacitor c=1.218E-14
    I_C239 (I0_one1 VSS) capacitor c=1.468E-14
    I_C240 (I0_two1 VSS) capacitor c=1.546E-14
    I_C241 (I0_one2 VSS) capacitor c=1.340E-14
    I_C242 (I0_two2 VSS) capacitor c=1.180E-14
    I_C243 (I0_one3 VSS) capacitor c=9.535E-15
    I_C244 (I0_two3 VSS) capacitor c=8.502E-15
    I_C245 (I1_I60_G1_0 VSS) capacitor c=4.220E-15
    I_C246 (I1_I60_G1_0n VSS) capacitor c=5.969E-16
    I_C247 (I1_I72_G1_0 VSS) capacitor c=5.845E-15
    I_C248 (I1_I72_G1_0n VSS) capacitor c=6.203E-16
    I_C249 (I1_I96_G1_0 VSS) capacitor c=3.804E-15
    I_C250 (I1_I96_G1_0n VSS) capacitor c=1.039E-15
    I_C251 (I1_I84_G1_0 VSS) capacitor c=2.889E-15
    I_C252 (I1_I84_G1_0n VSS) capacitor c=1.123E-15
    I_C253 (I1_I48_G1_0 VSS) capacitor c=4.072E-15
    I_C254 (I1_I48_G1_0n VSS) capacitor c=7.101E-16
    I_C255 (I1_I60_G0_0 VSS) capacitor c=3.630E-15
    I_C256 (I1_I60_G0_0n VSS) capacitor c=1.809E-15
    I_C257 (I1_I96_G0_0 VSS) capacitor c=5.062E-15
    I_C258 (I1_I96_G0_0n VSS) capacitor c=2.064E-15
    I_C259 (I1_I48_G0_0 VSS) capacitor c=4.463E-15
    I_C260 (I1_I48_G0_0n VSS) capacitor c=1.522E-15
    I_C261 (I1_I72_G0_0 VSS) capacitor c=3.404E-15
    I_C262 (I1_I72_G0_0n VSS) capacitor c=2.173E-15
    I_C263 (I1_I84_G0_0 VSS) capacitor c=4.896E-15
    I_C264 (I1_I84_G0_0n VSS) capacitor c=1.591E-15
    I_C265 (I1_I108_G1_0 VSS) capacitor c=4.956E-15
    I_C266 (I1_I108_G1_0n VSS) capacitor c=1.330E-15
    I_C267 (I2_I2_nor2 VSS) capacitor c=8.854E-16
    I_C268 (I2_OR_2 VSS) capacitor c=5.693E-16
    I_C269 (I1_I48_cinn VSS) capacitor c=6.664E-16
    I_C270 (I1_I60_cinn VSS) capacitor c=1.510E-15
    I_C271 (I1_I72_cinn VSS) capacitor c=6.700E-16
    I_C272 (I1_I108_G0_0 VSS) capacitor c=3.816E-15
    I_C273 (I1_I108_G0_0n VSS) capacitor c=2.280E-15
    I_C274 (I2_I2_nand2 VSS) capacitor c=9.889E-16
    I_C275 (I2_AND_2 VSS) capacitor c=8.342E-16
    I_C276 (I2_NOT_2 VSS) capacitor c=6.175E-16
    I_C277 (I2_I2_nand1 VSS) capacitor c=7.813E-16
    I_C278 (I2_AND_1 VSS) capacitor c=7.065E-16
    I_C279 (I2_I2_nor1 VSS) capacitor c=7.535E-16
    I_C280 (I2_OR_1 VSS) capacitor c=6.976E-16
    I_C281 (I2_I2_nor0 VSS) capacitor c=8.950E-16
    I_C282 (I2_OR_0 VSS) capacitor c=5.342E-16
    I_C283 (I1_nakn6 VSS) capacitor c=2.635E-15
    I_C284 (I1_nak6 VSS) capacitor c=9.745E-16
    I_C285 (I1_nqkn6 VSS) capacitor c=1.902E-15
    I_C286 (I1_nqk6 VSS) capacitor c=1.266E-15
    I_C287 (I1_nqkn5 VSS) capacitor c=2.127E-15
    I_C288 (I1_nqk5 VSS) capacitor c=1.064E-15
    I_C289 (I1_nqkn4 VSS) capacitor c=2.142E-15
    I_C290 (I1_nqk4 VSS) capacitor c=9.826E-16
    I_C291 (I1_I84_cinn VSS) capacitor c=6.715E-16
    I_C292 (I1_I96_cinn VSS) capacitor c=8.774E-16
    I_C293 (I2_I2_nand4 VSS) capacitor c=9.713E-16
    I_C294 (I2_AND_4 VSS) capacitor c=1.014E-15
    I_C295 (I2_I2_nor4 VSS) capacitor c=8.862E-16
    I_C296 (I2_OR_4 VSS) capacitor c=8.419E-16
    I_C297 (I2_NOT_1 VSS) capacitor c=5.447E-16
    I_C298 (I2_I2_nand0 VSS) capacitor c=6.787E-16
    I_C299 (I2_AND_0 VSS) capacitor c=7.329E-16
    I_C300 (I1_nbkn2 VSS) capacitor c=1.899E-15
    I_C301 (I1_nbk2 VSS) capacitor c=6.845E-16
    I_C302 (I1_nbkn1 VSS) capacitor c=1.726E-15
    I_C303 (I1_nbk1 VSS) capacitor c=7.438E-16
    I_C304 (I1_nakn5 VSS) capacitor c=2.390E-15
    I_C305 (I1_nak5 VSS) capacitor c=6.764E-16
    I_C306 (I1_nakn4 VSS) capacitor c=2.053E-15
    I_C307 (I1_nak4 VSS) capacitor c=6.732E-16
    I_C308 (I1_nakn3 VSS) capacitor c=2.464E-15
    I_C309 (I1_nak3 VSS) capacitor c=1.085E-15
    I_C310 (I1_nakn2 VSS) capacitor c=2.093E-15
    I_C311 (I1_nak2 VSS) capacitor c=6.506E-16
    I_C312 (I1_nakn1 VSS) capacitor c=1.944E-15
    I_C313 (I1_nak1 VSS) capacitor c=7.478E-16
    I_C314 (I1_nqkn3 VSS) capacitor c=2.275E-15
    I_C315 (I1_nqk3 VSS) capacitor c=8.825E-16
    I_C316 (I1_I108_cinn VSS) capacitor c=6.360E-16
    I_C317 (I2_NOT_4 VSS) capacitor c=8.919E-16
    I_C318 (I2_NOT_0 VSS) capacitor c=5.543E-16
    I_C319 (I1_nbkn3 VSS) capacitor c=2.254E-15
    I_C320 (I1_nbk3 VSS) capacitor c=6.900E-16
    I_C321 (I1_nqkn2 VSS) capacitor c=2.737E-15
    I_C322 (I1_nqk2 VSS) capacitor c=1.044E-15
    I_C323 (I1_nbkn4 VSS) capacitor c=2.169E-15
    I_C324 (I1_nbk4 VSS) capacitor c=6.466E-16
    I_C325 (I1_sqn VSS) capacitor c=9.780E-16
    I_C326 (I1_I120_cinn VSS) capacitor c=6.167E-16
    I_C327 (I1_I120_G0_0 VSS) capacitor c=3.434E-15
    I_C328 (I1_I120_G0_0n VSS) capacitor c=2.113E-15
    I_C329 (I1_I120_G1_0 VSS) capacitor c=4.538E-15
    I_C330 (I1_I120_G1_0n VSS) capacitor c=1.079E-15
    I_C331 (I2_I1_I8_G0_0 VSS) capacitor c=5.204E-15
    I_C332 (I2_I1_I8_G0_0n VSS) capacitor c=1.548E-15
    I_C333 (I2_I1_I8_cinn VSS) capacitor c=7.330E-16
    I_C334 (I2_I4_dzn VSS) capacitor c=8.963E-16
    I_C335 (I1_nqkn1 VSS) capacitor c=2.100E-15
    I_C336 (I1_nqk1 VSS) capacitor c=6.898E-16
    I_C337 (DIVQ_0 VSS) capacitor c=2.128E-15
    I_C338 (I1_nbkn5 VSS) capacitor c=3.277E-15
    I_C339 (I1_nbk5 VSS) capacitor c=6.447E-16
    I_C340 (I1_I132_cinn VSS) capacitor c=6.910E-16
    I_C341 (I2_I1_I8_G1_0 VSS) capacitor c=4.511E-15
    I_C342 (I2_I1_I8_G1_0n VSS) capacitor c=9.263E-16
    I_C343 (I2_I4_cn VSS) capacitor c=7.108E-16
    I_C344 (I1_nbkn6 VSS) capacitor c=2.159E-15
    I_C345 (I1_nbk6 VSS) capacitor c=8.853E-16
    I_C346 (I1_dmn0 VSS) capacitor c=1.141E-15
    I_C347 (I1_dm0 VSS) capacitor c=1.988E-15
    I_C348 (I1_I132_G0_0 VSS) capacitor c=3.503E-15
    I_C349 (I1_I132_G0_0n VSS) capacitor c=1.944E-15
    I_C350 (I1_dmn1 VSS) capacitor c=1.522E-15
    I_C351 (I1_dm1 VSS) capacitor c=1.854E-15
    I_C352 (I1_dmn2 VSS) capacitor c=3.105E-15
    I_C353 (I1_dm2 VSS) capacitor c=1.760E-15
    I_C354 (I1_dmn3 VSS) capacitor c=1.862E-15
    I_C355 (I1_dm3 VSS) capacitor c=1.710E-15
    I_C356 (I1_dmn4 VSS) capacitor c=1.793E-15
    I_C357 (I1_dm4 VSS) capacitor c=2.119E-15
    I_C358 (I1_I132_G1_0 VSS) capacitor c=4.154E-15
    I_C359 (I1_I132_G1_0n VSS) capacitor c=1.226E-15
    I_C360 (I1_I152_cinn VSS) capacitor c=7.684E-16
    I_C361 (I1_dmn5 VSS) capacitor c=2.299E-15
    I_C362 (I1_dm5 VSS) capacitor c=1.478E-15
    I_C363 (I1_dmn6 VSS) capacitor c=3.389E-15
    I_C364 (I1_dm6 VSS) capacitor c=1.662E-15
    I_C365 (I2_NOT_3 VSS) capacitor c=8.966E-16
    I_C366 (I2_I2_nand3 VSS) capacitor c=7.231E-16
    I_C367 (I2_AND_3 VSS) capacitor c=7.286E-16
    I_C368 (I2_I2_nor3 VSS) capacitor c=6.992E-16
    I_C369 (I2_OR_3 VSS) capacitor c=7.084E-16
    I_C370 (I2_I2_nor6 VSS) capacitor c=6.758E-16
    I_C371 (I2_OR_6 VSS) capacitor c=6.950E-16
    I_C372 (I0_rc8 VSS) capacitor c=2.662E-15
    I_C373 (I0_I77_cinn VSS) capacitor c=7.252E-16
    I_C374 (I1_nrkn1 VSS) capacitor c=1.794E-15
    I_C375 (I1_nrk1 VSS) capacitor c=8.030E-16
    I_C376 (I1_I152_G0_0 VSS) capacitor c=4.158E-15
    I_C377 (I1_I152_G0_0n VSS) capacitor c=1.644E-15
    I_C378 (I1_dmn7 VSS) capacitor c=2.247E-15
    I_C379 (I1_dm7 VSS) capacitor c=1.666E-15
    I_C380 (I2_I2_nor5 VSS) capacitor c=9.511E-16
    I_C381 (I2_OR_5 VSS) capacitor c=6.421E-16
    I_C382 (I2_NOT_6 VSS) capacitor c=5.320E-16
    I_C383 (I2_NOT_5 VSS) capacitor c=7.542E-16
    I_C384 (I2_I2_nand6 VSS) capacitor c=7.584E-16
    I_C385 (I2_AND_6 VSS) capacitor c=8.424E-16
    I_C386 (I0_pp0_8 VSS) capacitor c=1.318E-14
    I_C387 (I0_sn0 VSS) capacitor c=3.888E-15
    I_C388 (I0_pp1_8 VSS) capacitor c=4.531E-15
    I_C389 (I0_sn1 VSS) capacitor c=4.093E-15
    I_C390 (I0_I77_G0_0 VSS) capacitor c=3.210E-15
    I_C391 (I0_I77_G0_0n VSS) capacitor c=1.489E-15
    I_C392 (I1_nrkn2 VSS) capacitor c=2.465E-15
    I_C393 (I1_nrk2 VSS) capacitor c=6.661E-16
    I_C394 (I2_I2_nand5 VSS) capacitor c=6.194E-16
    I_C395 (I2_AND_5 VSS) capacitor c=6.548E-16
    I_C396 (I2_I0_opn0 VSS) capacitor c=1.248E-15
    I_C397 (I2_I2_nand7 VSS) capacitor c=7.480E-16
    I_C398 (I2_AND_7 VSS) capacitor c=9.051E-16
    I_C399 (I2_I2_nor7 VSS) capacitor c=6.670E-16
    I_C400 (I2_OR_7 VSS) capacitor c=5.579E-16
    I_C401 (I0_pp2_8 VSS) capacitor c=4.951E-15
    I_C402 (I0_sn2 VSS) capacitor c=3.597E-15
    I_C403 (I1_nrkn3 VSS) capacitor c=2.130E-15
    I_C404 (I1_nrk3 VSS) capacitor c=8.456E-16
    I_C405 (I1_nrkn4 VSS) capacitor c=2.215E-15
    I_C406 (I1_nrk4 VSS) capacitor c=6.576E-16
    I_C407 (I1_nrkn5 VSS) capacitor c=2.058E-15
    I_C408 (I1_nrk5 VSS) capacitor c=7.196E-16
    I_C409 (I1_I152_G1_0 VSS) capacitor c=4.537E-15
    I_C410 (I1_I152_G1_0n VSS) capacitor c=8.765E-16
    I_C411 (I2_I0_opn1 VSS) capacitor c=1.477E-15
    I_C412 (I2_NOT_7 VSS) capacitor c=5.757E-16
    I_C413 (I0_pp3_8 VSS) capacitor c=3.713E-15
    I_C414 (I0_sn3 VSS) capacitor c=2.359E-15
    I_C415 (I0_I77_G1_0 VSS) capacitor c=4.234E-15
    I_C416 (I0_I77_G1_0n VSS) capacitor c=5.950E-16
    I_C417 (I1_nrkn6 VSS) capacitor c=1.816E-15
    I_C418 (I1_nrk6 VSS) capacitor c=6.439E-16
    I_C419 (I2_I0_opn2 VSS) capacitor c=1.422E-15
    I_C420 (I2_I0_opn3 VSS) capacitor c=1.625E-15
    I_C421 (I2_I4_zd VSS) capacitor c=8.505E-16
    I_C422 (I0_cm5_1 VSS) capacitor c=4.605E-15
    I_C423 (I0_cm5_2 VSS) capacitor c=5.236E-15
    I_C424 (I0_cm5_0 VSS) capacitor c=4.044E-15
    I_C425 (I0_pp0_6 VSS) capacitor c=4.673E-15
    I_C426 (I0_pp1_4 VSS) capacitor c=4.360E-15
    I_C427 (I0_pp2_2 VSS) capacitor c=4.078E-15
    I_C428 (I0_pp3_0 VSS) capacitor c=4.584E-15
    I_C429 (I0_cm6_1 VSS) capacitor c=3.771E-15
    I_C430 (I0_cm6_2 VSS) capacitor c=4.351E-15
    I_C431 (I0_cm6_0 VSS) capacitor c=2.457E-15
    I_C432 (I0_pp0_7 VSS) capacitor c=6.212E-15
    I_C433 (I0_pp1_5 VSS) capacitor c=4.572E-15
    I_C434 (I0_pp2_3 VSS) capacitor c=4.698E-15
    I_C435 (I0_pp3_1 VSS) capacitor c=5.443E-15
    I_C436 (I0_cm7_1 VSS) capacitor c=3.245E-15
    I_C437 (I0_cm7_2 VSS) capacitor c=4.568E-15
    I_C438 (I0_cm7_0 VSS) capacitor c=2.546E-15
    I_C439 (I0_pp1_6 VSS) capacitor c=5.210E-15
    I_C440 (I0_pp2_4 VSS) capacitor c=4.064E-15
    I_C441 (I0_pp3_2 VSS) capacitor c=7.149E-15
    I_C442 (I0_cm8_1 VSS) capacitor c=2.804E-15
    I_C443 (I0_cm8_2 VSS) capacitor c=3.768E-15
    I_C444 (I0_cm8_0 VSS) capacitor c=2.684E-15
    I_C445 (I0_pp1_7 VSS) capacitor c=5.016E-15
    I_C446 (I0_pp2_5 VSS) capacitor c=4.861E-15
    I_C447 (I0_pp3_3 VSS) capacitor c=6.247E-15
    I_C448 (I0_cm9_1 VSS) capacitor c=2.982E-15
    I_C449 (I0_cm9_2 VSS) capacitor c=3.157E-15
    I_C450 (I0_cm9_0 VSS) capacitor c=4.386E-15
    I_C451 (I0_pp2_6 VSS) capacitor c=4.281E-15
    I_C452 (I0_pp3_4 VSS) capacitor c=4.444E-15
    I_C453 (I0_cm11_1 VSS) capacitor c=2.749E-15
    I_C454 (I0_cm10_2 VSS) capacitor c=3.029E-15
    I_C455 (I0_cm11_2 VSS) capacitor c=3.585E-15
    I_C456 (I0_cm11_0 VSS) capacitor c=2.349E-15
    I_C457 (I0_pp3_6 VSS) capacitor c=4.932E-15
    I_C458 (I0_cm10_1 VSS) capacitor c=2.894E-15
    I_C459 (I0_cm10_0 VSS) capacitor c=3.144E-15
    I_C460 (I0_pp2_7 VSS) capacitor c=3.896E-15
    I_C461 (I0_pp3_5 VSS) capacitor c=6.887E-15
    I_C462 (I1_I48_pn7 VSS) capacitor c=3.268E-15
    I_C463 (I1_I48_pn6 VSS) capacitor c=4.214E-15
    I_C464 (I1_I48_P7_6 VSS) capacitor c=2.017E-15
    I_C465 (I1_I60_pn7 VSS) capacitor c=3.811E-15
    I_C466 (I1_I60_pn6 VSS) capacitor c=4.657E-15
    I_C467 (I1_I60_P7_6 VSS) capacitor c=1.488E-15
    I_C468 (I1_I72_pn7 VSS) capacitor c=4.114E-15
    I_C469 (I1_I72_pn6 VSS) capacitor c=5.465E-15
    I_C470 (I1_I72_P7_6 VSS) capacitor c=2.152E-15
    I_C471 (I1_I84_pn7 VSS) capacitor c=3.161E-15
    I_C472 (I1_I84_pn6 VSS) capacitor c=4.287E-15
    I_C473 (I1_I84_P7_6 VSS) capacitor c=1.529E-15
    I_C474 (I1_I96_pn7 VSS) capacitor c=3.527E-15
    I_C475 (I1_I96_pn6 VSS) capacitor c=5.749E-15
    I_C476 (I1_I96_P7_6 VSS) capacitor c=1.606E-15
    I_C477 (I1_I60_pn5 VSS) capacitor c=5.014E-15
    I_C478 (I1_I60_P5_4 VSS) capacitor c=2.173E-15
    I_C479 (I1_I60_P6_5 VSS) capacitor c=2.173E-15
    I_C480 (I1_I72_pn5 VSS) capacitor c=5.601E-15
    I_C481 (I1_I72_P5_4 VSS) capacitor c=2.326E-15
    I_C482 (I1_I72_P6_5 VSS) capacitor c=1.895E-15
    I_C483 (I1_I84_pn5 VSS) capacitor c=4.235E-15
    I_C484 (I1_I84_P6_5 VSS) capacitor c=1.678E-15
    I_C485 (I1_I84_P5_4 VSS) capacitor c=3.625E-15
    I_C486 (I1_I96_pn5 VSS) capacitor c=4.832E-15
    I_C487 (I1_I96_P6_5 VSS) capacitor c=1.599E-15
    I_C488 (I1_I96_P5_4 VSS) capacitor c=2.324E-15
    I_C489 (I1_I48_pn5 VSS) capacitor c=4.663E-15
    I_C490 (I1_I48_P5_4 VSS) capacitor c=2.943E-15
    I_C491 (I1_I48_P6_5 VSS) capacitor c=1.464E-15
    I_C492 (I1_I60_P4_3 VSS) capacitor c=2.596E-15
    I_C493 (I1_I72_P4_3 VSS) capacitor c=2.256E-15
    I_C494 (I1_I84_P4_3 VSS) capacitor c=3.225E-15
    I_C495 (I1_I96_P4_3 VSS) capacitor c=2.440E-15
    I_C496 (I1_I96_pn2 VSS) capacitor c=5.603E-15
    I_C497 (I1_I96_P3_2 VSS) capacitor c=1.932E-15
    I_C498 (I1_I108_pn7 VSS) capacitor c=4.558E-15
    I_C499 (I1_I108_pn6 VSS) capacitor c=5.685E-15
    I_C500 (I1_I108_P7_6 VSS) capacitor c=1.712E-15
    I_C501 (I1_I48_P4_3 VSS) capacitor c=2.650E-15
    I_C502 (I1_I48_pn2 VSS) capacitor c=5.227E-15
    I_C503 (I1_I48_P3_2 VSS) capacitor c=2.257E-15
    I_C504 (I1_I60_pn2 VSS) capacitor c=4.802E-15
    I_C505 (I1_I60_P3_2 VSS) capacitor c=2.195E-15
    I_C506 (I1_I60_pn1 VSS) capacitor c=2.977E-15
    I_C507 (I1_I60_P2_1 VSS) capacitor c=1.532E-15
    I_C508 (I1_I72_pn2 VSS) capacitor c=4.263E-15
    I_C509 (I1_I72_P3_2 VSS) capacitor c=2.572E-15
    I_C510 (I1_I84_pn2 VSS) capacitor c=4.204E-15
    I_C511 (I1_I84_P3_2 VSS) capacitor c=1.770E-15
    I_C512 (I1_I96_pn1 VSS) capacitor c=4.214E-15
    I_C513 (I1_I96_P2_1 VSS) capacitor c=1.323E-15
    I_C514 (I1_I108_pn5 VSS) capacitor c=4.855E-15
    I_C515 (I1_I108_P5_4 VSS) capacitor c=2.444E-15
    I_C516 (I1_I48_pn1 VSS) capacitor c=3.540E-15
    I_C517 (I1_I48_P2_1 VSS) capacitor c=1.650E-15
    I_C518 (I1_I72_pn1 VSS) capacitor c=2.860E-15
    I_C519 (I1_I72_P2_1 VSS) capacitor c=1.405E-15
    I_C520 (I1_I84_pn1 VSS) capacitor c=4.051E-15
    I_C521 (I1_I84_P2_1 VSS) capacitor c=1.439E-15
    I_C522 (I1_I108_P4_3 VSS) capacitor c=2.317E-15
    I_C523 (I1_I108_P6_5 VSS) capacitor c=1.480E-15
    I_C524 (I1_I108_pn2 VSS) capacitor c=4.300E-15
    I_C525 (I1_I108_P3_2 VSS) capacitor c=2.736E-15
    I_C526 (I1_I108_pn1 VSS) capacitor c=3.724E-15
    I_C527 (I1_I108_P2_1 VSS) capacitor c=1.818E-15
    I_C528 (I2_I3_o2_0 VSS) capacitor c=1.125E-15
    I_C529 (I2_I3_o2_1 VSS) capacitor c=8.347E-16
    I_C530 (I2_I3_q2_1 VSS) capacitor c=1.417E-15
    I_C531 (I2_I3_o4_0 VSS) capacitor c=1.052E-15
    I_C532 (I2_I3_o4_1 VSS) capacitor c=1.511E-15
    I_C533 (I2_I3_q4_1 VSS) capacitor c=2.774E-15
    I_C534 (I2_I3_o1_0 VSS) capacitor c=1.506E-15
    I_C535 (I2_I3_o1_1 VSS) capacitor c=1.036E-15
    I_C536 (I2_I3_q1_1 VSS) capacitor c=1.125E-15
    I_C537 (I2_I4_za0 VSS) capacitor c=8.323E-16
    I_C538 (I2_I3_o0_0 VSS) capacitor c=1.628E-15
    I_C539 (I2_I3_o0_1 VSS) capacitor c=1.384E-15
    I_C540 (I2_I3_q0_1 VSS) capacitor c=8.440E-16
    I_C541 (I1_I120_pn2 VSS) capacitor c=4.181E-15
    I_C542 (I1_I120_P3_2 VSS) capacitor c=2.557E-15
    I_C543 (I1_I120_P4_3 VSS) capacitor c=2.853E-15
    I_C544 (I1_I120_pn5 VSS) capacitor c=4.698E-15
    I_C545 (I1_I120_P5_4 VSS) capacitor c=2.004E-15
    I_C546 (I1_I120_pn7 VSS) capacitor c=4.051E-15
    I_C547 (I1_I120_pn6 VSS) capacitor c=5.521E-15
    I_C548 (I1_I120_P7_6 VSS) capacitor c=1.418E-15
    I_C549 (I2_I4_za1 VSS) capacitor c=1.498E-15
    I_C550 (I1_z1_1 VSS) capacitor c=6.715E-16
    I_C551 (I1_z2_0 VSS) capacitor c=7.528E-16
    I_C552 (I1_z2_1 VSS) capacitor c=1.371E-15
    I_C553 (DIVDZ VSS) capacitor c=1.267E-15
    I_C554 (I1_z1_0 VSS) capacitor c=1.174E-15
    I_C555 (I1_I120_pn1 VSS) capacitor c=3.822E-15
    I_C556 (I1_I120_P2_1 VSS) capacitor c=1.652E-15
    I_C557 (I1_I120_P6_5 VSS) capacitor c=1.587E-15
    I_C558 (I2_I1_I8_pn2 VSS) capacitor c=5.096E-15
    I_C559 (I2_I1_I8_pn1 VSS) capacitor c=4.046E-15
    I_C560 (I2_I1_I8_P2_1 VSS) capacitor c=1.737E-15
    I_C561 (I1_vn VSS) capacitor c=1.293E-15
    I_C562 (DIVV VSS) capacitor c=1.855E-15
    I_C563 (I1_z1_2 VSS) capacitor c=8.278E-16
    I_C564 (I2_I4_zb0 VSS) capacitor c=2.783E-15
    I_C565 (I2_I4_zb1 VSS) capacitor c=7.405E-16
    I_C566 (I2_I4_zc0 VSS) capacitor c=6.920E-15
    I_C567 (I1_z1_3 VSS) capacitor c=1.004E-15
    I_C568 (I2_I1_I8_P4_3 VSS) capacitor c=2.691E-15
    I_C569 (I2_I1_I8_P3_2 VSS) capacitor c=1.515E-15
    I_C570 (I2_I4_za2 VSS) capacitor c=1.461E-15
    I_C571 (I1_I132_pn2 VSS) capacitor c=3.983E-15
    I_C572 (I1_I132_pn1 VSS) capacitor c=2.768E-15
    I_C573 (I1_I132_P2_1 VSS) capacitor c=1.996E-15
    I_C574 (I1_I132_P4_3 VSS) capacitor c=2.218E-15
    I_C575 (I1_I132_pn6 VSS) capacitor c=5.477E-15
    I_C576 (I1_I132_pn5 VSS) capacitor c=4.976E-15
    I_C577 (I1_I132_P6_5 VSS) capacitor c=1.676E-15
    I_C578 (I2_I1_I8_pn5 VSS) capacitor c=5.762E-15
    I_C579 (I2_I1_I8_P5_4 VSS) capacitor c=2.453E-15
    I_C580 (I2_I4_za3 VSS) capacitor c=1.302E-15
    I_C581 (I1_I132_P3_2 VSS) capacitor c=3.772E-15
    I_C582 (I1_I132_P5_4 VSS) capacitor c=2.722E-15
    I_C583 (I1_I132_pn7 VSS) capacitor c=3.984E-15
    I_C584 (I1_I132_P7_6 VSS) capacitor c=2.049E-15
    I_C585 (I2_I1_I8_pn6 VSS) capacitor c=3.615E-15
    I_C586 (I2_I1_I8_P6_5 VSS) capacitor c=2.111E-15
    I_C587 (I2_I1_I8_pn7 VSS) capacitor c=4.672E-15
    I_C588 (I2_I1_I8_P7_6 VSS) capacitor c=1.362E-15
    I_C589 (I1_I152_pn2 VSS) capacitor c=4.179E-15
    I_C590 (I1_I152_pn1 VSS) capacitor c=3.418E-15
    I_C591 (I1_I152_P2_1 VSS) capacitor c=1.454E-15
    I_C592 (I1_I152_P4_3 VSS) capacitor c=2.286E-15
    I_C593 (I1_I152_pn6 VSS) capacitor c=3.931E-15
    I_C594 (I1_I152_pn5 VSS) capacitor c=4.217E-15
    I_C595 (I1_I152_P6_5 VSS) capacitor c=1.483E-15
    I_C596 (I2_I3_o3_0 VSS) capacitor c=9.112E-16
    I_C597 (I2_I3_o3_1 VSS) capacitor c=1.246E-15
    I_C598 (I2_I3_q3_1 VSS) capacitor c=5.225E-15
    I_C599 (I2_I3_o5_0 VSS) capacitor c=9.609E-16
    I_C600 (I2_I3_o5_1 VSS) capacitor c=7.462E-16
    I_C601 (I2_I3_q5_1 VSS) capacitor c=3.670E-15
    I_C602 (I2_I3_o6_0 VSS) capacitor c=7.325E-16
    I_C603 (I2_I3_o6_1 VSS) capacitor c=8.928E-16
    I_C604 (I2_I3_q6_1 VSS) capacitor c=3.278E-15
    I_C605 (I0_I77_pn2 VSS) capacitor c=5.270E-15
    I_C606 (I0_I77_pn1 VSS) capacitor c=3.497E-15
    I_C607 (I0_I77_P2_1 VSS) capacitor c=1.440E-15
    I_C608 (I2_I4_za4 VSS) capacitor c=1.866E-15
    I_C609 (I1_I152_P3_2 VSS) capacitor c=2.617E-15
    I_C610 (I1_I152_P5_4 VSS) capacitor c=2.254E-15
    I_C611 (I1_I152_pn7 VSS) capacitor c=2.811E-15
    I_C612 (I1_I152_P7_6 VSS) capacitor c=1.421E-15
    I_C613 (I2_I0_h00 VSS) capacitor c=2.931E-15
    I_C614 (I2_I0_l10 VSS) capacitor c=7.622E-16
    I_C615 (I2_SEL_AND VSS) capacitor c=1.434E-14
    I_C616 (I2_SEL_AS VSS) capacitor c=1.390E-14
    I_C617 (I2_I0_l11 VSS) capacitor c=2.252E-15
    I_C618 (I2_SEL_OR VSS) capacitor c=1.409E-14
    I_C619 (I2_I3_o7_0 VSS) capacitor c=8.229E-16
    I_C620 (I2_I3_o7_1 VSS) capacitor c=9.124E-16
    I_C621 (I2_I3_q7_1 VSS) capacitor c=2.236E-15
    I_C622 (I0_I77_P3_2 VSS) capacitor c=1.744E-15
    I_C623 (I0_I77_P4_3 VSS) capacitor c=2.818E-15
    I_C624 (I2_I0_h01 VSS) capacitor c=1.770E-15
    I_C625 (I2_I0_l00 VSS) capacitor c=8.518E-16
    I_C626 (I2_SEL_XOR VSS) capacitor c=1.415E-14
    I_C627 (I2_I0_l01 VSS) capacitor c=1.468E-15
    I_C628 (I2_SEL_NOT VSS) capacitor c=1.562E-14
    I_C629 (I2_I0_h10 VSS) capacitor c=1.752E-15
    I_C630 (I2_SEL_MUL VSS) capacitor c=2.541E-14
    I_C631 (I2_SEL_DIV VSS) capacitor c=2.416E-14
    I_C632 (I0_I77_pn5 VSS) capacitor c=5.292E-15
    I_C633 (I0_I77_P5_4 VSS) capacitor c=3.079E-15
    I_C634 (I0_I77_pn6 VSS) capacitor c=5.236E-15
    I_C635 (I0_I77_P6_5 VSS) capacitor c=1.615E-15
    I_C636 (I2_I4_zb2 VSS) capacitor c=8.185E-16
    I_C637 (I2_I4_zb3 VSS) capacitor c=9.376E-16
    I_C638 (I2_I4_zc1 VSS) capacitor c=7.773E-16
    I_C639 (I2_I4_za5 VSS) capacitor c=9.171E-16
    I_C640 (I2_I4_za6 VSS) capacitor c=1.027E-15
    I_C641 (I0_I77_pn7 VSS) capacitor c=6.005E-15
    I_C642 (I0_I77_P7_6 VSS) capacitor c=2.051E-15
    I_C643 (I2_I4_za7 VSS) capacitor c=9.082E-16
    I_C644 (I1_I48_gn7 VSS) capacitor c=1.115E-15
    I_C645 (I1_p0_6 VSS) capacitor c=4.310E-15
    I_C646 (I1_I60_gn7 VSS) capacitor c=6.647E-16
    I_C647 (I1_p1_6 VSS) capacitor c=3.327E-15
    I_C648 (I1_I72_gn7 VSS) capacitor c=7.148E-16
    I_C649 (I1_p3_6 VSS) capacitor c=3.951E-15
    I_C650 (I1_I96_gn7 VSS) capacitor c=7.061E-16
    I_C651 (I1_I48_P7_4n VSS) capacitor c=9.912E-16
    I_C652 (I1_I48_gn6 VSS) capacitor c=2.078E-15
    I_C653 (I1_p0_5 VSS) capacitor c=2.972E-15
    I_C654 (I1_I60_gn6 VSS) capacitor c=1.809E-15
    I_C655 (I1_I60_P7_4n VSS) capacitor c=8.591E-16
    I_C656 (I1_I60_P5_2n VSS) capacitor c=1.113E-15
    I_C657 (I1_I72_P7_4n VSS) capacitor c=1.125E-15
    I_C658 (I1_I72_P5_2n VSS) capacitor c=1.092E-15
    I_C659 (I1_p2_5 VSS) capacitor c=2.780E-15
    I_C660 (I1_I84_gn6 VSS) capacitor c=1.733E-15
    I_C661 (I1_p2_6 VSS) capacitor c=3.004E-15
    I_C662 (I1_I84_gn7 VSS) capacitor c=8.045E-16
    I_C663 (I1_I84_P7_4n VSS) capacitor c=8.886E-16
    I_C664 (I1_I96_gn5 VSS) capacitor c=1.690E-15
    I_C665 (I1_p3_5 VSS) capacitor c=3.607E-15
    I_C666 (I1_I96_gn6 VSS) capacitor c=2.380E-15
    I_C667 (I1_I96_P7_4n VSS) capacitor c=8.837E-16
    I_C668 (I1_p4_6 VSS) capacitor c=3.109E-15
    I_C669 (I1_I108_gn7 VSS) capacitor c=1.059E-15
    I_C670 (I1_I48_gn5 VSS) capacitor c=2.017E-15
    I_C671 (I1_I60_gn5 VSS) capacitor c=1.363E-15
    I_C672 (I1_I72_gn5 VSS) capacitor c=1.506E-15
    I_C673 (I1_p1_5 VSS) capacitor c=2.678E-15
    I_C674 (I1_I72_gn6 VSS) capacitor c=2.251E-15
    I_C675 (I1_I84_gn5 VSS) capacitor c=1.281E-15
    I_C676 (I1_I84_P6_3n VSS) capacitor c=1.189E-15
    I_C677 (I1_I84_P5_2n VSS) capacitor c=1.546E-15
    I_C678 (I1_I96_gn4 VSS) capacitor c=2.220E-15
    I_C679 (I1_I96_P6_3n VSS) capacitor c=1.059E-15
    I_C680 (I1_I96_P5_2n VSS) capacitor c=1.427E-15
    I_C681 (I1_p4_5 VSS) capacitor c=2.564E-15
    I_C682 (I1_I108_gn6 VSS) capacitor c=2.006E-15
    I_C683 (I1_I48_P5_2n VSS) capacitor c=8.688E-16
    I_C684 (I1_I48_P6_3n VSS) capacitor c=8.912E-16
    I_C685 (I1_I60_gn4 VSS) capacitor c=1.696E-15
    I_C686 (I1_I60_P6_3n VSS) capacitor c=9.333E-16
    I_C687 (I1_I72_gn4 VSS) capacitor c=1.438E-15
    I_C688 (I1_I72_P6_3n VSS) capacitor c=1.047E-15
    I_C689 (I1_I84_gn4 VSS) capacitor c=2.564E-15
    I_C690 (I1_I96_P4_1n VSS) capacitor c=1.429E-15
    I_C691 (I1_I108_gn5 VSS) capacitor c=1.390E-15
    I_C692 (I1_I48_gn4 VSS) capacitor c=2.472E-15
    I_C693 (I1_I48_P4_1n VSS) capacitor c=1.294E-15
    I_C694 (I1_p0_2 VSS) capacitor c=3.038E-15
    I_C695 (I1_I60_gn3 VSS) capacitor c=1.785E-15
    I_C696 (I1_I60_P4_1n VSS) capacitor c=1.921E-15
    I_C697 (I1_p1_2 VSS) capacitor c=3.025E-15
    I_C698 (I1_I72_gn3 VSS) capacitor c=1.493E-15
    I_C699 (I1_I72_P4_1n VSS) capacitor c=1.144E-15
    I_C700 (I1_p2_2 VSS) capacitor c=2.537E-15
    I_C701 (I1_I84_gn3 VSS) capacitor c=1.422E-15
    I_C702 (I1_I84_P4_1n VSS) capacitor c=1.338E-15
    I_C703 (I1_p3_2 VSS) capacitor c=2.590E-15
    I_C704 (I1_I96_gn3 VSS) capacitor c=2.136E-15
    I_C705 (I1_I108_gn4 VSS) capacitor c=2.498E-15
    I_C706 (I1_I108_P7_4n VSS) capacitor c=1.141E-15
    I_C707 (I1_I48_gn1 VSS) capacitor c=1.758E-15
    I_C708 (I1_p0_1 VSS) capacitor c=2.521E-15
    I_C709 (I1_I60_gn2 VSS) capacitor c=1.971E-15
    I_C710 (I1_p0_0 VSS) capacitor c=2.416E-15
    I_C711 (I1_I60_gn1 VSS) capacitor c=1.889E-15
    I_C712 (I1_p1_1 VSS) capacitor c=2.561E-15
    I_C713 (I1_I72_gn2 VSS) capacitor c=2.059E-15
    I_C714 (I1_p1_0 VSS) capacitor c=3.232E-15
    I_C715 (I1_I72_gn1 VSS) capacitor c=1.702E-15
    I_C716 (I1_p2_1 VSS) capacitor c=2.589E-15
    I_C717 (I1_I84_gn2 VSS) capacitor c=1.764E-15
    I_C718 (I1_p2_0 VSS) capacitor c=2.979E-15
    I_C719 (I1_I84_gn1 VSS) capacitor c=1.920E-15
    I_C720 (I1_p3_0 VSS) capacitor c=3.317E-15
    I_C721 (I1_I96_gn1 VSS) capacitor c=3.054E-15
    I_C722 (I1_p3_1 VSS) capacitor c=2.979E-15
    I_C723 (I1_I96_gn2 VSS) capacitor c=2.087E-15
    I_C724 (I1_p4_2 VSS) capacitor c=2.815E-15
    I_C725 (I1_I108_gn3 VSS) capacitor c=1.959E-15
    I_C726 (I1_I108_P6_3n VSS) capacitor c=1.042E-15
    I_C727 (I1_I108_P5_2n VSS) capacitor c=1.394E-15
    I_C728 (I1_I48_gn3 VSS) capacitor c=1.877E-15
    I_C729 (I2_I3_n2_1 VSS) capacitor c=8.051E-16
    I_C730 (I1_I48_gn2 VSS) capacitor c=1.534E-15
    I_C731 (I1_aa7 VSS) capacitor c=3.065E-15
    I_C732 (I1_I48_gn0 VSS) capacitor c=1.088E-15
    I_C733 (I1_aa5 VSS) capacitor c=2.704E-15
    I_C734 (I1_I72_gn0 VSS) capacitor c=8.425E-16
    I_C735 (I1_p4_1 VSS) capacitor c=2.692E-15
    I_C736 (I1_I108_gn2 VSS) capacitor c=2.128E-15
    I_C737 (I1_I108_P4_1n VSS) capacitor c=1.109E-15
    I_C738 (I2_I3_n2_2 VSS) capacitor c=1.283E-15
    I_C739 (I2_I3_n2_3 VSS) capacitor c=1.096E-15
    I_C740 (I2_I3_n2_0 VSS) capacitor c=8.145E-16
    I_C741 (I2_I3_n1_0 VSS) capacitor c=8.356E-16
    I_C742 (I2_I3_n1_1 VSS) capacitor c=9.044E-16
    I_C743 (I2_I3_n0_0 VSS) capacitor c=8.710E-16
    I_C744 (I2_I3_n0_1 VSS) capacitor c=6.754E-16
    I_C745 (I1_aa6 VSS) capacitor c=2.136E-15
    I_C746 (I1_I60_gn0 VSS) capacitor c=1.240E-15
    I_C747 (I1_aa4 VSS) capacitor c=4.158E-15
    I_C748 (I1_I84_gn0 VSS) capacitor c=8.363E-16
    I_C749 (I1_aa3 VSS) capacitor c=4.628E-15
    I_C750 (I1_I96_gn0 VSS) capacitor c=8.535E-16
    I_C751 (I1_aa2 VSS) capacitor c=3.724E-15
    I_C752 (I1_I108_gn0 VSS) capacitor c=1.082E-15
    I_C753 (I1_p4_0 VSS) capacitor c=3.090E-15
    I_C754 (I1_I108_gn1 VSS) capacitor c=1.184E-15
    I_C755 (I1_I120_gn5 VSS) capacitor c=1.426E-15
    I_C756 (I1_p5_6 VSS) capacitor c=3.343E-15
    I_C757 (I1_I120_gn7 VSS) capacitor c=1.243E-15
    I_C758 (I2_I3_n4_0 VSS) capacitor c=7.866E-16
    I_C759 (I2_I3_n4_1 VSS) capacitor c=8.217E-16
    I_C760 (I2_I3_n1_2 VSS) capacitor c=1.199E-15
    I_C761 (I2_I3_n1_3 VSS) capacitor c=7.545E-16
    I_C762 (I2_I3_n0_2 VSS) capacitor c=1.214E-15
    I_C763 (I1_I120_gn4 VSS) capacitor c=1.786E-15
    I_C764 (I1_p5_5 VSS) capacitor c=2.722E-15
    I_C765 (I1_I120_gn6 VSS) capacitor c=1.341E-15
    I_C766 (I2_I3_n4_2 VSS) capacitor c=1.498E-15
    I_C767 (I2_I3_n4_3 VSS) capacitor c=7.664E-16
    I_C768 (I2_I3_q2_2 VSS) capacitor c=1.166E-15
    I_C769 (I2_I3_n0_3 VSS) capacitor c=1.021E-15
    I_C770 (I2_I3_q1_2 VSS) capacitor c=7.003E-16
    I_C771 (I2_I3_q0_2 VSS) capacitor c=8.516E-16
    I_C772 (I1_p5_0 VSS) capacitor c=3.378E-15
    I_C773 (I1_I120_gn1 VSS) capacitor c=2.048E-15
    I_C774 (I1_p5_1 VSS) capacitor c=2.527E-15
    I_C775 (I1_I120_gn2 VSS) capacitor c=1.995E-15
    I_C776 (I1_p5_2 VSS) capacitor c=3.487E-15
    I_C777 (I1_I120_gn3 VSS) capacitor c=1.719E-15
    I_C778 (I1_I120_P7_4n VSS) capacitor c=1.279E-15
    I_C779 (I1_I120_P5_2n VSS) capacitor c=8.779E-16
    I_C780 (I2_I3_q3_2 VSS) capacitor c=1.356E-15
    I_C781 (I2_I3_n0_4 VSS) capacitor c=8.900E-16
    I_C782 (I2_I3_n0_5 VSS) capacitor c=5.879E-15
    I_C783 (I2_I3_o0_2 VSS) capacitor c=1.454E-15
    I_C784 (MULP_0 VSS) capacitor c=9.144E-16
    I_C785 (DIVQ_7 VSS) capacitor c=3.532E-15
    I_C786 (MULP_1 VSS) capacitor c=1.385E-15
    I_C787 (I2_I3_n1_4 VSS) capacitor c=8.891E-16
    I_C788 (I2_I3_n1_5 VSS) capacitor c=5.143E-15
    I_C789 (I2_I3_o1_2 VSS) capacitor c=4.473E-15
    I_C790 (I2_I3_n2_4 VSS) capacitor c=1.196E-15
    I_C791 (I2_I3_n2_5 VSS) capacitor c=3.309E-15
    I_C792 (I2_I3_o2_2 VSS) capacitor c=6.100E-15
    I_C793 (MULP_2 VSS) capacitor c=1.361E-15
    I_C794 (I2_I3_n3_4 VSS) capacitor c=1.180E-15
    I_C795 (I2_I3_n3_5 VSS) capacitor c=9.001E-16
    I_C796 (I2_I3_o3_2 VSS) capacitor c=4.562E-15
    I_C797 (DIVQ_3 VSS) capacitor c=2.352E-15
    I_C798 (DIVQ_6 VSS) capacitor c=3.664E-15
    I_C799 (I2_I3_n6_5 VSS) capacitor c=2.538E-15
    I_C800 (MULP_3 VSS) capacitor c=1.352E-15
    I_C801 (DIVQ_2 VSS) capacitor c=1.458E-15
    I_C802 (DIVQ_4 VSS) capacitor c=2.433E-15
    I_C803 (I2_I3_n4_5 VSS) capacitor c=1.156E-15
    I_C804 (DIVQ_1 VSS) capacitor c=1.089E-15
    I_C805 (I1_aa1 VSS) capacitor c=3.082E-15
    I_C806 (I1_I120_gn0 VSS) capacitor c=7.166E-16
    I_C807 (I1_I120_P4_1n VSS) capacitor c=1.205E-15
    I_C808 (I1_I120_P6_3n VSS) capacitor c=1.123E-15
    I_C809 (I2_I1_I8_gn2 VSS) capacitor c=1.857E-15
    I_C810 (I2_I1_I8_gn1 VSS) capacitor c=2.076E-15
    I_C811 (I2_I3_q4_2 VSS) capacitor c=1.114E-15
    I_C812 (I2_I1_I8_gn0 VSS) capacitor c=1.365E-15
    I_C813 (MULP_4 VSS) capacitor c=1.285E-15
    I_C814 (I2_I3_n4_4 VSS) capacitor c=7.169E-16
    I_C815 (I2_I3_o4_2 VSS) capacitor c=5.058E-15
    I_C816 (DIVQ_5 VSS) capacitor c=2.820E-15
    I_C817 (I2_I3_n5_5 VSS) capacitor c=1.223E-15
    I_C818 (I1_p6_1 VSS) capacitor c=2.973E-15
    I_C819 (I1_I132_gn2 VSS) capacitor c=1.839E-15
    I_C820 (I2_I1_I8_P4_1n VSS) capacitor c=1.148E-15
    I_C821 (I2_I4_v1 VSS) capacitor c=7.667E-16
    I_C822 (I2_I4_v2 VSS) capacitor c=7.500E-16
    I_C823 (I2_I3_n7_5 VSS) capacitor c=2.219E-15
    I_C824 (I2_I3_n5_4 VSS) capacitor c=8.022E-16
    I_C825 (I2_I3_o5_2 VSS) capacitor c=4.035E-15
    I_C826 (MULP_5 VSS) capacitor c=8.747E-16
    I_C827 (I1_I132_gn0 VSS) capacitor c=7.658E-16
    I_C828 (I1_p6_0 VSS) capacitor c=2.932E-15
    I_C829 (I1_I132_gn1 VSS) capacitor c=1.849E-15
    I_C830 (I1_p6_2 VSS) capacitor c=2.428E-15
    I_C831 (I1_I132_gn3 VSS) capacitor c=1.557E-15
    I_C832 (I1_I132_gn4 VSS) capacitor c=1.617E-15
    I_C833 (I1_I132_gn5 VSS) capacitor c=1.622E-15
    I_C834 (I1_p6_5 VSS) capacitor c=2.651E-15
    I_C835 (I1_I132_gn6 VSS) capacitor c=1.566E-15
    I_C836 (I1_p6_6 VSS) capacitor c=2.818E-15
    I_C837 (I1_I132_gn7 VSS) capacitor c=6.853E-16
    I_C838 (I2_I1_I8_gn4 VSS) capacitor c=1.567E-15
    I_C839 (I2_I1_I8_P6_3n VSS) capacitor c=8.250E-16
    I_C840 (I2_I1_I8_P5_2n VSS) capacitor c=1.193E-15
    I_C841 (I2_I3_q5_2 VSS) capacitor c=1.343E-15
    I_C842 (I1_I132_P4_1n VSS) capacitor c=1.216E-15
    I_C843 (I1_I132_P6_3n VSS) capacitor c=1.409E-15
    I_C844 (I2_I1_I8_gn3 VSS) capacitor c=1.762E-15
    I_C845 (I2_I1_I8_P7_4n VSS) capacitor c=1.092E-15
    I_C846 (I2_I3_q6_2 VSS) capacitor c=1.232E-15
    I_C847 (I2_I3_n6_4 VSS) capacitor c=1.966E-15
    I_C848 (I2_I3_o6_2 VSS) capacitor c=2.849E-15
    I_C849 (MULP_6 VSS) capacitor c=1.245E-15
    I_C850 (I1_p7_0 VSS) capacitor c=2.819E-15
    I_C851 (I1_I152_gn0 VSS) capacitor c=1.337E-15
    I_C852 (I1_I152_gn3 VSS) capacitor c=1.516E-15
    I_C853 (I1_I132_P5_2n VSS) capacitor c=1.196E-15
    I_C854 (I1_I132_P7_4n VSS) capacitor c=1.103E-15
    I_C855 (I2_I1_I8_gn5 VSS) capacitor c=1.646E-15
    I_C856 (I2_I1_I8_gn7 VSS) capacitor c=1.299E-15
    I_C857 (I2_I3_q7_2 VSS) capacitor c=7.731E-16
    I_C858 (I2_I3_n7_4 VSS) capacitor c=4.352E-15
    I_C859 (I2_I3_o7_2 VSS) capacitor c=2.160E-15
    I_C860 (MULP_7 VSS) capacitor c=1.816E-15
    I_C861 (DIVR_0 VSS) capacitor c=1.241E-15
    I_C862 (I2_I3_hd8 VSS) capacitor c=8.607E-16
    I_C863 (I1_p7_1 VSS) capacitor c=2.548E-15
    I_C864 (I1_I152_gn1 VSS) capacitor c=2.077E-15
    I_C865 (I1_p7_2 VSS) capacitor c=2.664E-15
    I_C866 (I1_I152_gn2 VSS) capacitor c=1.538E-15
    I_C867 (I1_I152_gn4 VSS) capacitor c=1.568E-15
    I_C868 (I1_p7_5 VSS) capacitor c=2.783E-15
    I_C869 (I1_I152_gn5 VSS) capacitor c=1.829E-15
    I_C870 (I2_I3_n3_2 VSS) capacitor c=1.336E-15
    I_C871 (I2_I1_I8_gn6 VSS) capacitor c=2.433E-15
    I_C872 (I2_I3_n6_2 VSS) capacitor c=1.346E-15
    I_C873 (I0_ha17_1 VSS) capacitor c=2.590E-15
    I_C874 (I0_ha18_0 VSS) capacitor c=2.859E-15
    I_C875 (I0_I77_gn0 VSS) capacitor c=6.411E-16
    I_C876 (MULP_8 VSS) capacitor c=1.458E-15
    I_C877 (I2_I3_hm8 VSS) capacitor c=9.232E-16
    I_C878 (MULP_9 VSS) capacitor c=1.216E-15
    I_C879 (I2_I3_hm9 VSS) capacitor c=1.002E-15
    I_C880 (I1_I152_P4_1n VSS) capacitor c=1.042E-15
    I_C881 (I1_I152_P6_3n VSS) capacitor c=1.117E-15
    I_C882 (I1_p7_6 VSS) capacitor c=2.882E-15
    I_C883 (I1_I152_gn6 VSS) capacitor c=1.245E-15
    I_C884 (I1_p7_7 VSS) capacitor c=2.889E-15
    I_C885 (I1_I152_gn7 VSS) capacitor c=1.106E-15
    I_C886 (I2_I3_n3_3 VSS) capacitor c=9.908E-16
    I_C887 (I2_I3_n5_2 VSS) capacitor c=1.690E-15
    I_C888 (I2_I3_n5_1 VSS) capacitor c=1.001E-15
    I_C889 (I2_I3_n3_0 VSS) capacitor c=7.788E-16
    I_C890 (I2_I3_n3_1 VSS) capacitor c=6.645E-16
    I_C891 (I2_I3_n5_3 VSS) capacitor c=9.705E-16
    I_C892 (I2_I3_n6_3 VSS) capacitor c=6.729E-16
    I_C893 (I2_I3_n6_0 VSS) capacitor c=7.609E-16
    I_C894 (I2_I3_n6_1 VSS) capacitor c=9.554E-16
    I_C895 (I0_ha19_1 VSS) capacitor c=2.586E-15
    I_C896 (I0_ha20_0 VSS) capacitor c=1.831E-15
    I_C897 (I0_I77_gn2 VSS) capacitor c=1.462E-15
    I_C898 (I0_ha18_1 VSS) capacitor c=2.836E-15
    I_C899 (I0_ha19_0 VSS) capacitor c=2.276E-15
    I_C900 (I0_I77_gn1 VSS) capacitor c=1.305E-15
    I_C901 (I2_I3_hd9 VSS) capacitor c=9.133E-16
    I_C902 (DIVR_1 VSS) capacitor c=1.200E-15
    I_C903 (I1_I152_P7_4n VSS) capacitor c=8.005E-16
    I_C904 (I2_I3_n5_0 VSS) capacitor c=8.944E-16
    I_C905 (I2_I3_n7_0 VSS) capacitor c=8.291E-16
    I_C906 (I2_I3_n7_1 VSS) capacitor c=6.160E-16
    I_C907 (I0_ha20_1 VSS) capacitor c=2.548E-15
    I_C908 (I0_ha21_0 VSS) capacitor c=3.187E-15
    I_C909 (I0_I77_gn3 VSS) capacitor c=1.385E-15
    I_C910 (I0_I77_P4_1n VSS) capacitor c=9.906E-16
    I_C911 (MULP_10 VSS) capacitor c=1.441E-15
    I_C912 (I2_I3_hm10 VSS) capacitor c=8.844E-16
    I_C913 (I2_I3_hm11 VSS) capacitor c=9.430E-16
    I_C914 (I2_I3_hd10 VSS) capacitor c=7.924E-16
    I_C915 (DIVR_2 VSS) capacitor c=1.406E-15
    I_C916 (I2_I3_hd11 VSS) capacitor c=7.752E-16
    I_C917 (DIVR_3 VSS) capacitor c=8.668E-16
    I_C918 (I1_I152_P5_2n VSS) capacitor c=1.210E-15
    I_C919 (I2_I3_n7_2 VSS) capacitor c=1.022E-15
    I_C920 (I2_I3_n7_3 VSS) capacitor c=8.216E-16
    I_C921 (I0_ha23_1 VSS) capacitor c=2.384E-15
    I_C922 (I0_ha24_0 VSS) capacitor c=3.468E-15
    I_C923 (I0_I77_gn6 VSS) capacitor c=1.808E-15
    I_C924 (I0_ha22_1 VSS) capacitor c=3.106E-15
    I_C925 (I0_ha23_0 VSS) capacitor c=3.168E-15
    I_C926 (I0_I77_gn5 VSS) capacitor c=1.484E-15
    I_C927 (I0_ha21_1 VSS) capacitor c=2.516E-15
    I_C928 (I0_ha22_0 VSS) capacitor c=2.630E-15
    I_C929 (I0_I77_gn4 VSS) capacitor c=2.006E-15
    I_C930 (I0_I77_P6_3n VSS) capacitor c=1.015E-15
    I_C931 (I2_I3_hm12 VSS) capacitor c=1.363E-15
    I_C932 (MULP_13 VSS) capacitor c=2.303E-15
    I_C933 (I2_I3_hm13 VSS) capacitor c=1.704E-15
    I_C934 (I2_I3_hd12 VSS) capacitor c=7.838E-16
    I_C935 (DIVR_4 VSS) capacitor c=1.450E-15
    I_C936 (I2_I3_hd13 VSS) capacitor c=8.815E-16
    I_C937 (DIVR_5 VSS) capacitor c=1.238E-15
    I_C938 (DIVR_7 VSS) capacitor c=1.495E-15
    I_C939 (I2_I3_hd15 VSS) capacitor c=1.285E-15
    I_C940 (I0_ha24_1 VSS) capacitor c=2.732E-15
    I_C941 (I0_ha25_0 VSS) capacitor c=2.538E-15
    I_C942 (I0_I77_gn7 VSS) capacitor c=1.406E-15
    I_C943 (I0_I77_P7_4n VSS) capacitor c=1.044E-15
    I_C944 (I0_I77_P5_2n VSS) capacitor c=1.226E-15
    I_C945 (MULP_14 VSS) capacitor c=1.674E-15
    I_C946 (I2_I3_hm14 VSS) capacitor c=1.666E-15
    I_C947 (MULP_15 VSS) capacitor c=1.699E-15
    I_C948 (I2_I3_hm15 VSS) capacitor c=1.238E-15
    I_C949 (I2_I3_hd14 VSS) capacitor c=9.137E-16
    I_C950 (DIVR_6 VSS) capacitor c=1.093E-15
    I_C951 (I0_pp0_2 VSS) capacitor c=3.953E-15
    I_C952 (I0_pp0_0 VSS) capacitor c=2.733E-15
    I_C953 (I0_pp0_1 VSS) capacitor c=3.009E-15
    I_C954 (I0_pp0_3 VSS) capacitor c=3.228E-15
    I_C955 (I0_pp0_4 VSS) capacitor c=4.973E-15
    I_C956 (I0_pp1_1 VSS) capacitor c=3.393E-15
    I_C957 (I0_pp1_0 VSS) capacitor c=4.698E-15
    I_C958 (I0_pp0_5 VSS) capacitor c=4.557E-15
    I_C959 (I0_pp2_0 VSS) capacitor c=3.784E-15
    I_C960 (I0_pp2_1 VSS) capacitor c=3.872E-15
    I_C961 (I0_pp1_2 VSS) capacitor c=3.757E-15
    I_C962 (I0_pp1_3 VSS) capacitor c=3.830E-15
    I_C963 (I0_pp3_7 VSS) capacitor c=4.418E-15
    I_C964 (I1_I60_G7_6 VSS) capacitor c=9.341E-16
    I_C965 (I1_I60_G7_4n VSS) capacitor c=1.089E-15
    I_C966 (I1_I72_G7_6 VSS) capacitor c=1.117E-15
    I_C967 (I1_I72_G7_4n VSS) capacitor c=1.072E-15
    I_C968 (I1_I84_G7_4n VSS) capacitor c=1.630E-15
    I_C969 (I1_I96_G7_6 VSS) capacitor c=1.243E-15
    I_C970 (I1_I96_G7_4n VSS) capacitor c=6.591E-16
    I_C971 (I1_I48_G7_4n VSS) capacitor c=1.207E-15
    I_C972 (I1_I48_G7_6 VSS) capacitor c=1.496E-15
    I_C973 (I1_I60_G5_2n VSS) capacitor c=1.387E-15
    I_C974 (I1_I60_G5_0 VSS) capacitor c=1.835E-15
    I_C975 (I1_I72_G5_2n VSS) capacitor c=1.418E-15
    I_C976 (I1_I72_G5_0 VSS) capacitor c=2.058E-15
    I_C977 (I1_I84_G7_6 VSS) capacitor c=9.613E-16
    I_C978 (I1_I84_G6_5 VSS) capacitor c=1.655E-15
    I_C979 (I1_I96_G5_2n VSS) capacitor c=1.184E-15
    I_C980 (I1_I96_G5_0 VSS) capacitor c=1.577E-15
    I_C981 (I1_I48_G5_4 VSS) capacitor c=2.107E-15
    I_C982 (I1_I48_G6_5 VSS) capacitor c=1.387E-15
    I_C983 (I1_I60_G6_5 VSS) capacitor c=2.166E-15
    I_C984 (I1_I60_G5_4 VSS) capacitor c=2.316E-15
    I_C985 (I1_I72_G6_5 VSS) capacitor c=1.652E-15
    I_C986 (I1_I72_G5_4 VSS) capacitor c=2.439E-15
    I_C987 (I1_I84_G5_4 VSS) capacitor c=2.609E-15
    I_C988 (I1_I84_G6_3n VSS) capacitor c=1.158E-15
    I_C989 (I1_c3_7 VSS) capacitor c=2.936E-15
    I_C990 (I1_I84_G5_2n VSS) capacitor c=1.218E-15
    I_C991 (I1_I84_G5_0 VSS) capacitor c=2.050E-15
    I_C992 (I1_I96_G5_4 VSS) capacitor c=2.895E-15
    I_C993 (I1_I96_G6_5 VSS) capacitor c=1.331E-15
    I_C994 (I1_I96_G6_3n VSS) capacitor c=1.336E-15
    I_C995 (I1_c4_7 VSS) capacitor c=2.169E-15
    I_C996 (I1_I108_G7_6 VSS) capacitor c=1.449E-15
    I_C997 (I1_I48_G5_2n VSS) capacitor c=7.839E-16
    I_C998 (I1_I48_G5_0 VSS) capacitor c=2.436E-15
    I_C999 (I1_I48_G6_3n VSS) capacitor c=1.085E-15
    I_C1000 (I1_c0_7 VSS) capacitor c=2.255E-15
    I_C1001 (I1_I60_G4_3 VSS) capacitor c=1.947E-15
    I_C1002 (I1_I60_G3_2 VSS) capacitor c=2.761E-15
    I_C1003 (I1_I60_G6_3n VSS) capacitor c=1.179E-15
    I_C1004 (I1_c1_7 VSS) capacitor c=2.552E-15
    I_C1005 (I1_I60_G4_1n VSS) capacitor c=1.520E-15
    I_C1006 (I1_I60_G4_0 VSS) capacitor c=1.908E-15
    I_C1007 (I1_I72_G4_3 VSS) capacitor c=2.716E-15
    I_C1008 (I1_I72_G3_2 VSS) capacitor c=2.895E-15
    I_C1009 (I1_I72_G6_3n VSS) capacitor c=1.351E-15
    I_C1010 (I1_c2_7 VSS) capacitor c=2.331E-15
    I_C1011 (I1_I84_G4_3 VSS) capacitor c=2.561E-15
    I_C1012 (I1_I96_G3_2 VSS) capacitor c=4.209E-15
    I_C1013 (I1_I96_G4_3 VSS) capacitor c=1.699E-15
    I_C1014 (I1_I96_G4_1n VSS) capacitor c=1.211E-15
    I_C1015 (I1_I96_G4_0 VSS) capacitor c=2.448E-15
    I_C1016 (I1_I108_G5_4 VSS) capacitor c=1.927E-15
    I_C1017 (I1_I108_G6_5 VSS) capacitor c=2.852E-15
    I_C1018 (I1_I48_G4_3 VSS) capacitor c=2.153E-15
    I_C1019 (I1_I48_G4_1n VSS) capacitor c=1.755E-15
    I_C1020 (I1_I48_G4_0 VSS) capacitor c=2.355E-15
    I_C1021 (I1_I60_G2_1 VSS) capacitor c=2.463E-15
    I_C1022 (I1_I72_G2_1 VSS) capacitor c=2.078E-15
    I_C1023 (I1_I72_G4_1n VSS) capacitor c=1.154E-15
    I_C1024 (I1_I72_G4_0 VSS) capacitor c=2.230E-15
    I_C1025 (I1_I84_G3_2 VSS) capacitor c=3.216E-15
    I_C1026 (I1_I84_G4_1n VSS) capacitor c=1.214E-15
    I_C1027 (I1_I84_G4_0 VSS) capacitor c=2.425E-15
    I_C1028 (I1_I96_G2_1 VSS) capacitor c=1.982E-15
    I_C1029 (I1_I108_G7_4n VSS) capacitor c=8.578E-16
    I_C1030 (I1_I108_G5_2n VSS) capacitor c=9.355E-16
    I_C1031 (I1_I108_G5_0 VSS) capacitor c=1.810E-15
    I_C1032 (I1_I48_G3_2 VSS) capacitor c=3.300E-15
    I_C1033 (I1_I48_G2_1 VSS) capacitor c=1.841E-15
    I_C1034 (I1_I84_G2_1 VSS) capacitor c=1.624E-15
    I_C1035 (I1_I108_G3_2 VSS) capacitor c=3.196E-15
    I_C1036 (I1_I108_G4_3 VSS) capacitor c=1.976E-15
    I_C1037 (I1_I108_G6_3n VSS) capacitor c=9.101E-16
    I_C1038 (I1_c5_7 VSS) capacitor c=2.219E-15
    I_C1039 (I1_I48_pn0 VSS) capacitor c=3.250E-15
    I_C1040 (I1_I60_pn0 VSS) capacitor c=2.078E-15
    I_C1041 (I1_I72_pn0 VSS) capacitor c=2.964E-15
    I_C1042 (I1_I108_G2_1 VSS) capacitor c=2.488E-15
    I_C1043 (I1_I108_G4_1n VSS) capacitor c=9.182E-16
    I_C1044 (I1_I108_G4_0 VSS) capacitor c=1.505E-15
    I_C1045 (I1_I84_pn0 VSS) capacitor c=2.998E-15
    I_C1046 (I1_I96_pn0 VSS) capacitor c=2.923E-15
    I_C1047 (I1_I108_pn0 VSS) capacitor c=2.807E-15
    I_C1048 (I1_I120_G5_4 VSS) capacitor c=2.480E-15
    I_C1049 (I1_I120_G6_5 VSS) capacitor c=1.701E-15
    I_C1050 (I1_I120_G7_6 VSS) capacitor c=1.054E-15
    I_C1051 (I1_I120_G2_1 VSS) capacitor c=2.358E-15
    I_C1052 (I1_I120_G3_2 VSS) capacitor c=2.588E-15
    I_C1053 (I1_I120_G4_3 VSS) capacitor c=2.175E-15
    I_C1054 (I1_I120_G7_4n VSS) capacitor c=8.462E-16
    I_C1055 (I1_I120_pn0 VSS) capacitor c=2.513E-15
    I_C1056 (I1_I120_G4_1n VSS) capacitor c=1.337E-15
    I_C1057 (I1_I120_G4_0 VSS) capacitor c=2.585E-15
    I_C1058 (I1_I120_G6_3n VSS) capacitor c=1.262E-15
    I_C1059 (I1_c6_7 VSS) capacitor c=2.209E-15
    I_C1060 (I1_I120_G5_2n VSS) capacitor c=1.374E-15
    I_C1061 (I1_I120_G5_0 VSS) capacitor c=1.807E-15
    I_C1062 (I2_I1_I8_G2_1 VSS) capacitor c=1.609E-15
    I_C1063 (I2_I1_I8_pn0 VSS) capacitor c=3.131E-15
    I_C1064 (I2_I1_I8_G4_1n VSS) capacitor c=1.189E-15
    I_C1065 (I2_I1_I8_G4_0 VSS) capacitor c=1.598E-15
    I_C1066 (I1_I132_pn0 VSS) capacitor c=2.429E-15
    I_C1067 (I1_I132_G2_1 VSS) capacitor c=1.799E-15
    I_C1068 (I1_I132_G3_2 VSS) capacitor c=3.643E-15
    I_C1069 (I1_I132_G4_3 VSS) capacitor c=1.990E-15
    I_C1070 (I1_I132_G5_4 VSS) capacitor c=2.370E-15
    I_C1071 (I1_I132_G6_5 VSS) capacitor c=1.602E-15
    I_C1072 (I1_I132_G7_6 VSS) capacitor c=1.843E-15
    I_C1073 (I2_I1_I8_G3_2 VSS) capacitor c=3.770E-15
    I_C1074 (I2_I1_I8_G5_2n VSS) capacitor c=9.938E-16
    I_C1075 (I2_I1_I8_G5_0 VSS) capacitor c=1.854E-15
    I_C1076 (I1_I132_G4_1n VSS) capacitor c=8.987E-16
    I_C1077 (I1_I132_G4_0 VSS) capacitor c=2.559E-15
    I_C1078 (I1_I132_G6_3n VSS) capacitor c=1.652E-15
    I_C1079 (I1_c7_7 VSS) capacitor c=3.100E-15
    I_C1080 (I2_I1_I8_G4_3 VSS) capacitor c=3.084E-15
    I_C1081 (I2_I1_I8_G5_4 VSS) capacitor c=2.929E-15
    I_C1082 (I2_I1_I8_G6_3n VSS) capacitor c=8.587E-16
    I_C1083 (I2_I1_I8_G7_4n VSS) capacitor c=9.699E-16
    I_C1084 (I1_I152_pn0 VSS) capacitor c=2.357E-15
    I_C1085 (I1_I132_G5_2n VSS) capacitor c=1.058E-15
    I_C1086 (I1_I132_G5_0 VSS) capacitor c=1.593E-15
    I_C1087 (I1_I132_G7_4n VSS) capacitor c=1.222E-15
    I_C1088 (I2_I1_I8_G6_5 VSS) capacitor c=1.621E-15
    I_C1089 (I2_I1_I8_G7_6 VSS) capacitor c=1.542E-15
    I_C1090 (I1_I152_G2_1 VSS) capacitor c=1.789E-15
    I_C1091 (I1_I152_G3_2 VSS) capacitor c=3.961E-15
    I_C1092 (I1_I152_G4_3 VSS) capacitor c=2.133E-15
    I_C1093 (I0_I77_pn0 VSS) capacitor c=2.202E-15
    I_C1094 (I1_I152_G4_1n VSS) capacitor c=9.380E-16
    I_C1095 (I1_I152_G4_0 VSS) capacitor c=1.805E-15
    I_C1096 (I1_I152_G5_4 VSS) capacitor c=2.396E-15
    I_C1097 (I1_I152_G6_5 VSS) capacitor c=1.422E-15
    I_C1098 (I0_I77_G2_1 VSS) capacitor c=2.559E-15
    I_C1099 (I1_I152_G6_3n VSS) capacitor c=8.749E-16
    I_C1100 (I1_rc6 VSS) capacitor c=1.585E-15
    I_C1101 (I1_I152_G7_4n VSS) capacitor c=1.182E-15
    I_C1102 (I1_rc7 VSS) capacitor c=5.094E-16
    I_C1103 (I1_I152_G7_6 VSS) capacitor c=1.349E-15
    I_C1104 (I0_I77_G3_2 VSS) capacitor c=2.045E-15
    I_C1105 (I0_I77_G4_3 VSS) capacitor c=2.503E-15
    I_C1106 (I0_I77_G4_1n VSS) capacitor c=8.935E-16
    I_C1107 (I0_I77_G4_0 VSS) capacitor c=1.674E-15
    I_C1108 (I1_I152_G5_2n VSS) capacitor c=9.539E-16
    I_C1109 (I1_I152_G5_0 VSS) capacitor c=1.615E-15
    I_C1110 (I0_I77_G6_5 VSS) capacitor c=2.988E-15
    I_C1111 (I0_I77_G5_4 VSS) capacitor c=1.623E-15
    I_C1112 (I0_I77_G5_2n VSS) capacitor c=1.486E-15
    I_C1113 (I0_I77_G5_0 VSS) capacitor c=1.582E-15
    I_C1114 (I0_I77_G6_3n VSS) capacitor c=1.066E-15
    I_C1115 (I0_kc7 VSS) capacitor c=2.049E-15
    I_C1116 (I0_I77_G7_6 VSS) capacitor c=2.015E-15
    I_C1117 (I0_I77_G7_4n VSS) capacitor c=1.466E-15
    I_C1118 (I0_kc8 VSS) capacitor c=4.820E-16
    I_C1119 (I1_nakn7 VSS) capacitor c=1.380E-15
    I_C1120 (I1_nqkn7 VSS) capacitor c=2.199E-15
    I_C1121 (I2_S_0 VSS) capacitor c=1.619E-15
    I_C1122 (I2_S_2 VSS) capacitor c=8.836E-16
    I_C1123 (I2_S_1 VSS) capacitor c=8.485E-16
    I_C1124 (I2_S_5 VSS) capacitor c=1.325E-15
    I_C1125 (I1_nbkn7 VSS) capacitor c=1.567E-15
    I_C1126 (I2_S_6 VSS) capacitor c=1.984E-15
    I_C1127 (I2_S_7 VSS) capacitor c=1.188E-15
    I_C1128 (I1_ru1 VSS) capacitor c=2.144E-15
    I_C1129 (I1_ru2 VSS) capacitor c=2.316E-15
    I_C1130 (I1_ru6 VSS) capacitor c=2.654E-15
    I_C1131 (I1_nrkn7 VSS) capacitor c=1.538E-15
    I_C1132 (I1_ru5 VSS) capacitor c=2.800E-15
    I_C1133 (I0_fa1_0 VSS) capacitor c=2.682E-15
    I_C1134 (I0_rc2 VSS) capacitor c=2.843E-15
    I_C1135 (I0_rc3 VSS) capacitor c=3.687E-15
    I_C1136 (I0_rc1 VSS) capacitor c=2.950E-15
    I_C1137 (I0_ha2_1 VSS) capacitor c=4.287E-15
    I_C1138 (I0_ha2_0 VSS) capacitor c=4.804E-15
    I_C1139 (I0_fa14_0 VSS) capacitor c=2.645E-15
    I_C1140 (I0_rc4 VSS) capacitor c=3.084E-15
    I_C1141 (I0_rc5 VSS) capacitor c=3.148E-15
    I_C1142 (I0_fa3_1 VSS) capacitor c=2.460E-15
    I_C1143 (I0_fa4_0 VSS) capacitor c=2.932E-15
    I_C1144 (I0_ha15_1 VSS) capacitor c=3.706E-15
    I_C1145 (I0_ha15_0 VSS) capacitor c=3.571E-15
    I_C1146 (I0_ha17_0 VSS) capacitor c=4.313E-15
    I_C1147 (I0_fa4_1 VSS) capacitor c=2.304E-15
    I_C1148 (I0_ha16_1 VSS) capacitor c=3.676E-15
    I_C1149 (I0_ha16_0 VSS) capacitor c=3.790E-15
    I_C1150 (I0_ha13_1 VSS) capacitor c=2.246E-15
    I_C1151 (I0_ha13_0 VSS) capacitor c=2.448E-15
    I_C1152 (I0_fa12_1 VSS) capacitor c=2.920E-15
    I_C1153 (I0_fa12_0 VSS) capacitor c=2.987E-15
    I_C1154 (I0_ha25_1 VSS) capacitor c=4.286E-16
    I_C1155 (I1_ru7 VSS) capacitor c=2.172E-15
    I_C1156 (I0_fa1_1 VSS) capacitor c=3.425E-15
    I_C1157 (I0_fa3_0 VSS) capacitor c=3.543E-15
    I_C1158 (I0_fa14_1 VSS) capacitor c=3.448E-15
    I_C1159 (I0_rc6 VSS) capacitor c=3.363E-15
    I_C1160 (I0_rc7 VSS) capacitor c=3.233E-15
    I_C1161 (XI0_I55_p1 VSS) capacitor c=9.132E-18
    I_C1162 (XI0_I55_p2 VSS) capacitor c=5.048E-16
    I_C1163 (XI0_I55_p3 VSS) capacitor c=3.995E-16
    I_C1164 (XI0_I55_p5 VSS) capacitor c=8.937E-16
    I_C1165 (XI0_I55_p4 VSS) capacitor c=3.348E-16
    I_C1166 (XI0_I55_n1 VSS) capacitor c=2.080E-18
    I_C1167 (XI0_I55_n2 VSS) capacitor c=4.273E-16
    I_C1168 (XI0_I55_n3 VSS) capacitor c=5.059E-16
    I_C1169 (XI0_I55_n5 VSS) capacitor c=9.856E-16
    I_C1170 (XI0_I55_n4 VSS) capacitor c=3.947E-16
    I_C1171 (XI0_I55_sn VSS) capacitor c=1.273E-15
    I_C1172 (XI0_I55_con VSS) capacitor c=1.986E-15
    I_C1173 (XI0_I76_p1 VSS) capacitor c=3.956E-18
    I_C1174 (XI0_I76_p2 VSS) capacitor c=4.975E-16
    I_C1175 (XI0_I76_p3 VSS) capacitor c=3.743E-16
    I_C1176 (XI0_I76_p5 VSS) capacitor c=8.925E-16
    I_C1177 (XI0_I76_p4 VSS) capacitor c=3.389E-16
    I_C1178 (XI0_I76_n1 VSS) capacitor c=2.459E-18
    I_C1179 (XI0_I76_n2 VSS) capacitor c=4.315E-16
    I_C1180 (XI0_I76_n3 VSS) capacitor c=4.982E-16
    I_C1181 (XI0_I76_n5 VSS) capacitor c=9.924E-16
    I_C1182 (XI0_I76_n4 VSS) capacitor c=3.975E-16
    I_C1183 (XI0_I76_sn VSS) capacitor c=1.275E-15
    I_C1184 (XI0_I76_con VSS) capacitor c=1.974E-15
    I_C1185 (XI0_I75_p1 VSS) capacitor c=5.028E-18
    I_C1186 (XI0_I75_p2 VSS) capacitor c=5.032E-16
    I_C1187 (XI0_I75_p3 VSS) capacitor c=3.810E-16
    I_C1188 (XI0_I75_p5 VSS) capacitor c=8.849E-16
    I_C1189 (XI0_I75_p4 VSS) capacitor c=3.375E-16
    I_C1190 (XI0_I75_n1 VSS) capacitor c=1.499E-18
    I_C1191 (XI0_I75_n2 VSS) capacitor c=4.502E-16
    I_C1192 (XI0_I75_n3 VSS) capacitor c=5.047E-16
    I_C1193 (XI0_I75_n5 VSS) capacitor c=9.770E-16
    I_C1194 (XI0_I75_n4 VSS) capacitor c=3.944E-16
    I_C1195 (XI0_I75_sn VSS) capacitor c=1.271E-15
    I_C1196 (XI0_I75_con VSS) capacitor c=2.002E-15
    I_C1197 (XI0_I47_p1 VSS) capacitor c=4.372E-18
    I_C1198 (XI0_I47_p2 VSS) capacitor c=5.141E-16
    I_C1199 (XI0_I47_p3 VSS) capacitor c=3.900E-16
    I_C1200 (XI0_I47_p5 VSS) capacitor c=1.065E-15
    I_C1201 (XI0_I47_p4 VSS) capacitor c=3.490E-16
    I_C1202 (XI0_I47_n1 VSS) capacitor c=2.698E-18
    I_C1203 (XI0_I47_n2 VSS) capacitor c=4.524E-16
    I_C1204 (XI0_I47_n3 VSS) capacitor c=5.030E-16
    I_C1205 (XI0_I47_n5 VSS) capacitor c=9.947E-16
    I_C1206 (XI0_I47_n4 VSS) capacitor c=3.912E-16
    I_C1207 (XI0_I47_sn VSS) capacitor c=1.277E-15
    I_C1208 (XI0_I47_con VSS) capacitor c=2.006E-15
    I_C1209 (XI0_I74_p1 VSS) capacitor c=3.586E-18
    I_C1210 (XI0_I74_p2 VSS) capacitor c=4.982E-16
    I_C1211 (XI0_I74_p3 VSS) capacitor c=3.960E-16
    I_C1212 (XI0_I74_p5 VSS) capacitor c=9.580E-16
    I_C1213 (XI0_I74_p4 VSS) capacitor c=3.734E-16
    I_C1214 (XI0_I74_n1 VSS) capacitor c=2.407E-18
    I_C1215 (XI0_I74_n2 VSS) capacitor c=4.684E-16
    I_C1216 (XI0_I74_n3 VSS) capacitor c=4.989E-16
    I_C1217 (XI0_I74_n5 VSS) capacitor c=9.905E-16
    I_C1218 (XI0_I74_n4 VSS) capacitor c=3.933E-16
    I_C1219 (XI0_I74_sn VSS) capacitor c=1.308E-15
    I_C1220 (XI0_I74_con VSS) capacitor c=2.010E-15
    I_C1221 (XI0_I57_p1 VSS) capacitor c=3.969E-18
    I_C1222 (XI0_I57_p2 VSS) capacitor c=5.273E-16
    I_C1223 (XI0_I57_p3 VSS) capacitor c=3.927E-16
    I_C1224 (XI0_I57_p5 VSS) capacitor c=1.060E-15
    I_C1225 (XI0_I57_p4 VSS) capacitor c=3.599E-16
    I_C1226 (XI0_I57_n1 VSS) capacitor c=2.409E-18
    I_C1227 (XI0_I57_n2 VSS) capacitor c=4.465E-16
    I_C1228 (XI0_I57_n3 VSS) capacitor c=5.228E-16
    I_C1229 (XI0_I57_n5 VSS) capacitor c=9.908E-16
    I_C1230 (XI0_I57_n4 VSS) capacitor c=3.929E-16
    I_C1231 (XI0_I57_sn VSS) capacitor c=1.256E-15
    I_C1232 (XI0_I57_con VSS) capacitor c=1.970E-15
    I_C1233 (XI0_I46_p1 VSS) capacitor c=5.475E-18
    I_C1234 (XI0_I46_p2 VSS) capacitor c=5.077E-16
    I_C1235 (XI0_I46_p3 VSS) capacitor c=4.027E-16
    I_C1236 (XI0_I46_p5 VSS) capacitor c=9.308E-16
    I_C1237 (XI0_I46_p4 VSS) capacitor c=3.326E-16
    I_C1238 (XI0_I46_n1 VSS) capacitor c=2.559E-18
    I_C1239 (XI0_I46_n2 VSS) capacitor c=4.451E-16
    I_C1240 (XI0_I46_n3 VSS) capacitor c=4.979E-16
    I_C1241 (XI0_I46_n5 VSS) capacitor c=1.002E-15
    I_C1242 (XI0_I46_n4 VSS) capacitor c=4.243E-16
    I_C1243 (XI0_I46_sn VSS) capacitor c=1.290E-15
    I_C1244 (XI0_I46_con VSS) capacitor c=1.972E-15
    I_C1245 (XI0_I72_p1 VSS) capacitor c=7.338E-18
    I_C1246 (XI0_I72_p2 VSS) capacitor c=4.982E-16
    I_C1247 (XI0_I72_p3 VSS) capacitor c=4.020E-16
    I_C1248 (XI0_I72_p5 VSS) capacitor c=1.045E-15
    I_C1249 (XI0_I72_p4 VSS) capacitor c=3.498E-16
    I_C1250 (XI0_I72_n1 VSS) capacitor c=2.264E-18
    I_C1251 (XI0_I72_n2 VSS) capacitor c=4.531E-16
    I_C1252 (XI0_I72_n3 VSS) capacitor c=5.097E-16
    I_C1253 (XI0_I72_n5 VSS) capacitor c=1.003E-15
    I_C1254 (XI0_I72_n4 VSS) capacitor c=4.052E-16
    I_C1255 (XI0_I72_sn VSS) capacitor c=1.283E-15
    I_C1256 (XI0_I72_con VSS) capacitor c=1.956E-15
    I_C1257 (XI0_I44_p1 VSS) capacitor c=3.500E-18
    I_C1258 (XI0_I44_p2 VSS) capacitor c=4.958E-16
    I_C1259 (XI0_I44_p3 VSS) capacitor c=3.991E-16
    I_C1260 (XI0_I44_p5 VSS) capacitor c=9.744E-16
    I_C1261 (XI0_I44_p4 VSS) capacitor c=3.491E-16
    I_C1262 (XI0_I44_n1 VSS) capacitor c=2.416E-18
    I_C1263 (XI0_I44_n2 VSS) capacitor c=4.504E-16
    I_C1264 (XI0_I44_n3 VSS) capacitor c=5.006E-16
    I_C1265 (XI0_I44_n5 VSS) capacitor c=9.991E-16
    I_C1266 (XI0_I44_n4 VSS) capacitor c=3.886E-16
    I_C1267 (XI0_I44_sn VSS) capacitor c=1.311E-15
    I_C1268 (XI0_I44_con VSS) capacitor c=1.986E-15
    I_C1269 (XI1_I190_p1 VSS) capacitor c=5.318E-16
    I_C1270 (XI1_I190_n1 VSS) capacitor c=3.216E-18
    I_C1271 (XI1_I190_n2 VSS) capacitor c=9.338E-18
    I_C1272 (XI1_I190_Bn VSS) capacitor c=1.046E-15
    I_C1273 (XI1_I190_An VSS) capacitor c=9.338E-16
    I_C1274 (XI0_I77_I44_p1 VSS) capacitor c=4.963E-16
    I_C1275 (XI0_I77_I44_n2 VSS) capacitor c=6.366E-18
    I_C1276 (XI0_I77_I44_Bn VSS) capacitor c=1.051E-15
    I_C1277 (XI0_I77_I44_An VSS) capacitor c=9.212E-16
    I_C1278 (XI0_I77_I43_p1 VSS) capacitor c=5.954E-16
    I_C1279 (XI0_I77_I43_n1 VSS) capacitor c=6.068E-19
    I_C1280 (XI0_I77_I43_n2 VSS) capacitor c=9.278E-18
    I_C1281 (XI0_I77_I43_Bn VSS) capacitor c=1.077E-15
    I_C1282 (XI0_I77_I43_An VSS) capacitor c=9.226E-16
    I_C1283 (XI0_I77_I14_p1 VSS) capacitor c=5.710E-16
    I_C1284 (XI0_I77_I14_n1 VSS) capacitor c=5.840E-19
    I_C1285 (XI0_I77_I14_n2 VSS) capacitor c=7.672E-18
    I_C1286 (XI0_I77_I14_Bn VSS) capacitor c=1.119E-15
    I_C1287 (XI0_I77_I14_An VSS) capacitor c=9.426E-16
    I_C1288 (XI0_I77_I15_p1 VSS) capacitor c=5.418E-16
    I_C1289 (XI0_I77_I15_n1 VSS) capacitor c=5.265E-19
    I_C1290 (XI0_I77_I15_n2 VSS) capacitor c=8.045E-18
    I_C1291 (XI0_I77_I15_Bn VSS) capacitor c=1.112E-15
    I_C1292 (XI0_I77_I15_An VSS) capacitor c=9.412E-16
    I_C1293 (XI1_I152_I43_p1 VSS) capacitor c=5.192E-16
    I_C1294 (XI1_I152_I43_n1 VSS) capacitor c=4.691E-19
    I_C1295 (XI1_I152_I43_n2 VSS) capacitor c=9.191E-18
    I_C1296 (XI1_I152_I43_Bn VSS) capacitor c=1.040E-15
    I_C1297 (XI1_I152_I43_An VSS) capacitor c=8.979E-16
    I_C1298 (XI1_I193_p1 VSS) capacitor c=4.948E-16
    I_C1299 (XI1_I193_n1 VSS) capacitor c=4.653E-19
    I_C1300 (XI1_I193_n2 VSS) capacitor c=7.380E-18
    I_C1301 (XI1_I193_Bn VSS) capacitor c=1.056E-15
    I_C1302 (XI1_I193_An VSS) capacitor c=8.934E-16
    I_C1303 (XI1_I187_p1 VSS) capacitor c=5.585E-16
    I_C1304 (XI1_I187_n1 VSS) capacitor c=9.759E-19
    I_C1305 (XI1_I187_n2 VSS) capacitor c=6.163E-18
    I_C1306 (XI1_I187_Bn VSS) capacitor c=1.095E-15
    I_C1307 (XI1_I187_An VSS) capacitor c=9.401E-16
    I_C1308 (XI0_I77_I13_p1 VSS) capacitor c=5.638E-16
    I_C1309 (XI0_I77_I13_n1 VSS) capacitor c=1.528E-18
    I_C1310 (XI0_I77_I13_n2 VSS) capacitor c=8.745E-18
    I_C1311 (XI0_I77_I13_Bn VSS) capacitor c=1.099E-15
    I_C1312 (XI0_I77_I13_An VSS) capacitor c=9.266E-16
    I_C1313 (XI1_I184_p1 VSS) capacitor c=4.924E-16
    I_C1314 (XI1_I184_n1 VSS) capacitor c=1.029E-18
    I_C1315 (XI1_I184_n2 VSS) capacitor c=9.201E-18
    I_C1316 (XI1_I184_Bn VSS) capacitor c=1.027E-15
    I_C1317 (XI1_I184_An VSS) capacitor c=9.305E-16
    I_C1318 (XI1_I181_p1 VSS) capacitor c=5.338E-16
    I_C1319 (XI1_I181_n1 VSS) capacitor c=2.316E-18
    I_C1320 (XI1_I181_n2 VSS) capacitor c=7.430E-18
    I_C1321 (XI1_I181_Bn VSS) capacitor c=1.050E-15
    I_C1322 (XI1_I181_An VSS) capacitor c=9.536E-16
    I_C1323 (XI0_I77_I42_p1 VSS) capacitor c=5.400E-16
    I_C1324 (XI0_I77_I42_n2 VSS) capacitor c=6.404E-18
    I_C1325 (XI0_I77_I42_Bn VSS) capacitor c=1.116E-15
    I_C1326 (XI0_I77_I42_An VSS) capacitor c=9.455E-16
    I_C1327 (XI0_I77_I12_p1 VSS) capacitor c=5.947E-16
    I_C1328 (XI0_I77_I12_n1 VSS) capacitor c=5.867E-18
    I_C1329 (XI0_I77_I12_n2 VSS) capacitor c=8.220E-18
    I_C1330 (XI0_I77_I12_Bn VSS) capacitor c=1.106E-15
    I_C1331 (XI0_I77_I12_An VSS) capacitor c=9.588E-16
    I_C1332 (XI0_I77_I11_p1 VSS) capacitor c=5.610E-16
    I_C1333 (XI0_I77_I11_n1 VSS) capacitor c=5.786E-19
    I_C1334 (XI0_I77_I11_n2 VSS) capacitor c=8.613E-18
    I_C1335 (XI0_I77_I11_Bn VSS) capacitor c=1.083E-15
    I_C1336 (XI0_I77_I11_An VSS) capacitor c=9.323E-16
    I_C1337 (XI1_I152_I15_p1 VSS) capacitor c=5.460E-16
    I_C1338 (XI1_I152_I15_n1 VSS) capacitor c=1.583E-18
    I_C1339 (XI1_I152_I15_n2 VSS) capacitor c=1.103E-17
    I_C1340 (XI1_I152_I15_Bn VSS) capacitor c=1.048E-15
    I_C1341 (XI1_I152_I15_An VSS) capacitor c=9.333E-16
    I_C1342 (XI1_I152_I44_p1 VSS) capacitor c=5.109E-16
    I_C1343 (XI1_I152_I44_n1 VSS) capacitor c=4.312E-19
    I_C1344 (XI1_I152_I44_n2 VSS) capacitor c=1.221E-17
    I_C1345 (XI1_I152_I44_Bn VSS) capacitor c=1.038E-15
    I_C1346 (XI1_I152_I44_An VSS) capacitor c=9.132E-16
    I_C1347 (XI1_I152_I42_p1 VSS) capacitor c=5.220E-16
    I_C1348 (XI1_I152_I42_n1 VSS) capacitor c=3.820E-19
    I_C1349 (XI1_I152_I42_n2 VSS) capacitor c=8.117E-18
    I_C1350 (XI1_I152_I42_Bn VSS) capacitor c=1.075E-15
    I_C1351 (XI1_I152_I42_An VSS) capacitor c=9.396E-16
    I_C1352 (XI1_I152_I39_p1 VSS) capacitor c=5.511E-16
    I_C1353 (XI1_I152_I39_n1 VSS) capacitor c=6.329E-19
    I_C1354 (XI1_I152_I39_n2 VSS) capacitor c=6.455E-18
    I_C1355 (XI1_I152_I39_Bn VSS) capacitor c=1.039E-15
    I_C1356 (XI1_I152_I39_An VSS) capacitor c=9.329E-16
    I_C1357 (XI1_I178_p1 VSS) capacitor c=5.228E-16
    I_C1358 (XI1_I178_n1 VSS) capacitor c=2.592E-19
    I_C1359 (XI1_I178_n2 VSS) capacitor c=9.408E-18
    I_C1360 (XI1_I178_Bn VSS) capacitor c=1.030E-15
    I_C1361 (XI1_I178_An VSS) capacitor c=9.505E-16
    I_C1362 (XI0_I77_I39_p1 VSS) capacitor c=5.528E-16
    I_C1363 (XI0_I77_I39_n1 VSS) capacitor c=3.700E-18
    I_C1364 (XI0_I77_I39_n2 VSS) capacitor c=9.754E-18
    I_C1365 (XI0_I77_I39_Bn VSS) capacitor c=1.067E-15
    I_C1366 (XI0_I77_I39_An VSS) capacitor c=9.956E-16
    I_C1367 (XI0_I77_I10_p1 VSS) capacitor c=5.311E-16
    I_C1368 (XI0_I77_I10_n1 VSS) capacitor c=1.302E-18
    I_C1369 (XI0_I77_I10_n2 VSS) capacitor c=9.339E-18
    I_C1370 (XI0_I77_I10_Bn VSS) capacitor c=1.031E-15
    I_C1371 (XI0_I77_I10_An VSS) capacitor c=9.232E-16
    I_C1372 (XI1_I152_I14_p1 VSS) capacitor c=5.328E-16
    I_C1373 (XI1_I152_I14_n1 VSS) capacitor c=2.919E-18
    I_C1374 (XI1_I152_I14_n2 VSS) capacitor c=9.782E-18
    I_C1375 (XI1_I152_I14_Bn VSS) capacitor c=1.055E-15
    I_C1376 (XI1_I152_I14_An VSS) capacitor c=8.929E-16
    I_C1377 (XI1_I175_p1 VSS) capacitor c=5.069E-16
    I_C1378 (XI1_I175_n1 VSS) capacitor c=6.350E-19
    I_C1379 (XI1_I175_n2 VSS) capacitor c=8.625E-18
    I_C1380 (XI1_I175_Bn VSS) capacitor c=1.031E-15
    I_C1381 (XI1_I175_An VSS) capacitor c=9.280E-16
    I_C1382 (XI0_I77_I38_p1 VSS) capacitor c=5.639E-16
    I_C1383 (XI0_I77_I38_n1 VSS) capacitor c=5.786E-19
    I_C1384 (XI0_I77_I38_n2 VSS) capacitor c=7.784E-18
    I_C1385 (XI0_I77_I38_Bn VSS) capacitor c=1.097E-15
    I_C1386 (XI0_I77_I38_An VSS) capacitor c=9.448E-16
    I_C1387 (XI0_I77_I9_p1 VSS) capacitor c=5.691E-16
    I_C1388 (XI0_I77_I9_n1 VSS) capacitor c=4.517E-19
    I_C1389 (XI0_I77_I9_n2 VSS) capacitor c=7.625E-18
    I_C1390 (XI0_I77_I9_Bn VSS) capacitor c=1.101E-15
    I_C1391 (XI0_I77_I9_An VSS) capacitor c=9.385E-16
    I_C1392 (XI2_I1_I8_I15_p1 VSS) capacitor c=5.632E-16
    I_C1393 (XI2_I1_I8_I15_n1 VSS) capacitor c=5.786E-19
    I_C1394 (XI2_I1_I8_I15_n2 VSS) capacitor c=1.347E-17
    I_C1395 (XI2_I1_I8_I15_Bn VSS) capacitor c=1.125E-15
    I_C1396 (XI2_I1_I8_I15_An VSS) capacitor c=9.466E-16
    I_C1397 (XI1_I132_I43_p1 VSS) capacitor c=5.142E-16
    I_C1398 (XI1_I132_I43_n1 VSS) capacitor c=5.805E-19
    I_C1399 (XI1_I132_I43_n2 VSS) capacitor c=9.175E-18
    I_C1400 (XI1_I132_I43_Bn VSS) capacitor c=1.065E-15
    I_C1401 (XI1_I132_I43_An VSS) capacitor c=9.399E-16
    I_C1402 (XI1_I152_I13_p1 VSS) capacitor c=5.415E-16
    I_C1403 (XI1_I152_I13_n2 VSS) capacitor c=8.792E-18
    I_C1404 (XI1_I152_I13_Bn VSS) capacitor c=1.040E-15
    I_C1405 (XI1_I152_I13_An VSS) capacitor c=9.315E-16
    I_C1406 (XI1_I152_I12_p1 VSS) capacitor c=5.208E-16
    I_C1407 (XI1_I152_I12_n2 VSS) capacitor c=7.615E-18
    I_C1408 (XI1_I152_I12_Bn VSS) capacitor c=1.018E-15
    I_C1409 (XI1_I152_I12_An VSS) capacitor c=9.140E-16
    I_C1410 (XI1_I152_I11_p1 VSS) capacitor c=5.248E-16
    I_C1411 (XI1_I152_I11_n1 VSS) capacitor c=7.859E-19
    I_C1412 (XI1_I152_I11_n2 VSS) capacitor c=1.072E-17
    I_C1413 (XI1_I152_I11_Bn VSS) capacitor c=1.059E-15
    I_C1414 (XI1_I152_I11_An VSS) capacitor c=8.844E-16
    I_C1415 (XI1_I152_I10_p1 VSS) capacitor c=5.156E-16
    I_C1416 (XI1_I152_I10_n1 VSS) capacitor c=8.606E-19
    I_C1417 (XI1_I152_I10_n2 VSS) capacitor c=8.608E-18
    I_C1418 (XI1_I152_I10_Bn VSS) capacitor c=1.024E-15
    I_C1419 (XI1_I152_I10_An VSS) capacitor c=9.325E-16
    I_C1420 (XI1_I152_I38_p1 VSS) capacitor c=5.294E-16
    I_C1421 (XI1_I152_I38_n2 VSS) capacitor c=1.115E-17
    I_C1422 (XI1_I152_I38_Bn VSS) capacitor c=1.045E-15
    I_C1423 (XI1_I152_I38_An VSS) capacitor c=9.624E-16
    I_C1424 (XI1_I152_I37_p1 VSS) capacitor c=5.588E-16
    I_C1425 (XI1_I152_I37_n1 VSS) capacitor c=5.786E-19
    I_C1426 (XI1_I152_I37_n2 VSS) capacitor c=8.766E-18
    I_C1427 (XI1_I152_I37_Bn VSS) capacitor c=1.042E-15
    I_C1428 (XI1_I152_I37_An VSS) capacitor c=9.091E-16
    I_C1429 (XI0_I77_I37_p1 VSS) capacitor c=5.407E-16
    I_C1430 (XI0_I77_I37_n2 VSS) capacitor c=6.343E-18
    I_C1431 (XI0_I77_I37_Bn VSS) capacitor c=1.133E-15
    I_C1432 (XI0_I77_I37_An VSS) capacitor c=9.164E-16
    I_C1433 (XI0_I77_I8_p1 VSS) capacitor c=5.404E-16
    I_C1434 (XI0_I77_I8_n1 VSS) capacitor c=4.503E-19
    I_C1435 (XI0_I77_I8_n2 VSS) capacitor c=9.121E-18
    I_C1436 (XI0_I77_I8_Bn VSS) capacitor c=1.076E-15
    I_C1437 (XI0_I77_I8_An VSS) capacitor c=9.548E-16
    I_C1438 (XI2_I1_I8_I14_p1 VSS) capacitor c=5.635E-16
    I_C1439 (XI2_I1_I8_I14_n1 VSS) capacitor c=4.325E-19
    I_C1440 (XI2_I1_I8_I14_n2 VSS) capacitor c=8.833E-18
    I_C1441 (XI2_I1_I8_I14_Bn VSS) capacitor c=1.061E-15
    I_C1442 (XI2_I1_I8_I14_An VSS) capacitor c=9.255E-16
    I_C1443 (XI2_I1_I8_I13_p1 VSS) capacitor c=4.993E-16
    I_C1444 (XI2_I1_I8_I13_n1 VSS) capacitor c=5.717E-19
    I_C1445 (XI2_I1_I8_I13_n2 VSS) capacitor c=7.137E-18
    I_C1446 (XI2_I1_I8_I13_Bn VSS) capacitor c=1.019E-15
    I_C1447 (XI2_I1_I8_I13_An VSS) capacitor c=9.335E-16
    I_C1448 (XI1_I132_I44_p1 VSS) capacitor c=5.431E-16
    I_C1449 (XI1_I132_I44_n1 VSS) capacitor c=9.373E-18
    I_C1450 (XI1_I132_I44_n2 VSS) capacitor c=9.835E-18
    I_C1451 (XI1_I132_I44_Bn VSS) capacitor c=1.102E-15
    I_C1452 (XI1_I132_I44_An VSS) capacitor c=9.121E-16
    I_C1453 (XI1_I132_I42_p1 VSS) capacitor c=5.646E-16
    I_C1454 (XI1_I132_I42_n2 VSS) capacitor c=7.013E-18
    I_C1455 (XI1_I132_I42_Bn VSS) capacitor c=1.052E-15
    I_C1456 (XI1_I132_I42_An VSS) capacitor c=9.390E-16
    I_C1457 (XI1_I132_I39_p1 VSS) capacitor c=5.403E-16
    I_C1458 (XI1_I132_I39_n1 VSS) capacitor c=2.126E-18
    I_C1459 (XI1_I132_I39_n2 VSS) capacitor c=1.044E-17
    I_C1460 (XI1_I132_I39_Bn VSS) capacitor c=1.090E-15
    I_C1461 (XI1_I132_I39_An VSS) capacitor c=8.931E-16
    I_C1462 (XI1_I152_I9_p1 VSS) capacitor c=5.319E-16
    I_C1463 (XI1_I152_I9_n2 VSS) capacitor c=3.737E-18
    I_C1464 (XI1_I152_I9_Bn VSS) capacitor c=1.036E-15
    I_C1465 (XI1_I152_I9_An VSS) capacitor c=9.064E-16
    I_C1466 (XI1_I152_I8_p1 VSS) capacitor c=5.724E-16
    I_C1467 (XI1_I152_I8_n1 VSS) capacitor c=5.786E-19
    I_C1468 (XI1_I152_I8_n2 VSS) capacitor c=9.375E-18
    I_C1469 (XI1_I152_I8_Bn VSS) capacitor c=1.104E-15
    I_C1470 (XI1_I152_I8_An VSS) capacitor c=9.166E-16
    I_C1471 (XI2_I1_I8_I44_p1 VSS) capacitor c=5.680E-16
    I_C1472 (XI2_I1_I8_I44_n1 VSS) capacitor c=5.873E-18
    I_C1473 (XI2_I1_I8_I44_n2 VSS) capacitor c=8.881E-18
    I_C1474 (XI2_I1_I8_I44_Bn VSS) capacitor c=1.088E-15
    I_C1475 (XI2_I1_I8_I44_An VSS) capacitor c=9.413E-16
    I_C1476 (XI2_I1_I8_I43_p1 VSS) capacitor c=5.143E-16
    I_C1477 (XI2_I1_I8_I43_n1 VSS) capacitor c=1.040E-18
    I_C1478 (XI2_I1_I8_I43_n2 VSS) capacitor c=6.000E-18
    I_C1479 (XI2_I1_I8_I43_Bn VSS) capacitor c=1.070E-15
    I_C1480 (XI2_I1_I8_I43_An VSS) capacitor c=9.159E-16
    I_C1481 (XI1_I132_I9_p1 VSS) capacitor c=5.392E-16
    I_C1482 (XI1_I132_I9_n1 VSS) capacitor c=3.820E-19
    I_C1483 (XI1_I132_I9_n2 VSS) capacitor c=6.282E-18
    I_C1484 (XI1_I132_I9_Bn VSS) capacitor c=1.036E-15
    I_C1485 (XI1_I132_I9_An VSS) capacitor c=9.238E-16
    I_C1486 (XI1_I132_I37_p1 VSS) capacitor c=5.331E-16
    I_C1487 (XI1_I132_I37_n1 VSS) capacitor c=6.742E-18
    I_C1488 (XI1_I132_I37_n2 VSS) capacitor c=9.512E-18
    I_C1489 (XI1_I132_I37_Bn VSS) capacitor c=1.063E-15
    I_C1490 (XI1_I132_I37_An VSS) capacitor c=9.254E-16
    I_C1491 (XI1_I132_I38_p1 VSS) capacitor c=5.151E-16
    I_C1492 (XI1_I132_I38_n2 VSS) capacitor c=8.532E-18
    I_C1493 (XI1_I132_I38_Bn VSS) capacitor c=1.050E-15
    I_C1494 (XI1_I132_I38_An VSS) capacitor c=9.568E-16
    I_C1495 (XI1_I132_I8_p1 VSS) capacitor c=5.903E-16
    I_C1496 (XI1_I132_I8_n1 VSS) capacitor c=3.820E-19
    I_C1497 (XI1_I132_I8_n2 VSS) capacitor c=8.470E-18
    I_C1498 (XI1_I132_I8_Bn VSS) capacitor c=1.099E-15
    I_C1499 (XI1_I132_I8_An VSS) capacitor c=9.209E-16
    I_C1500 (XI1_I39_p1 VSS) capacitor c=5.615E-16
    I_C1501 (XI1_I39_n1 VSS) capacitor c=5.786E-19
    I_C1502 (XI1_I39_n2 VSS) capacitor c=8.330E-18
    I_C1503 (XI1_I39_Bn VSS) capacitor c=1.067E-15
    I_C1504 (XI1_I39_An VSS) capacitor c=9.413E-16
    I_C1505 (XI2_I1_I8_I11_p1 VSS) capacitor c=5.596E-16
    I_C1506 (XI2_I1_I8_I11_n1 VSS) capacitor c=5.937E-19
    I_C1507 (XI2_I1_I8_I11_n2 VSS) capacitor c=1.168E-17
    I_C1508 (XI2_I1_I8_I11_Bn VSS) capacitor c=1.074E-15
    I_C1509 (XI2_I1_I8_I11_An VSS) capacitor c=9.249E-16
    I_C1510 (XI2_I1_I8_I12_p1 VSS) capacitor c=5.549E-16
    I_C1511 (XI2_I1_I8_I12_n1 VSS) capacitor c=4.052E-21
    I_C1512 (XI2_I1_I8_I12_n2 VSS) capacitor c=6.869E-18
    I_C1513 (XI2_I1_I8_I12_Bn VSS) capacitor c=1.074E-15
    I_C1514 (XI2_I1_I8_I12_An VSS) capacitor c=9.049E-16
    I_C1515 (XI1_I132_I15_p1 VSS) capacitor c=5.252E-16
    I_C1516 (XI1_I132_I15_n1 VSS) capacitor c=3.820E-19
    I_C1517 (XI1_I132_I15_n2 VSS) capacitor c=8.546E-18
    I_C1518 (XI1_I132_I15_Bn VSS) capacitor c=1.036E-15
    I_C1519 (XI1_I132_I15_An VSS) capacitor c=9.231E-16
    I_C1520 (XI1_I132_I14_p1 VSS) capacitor c=5.175E-16
    I_C1521 (XI1_I132_I14_n1 VSS) capacitor c=3.820E-19
    I_C1522 (XI1_I132_I14_n2 VSS) capacitor c=8.457E-18
    I_C1523 (XI1_I132_I14_Bn VSS) capacitor c=1.044E-15
    I_C1524 (XI1_I132_I14_An VSS) capacitor c=9.606E-16
    I_C1525 (XI1_I132_I12_p1 VSS) capacitor c=5.479E-16
    I_C1526 (XI1_I132_I12_n1 VSS) capacitor c=3.505E-18
    I_C1527 (XI1_I132_I12_n2 VSS) capacitor c=1.017E-17
    I_C1528 (XI1_I132_I12_Bn VSS) capacitor c=1.052E-15
    I_C1529 (XI1_I132_I12_An VSS) capacitor c=9.334E-16
    I_C1530 (XI1_I132_I11_p1 VSS) capacitor c=5.525E-16
    I_C1531 (XI1_I132_I11_n1 VSS) capacitor c=1.975E-18
    I_C1532 (XI1_I132_I11_n2 VSS) capacitor c=1.199E-17
    I_C1533 (XI1_I132_I11_Bn VSS) capacitor c=1.083E-15
    I_C1534 (XI1_I132_I11_An VSS) capacitor c=9.403E-16
    I_C1535 (XI1_I132_I10_p1 VSS) capacitor c=5.597E-16
    I_C1536 (XI1_I132_I10_n1 VSS) capacitor c=2.314E-18
    I_C1537 (XI1_I132_I10_n2 VSS) capacitor c=8.810E-18
    I_C1538 (XI1_I132_I10_Bn VSS) capacitor c=1.080E-15
    I_C1539 (XI1_I132_I10_An VSS) capacitor c=9.030E-16
    I_C1540 (XI1_I36_p1 VSS) capacitor c=5.426E-16
    I_C1541 (XI1_I36_n1 VSS) capacitor c=7.041E-19
    I_C1542 (XI1_I36_n2 VSS) capacitor c=6.124E-18
    I_C1543 (XI1_I36_Bn VSS) capacitor c=1.135E-15
    I_C1544 (XI1_I36_An VSS) capacitor c=9.301E-16
    I_C1545 (XI2_I1_I8_I42_p1 VSS) capacitor c=5.614E-16
    I_C1546 (XI2_I1_I8_I42_n2 VSS) capacitor c=9.815E-18
    I_C1547 (XI2_I1_I8_I42_Bn VSS) capacitor c=1.095E-15
    I_C1548 (XI2_I1_I8_I42_An VSS) capacitor c=9.427E-16
    I_C1549 (XI1_I120_I44_p1 VSS) capacitor c=5.498E-16
    I_C1550 (XI1_I120_I44_n2 VSS) capacitor c=1.366E-17
    I_C1551 (XI1_I120_I44_Bn VSS) capacitor c=1.077E-15
    I_C1552 (XI1_I120_I44_An VSS) capacitor c=9.205E-16
    I_C1553 (XI1_I120_I42_p1 VSS) capacitor c=5.551E-16
    I_C1554 (XI1_I120_I42_n1 VSS) capacitor c=1.791E-18
    I_C1555 (XI1_I120_I42_n2 VSS) capacitor c=1.080E-17
    I_C1556 (XI1_I120_I42_Bn VSS) capacitor c=1.093E-15
    I_C1557 (XI1_I120_I42_An VSS) capacitor c=9.317E-16
    I_C1558 (XI1_I132_I13_p1 VSS) capacitor c=5.353E-16
    I_C1559 (XI1_I132_I13_n2 VSS) capacitor c=5.903E-18
    I_C1560 (XI1_I132_I13_Bn VSS) capacitor c=1.032E-15
    I_C1561 (XI1_I132_I13_An VSS) capacitor c=9.114E-16
    I_C1562 (XI1_I120_I39_p1 VSS) capacitor c=5.458E-16
    I_C1563 (XI1_I120_I39_n1 VSS) capacitor c=5.786E-19
    I_C1564 (XI1_I120_I39_n2 VSS) capacitor c=1.258E-17
    I_C1565 (XI1_I120_I39_Bn VSS) capacitor c=1.089E-15
    I_C1566 (XI1_I120_I39_An VSS) capacitor c=9.186E-16
    I_C1567 (XI1_I120_I37_p1 VSS) capacitor c=5.334E-16
    I_C1568 (XI1_I120_I37_n1 VSS) capacitor c=6.026E-18
    I_C1569 (XI1_I120_I37_n2 VSS) capacitor c=9.670E-18
    I_C1570 (XI1_I120_I37_Bn VSS) capacitor c=1.055E-15
    I_C1571 (XI1_I120_I37_An VSS) capacitor c=8.763E-16
    I_C1572 (XI1_I33_p1 VSS) capacitor c=5.990E-16
    I_C1573 (XI1_I33_n1 VSS) capacitor c=8.459E-19
    I_C1574 (XI1_I33_n2 VSS) capacitor c=7.071E-18
    I_C1575 (XI1_I33_Bn VSS) capacitor c=1.065E-15
    I_C1576 (XI1_I33_An VSS) capacitor c=9.487E-16
    I_C1577 (XI2_I1_I8_I9_p1 VSS) capacitor c=5.894E-16
    I_C1578 (XI2_I1_I8_I9_n1 VSS) capacitor c=3.971E-18
    I_C1579 (XI2_I1_I8_I9_n2 VSS) capacitor c=7.558E-18
    I_C1580 (XI2_I1_I8_I9_Bn VSS) capacitor c=1.090E-15
    I_C1581 (XI2_I1_I8_I9_An VSS) capacitor c=9.948E-16
    I_C1582 (XI2_I1_I8_I10_p1 VSS) capacitor c=5.508E-16
    I_C1583 (XI2_I1_I8_I10_n1 VSS) capacitor c=6.122E-18
    I_C1584 (XI2_I1_I8_I10_n2 VSS) capacitor c=8.254E-18
    I_C1585 (XI2_I1_I8_I10_Bn VSS) capacitor c=1.065E-15
    I_C1586 (XI2_I1_I8_I10_An VSS) capacitor c=9.285E-16
    I_C1587 (XI1_I120_I43_p1 VSS) capacitor c=5.273E-16
    I_C1588 (XI1_I120_I43_n1 VSS) capacitor c=3.820E-19
    I_C1589 (XI1_I120_I43_n2 VSS) capacitor c=1.117E-17
    I_C1590 (XI1_I120_I43_Bn VSS) capacitor c=1.038E-15
    I_C1591 (XI1_I120_I43_An VSS) capacitor c=9.135E-16
    I_C1592 (XI1_I120_I38_p1 VSS) capacitor c=5.468E-16
    I_C1593 (XI1_I120_I38_n1 VSS) capacitor c=4.694E-18
    I_C1594 (XI1_I120_I38_n2 VSS) capacitor c=8.672E-18
    I_C1595 (XI1_I120_I38_Bn VSS) capacitor c=1.051E-15
    I_C1596 (XI1_I120_I38_An VSS) capacitor c=9.344E-16
    I_C1597 (XI1_I120_I9_p1 VSS) capacitor c=5.398E-16
    I_C1598 (XI1_I120_I9_n1 VSS) capacitor c=1.739E-19
    I_C1599 (XI1_I120_I9_n2 VSS) capacitor c=1.229E-17
    I_C1600 (XI1_I120_I9_Bn VSS) capacitor c=1.046E-15
    I_C1601 (XI1_I120_I9_An VSS) capacitor c=8.996E-16
    I_C1602 (XI1_I155_p1 VSS) capacitor c=5.204E-16
    I_C1603 (XI1_I155_n2 VSS) capacitor c=8.040E-18
    I_C1604 (XI1_I155_Bn VSS) capacitor c=1.044E-15
    I_C1605 (XI1_I155_An VSS) capacitor c=8.882E-16
    I_C1606 (XI1_I158_p1 VSS) capacitor c=5.426E-16
    I_C1607 (XI1_I158_n1 VSS) capacitor c=4.456E-19
    I_C1608 (XI1_I158_n2 VSS) capacitor c=9.273E-18
    I_C1609 (XI1_I158_Bn VSS) capacitor c=1.033E-15
    I_C1610 (XI1_I158_An VSS) capacitor c=9.092E-16
    I_C1611 (XI2_I1_I8_I38_p1 VSS) capacitor c=5.541E-16
    I_C1612 (XI2_I1_I8_I38_n1 VSS) capacitor c=1.601E-18
    I_C1613 (XI2_I1_I8_I38_n2 VSS) capacitor c=5.929E-18
    I_C1614 (XI2_I1_I8_I38_Bn VSS) capacitor c=1.100E-15
    I_C1615 (XI2_I1_I8_I38_An VSS) capacitor c=9.309E-16
    I_C1616 (XI2_I1_I8_I8_p1 VSS) capacitor c=5.788E-16
    I_C1617 (XI2_I1_I8_I8_n2 VSS) capacitor c=6.360E-18
    I_C1618 (XI2_I1_I8_I8_Bn VSS) capacitor c=1.057E-15
    I_C1619 (XI2_I1_I8_I8_An VSS) capacitor c=9.436E-16
    I_C1620 (XI2_I1_I8_I37_p1 VSS) capacitor c=5.724E-16
    I_C1621 (XI2_I1_I8_I37_n1 VSS) capacitor c=1.774E-19
    I_C1622 (XI2_I1_I8_I37_n2 VSS) capacitor c=6.683E-18
    I_C1623 (XI2_I1_I8_I37_Bn VSS) capacitor c=1.035E-15
    I_C1624 (XI2_I1_I8_I37_An VSS) capacitor c=9.367E-16
    I_C1625 (XI2_I1_I8_I39_p1 VSS) capacitor c=5.742E-16
    I_C1626 (XI2_I1_I8_I39_n2 VSS) capacitor c=1.022E-17
    I_C1627 (XI2_I1_I8_I39_Bn VSS) capacitor c=1.061E-15
    I_C1628 (XI2_I1_I8_I39_An VSS) capacitor c=9.297E-16
    I_C1629 (XI1_I120_I10_p1 VSS) capacitor c=5.475E-16
    I_C1630 (XI1_I120_I10_n1 VSS) capacitor c=1.098E-18
    I_C1631 (XI1_I120_I10_n2 VSS) capacitor c=8.161E-18
    I_C1632 (XI1_I120_I10_Bn VSS) capacitor c=1.067E-15
    I_C1633 (XI1_I120_I10_An VSS) capacitor c=9.340E-16
    I_C1634 (XI1_I120_I8_p1 VSS) capacitor c=5.291E-16
    I_C1635 (XI1_I120_I8_n1 VSS) capacitor c=6.140E-18
    I_C1636 (XI1_I120_I8_n2 VSS) capacitor c=5.901E-18
    I_C1637 (XI1_I120_I8_Bn VSS) capacitor c=1.052E-15
    I_C1638 (XI1_I120_I8_An VSS) capacitor c=9.098E-16
    I_C1639 (XI1_I1_p1 VSS) capacitor c=5.143E-16
    I_C1640 (XI1_I1_n2 VSS) capacitor c=6.181E-18
    I_C1641 (XI1_I1_Bn VSS) capacitor c=1.070E-15
    I_C1642 (XI1_I1_An VSS) capacitor c=8.964E-16
    I_C1643 (XI1_I27_p1 VSS) capacitor c=5.882E-16
    I_C1644 (XI1_I27_n1 VSS) capacitor c=4.807E-19
    I_C1645 (XI1_I27_n2 VSS) capacitor c=8.256E-18
    I_C1646 (XI1_I27_Bn VSS) capacitor c=1.104E-15
    I_C1647 (XI1_I27_An VSS) capacitor c=9.010E-16
    I_C1648 (XI1_I30_p1 VSS) capacitor c=5.702E-16
    I_C1649 (XI1_I30_n2 VSS) capacitor c=8.572E-18
    I_C1650 (XI1_I30_Bn VSS) capacitor c=1.033E-15
    I_C1651 (XI1_I30_An VSS) capacitor c=9.208E-16
    I_C1652 (XI1_I120_I15_p1 VSS) capacitor c=5.432E-16
    I_C1653 (XI1_I120_I15_n2 VSS) capacitor c=8.512E-18
    I_C1654 (XI1_I120_I15_Bn VSS) capacitor c=1.028E-15
    I_C1655 (XI1_I120_I15_An VSS) capacitor c=9.258E-16
    I_C1656 (XI1_I120_I13_p1 VSS) capacitor c=5.586E-16
    I_C1657 (XI1_I120_I13_n1 VSS) capacitor c=5.786E-19
    I_C1658 (XI1_I120_I13_n2 VSS) capacitor c=9.163E-18
    I_C1659 (XI1_I120_I13_Bn VSS) capacitor c=1.041E-15
    I_C1660 (XI1_I120_I13_An VSS) capacitor c=8.779E-16
    I_C1661 (XI1_I120_I12_p1 VSS) capacitor c=5.171E-16
    I_C1662 (XI1_I120_I12_n2 VSS) capacitor c=8.028E-18
    I_C1663 (XI1_I120_I12_Bn VSS) capacitor c=1.027E-15
    I_C1664 (XI1_I120_I12_An VSS) capacitor c=9.088E-16
    I_C1665 (XI1_I120_I11_p1 VSS) capacitor c=5.782E-16
    I_C1666 (XI1_I120_I11_n1 VSS) capacitor c=2.865E-19
    I_C1667 (XI1_I120_I11_n2 VSS) capacitor c=8.952E-18
    I_C1668 (XI1_I120_I11_Bn VSS) capacitor c=1.051E-15
    I_C1669 (XI1_I120_I11_An VSS) capacitor c=8.961E-16
    I_C1670 (XI1_I108_I38_p1 VSS) capacitor c=5.402E-16
    I_C1671 (XI1_I108_I38_n1 VSS) capacitor c=4.990E-18
    I_C1672 (XI1_I108_I38_n2 VSS) capacitor c=9.000E-18
    I_C1673 (XI1_I108_I38_Bn VSS) capacitor c=1.053E-15
    I_C1674 (XI1_I108_I38_An VSS) capacitor c=9.172E-16
    I_C1675 (XI1_I108_I37_p1 VSS) capacitor c=5.300E-16
    I_C1676 (XI1_I108_I37_n1 VSS) capacitor c=3.437E-18
    I_C1677 (XI1_I108_I37_n2 VSS) capacitor c=4.988E-18
    I_C1678 (XI1_I108_I37_Bn VSS) capacitor c=1.050E-15
    I_C1679 (XI1_I108_I37_An VSS) capacitor c=9.481E-16
    I_C1680 (XI1_I108_I8_p1 VSS) capacitor c=5.695E-16
    I_C1681 (XI1_I108_I8_n1 VSS) capacitor c=5.786E-19
    I_C1682 (XI1_I108_I8_n2 VSS) capacitor c=8.301E-18
    I_C1683 (XI1_I108_I8_Bn VSS) capacitor c=1.075E-15
    I_C1684 (XI1_I108_I8_An VSS) capacitor c=9.119E-16
    I_C1685 (XI1_I164_p1 VSS) capacitor c=5.925E-16
    I_C1686 (XI1_I164_n2 VSS) capacitor c=7.893E-18
    I_C1687 (XI1_I164_Bn VSS) capacitor c=1.095E-15
    I_C1688 (XI1_I164_An VSS) capacitor c=9.373E-16
    I_C1689 (XI1_I161_p1 VSS) capacitor c=5.563E-16
    I_C1690 (XI1_I161_n2 VSS) capacitor c=5.194E-18
    I_C1691 (XI1_I161_Bn VSS) capacitor c=1.036E-15
    I_C1692 (XI1_I161_An VSS) capacitor c=9.661E-16
    I_C1693 (XI1_I4_p1 VSS) capacitor c=5.632E-16
    I_C1694 (XI1_I4_n1 VSS) capacitor c=1.471E-18
    I_C1695 (XI1_I4_n2 VSS) capacitor c=9.407E-18
    I_C1696 (XI1_I4_Bn VSS) capacitor c=1.070E-15
    I_C1697 (XI1_I4_An VSS) capacitor c=9.783E-16
    I_C1698 (XI1_I7_p1 VSS) capacitor c=5.314E-16
    I_C1699 (XI1_I7_n1 VSS) capacitor c=6.132E-19
    I_C1700 (XI1_I7_n2 VSS) capacitor c=6.310E-18
    I_C1701 (XI1_I7_Bn VSS) capacitor c=1.049E-15
    I_C1702 (XI1_I7_An VSS) capacitor c=9.702E-16
    I_C1703 (XI1_I10_p1 VSS) capacitor c=5.628E-16
    I_C1704 (XI1_I10_n1 VSS) capacitor c=1.303E-18
    I_C1705 (XI1_I10_n2 VSS) capacitor c=6.253E-18
    I_C1706 (XI1_I10_Bn VSS) capacitor c=1.055E-15
    I_C1707 (XI1_I10_An VSS) capacitor c=9.553E-16
    I_C1708 (XI1_I173_p1 VSS) capacitor c=5.476E-16
    I_C1709 (XI1_I173_n2 VSS) capacitor c=1.033E-17
    I_C1710 (XI1_I173_Bn VSS) capacitor c=1.013E-15
    I_C1711 (XI1_I173_An VSS) capacitor c=9.290E-16
    I_C1712 (XI1_I21_p1 VSS) capacitor c=5.426E-16
    I_C1713 (XI1_I21_n1 VSS) capacitor c=3.820E-19
    I_C1714 (XI1_I21_n2 VSS) capacitor c=9.864E-18
    I_C1715 (XI1_I21_Bn VSS) capacitor c=1.079E-15
    I_C1716 (XI1_I21_An VSS) capacitor c=9.303E-16
    I_C1717 (XI1_I24_p1 VSS) capacitor c=5.671E-16
    I_C1718 (XI1_I24_n1 VSS) capacitor c=3.919E-19
    I_C1719 (XI1_I24_n2 VSS) capacitor c=8.686E-18
    I_C1720 (XI1_I24_Bn VSS) capacitor c=1.082E-15
    I_C1721 (XI1_I24_An VSS) capacitor c=9.562E-16
    I_C1722 (XI1_I120_I14_p1 VSS) capacitor c=5.427E-16
    I_C1723 (XI1_I120_I14_n1 VSS) capacitor c=1.730E-18
    I_C1724 (XI1_I120_I14_n2 VSS) capacitor c=6.364E-18
    I_C1725 (XI1_I120_I14_Bn VSS) capacitor c=1.039E-15
    I_C1726 (XI1_I120_I14_An VSS) capacitor c=8.987E-16
    I_C1727 (XI1_I108_I39_p1 VSS) capacitor c=5.395E-16
    I_C1728 (XI1_I108_I39_n1 VSS) capacitor c=1.168E-18
    I_C1729 (XI1_I108_I39_n2 VSS) capacitor c=7.045E-18
    I_C1730 (XI1_I108_I39_Bn VSS) capacitor c=1.060E-15
    I_C1731 (XI1_I108_I39_An VSS) capacitor c=9.108E-16
    I_C1732 (XI1_I108_I9_p1 VSS) capacitor c=5.684E-16
    I_C1733 (XI1_I108_I9_n1 VSS) capacitor c=6.142E-18
    I_C1734 (XI1_I108_I9_n2 VSS) capacitor c=8.691E-18
    I_C1735 (XI1_I108_I9_Bn VSS) capacitor c=1.091E-15
    I_C1736 (XI1_I108_I9_An VSS) capacitor c=9.533E-16
    I_C1737 (XI1_I96_I37_p1 VSS) capacitor c=5.336E-16
    I_C1738 (XI1_I96_I37_n2 VSS) capacitor c=1.013E-17
    I_C1739 (XI1_I96_I37_Bn VSS) capacitor c=1.069E-15
    I_C1740 (XI1_I96_I37_An VSS) capacitor c=9.066E-16
    I_C1741 (XI1_I96_I8_p1 VSS) capacitor c=5.614E-16
    I_C1742 (XI1_I96_I8_n2 VSS) capacitor c=7.259E-18
    I_C1743 (XI1_I96_I8_Bn VSS) capacitor c=1.053E-15
    I_C1744 (XI1_I96_I8_An VSS) capacitor c=9.045E-16
    I_C1745 (XI1_I167_p1 VSS) capacitor c=5.390E-16
    I_C1746 (XI1_I167_n1 VSS) capacitor c=2.786E-18
    I_C1747 (XI1_I167_n2 VSS) capacitor c=6.300E-18
    I_C1748 (XI1_I167_Bn VSS) capacitor c=1.096E-15
    I_C1749 (XI1_I167_An VSS) capacitor c=9.693E-16
    I_C1750 (XI1_I84_I8_p1 VSS) capacitor c=5.712E-16
    I_C1751 (XI1_I84_I8_n1 VSS) capacitor c=4.657E-19
    I_C1752 (XI1_I84_I8_n2 VSS) capacitor c=9.380E-18
    I_C1753 (XI1_I84_I8_Bn VSS) capacitor c=1.110E-15
    I_C1754 (XI1_I84_I8_An VSS) capacitor c=9.306E-16
    I_C1755 (XI1_I170_p1 VSS) capacitor c=5.836E-16
    I_C1756 (XI1_I170_n2 VSS) capacitor c=8.524E-18
    I_C1757 (XI1_I170_Bn VSS) capacitor c=1.074E-15
    I_C1758 (XI1_I170_An VSS) capacitor c=9.352E-16
    I_C1759 (XI1_I13_p1 VSS) capacitor c=5.945E-16
    I_C1760 (XI1_I13_n2 VSS) capacitor c=1.206E-17
    I_C1761 (XI1_I13_Bn VSS) capacitor c=1.143E-15
    I_C1762 (XI1_I13_An VSS) capacitor c=8.993E-16
    I_C1763 (XI1_I16_p1 VSS) capacitor c=5.456E-16
    I_C1764 (XI1_I16_n1 VSS) capacitor c=2.809E-18
    I_C1765 (XI1_I16_n2 VSS) capacitor c=7.010E-18
    I_C1766 (XI1_I16_Bn VSS) capacitor c=1.048E-15
    I_C1767 (XI1_I16_An VSS) capacitor c=9.687E-16
    I_C1768 (XI1_I19_p1 VSS) capacitor c=6.013E-16
    I_C1769 (XI1_I19_n1 VSS) capacitor c=6.138E-18
    I_C1770 (XI1_I19_n2 VSS) capacitor c=7.714E-18
    I_C1771 (XI1_I19_Bn VSS) capacitor c=1.141E-15
    I_C1772 (XI1_I19_An VSS) capacitor c=8.859E-16
    I_C1773 (XI1_I48_I8_p1 VSS) capacitor c=5.966E-16
    I_C1774 (XI1_I48_I8_n1 VSS) capacitor c=1.807E-18
    I_C1775 (XI1_I48_I8_n2 VSS) capacitor c=5.636E-18
    I_C1776 (XI1_I48_I8_Bn VSS) capacitor c=1.102E-15
    I_C1777 (XI1_I48_I8_An VSS) capacitor c=9.298E-16
    I_C1778 (XI1_I108_I44_p1 VSS) capacitor c=5.315E-16
    I_C1779 (XI1_I108_I44_n2 VSS) capacitor c=9.007E-18
    I_C1780 (XI1_I108_I44_Bn VSS) capacitor c=1.061E-15
    I_C1781 (XI1_I108_I44_An VSS) capacitor c=9.131E-16
    I_C1782 (XI1_I108_I42_p1 VSS) capacitor c=5.260E-16
    I_C1783 (XI1_I108_I42_n2 VSS) capacitor c=5.960E-18
    I_C1784 (XI1_I108_I42_Bn VSS) capacitor c=1.037E-15
    I_C1785 (XI1_I108_I42_An VSS) capacitor c=8.904E-16
    I_C1786 (XI1_I108_I10_p1 VSS) capacitor c=5.561E-16
    I_C1787 (XI1_I108_I10_n1 VSS) capacitor c=2.677E-18
    I_C1788 (XI1_I108_I10_n2 VSS) capacitor c=7.777E-18
    I_C1789 (XI1_I108_I10_Bn VSS) capacitor c=1.106E-15
    I_C1790 (XI1_I108_I10_An VSS) capacitor c=9.794E-16
    I_C1791 (XI1_I96_I9_p1 VSS) capacitor c=5.613E-16
    I_C1792 (XI1_I96_I9_n1 VSS) capacitor c=5.786E-19
    I_C1793 (XI1_I96_I9_n2 VSS) capacitor c=7.584E-18
    I_C1794 (XI1_I96_I9_Bn VSS) capacitor c=1.077E-15
    I_C1795 (XI1_I96_I9_An VSS) capacitor c=9.117E-16
    I_C1796 (XI1_I84_I37_p1 VSS) capacitor c=5.335E-16
    I_C1797 (XI1_I84_I37_n1 VSS) capacitor c=2.385E-18
    I_C1798 (XI1_I84_I37_n2 VSS) capacitor c=7.241E-18
    I_C1799 (XI1_I84_I37_Bn VSS) capacitor c=1.042E-15
    I_C1800 (XI1_I84_I37_An VSS) capacitor c=9.535E-16
    I_C1801 (XI1_I84_I9_p1 VSS) capacitor c=5.904E-16
    I_C1802 (XI1_I84_I9_n1 VSS) capacitor c=5.786E-19
    I_C1803 (XI1_I84_I9_n2 VSS) capacitor c=8.309E-18
    I_C1804 (XI1_I84_I9_Bn VSS) capacitor c=1.095E-15
    I_C1805 (XI1_I84_I9_An VSS) capacitor c=9.554E-16
    I_C1806 (XI1_I72_I37_p1 VSS) capacitor c=5.739E-16
    I_C1807 (XI1_I72_I37_n1 VSS) capacitor c=3.820E-19
    I_C1808 (XI1_I72_I37_n2 VSS) capacitor c=7.895E-18
    I_C1809 (XI1_I72_I37_Bn VSS) capacitor c=1.062E-15
    I_C1810 (XI1_I72_I37_An VSS) capacitor c=9.213E-16
    I_C1811 (XI1_I72_I8_p1 VSS) capacitor c=5.575E-16
    I_C1812 (XI1_I72_I8_n1 VSS) capacitor c=5.786E-19
    I_C1813 (XI1_I72_I8_n2 VSS) capacitor c=7.868E-18
    I_C1814 (XI1_I72_I8_Bn VSS) capacitor c=1.059E-15
    I_C1815 (XI1_I72_I8_An VSS) capacitor c=9.400E-16
    I_C1816 (XI1_I60_I8_p1 VSS) capacitor c=5.272E-16
    I_C1817 (XI1_I60_I8_n1 VSS) capacitor c=5.540E-19
    I_C1818 (XI1_I60_I8_n2 VSS) capacitor c=9.986E-18
    I_C1819 (XI1_I60_I8_Bn VSS) capacitor c=1.068E-15
    I_C1820 (XI1_I60_I8_An VSS) capacitor c=9.683E-16
    I_C1821 (XI1_I48_I37_p1 VSS) capacitor c=5.293E-16
    I_C1822 (XI1_I48_I37_n1 VSS) capacitor c=5.786E-19
    I_C1823 (XI1_I48_I37_n2 VSS) capacitor c=9.070E-18
    I_C1824 (XI1_I48_I37_Bn VSS) capacitor c=1.087E-15
    I_C1825 (XI1_I48_I37_An VSS) capacitor c=8.942E-16
    I_C1826 (XI1_I60_I37_p1 VSS) capacitor c=5.954E-16
    I_C1827 (XI1_I60_I37_n2 VSS) capacitor c=1.326E-17
    I_C1828 (XI1_I60_I37_Bn VSS) capacitor c=1.102E-15
    I_C1829 (XI1_I60_I37_An VSS) capacitor c=9.582E-16
    I_C1830 (XI1_I48_I10_p1 VSS) capacitor c=5.384E-16
    I_C1831 (XI1_I48_I10_n1 VSS) capacitor c=5.154E-19
    I_C1832 (XI1_I48_I10_n2 VSS) capacitor c=8.607E-18
    I_C1833 (XI1_I48_I10_Bn VSS) capacitor c=1.092E-15
    I_C1834 (XI1_I48_I10_An VSS) capacitor c=9.432E-16
    I_C1835 (XI1_I108_I43_p1 VSS) capacitor c=6.014E-16
    I_C1836 (XI1_I108_I43_n1 VSS) capacitor c=4.788E-19
    I_C1837 (XI1_I108_I43_n2 VSS) capacitor c=1.526E-17
    I_C1838 (XI1_I108_I43_Bn VSS) capacitor c=1.090E-15
    I_C1839 (XI1_I108_I43_An VSS) capacitor c=9.368E-16
    I_C1840 (XI1_I96_I38_p1 VSS) capacitor c=5.284E-16
    I_C1841 (XI1_I96_I38_n1 VSS) capacitor c=6.559E-19
    I_C1842 (XI1_I96_I38_n2 VSS) capacitor c=7.318E-18
    I_C1843 (XI1_I96_I38_Bn VSS) capacitor c=1.060E-15
    I_C1844 (XI1_I96_I38_An VSS) capacitor c=9.643E-16
    I_C1845 (XI1_I108_I11_p1 VSS) capacitor c=5.542E-16
    I_C1846 (XI1_I108_I11_n1 VSS) capacitor c=3.571E-18
    I_C1847 (XI1_I108_I11_n2 VSS) capacitor c=7.162E-18
    I_C1848 (XI1_I108_I11_Bn VSS) capacitor c=1.071E-15
    I_C1849 (XI1_I108_I11_An VSS) capacitor c=9.270E-16
    I_C1850 (XI1_I96_I10_p1 VSS) capacitor c=5.317E-16
    I_C1851 (XI1_I96_I10_n1 VSS) capacitor c=1.063E-18
    I_C1852 (XI1_I96_I10_n2 VSS) capacitor c=9.551E-18
    I_C1853 (XI1_I96_I10_Bn VSS) capacitor c=1.051E-15
    I_C1854 (XI1_I96_I10_An VSS) capacitor c=9.207E-16
    I_C1855 (XI1_I84_I38_p1 VSS) capacitor c=5.347E-16
    I_C1856 (XI1_I84_I38_n1 VSS) capacitor c=4.475E-18
    I_C1857 (XI1_I84_I38_n2 VSS) capacitor c=7.282E-18
    I_C1858 (XI1_I84_I38_Bn VSS) capacitor c=1.071E-15
    I_C1859 (XI1_I84_I38_An VSS) capacitor c=9.323E-16
    I_C1860 (XI1_I84_I10_p1 VSS) capacitor c=5.362E-16
    I_C1861 (XI1_I84_I10_n1 VSS) capacitor c=4.922E-19
    I_C1862 (XI1_I84_I10_n2 VSS) capacitor c=8.660E-18
    I_C1863 (XI1_I84_I10_Bn VSS) capacitor c=1.082E-15
    I_C1864 (XI1_I84_I10_An VSS) capacitor c=9.181E-16
    I_C1865 (XI1_I72_I38_p1 VSS) capacitor c=5.368E-16
    I_C1866 (XI1_I72_I38_n1 VSS) capacitor c=2.935E-18
    I_C1867 (XI1_I72_I38_n2 VSS) capacitor c=8.341E-18
    I_C1868 (XI1_I72_I38_Bn VSS) capacitor c=1.096E-15
    I_C1869 (XI1_I72_I38_An VSS) capacitor c=9.180E-16
    I_C1870 (XI1_I72_I9_p1 VSS) capacitor c=5.444E-16
    I_C1871 (XI1_I72_I9_n1 VSS) capacitor c=2.029E-18
    I_C1872 (XI1_I72_I9_n2 VSS) capacitor c=9.123E-18
    I_C1873 (XI1_I72_I9_Bn VSS) capacitor c=1.083E-15
    I_C1874 (XI1_I72_I9_An VSS) capacitor c=9.791E-16
    I_C1875 (XI1_I72_I10_p1 VSS) capacitor c=5.445E-16
    I_C1876 (XI1_I72_I10_n1 VSS) capacitor c=4.765E-19
    I_C1877 (XI1_I72_I10_n2 VSS) capacitor c=8.747E-18
    I_C1878 (XI1_I72_I10_Bn VSS) capacitor c=1.059E-15
    I_C1879 (XI1_I72_I10_An VSS) capacitor c=9.295E-16
    I_C1880 (XI1_I60_I38_p1 VSS) capacitor c=5.667E-16
    I_C1881 (XI1_I60_I38_n2 VSS) capacitor c=8.365E-18
    I_C1882 (XI1_I60_I38_Bn VSS) capacitor c=1.071E-15
    I_C1883 (XI1_I60_I38_An VSS) capacitor c=8.915E-16
    I_C1884 (XI1_I60_I9_p1 VSS) capacitor c=5.357E-16
    I_C1885 (XI1_I60_I9_n1 VSS) capacitor c=5.636E-19
    I_C1886 (XI1_I60_I9_n2 VSS) capacitor c=8.660E-18
    I_C1887 (XI1_I60_I9_Bn VSS) capacitor c=1.042E-15
    I_C1888 (XI1_I60_I9_An VSS) capacitor c=8.901E-16
    I_C1889 (XI1_I48_I38_p1 VSS) capacitor c=5.377E-16
    I_C1890 (XI1_I48_I38_n1 VSS) capacitor c=4.250E-19
    I_C1891 (XI1_I48_I38_n2 VSS) capacitor c=1.153E-17
    I_C1892 (XI1_I48_I38_Bn VSS) capacitor c=1.083E-15
    I_C1893 (XI1_I48_I38_An VSS) capacitor c=9.114E-16
    I_C1894 (XI1_I60_I10_p1 VSS) capacitor c=5.388E-16
    I_C1895 (XI1_I60_I10_n1 VSS) capacitor c=3.820E-19
    I_C1896 (XI1_I60_I10_n2 VSS) capacitor c=5.895E-18
    I_C1897 (XI1_I60_I10_Bn VSS) capacitor c=1.055E-15
    I_C1898 (XI1_I60_I10_An VSS) capacitor c=9.263E-16
    I_C1899 (XI1_I48_I9_p1 VSS) capacitor c=5.461E-16
    I_C1900 (XI1_I48_I9_n1 VSS) capacitor c=4.457E-18
    I_C1901 (XI1_I48_I9_n2 VSS) capacitor c=1.017E-17
    I_C1902 (XI1_I48_I9_Bn VSS) capacitor c=1.061E-15
    I_C1903 (XI1_I48_I9_An VSS) capacitor c=9.327E-16
    I_C1904 (XI1_I48_I11_p1 VSS) capacitor c=5.294E-16
    I_C1905 (XI1_I48_I11_n2 VSS) capacitor c=8.730E-18
    I_C1906 (XI1_I48_I11_Bn VSS) capacitor c=1.042E-15
    I_C1907 (XI1_I48_I11_An VSS) capacitor c=9.253E-16
    I_C1908 (XI1_I108_I12_p1 VSS) capacitor c=5.341E-16
    I_C1909 (XI1_I108_I12_n1 VSS) capacitor c=6.257E-19
    I_C1910 (XI1_I108_I12_n2 VSS) capacitor c=6.740E-18
    I_C1911 (XI1_I108_I12_Bn VSS) capacitor c=1.058E-15
    I_C1912 (XI1_I108_I12_An VSS) capacitor c=9.148E-16
    I_C1913 (XI1_I96_I39_p1 VSS) capacitor c=5.618E-16
    I_C1914 (XI1_I96_I39_n1 VSS) capacitor c=3.820E-19
    I_C1915 (XI1_I96_I39_n2 VSS) capacitor c=1.003E-17
    I_C1916 (XI1_I96_I39_Bn VSS) capacitor c=1.060E-15
    I_C1917 (XI1_I96_I39_An VSS) capacitor c=9.275E-16
    I_C1918 (XI1_I96_I11_p1 VSS) capacitor c=5.436E-16
    I_C1919 (XI1_I96_I11_n1 VSS) capacitor c=1.684E-18
    I_C1920 (XI1_I96_I11_n2 VSS) capacitor c=7.713E-18
    I_C1921 (XI1_I96_I11_Bn VSS) capacitor c=1.071E-15
    I_C1922 (XI1_I96_I11_An VSS) capacitor c=9.309E-16
    I_C1923 (XI1_I84_I39_p1 VSS) capacitor c=5.312E-16
    I_C1924 (XI1_I84_I39_n2 VSS) capacitor c=6.855E-18
    I_C1925 (XI1_I84_I39_Bn VSS) capacitor c=1.064E-15
    I_C1926 (XI1_I84_I39_An VSS) capacitor c=9.219E-16
    I_C1927 (XI1_I84_I11_p1 VSS) capacitor c=5.527E-16
    I_C1928 (XI1_I84_I11_n1 VSS) capacitor c=3.820E-19
    I_C1929 (XI1_I84_I11_n2 VSS) capacitor c=5.745E-18
    I_C1930 (XI1_I84_I11_Bn VSS) capacitor c=1.068E-15
    I_C1931 (XI1_I84_I11_An VSS) capacitor c=9.208E-16
    I_C1932 (XI1_I72_I39_p1 VSS) capacitor c=5.326E-16
    I_C1933 (XI1_I72_I39_n1 VSS) capacitor c=4.645E-19
    I_C1934 (XI1_I72_I39_n2 VSS) capacitor c=7.606E-18
    I_C1935 (XI1_I72_I39_Bn VSS) capacitor c=1.092E-15
    I_C1936 (XI1_I72_I39_An VSS) capacitor c=9.320E-16
    I_C1937 (XI1_I72_I11_p1 VSS) capacitor c=5.398E-16
    I_C1938 (XI1_I72_I11_n2 VSS) capacitor c=8.036E-18
    I_C1939 (XI1_I72_I11_Bn VSS) capacitor c=1.062E-15
    I_C1940 (XI1_I72_I11_An VSS) capacitor c=9.128E-16
    I_C1941 (XI1_I60_I39_p1 VSS) capacitor c=5.938E-16
    I_C1942 (XI1_I60_I39_n2 VSS) capacitor c=8.225E-18
    I_C1943 (XI1_I60_I39_Bn VSS) capacitor c=1.078E-15
    I_C1944 (XI1_I60_I39_An VSS) capacitor c=9.312E-16
    I_C1945 (XI1_I60_I11_p1 VSS) capacitor c=5.240E-16
    I_C1946 (XI1_I60_I11_n1 VSS) capacitor c=3.820E-19
    I_C1947 (XI1_I60_I11_n2 VSS) capacitor c=8.361E-18
    I_C1948 (XI1_I60_I11_Bn VSS) capacitor c=1.031E-15
    I_C1949 (XI1_I60_I11_An VSS) capacitor c=9.118E-16
    I_C1950 (XI1_I48_I39_p1 VSS) capacitor c=5.607E-16
    I_C1951 (XI1_I48_I39_n1 VSS) capacitor c=4.715E-19
    I_C1952 (XI1_I48_I39_n2 VSS) capacitor c=8.199E-18
    I_C1953 (XI1_I48_I39_Bn VSS) capacitor c=1.050E-15
    I_C1954 (XI1_I48_I39_An VSS) capacitor c=9.410E-16
    I_C1955 (XI1_I48_I12_p1 VSS) capacitor c=4.937E-16
    I_C1956 (XI1_I48_I12_n1 VSS) capacitor c=5.795E-19
    I_C1957 (XI1_I48_I12_n2 VSS) capacitor c=8.975E-18
    I_C1958 (XI1_I48_I12_Bn VSS) capacitor c=1.032E-15
    I_C1959 (XI1_I48_I12_An VSS) capacitor c=9.203E-16
    I_C1960 (XI1_I108_I13_p1 VSS) capacitor c=5.385E-16
    I_C1961 (XI1_I108_I13_n1 VSS) capacitor c=2.865E-19
    I_C1962 (XI1_I108_I13_n2 VSS) capacitor c=5.740E-18
    I_C1963 (XI1_I108_I13_Bn VSS) capacitor c=1.076E-15
    I_C1964 (XI1_I108_I13_An VSS) capacitor c=9.121E-16
    I_C1965 (XI1_I96_I12_p1 VSS) capacitor c=5.725E-16
    I_C1966 (XI1_I96_I12_n1 VSS) capacitor c=3.151E-19
    I_C1967 (XI1_I96_I12_n2 VSS) capacitor c=6.224E-18
    I_C1968 (XI1_I96_I12_Bn VSS) capacitor c=1.066E-15
    I_C1969 (XI1_I96_I12_An VSS) capacitor c=9.118E-16
    I_C1970 (XI1_I84_I12_p1 VSS) capacitor c=5.479E-16
    I_C1971 (XI1_I84_I12_n1 VSS) capacitor c=4.830E-18
    I_C1972 (XI1_I84_I12_n2 VSS) capacitor c=7.354E-18
    I_C1973 (XI1_I84_I12_Bn VSS) capacitor c=1.064E-15
    I_C1974 (XI1_I84_I12_An VSS) capacitor c=9.360E-16
    I_C1975 (XI1_I72_I12_p1 VSS) capacitor c=5.356E-16
    I_C1976 (XI1_I72_I12_n1 VSS) capacitor c=5.786E-19
    I_C1977 (XI1_I72_I12_n2 VSS) capacitor c=8.518E-18
    I_C1978 (XI1_I72_I12_Bn VSS) capacitor c=1.064E-15
    I_C1979 (XI1_I72_I12_An VSS) capacitor c=9.433E-16
    I_C1980 (XI1_I60_I12_p1 VSS) capacitor c=5.430E-16
    I_C1981 (XI1_I60_I12_n1 VSS) capacitor c=5.399E-18
    I_C1982 (XI1_I60_I12_n2 VSS) capacitor c=6.918E-18
    I_C1983 (XI1_I60_I12_Bn VSS) capacitor c=1.035E-15
    I_C1984 (XI1_I60_I12_An VSS) capacitor c=9.172E-16
    I_C1985 (XI1_I48_I42_p1 VSS) capacitor c=5.735E-16
    I_C1986 (XI1_I48_I42_n2 VSS) capacitor c=6.695E-18
    I_C1987 (XI1_I48_I42_Bn VSS) capacitor c=1.065E-15
    I_C1988 (XI1_I48_I42_An VSS) capacitor c=9.171E-16
    I_C1989 (XI1_I108_I14_p1 VSS) capacitor c=5.936E-16
    I_C1990 (XI1_I108_I14_n1 VSS) capacitor c=5.145E-18
    I_C1991 (XI1_I108_I14_n2 VSS) capacitor c=9.467E-18
    I_C1992 (XI1_I108_I14_Bn VSS) capacitor c=1.050E-15
    I_C1993 (XI1_I108_I14_An VSS) capacitor c=9.738E-16
    I_C1994 (XI1_I96_I42_p1 VSS) capacitor c=5.810E-16
    I_C1995 (XI1_I96_I42_n2 VSS) capacitor c=8.259E-18
    I_C1996 (XI1_I96_I42_Bn VSS) capacitor c=1.084E-15
    I_C1997 (XI1_I96_I42_An VSS) capacitor c=9.218E-16
    I_C1998 (XI1_I96_I13_p1 VSS) capacitor c=5.663E-16
    I_C1999 (XI1_I96_I13_n1 VSS) capacitor c=5.786E-19
    I_C2000 (XI1_I96_I13_n2 VSS) capacitor c=1.165E-17
    I_C2001 (XI1_I96_I13_Bn VSS) capacitor c=1.058E-15
    I_C2002 (XI1_I96_I13_An VSS) capacitor c=9.254E-16
    I_C2003 (XI1_I84_I42_p1 VSS) capacitor c=5.173E-16
    I_C2004 (XI1_I84_I42_n1 VSS) capacitor c=4.632E-19
    I_C2005 (XI1_I84_I42_n2 VSS) capacitor c=7.735E-18
    I_C2006 (XI1_I84_I42_Bn VSS) capacitor c=1.092E-15
    I_C2007 (XI1_I84_I42_An VSS) capacitor c=9.498E-16
    I_C2008 (XI1_I84_I13_p1 VSS) capacitor c=5.379E-16
    I_C2009 (XI1_I84_I13_n1 VSS) capacitor c=5.788E-19
    I_C2010 (XI1_I84_I13_n2 VSS) capacitor c=6.491E-18
    I_C2011 (XI1_I84_I13_Bn VSS) capacitor c=1.055E-15
    I_C2012 (XI1_I84_I13_An VSS) capacitor c=9.394E-16
    I_C2013 (XI1_I72_I42_p1 VSS) capacitor c=5.532E-16
    I_C2014 (XI1_I72_I42_n2 VSS) capacitor c=7.596E-18
    I_C2015 (XI1_I72_I42_Bn VSS) capacitor c=1.079E-15
    I_C2016 (XI1_I72_I42_An VSS) capacitor c=9.197E-16
    I_C2017 (XI1_I72_I13_p1 VSS) capacitor c=5.107E-16
    I_C2018 (XI1_I72_I13_n1 VSS) capacitor c=1.255E-18
    I_C2019 (XI1_I72_I13_n2 VSS) capacitor c=7.137E-18
    I_C2020 (XI1_I72_I13_Bn VSS) capacitor c=1.079E-15
    I_C2021 (XI1_I72_I13_An VSS) capacitor c=9.356E-16
    I_C2022 (XI1_I60_I42_p1 VSS) capacitor c=5.748E-16
    I_C2023 (XI1_I60_I42_n2 VSS) capacitor c=8.874E-18
    I_C2024 (XI1_I60_I42_Bn VSS) capacitor c=1.103E-15
    I_C2025 (XI1_I60_I42_An VSS) capacitor c=9.222E-16
    I_C2026 (XI1_I60_I13_p1 VSS) capacitor c=5.459E-16
    I_C2027 (XI1_I60_I13_n2 VSS) capacitor c=6.944E-18
    I_C2028 (XI1_I60_I13_Bn VSS) capacitor c=1.050E-15
    I_C2029 (XI1_I60_I13_An VSS) capacitor c=9.242E-16
    I_C2030 (XI1_I48_I13_p1 VSS) capacitor c=4.983E-16
    I_C2031 (XI1_I48_I13_n1 VSS) capacitor c=1.068E-18
    I_C2032 (XI1_I48_I13_n2 VSS) capacitor c=8.281E-18
    I_C2033 (XI1_I48_I13_Bn VSS) capacitor c=1.054E-15
    I_C2034 (XI1_I48_I13_An VSS) capacitor c=9.223E-16
    I_C2035 (XI1_I48_I14_p1 VSS) capacitor c=5.415E-16
    I_C2036 (XI1_I48_I14_n1 VSS) capacitor c=5.420E-19
    I_C2037 (XI1_I48_I14_n2 VSS) capacitor c=4.664E-18
    I_C2038 (XI1_I48_I14_Bn VSS) capacitor c=1.053E-15
    I_C2039 (XI1_I48_I14_An VSS) capacitor c=9.351E-16
    I_C2040 (XI1_I48_I43_p1 VSS) capacitor c=5.686E-16
    I_C2041 (XI1_I48_I43_n1 VSS) capacitor c=4.279E-19
    I_C2042 (XI1_I48_I43_n2 VSS) capacitor c=1.559E-17
    I_C2043 (XI1_I48_I43_Bn VSS) capacitor c=1.079E-15
    I_C2044 (XI1_I48_I43_An VSS) capacitor c=9.241E-16
    I_C2045 (XI1_I108_I15_p1 VSS) capacitor c=5.558E-16
    I_C2046 (XI1_I108_I15_n2 VSS) capacitor c=7.853E-18
    I_C2047 (XI1_I108_I15_Bn VSS) capacitor c=1.031E-15
    I_C2048 (XI1_I108_I15_An VSS) capacitor c=9.146E-16
    I_C2049 (XI1_I96_I43_p1 VSS) capacitor c=5.642E-16
    I_C2050 (XI1_I96_I43_n2 VSS) capacitor c=1.077E-17
    I_C2051 (XI1_I96_I43_Bn VSS) capacitor c=1.147E-15
    I_C2052 (XI1_I96_I43_An VSS) capacitor c=9.264E-16
    I_C2053 (XI1_I96_I44_p1 VSS) capacitor c=5.458E-16
    I_C2054 (XI1_I96_I44_n1 VSS) capacitor c=6.480E-19
    I_C2055 (XI1_I96_I44_n2 VSS) capacitor c=7.828E-18
    I_C2056 (XI1_I96_I44_Bn VSS) capacitor c=1.055E-15
    I_C2057 (XI1_I96_I44_An VSS) capacitor c=9.663E-16
    I_C2058 (XI1_I96_I14_p1 VSS) capacitor c=6.079E-16
    I_C2059 (XI1_I96_I14_n1 VSS) capacitor c=5.786E-19
    I_C2060 (XI1_I96_I14_n2 VSS) capacitor c=9.665E-18
    I_C2061 (XI1_I96_I14_Bn VSS) capacitor c=1.069E-15
    I_C2062 (XI1_I96_I14_An VSS) capacitor c=9.345E-16
    I_C2063 (XI1_I84_I43_p1 VSS) capacitor c=5.134E-16
    I_C2064 (XI1_I84_I43_n1 VSS) capacitor c=5.786E-19
    I_C2065 (XI1_I84_I43_n2 VSS) capacitor c=8.677E-18
    I_C2066 (XI1_I84_I43_Bn VSS) capacitor c=1.034E-15
    I_C2067 (XI1_I84_I43_An VSS) capacitor c=9.321E-16
    I_C2068 (XI1_I84_I14_p1 VSS) capacitor c=5.078E-16
    I_C2069 (XI1_I84_I14_n2 VSS) capacitor c=7.354E-18
    I_C2070 (XI1_I84_I14_Bn VSS) capacitor c=1.063E-15
    I_C2071 (XI1_I84_I14_An VSS) capacitor c=9.119E-16
    I_C2072 (XI1_I72_I44_p1 VSS) capacitor c=5.453E-16
    I_C2073 (XI1_I72_I44_n1 VSS) capacitor c=8.505E-18
    I_C2074 (XI1_I72_I44_n2 VSS) capacitor c=6.994E-18
    I_C2075 (XI1_I72_I44_Bn VSS) capacitor c=1.036E-15
    I_C2076 (XI1_I72_I44_An VSS) capacitor c=9.351E-16
    I_C2077 (XI1_I72_I14_p1 VSS) capacitor c=5.940E-16
    I_C2078 (XI1_I72_I14_n2 VSS) capacitor c=7.955E-18
    I_C2079 (XI1_I72_I14_Bn VSS) capacitor c=1.042E-15
    I_C2080 (XI1_I72_I14_An VSS) capacitor c=9.107E-16
    I_C2081 (XI1_I60_I43_p1 VSS) capacitor c=5.603E-16
    I_C2082 (XI1_I60_I43_n2 VSS) capacitor c=8.143E-18
    I_C2083 (XI1_I60_I43_Bn VSS) capacitor c=1.073E-15
    I_C2084 (XI1_I60_I43_An VSS) capacitor c=9.142E-16
    I_C2085 (XI1_I60_I14_p1 VSS) capacitor c=5.322E-16
    I_C2086 (XI1_I60_I14_n1 VSS) capacitor c=5.786E-19
    I_C2087 (XI1_I60_I14_n2 VSS) capacitor c=8.097E-18
    I_C2088 (XI1_I60_I14_Bn VSS) capacitor c=1.039E-15
    I_C2089 (XI1_I60_I14_An VSS) capacitor c=9.021E-16
    I_C2090 (XI1_I48_I44_p1 VSS) capacitor c=5.768E-16
    I_C2091 (XI1_I48_I44_n2 VSS) capacitor c=1.201E-17
    I_C2092 (XI1_I48_I44_Bn VSS) capacitor c=1.078E-15
    I_C2093 (XI1_I48_I44_An VSS) capacitor c=9.052E-16
    I_C2094 (XI1_I96_I15_p1 VSS) capacitor c=5.627E-16
    I_C2095 (XI1_I96_I15_n2 VSS) capacitor c=5.772E-18
    I_C2096 (XI1_I96_I15_Bn VSS) capacitor c=1.100E-15
    I_C2097 (XI1_I96_I15_An VSS) capacitor c=9.233E-16
    I_C2098 (XI1_I84_I44_p1 VSS) capacitor c=5.207E-16
    I_C2099 (XI1_I84_I44_n1 VSS) capacitor c=6.641E-19
    I_C2100 (XI1_I84_I44_n2 VSS) capacitor c=9.579E-18
    I_C2101 (XI1_I84_I44_Bn VSS) capacitor c=1.077E-15
    I_C2102 (XI1_I84_I44_An VSS) capacitor c=9.513E-16
    I_C2103 (XI1_I84_I15_p1 VSS) capacitor c=5.555E-16
    I_C2104 (XI1_I84_I15_n1 VSS) capacitor c=5.026E-18
    I_C2105 (XI1_I84_I15_n2 VSS) capacitor c=6.675E-18
    I_C2106 (XI1_I84_I15_Bn VSS) capacitor c=1.054E-15
    I_C2107 (XI1_I84_I15_An VSS) capacitor c=9.841E-16
    I_C2108 (XI1_I72_I43_p1 VSS) capacitor c=5.398E-16
    I_C2109 (XI1_I72_I43_n1 VSS) capacitor c=1.432E-18
    I_C2110 (XI1_I72_I43_n2 VSS) capacitor c=7.042E-18
    I_C2111 (XI1_I72_I43_Bn VSS) capacitor c=1.072E-15
    I_C2112 (XI1_I72_I43_An VSS) capacitor c=9.401E-16
    I_C2113 (XI1_I72_I15_p1 VSS) capacitor c=5.466E-16
    I_C2114 (XI1_I72_I15_n2 VSS) capacitor c=6.378E-18
    I_C2115 (XI1_I72_I15_Bn VSS) capacitor c=1.044E-15
    I_C2116 (XI1_I72_I15_An VSS) capacitor c=9.349E-16
    I_C2117 (XI1_I60_I44_p1 VSS) capacitor c=5.357E-16
    I_C2118 (XI1_I60_I44_n1 VSS) capacitor c=1.432E-18
    I_C2119 (XI1_I60_I44_n2 VSS) capacitor c=6.309E-18
    I_C2120 (XI1_I60_I44_Bn VSS) capacitor c=1.068E-15
    I_C2121 (XI1_I60_I44_An VSS) capacitor c=9.043E-16
    I_C2122 (XI1_I60_I15_p1 VSS) capacitor c=5.330E-16
    I_C2123 (XI1_I60_I15_n1 VSS) capacitor c=1.405E-18
    I_C2124 (XI1_I60_I15_n2 VSS) capacitor c=8.157E-18
    I_C2125 (XI1_I60_I15_Bn VSS) capacitor c=1.053E-15
    I_C2126 (XI1_I60_I15_An VSS) capacitor c=8.859E-16
    I_C2127 (XI1_I48_I15_p1 VSS) capacitor c=5.091E-16
    I_C2128 (XI1_I48_I15_n1 VSS) capacitor c=6.698E-19
    I_C2129 (XI1_I48_I15_n2 VSS) capacitor c=8.512E-18
    I_C2130 (XI1_I48_I15_Bn VSS) capacitor c=1.032E-15
    I_C2131 (XI1_I48_I15_An VSS) capacitor c=9.513E-16
    I_C2132 (XI0_I68_xp1 VSS) capacitor c=5.082E-16
    I_C2133 (XI0_I68_an VSS) capacitor c=1.246E-19
    I_C2134 (XI0_I68_xn2 VSS) capacitor c=3.872E-18
    I_C2135 (XI0_I68_xn1 VSS) capacitor c=3.969E-16
    I_C2136 (XI0_I68_con VSS) capacitor c=8.497E-16
    I_C2137 (XI0_I68_xbn VSS) capacitor c=1.455E-15
    I_C2138 (XI0_I68_xan VSS) capacitor c=9.840E-16
    I_C2139 (XI0_I65_xp1 VSS) capacitor c=5.116E-16
    I_C2140 (XI0_I65_an VSS) capacitor c=1.246E-19
    I_C2141 (XI0_I65_xn2 VSS) capacitor c=3.872E-18
    I_C2142 (XI0_I65_xn1 VSS) capacitor c=4.075E-16
    I_C2143 (XI0_I65_con VSS) capacitor c=8.551E-16
    I_C2144 (XI0_I65_xbn VSS) capacitor c=1.422E-15
    I_C2145 (XI0_I65_xan VSS) capacitor c=9.777E-16
    I_C2146 (XI0_I66_xp1 VSS) capacitor c=5.089E-16
    I_C2147 (XI0_I66_an VSS) capacitor c=3.731E-18
    I_C2148 (XI0_I66_xn2 VSS) capacitor c=3.861E-18
    I_C2149 (XI0_I66_xn1 VSS) capacitor c=4.852E-16
    I_C2150 (XI0_I66_con VSS) capacitor c=8.202E-16
    I_C2151 (XI0_I66_xbn VSS) capacitor c=1.674E-15
    I_C2152 (XI0_I66_xan VSS) capacitor c=9.833E-16
    I_C2153 (XI0_I67_xp1 VSS) capacitor c=5.145E-16
    I_C2154 (XI0_I67_an VSS) capacitor c=8.348E-20
    I_C2155 (XI0_I67_xn2 VSS) capacitor c=3.254E-18
    I_C2156 (XI0_I67_xn1 VSS) capacitor c=4.677E-16
    I_C2157 (XI0_I67_con VSS) capacitor c=8.393E-16
    I_C2158 (XI0_I67_xbn VSS) capacitor c=1.493E-15
    I_C2159 (XI0_I67_xan VSS) capacitor c=9.967E-16
    I_C2160 (XI0_I56_xp1 VSS) capacitor c=5.222E-16
    I_C2161 (XI0_I56_an VSS) capacitor c=5.965E-18
    I_C2162 (XI0_I56_xn2 VSS) capacitor c=3.880E-18
    I_C2163 (XI0_I56_xn1 VSS) capacitor c=4.061E-16
    I_C2164 (XI0_I56_con VSS) capacitor c=8.559E-16
    I_C2165 (XI0_I56_xbn VSS) capacitor c=1.547E-15
    I_C2166 (XI0_I56_xan VSS) capacitor c=1.006E-15
    I_C2167 (XI0_I64_xp1 VSS) capacitor c=5.134E-16
    I_C2168 (XI0_I64_an VSS) capacitor c=1.246E-19
    I_C2169 (XI0_I64_xn2 VSS) capacitor c=3.343E-18
    I_C2170 (XI0_I64_xn1 VSS) capacitor c=4.661E-16
    I_C2171 (XI0_I64_con VSS) capacitor c=8.253E-16
    I_C2172 (XI0_I64_xbn VSS) capacitor c=1.538E-15
    I_C2173 (XI0_I64_xan VSS) capacitor c=1.001E-15
    I_C2174 (XI0_I63_xp1 VSS) capacitor c=5.257E-16
    I_C2175 (XI0_I63_xn2 VSS) capacitor c=3.233E-18
    I_C2176 (XI0_I63_xn1 VSS) capacitor c=4.179E-16
    I_C2177 (XI0_I63_con VSS) capacitor c=8.327E-16
    I_C2178 (XI0_I63_xbn VSS) capacitor c=1.491E-15
    I_C2179 (XI0_I63_xan VSS) capacitor c=9.925E-16
    I_C2180 (XI0_I62_xp1 VSS) capacitor c=5.066E-16
    I_C2181 (XI0_I62_an VSS) capacitor c=8.739E-20
    I_C2182 (XI0_I62_xn2 VSS) capacitor c=2.994E-18
    I_C2183 (XI0_I62_xn1 VSS) capacitor c=4.663E-16
    I_C2184 (XI0_I62_con VSS) capacitor c=8.314E-16
    I_C2185 (XI0_I62_xbn VSS) capacitor c=1.522E-15
    I_C2186 (XI0_I62_xan VSS) capacitor c=9.824E-16
    I_C2187 (XI0_I61_xp1 VSS) capacitor c=5.143E-16
    I_C2188 (XI0_I61_an VSS) capacitor c=2.606E-18
    I_C2189 (XI0_I61_xn2 VSS) capacitor c=4.185E-18
    I_C2190 (XI0_I61_xn1 VSS) capacitor c=4.530E-16
    I_C2191 (XI0_I61_con VSS) capacitor c=8.548E-16
    I_C2192 (XI0_I61_xbn VSS) capacitor c=1.747E-15
    I_C2193 (XI0_I61_xan VSS) capacitor c=1.006E-15
    I_C2194 (XI0_I59_xp1 VSS) capacitor c=5.148E-16
    I_C2195 (XI0_I59_an VSS) capacitor c=2.439E-18
    I_C2196 (XI0_I59_xn2 VSS) capacitor c=4.204E-18
    I_C2197 (XI0_I59_xn1 VSS) capacitor c=4.471E-16
    I_C2198 (XI0_I59_con VSS) capacitor c=8.608E-16
    I_C2199 (XI0_I59_xbn VSS) capacitor c=1.740E-15
    I_C2200 (XI0_I59_xan VSS) capacitor c=9.972E-16
    I_C2201 (XI0_I60_xp1 VSS) capacitor c=5.146E-16
    I_C2202 (XI0_I60_an VSS) capacitor c=1.396E-18
    I_C2203 (XI0_I60_xn2 VSS) capacitor c=4.041E-18
    I_C2204 (XI0_I60_xn1 VSS) capacitor c=4.400E-16
    I_C2205 (XI0_I60_con VSS) capacitor c=8.281E-16
    I_C2206 (XI0_I60_xbn VSS) capacitor c=1.728E-15
    I_C2207 (XI0_I60_xan VSS) capacitor c=9.968E-16
    I_C2208 (XI0_I58_xp1 VSS) capacitor c=5.119E-16
    I_C2209 (XI0_I58_xn2 VSS) capacitor c=7.443E-18
    I_C2210 (XI0_I58_xn1 VSS) capacitor c=4.269E-16
    I_C2211 (XI0_I58_con VSS) capacitor c=8.524E-16
    I_C2212 (XI0_I58_xbn VSS) capacitor c=1.483E-15
    I_C2213 (XI0_I58_xan VSS) capacitor c=1.002E-15
    I_C2214 (XI0_I73_xp1 VSS) capacitor c=5.277E-16
    I_C2215 (XI0_I73_xn2 VSS) capacitor c=3.158E-18
    I_C2216 (XI0_I73_xn1 VSS) capacitor c=4.455E-16
    I_C2217 (XI0_I73_con VSS) capacitor c=8.106E-16
    I_C2218 (XI0_I73_xbn VSS) capacitor c=1.509E-15
    I_C2219 (XI0_I73_xan VSS) capacitor c=1.001E-15
    I_C2220 (XI0_I45_xp1 VSS) capacitor c=5.252E-16
    I_C2221 (XI0_I45_an VSS) capacitor c=2.759E-18
    I_C2222 (XI0_I45_xn2 VSS) capacitor c=3.634E-18
    I_C2223 (XI0_I45_xn1 VSS) capacitor c=4.635E-16
    I_C2224 (XI0_I45_con VSS) capacitor c=8.327E-16
    I_C2225 (XI0_I45_xbn VSS) capacitor c=1.857E-15
    I_C2226 (XI0_I45_xan VSS) capacitor c=1.002E-15
    I_C2227 (XI0_I70_xp1 VSS) capacitor c=5.111E-16
    I_C2228 (XI0_I70_an VSS) capacitor c=3.795E-18
    I_C2229 (XI0_I70_xn2 VSS) capacitor c=5.492E-18
    I_C2230 (XI0_I70_xn1 VSS) capacitor c=4.731E-16
    I_C2231 (XI0_I70_con VSS) capacitor c=8.450E-16
    I_C2232 (XI0_I70_xbn VSS) capacitor c=1.495E-15
    I_C2233 (XI0_I70_xan VSS) capacitor c=9.871E-16
    I_C2234 (XI0_I69_xp1 VSS) capacitor c=5.192E-16
    I_C2235 (XI0_I69_an VSS) capacitor c=2.638E-18
    I_C2236 (XI0_I69_xn2 VSS) capacitor c=4.742E-18
    I_C2237 (XI0_I69_xn1 VSS) capacitor c=4.715E-16
    I_C2238 (XI0_I69_con VSS) capacitor c=8.373E-16
    I_C2239 (XI0_I69_xbn VSS) capacitor c=1.766E-15
    I_C2240 (XI0_I69_xan VSS) capacitor c=9.840E-16
    I_C2241 (XI0_I71_xp1 VSS) capacitor c=5.086E-16
    I_C2242 (XI0_I71_xn2 VSS) capacitor c=4.041E-18
    I_C2243 (XI0_I71_xn1 VSS) capacitor c=4.840E-16
    I_C2244 (XI0_I71_con VSS) capacitor c=8.412E-16
    I_C2245 (XI0_I71_xbn VSS) capacitor c=1.559E-15
    I_C2246 (XI0_I71_xan VSS) capacitor c=9.812E-16
    I_C2247 (XI0_I77_I31_XG_p1 VSS) capacitor c=2.653E-16
    I_C2248 (XI0_I77_I31_XG_n1 VSS) capacitor c=3.540E-18
    I_C2249 (XI1_I189_p1 VSS) capacitor c=2.744E-16
    I_C2250 (XI1_I189_n1 VSS) capacitor c=1.137E-19
    I_C2251 (XI1_I192_p1 VSS) capacitor c=2.690E-16
    I_C2252 (XI1_I192_n1 VSS) capacitor c=1.267E-18
    I_C2253 (XI0_I77_I30_XG_p1 VSS) capacitor c=2.759E-16
    I_C2254 (XI0_I77_I30_XG_n1 VSS) capacitor c=3.356E-20
    I_C2255 (XI0_I77_I27_XG_p1 VSS) capacitor c=2.717E-16
    I_C2256 (XI0_I77_I27_XG_n1 VSS) capacitor c=2.931E-18
    I_C2257 (XI0_I77_I29_XG_p1 VSS) capacitor c=2.541E-16
    I_C2258 (XI0_I77_I29_XG_n1 VSS) capacitor c=6.649E-18
    I_C2259 (XI1_I152_I29_XG_p1 VSS) capacitor c=2.859E-16
    I_C2260 (XI1_I186_p1 VSS) capacitor c=2.730E-16
    I_C2261 (XI1_I186_n1 VSS) capacitor c=2.692E-18
    I_C2262 (XI1_I183_p1 VSS) capacitor c=2.569E-16
    I_C2263 (XI1_I183_n1 VSS) capacitor c=4.272E-18
    I_C2264 (XI0_I77_I28_XG_p1 VSS) capacitor c=2.566E-16
    I_C2265 (XI0_I77_I28_XG_n1 VSS) capacitor c=1.596E-18
    I_C2266 (XI1_I152_I31_XG_p1 VSS) capacitor c=2.735E-16
    I_C2267 (XI1_I152_I27_XG_p1 VSS) capacitor c=2.572E-16
    I_C2268 (XI1_I152_I27_XG_n1 VSS) capacitor c=3.737E-19
    I_C2269 (XI1_I180_p1 VSS) capacitor c=2.588E-16
    I_C2270 (XI1_I180_n1 VSS) capacitor c=7.770E-19
    I_C2271 (XI0_I77_I26_XG_p1 VSS) capacitor c=2.586E-16
    I_C2272 (XI0_I77_I26_XG_n1 VSS) capacitor c=6.309E-18
    I_C2273 (XI1_I152_I30_XG_p1 VSS) capacitor c=2.429E-16
    I_C2274 (XI1_I152_I30_XG_n1 VSS) capacitor c=8.864E-19
    I_C2275 (XI1_I152_I28_XG_p1 VSS) capacitor c=2.467E-16
    I_C2276 (XI1_I152_I28_XG_n1 VSS) capacitor c=3.096E-19
    I_C2277 (XI1_I152_I26_XG_p1 VSS) capacitor c=2.659E-16
    I_C2278 (XI1_I152_I26_XG_n1 VSS) capacitor c=3.831E-18
    I_C2279 (XI1_I177_p1 VSS) capacitor c=2.576E-16
    I_C2280 (XI1_I177_n1 VSS) capacitor c=3.975E-18
    I_C2281 (XI2_I3_I94_p1 VSS) capacitor c=2.561E-16
    I_C2282 (XI2_I3_I94_n1 VSS) capacitor c=5.294E-18
    I_C2283 (XI1_I132_I29_XG_p1 VSS) capacitor c=2.812E-16
    I_C2284 (XI1_I132_I29_XG_n1 VSS) capacitor c=3.624E-18
    I_C2285 (XI1_I132_I27_XG_p1 VSS) capacitor c=2.514E-16
    I_C2286 (XI1_I132_I27_XG_n1 VSS) capacitor c=1.725E-18
    I_C2287 (XI2_I3_I82_p1 VSS) capacitor c=2.530E-16
    I_C2288 (XI2_I3_I82_n1 VSS) capacitor c=3.678E-18
    I_C2289 (XI2_I1_I8_I31_XG_p1 VSS) capacitor c=2.551E-16
    I_C2290 (XI2_I1_I8_I31_XG_n1 VSS) capacitor c=3.433E-18
    I_C2291 (XI2_I1_I8_I29_XG_p1 VSS) capacitor c=2.343E-16
    I_C2292 (XI2_I1_I8_I29_XG_n1 VSS) capacitor c=1.023E-20
    I_C2293 (XI2_I1_I8_I30_XG_p1 VSS) capacitor c=2.526E-16
    I_C2294 (XI2_I1_I8_I30_XG_n1 VSS) capacitor c=3.983E-19
    I_C2295 (XI1_I132_I31_XG_p1 VSS) capacitor c=2.825E-16
    I_C2296 (XI1_I132_I28_XG_p1 VSS) capacitor c=2.630E-16
    I_C2297 (XI1_I132_I26_XG_p1 VSS) capacitor c=2.535E-16
    I_C2298 (XI1_I132_I26_XG_n1 VSS) capacitor c=3.130E-18
    I_C2299 (XI1_I38_p1 VSS) capacitor c=2.746E-16
    I_C2300 (XI1_I38_n1 VSS) capacitor c=1.327E-19
    I_C2301 (XI2_I1_I8_I27_XG_p1 VSS) capacitor c=2.619E-16
    I_C2302 (XI1_I132_I30_XG_p1 VSS) capacitor c=2.678E-16
    I_C2303 (XI1_I35_p1 VSS) capacitor c=2.601E-16
    I_C2304 (XI1_I35_n1 VSS) capacitor c=2.677E-18
    I_C2305 (XI2_I3_I70_p1 VSS) capacitor c=2.461E-16
    I_C2306 (XI2_I3_I70_n1 VSS) capacitor c=3.366E-19
    I_C2307 (XI2_I1_I8_I28_XG_p1 VSS) capacitor c=2.565E-16
    I_C2308 (XI1_I157_p1 VSS) capacitor c=2.500E-16
    I_C2309 (XI1_I157_n1 VSS) capacitor c=6.374E-19
    I_C2310 (XI2_I3_I58_p1 VSS) capacitor c=2.516E-16
    I_C2311 (XI2_I1_I8_I26_XG_p1 VSS) capacitor c=2.539E-16
    I_C2312 (XI2_I1_I8_I26_XG_n1 VSS) capacitor c=7.376E-18
    I_C2313 (XI1_I120_I26_XG_p1 VSS) capacitor c=2.670E-16
    I_C2314 (XI1_I120_I26_XG_n1 VSS) capacitor c=3.239E-18
    I_C2315 (XI1_I32_p1 VSS) capacitor c=2.634E-16
    I_C2316 (XI1_I32_n1 VSS) capacitor c=1.948E-18
    I_C2317 (XI2_I3_I22_p1 VSS) capacitor c=2.389E-16
    I_C2318 (XI2_I3_I22_n1 VSS) capacitor c=1.746E-18
    I_C2319 (XI2_I3_I46_p1 VSS) capacitor c=2.460E-16
    I_C2320 (XI2_I3_I46_n1 VSS) capacitor c=1.556E-18
    I_C2321 (XI2_I3_I34_p1 VSS) capacitor c=2.551E-16
    I_C2322 (XI1_I120_I31_XG_p1 VSS) capacitor c=2.441E-16
    I_C2323 (XI1_I120_I31_XG_n1 VSS) capacitor c=2.739E-19
    I_C2324 (XI1_I120_I29_XG_p1 VSS) capacitor c=2.541E-16
    I_C2325 (XI1_I120_I29_XG_n1 VSS) capacitor c=1.610E-18
    I_C2326 (XI1_I120_I27_XG_p1 VSS) capacitor c=2.363E-16
    I_C2327 (XI1_I120_I27_XG_n1 VSS) capacitor c=1.836E-18
    I_C2328 (XI1_I120_I30_XG_p1 VSS) capacitor c=2.164E-16
    I_C2329 (XI1_I120_I28_XG_p1 VSS) capacitor c=2.484E-16
    I_C2330 (XI1_I120_I28_XG_n1 VSS) capacitor c=8.701E-18
    I_C2331 (XI1_I160_p1 VSS) capacitor c=2.393E-16
    I_C2332 (XI1_I160_n1 VSS) capacitor c=6.365E-18
    I_C2333 (XI1_I29_p1 VSS) capacitor c=2.724E-16
    I_C2334 (XI1_I29_n1 VSS) capacitor c=4.146E-18
    I_C2335 (XI2_I3_I10_p1 VSS) capacitor c=2.554E-16
    I_C2336 (XI1_I163_p1 VSS) capacitor c=2.579E-16
    I_C2337 (XI1_I3_p1 VSS) capacitor c=2.755E-16
    I_C2338 (XI1_I3_n1 VSS) capacitor c=2.422E-18
    I_C2339 (XI1_I6_p1 VSS) capacitor c=2.539E-16
    I_C2340 (XI1_I6_n1 VSS) capacitor c=5.528E-18
    I_C2341 (XI1_I9_p1 VSS) capacitor c=2.609E-16
    I_C2342 (XI1_I9_n1 VSS) capacitor c=5.803E-18
    I_C2343 (XI1_I12_p1 VSS) capacitor c=2.655E-16
    I_C2344 (XI1_I12_n1 VSS) capacitor c=7.971E-19
    I_C2345 (XI1_I15_p1 VSS) capacitor c=2.483E-16
    I_C2346 (XI1_I15_n1 VSS) capacitor c=4.080E-18
    I_C2347 (XI1_I23_p1 VSS) capacitor c=2.682E-16
    I_C2348 (XI1_I23_n1 VSS) capacitor c=4.136E-18
    I_C2349 (XI1_I26_p1 VSS) capacitor c=2.666E-16
    I_C2350 (XI1_I26_n1 VSS) capacitor c=2.250E-18
    I_C2351 (XI1_I166_p1 VSS) capacitor c=2.722E-16
    I_C2352 (XI1_I169_p1 VSS) capacitor c=2.638E-16
    I_C2353 (XI1_I169_n1 VSS) capacitor c=7.285E-18
    I_C2354 (XI1_I172_p1 VSS) capacitor c=2.475E-16
    I_C2355 (XI1_I172_n1 VSS) capacitor c=3.432E-18
    I_C2356 (XI1_I18_p1 VSS) capacitor c=2.660E-16
    I_C2357 (XI1_I108_I28_XG_p1 VSS) capacitor c=2.669E-16
    I_C2358 (XI1_I108_I28_XG_n1 VSS) capacitor c=7.884E-19
    I_C2359 (XI1_I108_I26_XG_p1 VSS) capacitor c=2.624E-16
    I_C2360 (XI1_I108_I26_XG_n1 VSS) capacitor c=9.771E-19
    I_C2361 (XI1_I108_I27_XG_p1 VSS) capacitor c=2.630E-16
    I_C2362 (XI1_I108_I27_XG_n1 VSS) capacitor c=6.991E-19
    I_C2363 (XI1_I108_I30_XG_p1 VSS) capacitor c=2.733E-16
    I_C2364 (XI1_I108_I30_XG_n1 VSS) capacitor c=4.107E-19
    I_C2365 (XI1_I48_I26_XG_p1 VSS) capacitor c=2.694E-16
    I_C2366 (XI1_I108_I29_XG_p1 VSS) capacitor c=2.862E-16
    I_C2367 (XI1_I108_I29_XG_n1 VSS) capacitor c=2.969E-18
    I_C2368 (XI1_I96_I26_XG_p1 VSS) capacitor c=2.783E-16
    I_C2369 (XI1_I96_I26_XG_n1 VSS) capacitor c=3.516E-18
    I_C2370 (XI1_I84_I26_XG_p1 VSS) capacitor c=2.936E-16
    I_C2371 (XI1_I84_I28_XG_p1 VSS) capacitor c=2.523E-16
    I_C2372 (XI1_I84_I28_XG_n1 VSS) capacitor c=8.053E-19
    I_C2373 (XI1_I72_I26_XG_p1 VSS) capacitor c=2.896E-16
    I_C2374 (XI1_I72_I26_XG_n1 VSS) capacitor c=2.269E-18
    I_C2375 (XI1_I72_I28_XG_p1 VSS) capacitor c=2.709E-16
    I_C2376 (XI1_I72_I28_XG_n1 VSS) capacitor c=2.485E-18
    I_C2377 (XI1_I60_I26_XG_p1 VSS) capacitor c=2.767E-16
    I_C2378 (XI1_I60_I26_XG_n1 VSS) capacitor c=5.002E-20
    I_C2379 (XI1_I48_I28_XG_p1 VSS) capacitor c=2.677E-16
    I_C2380 (XI1_I48_I28_XG_n1 VSS) capacitor c=1.278E-17
    I_C2381 (XI1_I48_I27_XG_p1 VSS) capacitor c=2.557E-16
    I_C2382 (XI1_I108_I31_XG_p1 VSS) capacitor c=2.510E-16
    I_C2383 (XI1_I108_I31_XG_n1 VSS) capacitor c=1.525E-18
    I_C2384 (XI1_I96_I28_XG_p1 VSS) capacitor c=2.356E-16
    I_C2385 (XI1_I96_I28_XG_n1 VSS) capacitor c=1.060E-18
    I_C2386 (XI1_I84_I27_XG_p1 VSS) capacitor c=2.678E-16
    I_C2387 (XI1_I84_I27_XG_n1 VSS) capacitor c=3.784E-19
    I_C2388 (XI1_I72_I30_XG_p1 VSS) capacitor c=2.689E-16
    I_C2389 (XI1_I72_I30_XG_n1 VSS) capacitor c=1.584E-18
    I_C2390 (XI1_I60_I28_XG_p1 VSS) capacitor c=2.776E-16
    I_C2391 (XI1_I60_I28_XG_n1 VSS) capacitor c=2.590E-18
    I_C2392 (XI1_I60_I30_XG_p1 VSS) capacitor c=2.687E-16
    I_C2393 (XI1_I60_I30_XG_n1 VSS) capacitor c=7.963E-18
    I_C2394 (XI1_I48_I30_XG_p1 VSS) capacitor c=2.685E-16
    I_C2395 (XI1_I48_I30_XG_n1 VSS) capacitor c=6.670E-18
    I_C2396 (XI1_I48_I29_XG_p1 VSS) capacitor c=2.651E-16
    I_C2397 (XI1_I48_I29_XG_n1 VSS) capacitor c=3.773E-18
    I_C2398 (XI1_I96_I27_XG_p1 VSS) capacitor c=2.659E-16
    I_C2399 (XI1_I96_I27_XG_n1 VSS) capacitor c=6.131E-18
    I_C2400 (XI1_I96_I30_XG_p1 VSS) capacitor c=2.616E-16
    I_C2401 (XI1_I96_I30_XG_n1 VSS) capacitor c=5.663E-18
    I_C2402 (XI1_I84_I29_XG_p1 VSS) capacitor c=2.607E-16
    I_C2403 (XI1_I84_I30_XG_p1 VSS) capacitor c=2.576E-16
    I_C2404 (XI1_I84_I30_XG_n1 VSS) capacitor c=1.513E-18
    I_C2405 (XI1_I72_I27_XG_p1 VSS) capacitor c=2.648E-16
    I_C2406 (XI1_I72_I27_XG_n1 VSS) capacitor c=2.647E-18
    I_C2407 (XI1_I60_I27_XG_p1 VSS) capacitor c=2.501E-16
    I_C2408 (XI1_I60_I27_XG_n1 VSS) capacitor c=1.814E-18
    I_C2409 (XI1_I96_I29_XG_p1 VSS) capacitor c=2.648E-16
    I_C2410 (XI1_I96_I29_XG_n1 VSS) capacitor c=2.051E-19
    I_C2411 (XI1_I84_I31_XG_p1 VSS) capacitor c=2.518E-16
    I_C2412 (XI1_I84_I31_XG_n1 VSS) capacitor c=5.669E-18
    I_C2413 (XI1_I72_I29_XG_p1 VSS) capacitor c=2.694E-16
    I_C2414 (XI1_I72_I29_XG_n1 VSS) capacitor c=4.104E-18
    I_C2415 (XI1_I60_I29_XG_p1 VSS) capacitor c=2.758E-16
    I_C2416 (XI1_I60_I29_XG_n1 VSS) capacitor c=1.804E-18
    I_C2417 (XI1_I48_I31_XG_p1 VSS) capacitor c=2.648E-16
    I_C2418 (XI1_I48_I31_XG_n1 VSS) capacitor c=4.082E-18
    I_C2419 (XI1_I96_I31_XG_p1 VSS) capacitor c=2.852E-16
    I_C2420 (XI1_I96_I31_XG_n1 VSS) capacitor c=1.203E-20
    I_C2421 (XI1_I72_I31_XG_p1 VSS) capacitor c=2.843E-16
    I_C2422 (XI1_I60_I31_XG_p1 VSS) capacitor c=2.887E-16
    I_C2423 (XI1_I60_I31_XG_n1 VSS) capacitor c=2.445E-18
    I_C2424 (XI0_I77_I36_XG_p1 VSS) capacitor c=9.379E-18
    I_C2425 (XI0_I77_I36_XG_n1 VSS) capacitor c=2.884E-16
    I_C2426 (XI0_I77_I25_XG_p1 VSS) capacitor c=1.176E-17
    I_C2427 (XI0_I77_I25_XG_n1 VSS) capacitor c=2.881E-16
    I_C2428 (XI0_I77_I35_XG_p1 VSS) capacitor c=1.552E-17
    I_C2429 (XI0_I77_I35_XG_n1 VSS) capacitor c=2.904E-16
    I_C2430 (XI0_I77_I34_XG_p1 VSS) capacitor c=1.336E-17
    I_C2431 (XI0_I77_I34_XG_n1 VSS) capacitor c=3.289E-16
    I_C2432 (XI0_I77_I23_XG_p1 VSS) capacitor c=2.063E-17
    I_C2433 (XI0_I77_I23_XG_n1 VSS) capacitor c=3.206E-16
    I_C2434 (XI0_I77_I24_XG_n1 VSS) capacitor c=2.976E-16
    I_C2435 (XI1_I152_I34_XG_p1 VSS) capacitor c=7.335E-19
    I_C2436 (XI1_I152_I34_XG_n1 VSS) capacitor c=3.117E-16
    I_C2437 (XI0_I77_I32_XG_p1 VSS) capacitor c=1.178E-17
    I_C2438 (XI0_I77_I32_XG_n1 VSS) capacitor c=3.285E-16
    I_C2439 (XI0_I77_I22_XG_p1 VSS) capacitor c=5.120E-19
    I_C2440 (XI0_I77_I22_XG_n1 VSS) capacitor c=2.979E-16
    I_C2441 (XI0_I77_I21_XG_p1 VSS) capacitor c=1.290E-17
    I_C2442 (XI0_I77_I21_XG_n1 VSS) capacitor c=2.977E-16
    I_C2443 (XI1_I152_I25_XG_p1 VSS) capacitor c=8.806E-18
    I_C2444 (XI1_I152_I25_XG_n1 VSS) capacitor c=3.390E-16
    I_C2445 (XI1_I152_I36_XG_p1 VSS) capacitor c=2.856E-18
    I_C2446 (XI1_I152_I36_XG_n1 VSS) capacitor c=2.877E-16
    I_C2447 (XI1_I152_I35_XG_p1 VSS) capacitor c=1.080E-17
    I_C2448 (XI1_I152_I35_XG_n1 VSS) capacitor c=3.384E-16
    I_C2449 (XI0_I77_I19_XG_p1 VSS) capacitor c=1.637E-17
    I_C2450 (XI0_I77_I19_XG_n1 VSS) capacitor c=3.119E-16
    I_C2451 (XI0_I77_I20_XG_p1 VSS) capacitor c=2.165E-17
    I_C2452 (XI0_I77_I20_XG_n1 VSS) capacitor c=2.903E-16
    I_C2453 (XI1_I152_I24_XG_n1 VSS) capacitor c=2.892E-16
    I_C2454 (XI1_I152_I23_XG_p1 VSS) capacitor c=6.350E-18
    I_C2455 (XI1_I152_I23_XG_n1 VSS) capacitor c=2.920E-16
    I_C2456 (XI1_I152_I32_XG_p1 VSS) capacitor c=1.401E-18
    I_C2457 (XI1_I152_I32_XG_n1 VSS) capacitor c=3.028E-16
    I_C2458 (XI1_I152_I19_XG_p1 VSS) capacitor c=1.124E-18
    I_C2459 (XI1_I152_I19_XG_n1 VSS) capacitor c=2.965E-16
    I_C2460 (XI0_I77_I17_XG_p1 VSS) capacitor c=1.814E-17
    I_C2461 (XI0_I77_I17_XG_n1 VSS) capacitor c=2.948E-16
    I_C2462 (XI1_I152_I22_XG_p1 VSS) capacitor c=9.412E-18
    I_C2463 (XI1_I152_I22_XG_n1 VSS) capacitor c=2.700E-16
    I_C2464 (XI1_I152_I21_XG_p1 VSS) capacitor c=6.587E-18
    I_C2465 (XI1_I152_I21_XG_n1 VSS) capacitor c=2.986E-16
    I_C2466 (XI1_I152_I20_XG_p1 VSS) capacitor c=8.673E-18
    I_C2467 (XI1_I152_I20_XG_n1 VSS) capacitor c=3.097E-16
    I_C2468 (XI2_I1_I8_I25_XG_p1 VSS) capacitor c=9.438E-18
    I_C2469 (XI2_I1_I8_I25_XG_n1 VSS) capacitor c=3.064E-16
    I_C2470 (XI2_I1_I8_I24_XG_p1 VSS) capacitor c=9.643E-18
    I_C2471 (XI2_I1_I8_I24_XG_n1 VSS) capacitor c=3.034E-16
    I_C2472 (XI1_I132_I36_XG_p1 VSS) capacitor c=2.446E-18
    I_C2473 (XI1_I132_I36_XG_n1 VSS) capacitor c=3.119E-16
    I_C2474 (XI1_I132_I34_XG_p1 VSS) capacitor c=2.453E-18
    I_C2475 (XI1_I132_I34_XG_n1 VSS) capacitor c=3.189E-16
    I_C2476 (XI1_I152_I17_XG_p1 VSS) capacitor c=1.171E-17
    I_C2477 (XI1_I152_I17_XG_n1 VSS) capacitor c=3.149E-16
    I_C2478 (XI2_I1_I8_I36_XG_p1 VSS) capacitor c=1.827E-18
    I_C2479 (XI2_I1_I8_I36_XG_n1 VSS) capacitor c=3.135E-16
    I_C2480 (XI2_I1_I8_I35_XG_p1 VSS) capacitor c=8.882E-19
    I_C2481 (XI2_I1_I8_I35_XG_n1 VSS) capacitor c=3.142E-16
    I_C2482 (XI2_I1_I8_I23_XG_p1 VSS) capacitor c=1.248E-17
    I_C2483 (XI2_I1_I8_I23_XG_n1 VSS) capacitor c=2.937E-16
    I_C2484 (XI2_I1_I8_I22_XG_p1 VSS) capacitor c=1.015E-17
    I_C2485 (XI2_I1_I8_I22_XG_n1 VSS) capacitor c=3.003E-16
    I_C2486 (XI1_I132_I35_XG_p1 VSS) capacitor c=1.696E-17
    I_C2487 (XI1_I132_I35_XG_n1 VSS) capacitor c=3.017E-16
    I_C2488 (XI1_I132_I32_XG_p1 VSS) capacitor c=2.833E-18
    I_C2489 (XI1_I132_I32_XG_n1 VSS) capacitor c=2.776E-16
    I_C2490 (XI1_I132_I19_XG_p1 VSS) capacitor c=1.615E-17
    I_C2491 (XI1_I132_I19_XG_n1 VSS) capacitor c=3.257E-16
    I_C2492 (XI2_I1_I8_I34_XG_p1 VSS) capacitor c=1.200E-17
    I_C2493 (XI2_I1_I8_I34_XG_n1 VSS) capacitor c=3.299E-16
    I_C2494 (XI2_I1_I8_I21_XG_n1 VSS) capacitor c=3.209E-16
    I_C2495 (XI1_I132_I25_XG_p1 VSS) capacitor c=1.730E-17
    I_C2496 (XI1_I132_I25_XG_n1 VSS) capacitor c=2.973E-16
    I_C2497 (XI1_I132_I24_XG_p1 VSS) capacitor c=1.452E-17
    I_C2498 (XI1_I132_I24_XG_n1 VSS) capacitor c=2.902E-16
    I_C2499 (XI1_I132_I23_XG_p1 VSS) capacitor c=1.721E-19
    I_C2500 (XI1_I132_I23_XG_n1 VSS) capacitor c=3.128E-16
    I_C2501 (XI1_I132_I22_XG_p1 VSS) capacitor c=2.190E-18
    I_C2502 (XI1_I132_I22_XG_n1 VSS) capacitor c=3.045E-16
    I_C2503 (XI1_I132_I21_XG_p1 VSS) capacitor c=1.291E-17
    I_C2504 (XI1_I132_I21_XG_n1 VSS) capacitor c=3.051E-16
    I_C2505 (XI1_I132_I20_XG_p1 VSS) capacitor c=8.609E-18
    I_C2506 (XI1_I132_I20_XG_n1 VSS) capacitor c=3.143E-16
    I_C2507 (XI1_I132_I17_XG_p1 VSS) capacitor c=2.190E-18
    I_C2508 (XI1_I132_I17_XG_n1 VSS) capacitor c=2.976E-16
    I_C2509 (XI2_I1_I8_I32_XG_p1 VSS) capacitor c=1.069E-17
    I_C2510 (XI2_I1_I8_I32_XG_n1 VSS) capacitor c=2.992E-16
    I_C2511 (XI2_I1_I8_I17_XG_p1 VSS) capacitor c=1.211E-17
    I_C2512 (XI2_I1_I8_I17_XG_n1 VSS) capacitor c=3.262E-16
    I_C2513 (XI2_I1_I8_I19_XG_p1 VSS) capacitor c=2.961E-18
    I_C2514 (XI2_I1_I8_I19_XG_n1 VSS) capacitor c=3.294E-16
    I_C2515 (XI2_I1_I8_I20_XG_p1 VSS) capacitor c=7.321E-18
    I_C2516 (XI2_I1_I8_I20_XG_n1 VSS) capacitor c=2.722E-16
    I_C2517 (XI1_I120_I34_XG_p1 VSS) capacitor c=3.623E-18
    I_C2518 (XI1_I120_I34_XG_n1 VSS) capacitor c=2.941E-16
    I_C2519 (XI1_I120_I35_XG_p1 VSS) capacitor c=2.434E-18
    I_C2520 (XI1_I120_I35_XG_n1 VSS) capacitor c=2.853E-16
    I_C2521 (XI1_I120_I32_XG_p1 VSS) capacitor c=5.279E-18
    I_C2522 (XI1_I120_I32_XG_n1 VSS) capacitor c=3.141E-16
    I_C2523 (XI1_I120_I19_XG_p1 VSS) capacitor c=2.666E-18
    I_C2524 (XI1_I120_I19_XG_n1 VSS) capacitor c=3.099E-16
    I_C2525 (XI1_I120_I17_XG_p1 VSS) capacitor c=1.464E-17
    I_C2526 (XI1_I120_I17_XG_n1 VSS) capacitor c=2.967E-16
    I_C2527 (XI1_I120_I36_XG_p1 VSS) capacitor c=1.085E-17
    I_C2528 (XI1_I120_I36_XG_n1 VSS) capacitor c=2.762E-16
    I_C2529 (XI1_I120_I22_XG_p1 VSS) capacitor c=6.389E-18
    I_C2530 (XI1_I120_I22_XG_n1 VSS) capacitor c=3.089E-16
    I_C2531 (XI1_I120_I21_XG_p1 VSS) capacitor c=7.668E-18
    I_C2532 (XI1_I120_I21_XG_n1 VSS) capacitor c=3.102E-16
    I_C2533 (XI1_I120_I20_XG_p1 VSS) capacitor c=9.557E-18
    I_C2534 (XI1_I120_I20_XG_n1 VSS) capacitor c=2.832E-16
    I_C2535 (XI1_I120_I25_XG_p1 VSS) capacitor c=1.423E-17
    I_C2536 (XI1_I120_I25_XG_n1 VSS) capacitor c=3.106E-16
    I_C2537 (XI1_I120_I24_XG_p1 VSS) capacitor c=1.733E-17
    I_C2538 (XI1_I120_I24_XG_n1 VSS) capacitor c=2.703E-16
    I_C2539 (XI1_I120_I23_XG_p1 VSS) capacitor c=3.331E-18
    I_C2540 (XI1_I120_I23_XG_n1 VSS) capacitor c=3.307E-16
    I_C2541 (XI1_I108_I17_XG_p1 VSS) capacitor c=2.037E-18
    I_C2542 (XI1_I108_I17_XG_n1 VSS) capacitor c=2.652E-16
    I_C2543 (XI1_I108_I19_XG_p1 VSS) capacitor c=1.184E-17
    I_C2544 (XI1_I108_I19_XG_n1 VSS) capacitor c=2.977E-16
    I_C2545 (XI1_I96_I17_XG_p1 VSS) capacitor c=4.393E-18
    I_C2546 (XI1_I96_I17_XG_n1 VSS) capacitor c=2.658E-16
    I_C2547 (XI1_I84_I17_XG_p1 VSS) capacitor c=6.889E-18
    I_C2548 (XI1_I84_I17_XG_n1 VSS) capacitor c=2.792E-16
    I_C2549 (XI1_I108_I32_XG_n1 VSS) capacitor c=3.077E-16
    I_C2550 (XI1_I108_I20_XG_p1 VSS) capacitor c=3.087E-18
    I_C2551 (XI1_I108_I20_XG_n1 VSS) capacitor c=3.094E-16
    I_C2552 (XI1_I72_I17_XG_p1 VSS) capacitor c=1.206E-18
    I_C2553 (XI1_I72_I17_XG_n1 VSS) capacitor c=2.603E-16
    I_C2554 (XI1_I60_I17_XG_p1 VSS) capacitor c=3.188E-18
    I_C2555 (XI1_I60_I17_XG_n1 VSS) capacitor c=3.046E-16
    I_C2556 (XI1_I48_I17_XG_p1 VSS) capacitor c=2.087E-17
    I_C2557 (XI1_I48_I17_XG_n1 VSS) capacitor c=2.852E-16
    I_C2558 (XI1_I108_I35_XG_p1 VSS) capacitor c=5.286E-18
    I_C2559 (XI1_I108_I35_XG_n1 VSS) capacitor c=2.866E-16
    I_C2560 (XI1_I108_I22_XG_p1 VSS) capacitor c=1.174E-17
    I_C2561 (XI1_I108_I22_XG_n1 VSS) capacitor c=3.102E-16
    I_C2562 (XI1_I108_I21_XG_p1 VSS) capacitor c=4.926E-18
    I_C2563 (XI1_I108_I21_XG_n1 VSS) capacitor c=2.787E-16
    I_C2564 (XI1_I84_I19_XG_p1 VSS) capacitor c=4.550E-18
    I_C2565 (XI1_I84_I19_XG_n1 VSS) capacitor c=3.253E-16
    I_C2566 (XI1_I84_I20_XG_p1 VSS) capacitor c=5.702E-18
    I_C2567 (XI1_I84_I20_XG_n1 VSS) capacitor c=3.042E-16
    I_C2568 (XI1_I72_I19_XG_p1 VSS) capacitor c=4.321E-18
    I_C2569 (XI1_I72_I19_XG_n1 VSS) capacitor c=3.115E-16
    I_C2570 (XI1_I48_I19_XG_p1 VSS) capacitor c=8.911E-18
    I_C2571 (XI1_I48_I19_XG_n1 VSS) capacitor c=3.157E-16
    I_C2572 (XI1_I48_I20_XG_p1 VSS) capacitor c=5.338E-19
    I_C2573 (XI1_I48_I20_XG_n1 VSS) capacitor c=2.687E-16
    I_C2574 (XI1_I48_I21_XG_p1 VSS) capacitor c=4.476E-19
    I_C2575 (XI1_I48_I21_XG_n1 VSS) capacitor c=3.062E-16
    I_C2576 (XI1_I108_I34_XG_p1 VSS) capacitor c=6.734E-18
    I_C2577 (XI1_I108_I34_XG_n1 VSS) capacitor c=2.793E-16
    I_C2578 (XI1_I108_I36_XG_p1 VSS) capacitor c=3.682E-18
    I_C2579 (XI1_I108_I36_XG_n1 VSS) capacitor c=2.936E-16
    I_C2580 (XI1_I96_I19_XG_p1 VSS) capacitor c=6.134E-18
    I_C2581 (XI1_I96_I19_XG_n1 VSS) capacitor c=2.878E-16
    I_C2582 (XI1_I96_I20_XG_p1 VSS) capacitor c=3.234E-19
    I_C2583 (XI1_I96_I20_XG_n1 VSS) capacitor c=2.868E-16
    I_C2584 (XI1_I84_I32_XG_p1 VSS) capacitor c=2.916E-19
    I_C2585 (XI1_I84_I32_XG_n1 VSS) capacitor c=2.976E-16
    I_C2586 (XI1_I84_I21_XG_p1 VSS) capacitor c=1.381E-17
    I_C2587 (XI1_I84_I21_XG_n1 VSS) capacitor c=3.097E-16
    I_C2588 (XI1_I72_I32_XG_n1 VSS) capacitor c=3.117E-16
    I_C2589 (XI1_I72_I20_XG_p1 VSS) capacitor c=3.111E-18
    I_C2590 (XI1_I72_I20_XG_n1 VSS) capacitor c=2.736E-16
    I_C2591 (XI1_I60_I19_XG_p1 VSS) capacitor c=1.179E-17
    I_C2592 (XI1_I60_I19_XG_n1 VSS) capacitor c=2.920E-16
    I_C2593 (XI1_I60_I20_XG_p1 VSS) capacitor c=8.474E-18
    I_C2594 (XI1_I60_I20_XG_n1 VSS) capacitor c=2.942E-16
    I_C2595 (XI1_I48_I32_XG_p1 VSS) capacitor c=4.424E-19
    I_C2596 (XI1_I48_I32_XG_n1 VSS) capacitor c=2.949E-16
    I_C2597 (XI1_I48_I22_XG_p1 VSS) capacitor c=3.878E-18
    I_C2598 (XI1_I48_I22_XG_n1 VSS) capacitor c=3.065E-16
    I_C2599 (XI1_I108_I24_XG_p1 VSS) capacitor c=2.415E-18
    I_C2600 (XI1_I108_I24_XG_n1 VSS) capacitor c=3.121E-16
    I_C2601 (XI1_I108_I23_XG_p1 VSS) capacitor c=5.412E-18
    I_C2602 (XI1_I108_I23_XG_n1 VSS) capacitor c=3.194E-16
    I_C2603 (XI1_I96_I32_XG_p1 VSS) capacitor c=7.177E-20
    I_C2604 (XI1_I96_I32_XG_n1 VSS) capacitor c=3.073E-16
    I_C2605 (XI1_I96_I22_XG_p1 VSS) capacitor c=1.290E-17
    I_C2606 (XI1_I96_I22_XG_n1 VSS) capacitor c=3.011E-16
    I_C2607 (XI1_I96_I21_XG_p1 VSS) capacitor c=1.173E-17
    I_C2608 (XI1_I96_I21_XG_n1 VSS) capacitor c=2.958E-16
    I_C2609 (XI1_I84_I22_XG_p1 VSS) capacitor c=8.026E-18
    I_C2610 (XI1_I84_I22_XG_n1 VSS) capacitor c=3.284E-16
    I_C2611 (XI1_I72_I35_XG_p1 VSS) capacitor c=1.568E-17
    I_C2612 (XI1_I72_I35_XG_n1 VSS) capacitor c=2.972E-16
    I_C2613 (XI1_I72_I21_XG_p1 VSS) capacitor c=1.169E-17
    I_C2614 (XI1_I72_I21_XG_n1 VSS) capacitor c=3.056E-16
    I_C2615 (XI1_I72_I22_XG_p1 VSS) capacitor c=2.352E-18
    I_C2616 (XI1_I72_I22_XG_n1 VSS) capacitor c=2.927E-16
    I_C2617 (XI1_I60_I32_XG_p1 VSS) capacitor c=6.736E-18
    I_C2618 (XI1_I60_I32_XG_n1 VSS) capacitor c=2.903E-16
    I_C2619 (XI1_I60_I35_XG_p1 VSS) capacitor c=1.022E-17
    I_C2620 (XI1_I60_I35_XG_n1 VSS) capacitor c=2.783E-16
    I_C2621 (XI1_I60_I21_XG_p1 VSS) capacitor c=4.374E-18
    I_C2622 (XI1_I60_I21_XG_n1 VSS) capacitor c=2.873E-16
    I_C2623 (XI1_I60_I22_XG_p1 VSS) capacitor c=2.826E-17
    I_C2624 (XI1_I60_I22_XG_n1 VSS) capacitor c=3.187E-16
    I_C2625 (XI1_I48_I35_XG_p1 VSS) capacitor c=7.698E-18
    I_C2626 (XI1_I48_I35_XG_n1 VSS) capacitor c=3.151E-16
    I_C2627 (XI1_I48_I34_XG_p1 VSS) capacitor c=5.514E-20
    I_C2628 (XI1_I48_I34_XG_n1 VSS) capacitor c=3.208E-16
    I_C2629 (XI1_I108_I25_XG_n1 VSS) capacitor c=2.721E-16
    I_C2630 (XI1_I96_I35_XG_p1 VSS) capacitor c=5.056E-18
    I_C2631 (XI1_I96_I35_XG_n1 VSS) capacitor c=2.994E-16
    I_C2632 (XI1_I96_I24_XG_p1 VSS) capacitor c=5.779E-18
    I_C2633 (XI1_I96_I24_XG_n1 VSS) capacitor c=3.005E-16
    I_C2634 (XI1_I96_I23_XG_n1 VSS) capacitor c=2.981E-16
    I_C2635 (XI1_I84_I34_XG_p1 VSS) capacitor c=1.113E-17
    I_C2636 (XI1_I84_I34_XG_n1 VSS) capacitor c=3.196E-16
    I_C2637 (XI1_I84_I35_XG_p1 VSS) capacitor c=9.366E-18
    I_C2638 (XI1_I84_I35_XG_n1 VSS) capacitor c=3.090E-16
    I_C2639 (XI1_I84_I23_XG_p1 VSS) capacitor c=2.527E-18
    I_C2640 (XI1_I84_I23_XG_n1 VSS) capacitor c=3.157E-16
    I_C2641 (XI1_I72_I23_XG_p1 VSS) capacitor c=1.104E-17
    I_C2642 (XI1_I72_I23_XG_n1 VSS) capacitor c=3.100E-16
    I_C2643 (XI1_I72_I24_XG_p1 VSS) capacitor c=1.181E-17
    I_C2644 (XI1_I72_I24_XG_n1 VSS) capacitor c=2.969E-16
    I_C2645 (XI1_I60_I23_XG_p1 VSS) capacitor c=2.648E-18
    I_C2646 (XI1_I60_I23_XG_n1 VSS) capacitor c=3.243E-16
    I_C2647 (XI1_I60_I24_XG_p1 VSS) capacitor c=7.948E-18
    I_C2648 (XI1_I60_I24_XG_n1 VSS) capacitor c=3.233E-16
    I_C2649 (XI1_I48_I24_XG_p1 VSS) capacitor c=2.345E-17
    I_C2650 (XI1_I48_I24_XG_n1 VSS) capacitor c=2.981E-16
    I_C2651 (XI1_I48_I23_XG_p1 VSS) capacitor c=1.322E-17
    I_C2652 (XI1_I48_I23_XG_n1 VSS) capacitor c=3.449E-16
    I_C2653 (XI1_I96_I34_XG_p1 VSS) capacitor c=7.911E-18
    I_C2654 (XI1_I96_I34_XG_n1 VSS) capacitor c=2.963E-16
    I_C2655 (XI1_I84_I24_XG_p1 VSS) capacitor c=5.055E-18
    I_C2656 (XI1_I84_I24_XG_n1 VSS) capacitor c=3.053E-16
    I_C2657 (XI1_I84_I25_XG_p1 VSS) capacitor c=6.986E-19
    I_C2658 (XI1_I84_I25_XG_n1 VSS) capacitor c=2.862E-16
    I_C2659 (XI1_I72_I34_XG_p1 VSS) capacitor c=2.955E-18
    I_C2660 (XI1_I72_I34_XG_n1 VSS) capacitor c=3.205E-16
    I_C2661 (XI1_I60_I34_XG_p1 VSS) capacitor c=3.236E-19
    I_C2662 (XI1_I60_I34_XG_n1 VSS) capacitor c=3.107E-16
    I_C2663 (XI1_I48_I25_XG_p1 VSS) capacitor c=9.409E-18
    I_C2664 (XI1_I48_I25_XG_n1 VSS) capacitor c=3.036E-16
    I_C2665 (XI1_I48_I36_XG_p1 VSS) capacitor c=6.811E-18
    I_C2666 (XI1_I48_I36_XG_n1 VSS) capacitor c=2.801E-16
    I_C2667 (XI1_I96_I36_XG_p1 VSS) capacitor c=3.039E-18
    I_C2668 (XI1_I96_I36_XG_n1 VSS) capacitor c=2.625E-16
    I_C2669 (XI1_I96_I25_XG_p1 VSS) capacitor c=5.903E-18
    I_C2670 (XI1_I96_I25_XG_n1 VSS) capacitor c=2.732E-16
    I_C2671 (XI1_I84_I36_XG_p1 VSS) capacitor c=8.183E-18
    I_C2672 (XI1_I84_I36_XG_n1 VSS) capacitor c=2.899E-16
    I_C2673 (XI1_I72_I36_XG_p1 VSS) capacitor c=4.352E-18
    I_C2674 (XI1_I72_I36_XG_n1 VSS) capacitor c=2.887E-16
    I_C2675 (XI1_I72_I25_XG_p1 VSS) capacitor c=7.549E-19
    I_C2676 (XI1_I72_I25_XG_n1 VSS) capacitor c=2.672E-16
    I_C2677 (XI1_I60_I36_XG_p1 VSS) capacitor c=2.853E-19
    I_C2678 (XI1_I60_I36_XG_n1 VSS) capacitor c=3.025E-16
    I_C2679 (XI1_I60_I25_XG_p1 VSS) capacitor c=2.281E-18
    I_C2680 (XI1_I60_I25_XG_n1 VSS) capacitor c=3.165E-16
    I_C2681 (XI0_I42_p1 VSS) capacitor c=2.968E-16
    I_C2682 (XI0_I42_xp1 VSS) capacitor c=3.321E-16
    I_C2683 (XI0_I42_n2 VSS) capacitor c=5.362E-18
    I_C2684 (XI0_I42_n1 VSS) capacitor c=5.997E-16
    I_C2685 (XI0_I42_xn2 VSS) capacitor c=2.863E-18
    I_C2686 (XI0_I42_xn1 VSS) capacitor c=5.176E-16
    I_C2687 (XI0_I42_xn VSS) capacitor c=1.684E-15
    I_C2688 (XI0_I42_xan VSS) capacitor c=1.343E-15
    I_C2689 (XI0_I42_xbn VSS) capacitor c=6.665E-16
    I_C2690 (XI0_I30_p1 VSS) capacitor c=2.952E-16
    I_C2691 (XI0_I30_xp1 VSS) capacitor c=3.280E-16
    I_C2692 (XI0_I30_n2 VSS) capacitor c=3.967E-18
    I_C2693 (XI0_I30_n1 VSS) capacitor c=5.955E-16
    I_C2694 (XI0_I30_xn2 VSS) capacitor c=2.438E-18
    I_C2695 (XI0_I30_xn1 VSS) capacitor c=5.260E-16
    I_C2696 (XI0_I30_xn VSS) capacitor c=1.717E-15
    I_C2697 (XI0_I30_xan VSS) capacitor c=1.409E-15
    I_C2698 (XI0_I30_xbn VSS) capacitor c=6.665E-16
    I_C2699 (XI0_I31_p1 VSS) capacitor c=2.995E-16
    I_C2700 (XI0_I31_xp1 VSS) capacitor c=3.308E-16
    I_C2701 (XI0_I31_n2 VSS) capacitor c=5.073E-18
    I_C2702 (XI0_I31_n1 VSS) capacitor c=6.252E-16
    I_C2703 (XI0_I31_xn2 VSS) capacitor c=4.418E-18
    I_C2704 (XI0_I31_xn1 VSS) capacitor c=4.932E-16
    I_C2705 (XI0_I31_xn VSS) capacitor c=1.701E-15
    I_C2706 (XI0_I31_xan VSS) capacitor c=1.550E-15
    I_C2707 (XI0_I31_xbn VSS) capacitor c=6.928E-16
    I_C2708 (XI0_I40_p1 VSS) capacitor c=3.520E-16
    I_C2709 (XI0_I40_xp1 VSS) capacitor c=3.068E-16
    I_C2710 (XI0_I40_n2 VSS) capacitor c=5.847E-18
    I_C2711 (XI0_I40_n1 VSS) capacitor c=5.992E-16
    I_C2712 (XI0_I40_xn2 VSS) capacitor c=3.904E-18
    I_C2713 (XI0_I40_xn1 VSS) capacitor c=5.143E-16
    I_C2714 (XI0_I40_xn VSS) capacitor c=1.697E-15
    I_C2715 (XI0_I40_xan VSS) capacitor c=1.455E-15
    I_C2716 (XI0_I40_xbn VSS) capacitor c=6.520E-16
    I_C2717 (XI0_I41_p1 VSS) capacitor c=3.057E-16
    I_C2718 (XI0_I41_xp1 VSS) capacitor c=3.244E-16
    I_C2719 (XI0_I41_n2 VSS) capacitor c=5.589E-18
    I_C2720 (XI0_I41_n1 VSS) capacitor c=5.991E-16
    I_C2721 (XI0_I41_xn2 VSS) capacitor c=3.346E-18
    I_C2722 (XI0_I41_xn1 VSS) capacitor c=5.137E-16
    I_C2723 (XI0_I41_xn VSS) capacitor c=1.742E-15
    I_C2724 (XI0_I41_xan VSS) capacitor c=1.430E-15
    I_C2725 (XI0_I41_xbn VSS) capacitor c=6.317E-16
    I_C2726 (XI0_I29_p1 VSS) capacitor c=3.477E-16
    I_C2727 (XI0_I29_xp1 VSS) capacitor c=3.300E-16
    I_C2728 (XI0_I29_n2 VSS) capacitor c=6.583E-18
    I_C2729 (XI0_I29_n1 VSS) capacitor c=5.756E-16
    I_C2730 (XI0_I29_xn2 VSS) capacitor c=3.501E-18
    I_C2731 (XI0_I29_xn1 VSS) capacitor c=5.441E-16
    I_C2732 (XI0_I29_xn VSS) capacitor c=1.759E-15
    I_C2733 (XI0_I29_xan VSS) capacitor c=1.551E-15
    I_C2734 (XI0_I29_xbn VSS) capacitor c=6.610E-16
    I_C2735 (XI0_I20_p1 VSS) capacitor c=3.020E-16
    I_C2736 (XI0_I20_xp1 VSS) capacitor c=3.248E-16
    I_C2737 (XI0_I20_n2 VSS) capacitor c=5.437E-18
    I_C2738 (XI0_I20_n1 VSS) capacitor c=5.667E-16
    I_C2739 (XI0_I20_xn2 VSS) capacitor c=3.140E-18
    I_C2740 (XI0_I20_xn1 VSS) capacitor c=4.983E-16
    I_C2741 (XI0_I20_xn VSS) capacitor c=1.681E-15
    I_C2742 (XI0_I20_xan VSS) capacitor c=1.358E-15
    I_C2743 (XI0_I20_xbn VSS) capacitor c=6.767E-16
    I_C2744 (XI0_I28_p1 VSS) capacitor c=3.609E-16
    I_C2745 (XI0_I28_xp1 VSS) capacitor c=3.302E-16
    I_C2746 (XI0_I28_n2 VSS) capacitor c=7.380E-18
    I_C2747 (XI0_I28_n1 VSS) capacitor c=6.006E-16
    I_C2748 (XI0_I28_xn2 VSS) capacitor c=3.181E-18
    I_C2749 (XI0_I28_xn1 VSS) capacitor c=4.999E-16
    I_C2750 (XI0_I28_xn VSS) capacitor c=1.728E-15
    I_C2751 (XI0_I28_xan VSS) capacitor c=1.325E-15
    I_C2752 (XI0_I28_xbn VSS) capacitor c=6.791E-16
    I_C2753 (XI0_I19_p1 VSS) capacitor c=3.412E-16
    I_C2754 (XI0_I19_xp1 VSS) capacitor c=3.289E-16
    I_C2755 (XI0_I19_n2 VSS) capacitor c=6.270E-18
    I_C2756 (XI0_I19_n1 VSS) capacitor c=5.926E-16
    I_C2757 (XI0_I19_xn2 VSS) capacitor c=4.152E-18
    I_C2758 (XI0_I19_xn1 VSS) capacitor c=5.179E-16
    I_C2759 (XI0_I19_xn VSS) capacitor c=1.715E-15
    I_C2760 (XI0_I19_xan VSS) capacitor c=1.576E-15
    I_C2761 (XI0_I19_xbn VSS) capacitor c=6.601E-16
    I_C2762 (XI0_I38_p1 VSS) capacitor c=3.328E-16
    I_C2763 (XI0_I38_xp1 VSS) capacitor c=3.289E-16
    I_C2764 (XI0_I38_n2 VSS) capacitor c=5.420E-18
    I_C2765 (XI0_I38_n1 VSS) capacitor c=5.900E-16
    I_C2766 (XI0_I38_xn2 VSS) capacitor c=1.408E-17
    I_C2767 (XI0_I38_xn1 VSS) capacitor c=5.229E-16
    I_C2768 (XI0_I38_xn VSS) capacitor c=1.719E-15
    I_C2769 (XI0_I38_xan VSS) capacitor c=1.363E-15
    I_C2770 (XI0_I38_xbn VSS) capacitor c=6.753E-16
    I_C2771 (XI0_I39_p1 VSS) capacitor c=2.966E-16
    I_C2772 (XI0_I39_xp1 VSS) capacitor c=3.342E-16
    I_C2773 (XI0_I39_n2 VSS) capacitor c=6.973E-18
    I_C2774 (XI0_I39_n1 VSS) capacitor c=5.783E-16
    I_C2775 (XI0_I39_xn2 VSS) capacitor c=3.308E-18
    I_C2776 (XI0_I39_xn1 VSS) capacitor c=5.098E-16
    I_C2777 (XI0_I39_xn VSS) capacitor c=1.715E-15
    I_C2778 (XI0_I39_xan VSS) capacitor c=1.407E-15
    I_C2779 (XI0_I39_xbn VSS) capacitor c=6.694E-16
    I_C2780 (XI0_I18_p1 VSS) capacitor c=3.311E-16
    I_C2781 (XI0_I18_xp1 VSS) capacitor c=3.367E-16
    I_C2782 (XI0_I18_n2 VSS) capacitor c=5.284E-18
    I_C2783 (XI0_I18_n1 VSS) capacitor c=5.967E-16
    I_C2784 (XI0_I18_xn2 VSS) capacitor c=2.947E-18
    I_C2785 (XI0_I18_xn1 VSS) capacitor c=5.317E-16
    I_C2786 (XI0_I18_xn VSS) capacitor c=1.732E-15
    I_C2787 (XI0_I18_xan VSS) capacitor c=1.383E-15
    I_C2788 (XI0_I18_xbn VSS) capacitor c=6.561E-16
    I_C2789 (XI0_I27_p1 VSS) capacitor c=3.334E-16
    I_C2790 (XI0_I27_xp1 VSS) capacitor c=3.228E-16
    I_C2791 (XI0_I27_n2 VSS) capacitor c=5.424E-18
    I_C2792 (XI0_I27_n1 VSS) capacitor c=5.801E-16
    I_C2793 (XI0_I27_xn2 VSS) capacitor c=4.117E-18
    I_C2794 (XI0_I27_xn1 VSS) capacitor c=5.301E-16
    I_C2795 (XI0_I27_xn VSS) capacitor c=1.727E-15
    I_C2796 (XI0_I27_xan VSS) capacitor c=1.373E-15
    I_C2797 (XI0_I27_xbn VSS) capacitor c=6.882E-16
    I_C2798 (XI0_I37_p1 VSS) capacitor c=3.335E-16
    I_C2799 (XI0_I37_xp1 VSS) capacitor c=3.309E-16
    I_C2800 (XI0_I37_n2 VSS) capacitor c=5.701E-18
    I_C2801 (XI0_I37_n1 VSS) capacitor c=6.312E-16
    I_C2802 (XI0_I37_xn2 VSS) capacitor c=3.302E-18
    I_C2803 (XI0_I37_xn1 VSS) capacitor c=5.371E-16
    I_C2804 (XI0_I37_xn VSS) capacitor c=1.711E-15
    I_C2805 (XI0_I37_xan VSS) capacitor c=1.337E-15
    I_C2806 (XI0_I37_xbn VSS) capacitor c=6.223E-16
    I_C2807 (XI0_I26_p1 VSS) capacitor c=3.271E-16
    I_C2808 (XI0_I26_xp1 VSS) capacitor c=3.456E-16
    I_C2809 (XI0_I26_n2 VSS) capacitor c=7.486E-18
    I_C2810 (XI0_I26_n1 VSS) capacitor c=6.194E-16
    I_C2811 (XI0_I26_xn2 VSS) capacitor c=3.042E-18
    I_C2812 (XI0_I26_xn1 VSS) capacitor c=5.471E-16
    I_C2813 (XI0_I26_xn VSS) capacitor c=1.735E-15
    I_C2814 (XI0_I26_xan VSS) capacitor c=1.458E-15
    I_C2815 (XI0_I26_xbn VSS) capacitor c=6.882E-16
    I_C2816 (XI0_I36_p1 VSS) capacitor c=3.235E-16
    I_C2817 (XI0_I36_xp1 VSS) capacitor c=3.470E-16
    I_C2818 (XI0_I36_n2 VSS) capacitor c=5.278E-18
    I_C2819 (XI0_I36_n1 VSS) capacitor c=5.875E-16
    I_C2820 (XI0_I36_xn2 VSS) capacitor c=6.563E-18
    I_C2821 (XI0_I36_xn1 VSS) capacitor c=5.549E-16
    I_C2822 (XI0_I36_xn VSS) capacitor c=1.688E-15
    I_C2823 (XI0_I36_xan VSS) capacitor c=1.368E-15
    I_C2824 (XI0_I36_xbn VSS) capacitor c=6.964E-16
    I_C2825 (XI0_I15_p1 VSS) capacitor c=3.741E-16
    I_C2826 (XI0_I15_xp1 VSS) capacitor c=3.371E-16
    I_C2827 (XI0_I15_n2 VSS) capacitor c=8.608E-18
    I_C2828 (XI0_I15_n1 VSS) capacitor c=5.610E-16
    I_C2829 (XI0_I15_xn2 VSS) capacitor c=2.839E-18
    I_C2830 (XI0_I15_xn1 VSS) capacitor c=4.937E-16
    I_C2831 (XI0_I15_xn VSS) capacitor c=1.723E-15
    I_C2832 (XI0_I15_xan VSS) capacitor c=1.280E-15
    I_C2833 (XI0_I15_xbn VSS) capacitor c=6.535E-16
    I_C2834 (XI0_I17_p1 VSS) capacitor c=3.230E-16
    I_C2835 (XI0_I17_xp1 VSS) capacitor c=3.357E-16
    I_C2836 (XI0_I17_n2 VSS) capacitor c=5.545E-18
    I_C2837 (XI0_I17_n1 VSS) capacitor c=5.830E-16
    I_C2838 (XI0_I17_xn2 VSS) capacitor c=2.720E-18
    I_C2839 (XI0_I17_xn1 VSS) capacitor c=5.217E-16
    I_C2840 (XI0_I17_xn VSS) capacitor c=1.687E-15
    I_C2841 (XI0_I17_xan VSS) capacitor c=1.695E-15
    I_C2842 (XI0_I17_xbn VSS) capacitor c=6.617E-16
    I_C2843 (XI0_I25_p1 VSS) capacitor c=3.366E-16
    I_C2844 (XI0_I25_xp1 VSS) capacitor c=3.090E-16
    I_C2845 (XI0_I25_n2 VSS) capacitor c=4.994E-18
    I_C2846 (XI0_I25_n1 VSS) capacitor c=5.889E-16
    I_C2847 (XI0_I25_xn2 VSS) capacitor c=2.888E-18
    I_C2848 (XI0_I25_xn1 VSS) capacitor c=5.072E-16
    I_C2849 (XI0_I25_xn VSS) capacitor c=1.687E-15
    I_C2850 (XI0_I25_xan VSS) capacitor c=1.477E-15
    I_C2851 (XI0_I25_xbn VSS) capacitor c=6.700E-16
    I_C2852 (XI0_I34_p1 VSS) capacitor c=3.305E-16
    I_C2853 (XI0_I34_xp1 VSS) capacitor c=3.207E-16
    I_C2854 (XI0_I34_n2 VSS) capacitor c=5.013E-18
    I_C2855 (XI0_I34_n1 VSS) capacitor c=5.736E-16
    I_C2856 (XI0_I34_xn2 VSS) capacitor c=3.137E-18
    I_C2857 (XI0_I34_xn1 VSS) capacitor c=5.004E-16
    I_C2858 (XI0_I34_xn VSS) capacitor c=1.736E-15
    I_C2859 (XI0_I34_xan VSS) capacitor c=1.443E-15
    I_C2860 (XI0_I34_xbn VSS) capacitor c=6.537E-16
    I_C2861 (XI0_I35_p1 VSS) capacitor c=3.259E-16
    I_C2862 (XI0_I35_xp1 VSS) capacitor c=3.244E-16
    I_C2863 (XI0_I35_n2 VSS) capacitor c=5.394E-18
    I_C2864 (XI0_I35_n1 VSS) capacitor c=5.968E-16
    I_C2865 (XI0_I35_xn2 VSS) capacitor c=3.265E-18
    I_C2866 (XI0_I35_xn1 VSS) capacitor c=5.174E-16
    I_C2867 (XI0_I35_xn VSS) capacitor c=1.722E-15
    I_C2868 (XI0_I35_xan VSS) capacitor c=1.372E-15
    I_C2869 (XI0_I35_xbn VSS) capacitor c=6.790E-16
    I_C2870 (XI0_I14_p1 VSS) capacitor c=3.508E-16
    I_C2871 (XI0_I14_xp1 VSS) capacitor c=3.354E-16
    I_C2872 (XI0_I14_n2 VSS) capacitor c=9.482E-18
    I_C2873 (XI0_I14_n1 VSS) capacitor c=5.944E-16
    I_C2874 (XI0_I14_xn2 VSS) capacitor c=3.166E-18
    I_C2875 (XI0_I14_xn1 VSS) capacitor c=5.068E-16
    I_C2876 (XI0_I14_xn VSS) capacitor c=1.745E-15
    I_C2877 (XI0_I14_xan VSS) capacitor c=1.294E-15
    I_C2878 (XI0_I14_xbn VSS) capacitor c=6.339E-16
    I_C2879 (XI0_I24_p1 VSS) capacitor c=3.505E-16
    I_C2880 (XI0_I24_xp1 VSS) capacitor c=3.229E-16
    I_C2881 (XI0_I24_n2 VSS) capacitor c=5.382E-18
    I_C2882 (XI0_I24_n1 VSS) capacitor c=5.933E-16
    I_C2883 (XI0_I24_xn2 VSS) capacitor c=2.992E-18
    I_C2884 (XI0_I24_xn1 VSS) capacitor c=5.188E-16
    I_C2885 (XI0_I24_xn VSS) capacitor c=1.746E-15
    I_C2886 (XI0_I24_xan VSS) capacitor c=1.354E-15
    I_C2887 (XI0_I24_xbn VSS) capacitor c=6.470E-16
    I_C2888 (XI0_I16_p1 VSS) capacitor c=3.325E-16
    I_C2889 (XI0_I16_xp1 VSS) capacitor c=3.063E-16
    I_C2890 (XI0_I16_n2 VSS) capacitor c=5.772E-18
    I_C2891 (XI0_I16_n1 VSS) capacitor c=5.981E-16
    I_C2892 (XI0_I16_xn2 VSS) capacitor c=5.552E-18
    I_C2893 (XI0_I16_xn1 VSS) capacitor c=5.309E-16
    I_C2894 (XI0_I16_xn VSS) capacitor c=1.730E-15
    I_C2895 (XI0_I16_xan VSS) capacitor c=1.416E-15
    I_C2896 (XI0_I16_xbn VSS) capacitor c=6.423E-16
    I_C2897 (XI0_I23_p1 VSS) capacitor c=3.262E-16
    I_C2898 (XI0_I23_xp1 VSS) capacitor c=3.201E-16
    I_C2899 (XI0_I23_n2 VSS) capacitor c=7.179E-18
    I_C2900 (XI0_I23_n1 VSS) capacitor c=5.945E-16
    I_C2901 (XI0_I23_xn2 VSS) capacitor c=3.160E-18
    I_C2902 (XI0_I23_xn1 VSS) capacitor c=5.086E-16
    I_C2903 (XI0_I23_xn VSS) capacitor c=1.694E-15
    I_C2904 (XI0_I23_xan VSS) capacitor c=1.314E-15
    I_C2905 (XI0_I23_xbn VSS) capacitor c=6.506E-16
    I_C2906 (XI0_I6_p1 VSS) capacitor c=3.241E-16
    I_C2907 (XI0_I6_xp1 VSS) capacitor c=3.299E-16
    I_C2908 (XI0_I6_n2 VSS) capacitor c=4.912E-18
    I_C2909 (XI0_I6_n1 VSS) capacitor c=6.112E-16
    I_C2910 (XI0_I6_xn2 VSS) capacitor c=3.520E-18
    I_C2911 (XI0_I6_xn1 VSS) capacitor c=5.172E-16
    I_C2912 (XI0_I6_xn VSS) capacitor c=1.731E-15
    I_C2913 (XI0_I6_xan VSS) capacitor c=1.448E-15
    I_C2914 (XI0_I6_xbn VSS) capacitor c=6.485E-16
    I_C2915 (XI0_I8_p1 VSS) capacitor c=3.145E-16
    I_C2916 (XI0_I8_xp1 VSS) capacitor c=3.294E-16
    I_C2917 (XI0_I8_n2 VSS) capacitor c=5.161E-18
    I_C2918 (XI0_I8_n1 VSS) capacitor c=5.900E-16
    I_C2919 (XI0_I8_xn2 VSS) capacitor c=3.658E-18
    I_C2920 (XI0_I8_xn1 VSS) capacitor c=5.122E-16
    I_C2921 (XI0_I8_xn VSS) capacitor c=1.737E-15
    I_C2922 (XI0_I8_xan VSS) capacitor c=1.330E-15
    I_C2923 (XI0_I8_xbn VSS) capacitor c=6.630E-16
    I_C2924 (XI0_I12_p1 VSS) capacitor c=3.380E-16
    I_C2925 (XI0_I12_xp1 VSS) capacitor c=3.195E-16
    I_C2926 (XI0_I12_n2 VSS) capacitor c=5.704E-18
    I_C2927 (XI0_I12_n1 VSS) capacitor c=5.756E-16
    I_C2928 (XI0_I12_xn2 VSS) capacitor c=2.835E-18
    I_C2929 (XI0_I12_xn1 VSS) capacitor c=5.041E-16
    I_C2930 (XI0_I12_xn VSS) capacitor c=1.709E-15
    I_C2931 (XI0_I12_xan VSS) capacitor c=1.393E-15
    I_C2932 (XI0_I12_xbn VSS) capacitor c=6.538E-16
    I_C2933 (XI0_I13_p1 VSS) capacitor c=3.237E-16
    I_C2934 (XI0_I13_xp1 VSS) capacitor c=3.194E-16
    I_C2935 (XI0_I13_n2 VSS) capacitor c=5.682E-18
    I_C2936 (XI0_I13_n1 VSS) capacitor c=6.094E-16
    I_C2937 (XI0_I13_xn2 VSS) capacitor c=2.204E-18
    I_C2938 (XI0_I13_xn1 VSS) capacitor c=5.248E-16
    I_C2939 (XI0_I13_xn VSS) capacitor c=1.718E-15
    I_C2940 (XI0_I13_xan VSS) capacitor c=1.452E-15
    I_C2941 (XI0_I13_xbn VSS) capacitor c=6.643E-16
    I_C2942 (XI0_I5_p1 VSS) capacitor c=3.204E-16
    I_C2943 (XI0_I5_xp1 VSS) capacitor c=3.150E-16
    I_C2944 (XI0_I5_n2 VSS) capacitor c=5.582E-18
    I_C2945 (XI0_I5_n1 VSS) capacitor c=5.712E-16
    I_C2946 (XI0_I5_xn2 VSS) capacitor c=2.889E-18
    I_C2947 (XI0_I5_xn1 VSS) capacitor c=4.910E-16
    I_C2948 (XI0_I5_xn VSS) capacitor c=1.718E-15
    I_C2949 (XI0_I5_xan VSS) capacitor c=1.328E-15
    I_C2950 (XI0_I5_xbn VSS) capacitor c=6.642E-16
    I_C2951 (XI0_I9_p1 VSS) capacitor c=3.444E-16
    I_C2952 (XI0_I9_xp1 VSS) capacitor c=3.279E-16
    I_C2953 (XI0_I9_n2 VSS) capacitor c=5.599E-18
    I_C2954 (XI0_I9_n1 VSS) capacitor c=6.073E-16
    I_C2955 (XI0_I9_xn2 VSS) capacitor c=3.367E-18
    I_C2956 (XI0_I9_xn1 VSS) capacitor c=5.440E-16
    I_C2957 (XI0_I9_xn VSS) capacitor c=1.712E-15
    I_C2958 (XI0_I9_xan VSS) capacitor c=1.439E-15
    I_C2959 (XI0_I9_xbn VSS) capacitor c=6.545E-16
    I_C2960 (XI0_I7_p1 VSS) capacitor c=3.112E-16
    I_C2961 (XI0_I7_xp1 VSS) capacitor c=3.197E-16
    I_C2962 (XI0_I7_n2 VSS) capacitor c=5.685E-18
    I_C2963 (XI0_I7_n1 VSS) capacitor c=6.179E-16
    I_C2964 (XI0_I7_xn2 VSS) capacitor c=3.046E-18
    I_C2965 (XI0_I7_xn1 VSS) capacitor c=5.360E-16
    I_C2966 (XI0_I7_xn VSS) capacitor c=1.697E-15
    I_C2967 (XI0_I7_xan VSS) capacitor c=1.372E-15
    I_C2968 (XI0_I7_xbn VSS) capacitor c=5.891E-16
    I_C2969 (XI0_I4_p1 VSS) capacitor c=3.363E-16
    I_C2970 (XI0_I4_xp1 VSS) capacitor c=3.103E-16
    I_C2971 (XI0_I4_n2 VSS) capacitor c=5.664E-18
    I_C2972 (XI0_I4_n1 VSS) capacitor c=6.180E-16
    I_C2973 (XI0_I4_xn2 VSS) capacitor c=4.051E-18
    I_C2974 (XI0_I4_xn1 VSS) capacitor c=5.454E-16
    I_C2975 (XI0_I4_xn VSS) capacitor c=1.676E-15
    I_C2976 (XI0_I4_xan VSS) capacitor c=1.432E-15
    I_C2977 (XI0_I4_xbn VSS) capacitor c=6.224E-16
    I_C2978 (XI0_I2_p1 VSS) capacitor c=3.338E-16
    I_C2979 (XI0_I2_xp1 VSS) capacitor c=3.200E-16
    I_C2980 (XI0_I2_n2 VSS) capacitor c=7.314E-18
    I_C2981 (XI0_I2_n1 VSS) capacitor c=5.798E-16
    I_C2982 (XI0_I2_xn2 VSS) capacitor c=6.872E-18
    I_C2983 (XI0_I2_xn1 VSS) capacitor c=4.958E-16
    I_C2984 (XI0_I2_xn VSS) capacitor c=1.701E-15
    I_C2985 (XI0_I2_xan VSS) capacitor c=1.315E-15
    I_C2986 (XI0_I2_xbn VSS) capacitor c=6.661E-16
    I_C2987 (XI0_I1_p1 VSS) capacitor c=3.161E-16
    I_C2988 (XI0_I1_xp1 VSS) capacitor c=3.265E-16
    I_C2989 (XI0_I1_n2 VSS) capacitor c=5.759E-18
    I_C2990 (XI0_I1_n1 VSS) capacitor c=5.910E-16
    I_C2991 (XI0_I1_xn2 VSS) capacitor c=3.326E-18
    I_C2992 (XI0_I1_xn1 VSS) capacitor c=5.172E-16
    I_C2993 (XI0_I1_xn VSS) capacitor c=1.710E-15
    I_C2994 (XI0_I1_xan VSS) capacitor c=1.385E-15
    I_C2995 (XI0_I1_xbn VSS) capacitor c=6.267E-16
    I_C2996 (XI0_I3_p1 VSS) capacitor c=3.485E-16
    I_C2997 (XI0_I3_xp1 VSS) capacitor c=2.871E-16
    I_C2998 (XI0_I3_n2 VSS) capacitor c=5.378E-18
    I_C2999 (XI0_I3_n1 VSS) capacitor c=5.855E-16
    I_C3000 (XI0_I3_xn2 VSS) capacitor c=7.358E-18
    I_C3001 (XI0_I3_xn1 VSS) capacitor c=4.774E-16
    I_C3002 (XI0_I3_xn VSS) capacitor c=1.698E-15
    I_C3003 (XI0_I3_xan VSS) capacitor c=1.287E-15
    I_C3004 (XI0_I3_xbn VSS) capacitor c=6.225E-16
    I_C3005 (XI2_I3_I115_n1 VSS) capacitor c=6.862E-18
    I_C3006 (XI2_I3_I119_n1 VSS) capacitor c=9.573E-18
    I_C3007 (XI2_I3_I117_n1 VSS) capacitor c=4.643E-18
    I_C3008 (XI2_I3_I114_n1 VSS) capacitor c=2.595E-18
    I_C3009 (XI0_I77_I31_XP_n1 VSS) capacitor c=7.009E-18
    I_C3010 (XI0_I77_I7_n1 VSS) capacitor c=2.206E-18
    I_C3011 (XI2_I0_I5_n1 VSS) capacitor c=1.024E-18
    I_C3012 (XI2_I3_I118_n1 VSS) capacitor c=4.928E-19
    I_C3013 (XI2_I3_I112_n1 VSS) capacitor c=5.548E-19
    I_C3014 (XI2_I3_I113_n1 VSS) capacitor c=1.600E-18
    I_C3015 (XI2_I3_I109_n1 VSS) capacitor c=5.779E-18
    I_C3016 (XI2_I4_I11_n1 VSS) capacitor c=6.263E-18
    I_C3017 (XI2_I4_I10_n1 VSS) capacitor c=4.078E-18
    I_C3018 (XI2_I3_I111_n1 VSS) capacitor c=2.096E-18
    I_C3019 (XI2_I3_I108_n1 VSS) capacitor c=1.946E-18
    I_C3020 (XI0_I77_I30_XP_n1 VSS) capacitor c=1.834E-18
    I_C3021 (XI0_I77_I4_n1 VSS) capacitor c=2.082E-18
    I_C3022 (XI0_I77_I5_n1 VSS) capacitor c=5.780E-19
    I_C3023 (XI0_I77_I6_n1 VSS) capacitor c=2.660E-18
    I_C3024 (XI2_I3_I91_n1 VSS) capacitor c=5.570E-18
    I_C3025 (XI2_I3_I87_n1 VSS) capacitor c=2.625E-18
    I_C3026 (XI2_I3_I86_n1 VSS) capacitor c=1.192E-17
    I_C3027 (XI2_I0_I8_n1 VSS) capacitor c=7.786E-19
    I_C3028 (XI2_I0_I7_n1 VSS) capacitor c=5.927E-18
    I_C3029 (XI2_I3_I106_n1 VSS) capacitor c=5.833E-19
    I_C3030 (XI2_I3_I104_n1 VSS) capacitor c=4.677E-19
    I_C3031 (XI2_I3_I102_n1 VSS) capacitor c=5.871E-18
    I_C3032 (XI0_I77_I28_XP_n1 VSS) capacitor c=1.065E-17
    I_C3033 (XI0_I77_I3_n1 VSS) capacitor c=3.516E-18
    I_C3034 (XI2_I3_I85_n1 VSS) capacitor c=2.177E-18
    I_C3035 (XI2_I3_I90_n1 VSS) capacitor c=1.049E-18
    I_C3036 (XI2_I3_I84_n1 VSS) capacitor c=1.782E-18
    I_C3037 (XI2_I2_I42_n1 VSS) capacitor c=5.304E-18
    I_C3038 (XI2_I0_I10_n1 VSS) capacitor c=4.130E-18
    I_C3039 (XI2_I0_I9_n1 VSS) capacitor c=4.090E-18
    I_C3040 (XI2_I3_I66_n1 VSS) capacitor c=4.466E-18
    I_C3041 (XI2_I3_I60_n1 VSS) capacitor c=9.093E-20
    I_C3042 (XI2_I2_I30_n1 VSS) capacitor c=5.803E-18
    I_C3043 (XI2_I3_I100_n1 VSS) capacitor c=5.392E-20
    I_C3044 (XI2_I3_I101_n1 VSS) capacitor c=7.107E-19
    I_C3045 (XI0_I77_I1_n1 VSS) capacitor c=2.998E-18
    I_C3046 (XI0_I77_I2_n1 VSS) capacitor c=5.094E-19
    I_C3047 (XI2_I3_I73_n1 VSS) capacitor c=3.043E-18
    I_C3048 (XI2_I3_I78_n1 VSS) capacitor c=1.755E-18
    I_C3049 (XI2_I3_I79_n1 VSS) capacitor c=3.495E-20
    I_C3050 (XI2_I3_I75_n1 VSS) capacitor c=2.188E-18
    I_C3051 (XI2_I3_I63_n1 VSS) capacitor c=3.323E-18
    I_C3052 (XI2_I3_I37_n1 VSS) capacitor c=4.160E-18
    I_C3053 (XI2_I3_I67_n1 VSS) capacitor c=6.960E-18
    I_C3054 (XI2_I3_I42_n1 VSS) capacitor c=3.640E-18
    I_C3055 (XI2_I3_I36_n1 VSS) capacitor c=4.070E-18
    I_C3056 (XI2_I3_I61_n1 VSS) capacitor c=2.456E-18
    I_C3057 (XI2_I3_I39_n1 VSS) capacitor c=4.074E-18
    I_C3058 (XI2_I3_I62_n1 VSS) capacitor c=2.664E-18
    I_C3059 (XI2_I3_I43_n1 VSS) capacitor c=2.168E-18
    I_C3060 (XI1_I152_I7_n1 VSS) capacitor c=5.107E-19
    I_C3061 (XI1_I152_I6_n1 VSS) capacitor c=3.699E-18
    I_C3062 (XI1_I152_I28_XP_n1 VSS) capacitor c=2.006E-18
    I_C3063 (XI2_I3_I99_n1 VSS) capacitor c=5.929E-19
    I_C3064 (XI2_I3_I98_n1 VSS) capacitor c=8.515E-19
    I_C3065 (XI2_I3_I96_n1 VSS) capacitor c=2.078E-18
    I_C3066 (XI0_I77_I0_n1 VSS) capacitor c=2.163E-19
    I_C3067 (XI2_I2_I36_n1 VSS) capacitor c=3.401E-18
    I_C3068 (XI2_I3_I74_n1 VSS) capacitor c=8.410E-19
    I_C3069 (XI2_I1_I8_I6_n1 VSS) capacitor c=9.350E-19
    I_C3070 (XI2_I2_I18_n1 VSS) capacitor c=2.273E-18
    I_C3071 (XI1_I152_I4_n1 VSS) capacitor c=2.812E-19
    I_C3072 (XI1_I152_I2_n1 VSS) capacitor c=4.164E-18
    I_C3073 (XI1_I174_n1 VSS) capacitor c=4.386E-19
    I_C3074 (XI2_I3_I97_n1 VSS) capacitor c=1.228E-18
    I_C3075 (XI2_I3_I88_n1 VSS) capacitor c=2.535E-18
    I_C3076 (XI2_I3_I92_n1 VSS) capacitor c=4.247E-19
    I_C3077 (XI2_I3_I95_n1 VSS) capacitor c=2.101E-18
    I_C3078 (XI2_I1_I8_I7_n1 VSS) capacitor c=9.551E-20
    I_C3079 (XI2_I1_I8_I5_n1 VSS) capacitor c=2.397E-18
    I_C3080 (XI1_I132_I31_XP_n1 VSS) capacitor c=1.499E-18
    I_C3081 (XI1_I132_I29_XP_n1 VSS) capacitor c=2.615E-19
    I_C3082 (XI1_I152_I3_n1 VSS) capacitor c=4.653E-18
    I_C3083 (XI1_I152_I0_n1 VSS) capacitor c=8.154E-18
    I_C3084 (XI2_I3_I76_n1 VSS) capacitor c=2.898E-18
    I_C3085 (XI2_I3_I80_n1 VSS) capacitor c=4.851E-18
    I_C3086 (XI2_I3_I83_n1 VSS) capacitor c=3.820E-19
    I_C3087 (XI2_I1_I8_I31_XP_n1 VSS) capacitor c=2.295E-18
    I_C3088 (XI2_I1_I8_I3_n1 VSS) capacitor c=3.135E-18
    I_C3089 (XI1_I150_n1 VSS) capacitor c=7.362E-18
    I_C3090 (XI1_I132_I30_XP_n1 VSS) capacitor c=6.611E-19
    I_C3091 (XI1_I132_I28_XP_n1 VSS) capacitor c=1.377E-18
    I_C3092 (XI2_I4_I19_n1 VSS) capacitor c=3.458E-18
    I_C3093 (XI2_I4_I9_n1 VSS) capacitor c=7.582E-18
    I_C3094 (XI2_I3_I71_n1 VSS) capacitor c=4.533E-18
    I_C3095 (XI2_I4_I16_n1 VSS) capacitor c=5.961E-18
    I_C3096 (XI2_I1_I8_I30_XP_n1 VSS) capacitor c=1.133E-18
    I_C3097 (XI2_I1_I8_I4_n1 VSS) capacitor c=6.099E-19
    I_C3098 (XI1_I132_I7_n1 VSS) capacitor c=3.693E-18
    I_C3099 (XI1_I132_I6_n1 VSS) capacitor c=1.275E-18
    I_C3100 (XI1_I148_n1 VSS) capacitor c=1.174E-18
    I_C3101 (XI1_I132_I5_n1 VSS) capacitor c=1.055E-18
    I_C3102 (XI1_I132_I4_n1 VSS) capacitor c=4.083E-18
    I_C3103 (XI1_I132_I3_n1 VSS) capacitor c=3.274E-18
    I_C3104 (XI1_I132_I1_n1 VSS) capacitor c=1.527E-18
    I_C3105 (XI1_I138_n1 VSS) capacitor c=2.243E-18
    I_C3106 (XI2_I3_I64_n1 VSS) capacitor c=5.072E-20
    I_C3107 (XI2_I3_I68_n1 VSS) capacitor c=1.150E-18
    I_C3108 (XI2_I4_I21_n1 VSS) capacitor c=8.033E-18
    I_C3109 (XI2_I1_I8_I28_XP_n1 VSS) capacitor c=1.422E-18
    I_C3110 (XI1_I146_n1 VSS) capacitor c=1.192E-17
    I_C3111 (XI1_I144_n1 VSS) capacitor c=6.467E-18
    I_C3112 (XI1_I140_n1 VSS) capacitor c=7.615E-19
    I_C3113 (XI1_I154_n1 VSS) capacitor c=1.862E-18
    I_C3114 (XI2_I3_I65_n1 VSS) capacitor c=5.409E-18
    I_C3115 (XI2_I3_I52_n1 VSS) capacitor c=8.554E-19
    I_C3116 (XI1_I199_n1 VSS) capacitor c=3.890E-18
    I_C3117 (XI2_I4_I22_n1 VSS) capacitor c=3.382E-18
    I_C3118 (XI2_I1_I8_I0_n1 VSS) capacitor c=4.666E-18
    I_C3119 (XI2_I3_I59_n1 VSS) capacitor c=1.107E-17
    I_C3120 (XI2_I1_I8_I1_n1 VSS) capacitor c=1.366E-18
    I_C3121 (XI2_I1_I8_I2_n1 VSS) capacitor c=4.453E-19
    I_C3122 (XI1_I120_I30_XP_n1 VSS) capacitor c=3.820E-19
    I_C3123 (XI2_I3_I17_n1 VSS) capacitor c=1.243E-18
    I_C3124 (XI2_I3_I53_n1 VSS) capacitor c=6.357E-18
    I_C3125 (XI2_I3_I29_n1 VSS) capacitor c=3.566E-18
    I_C3126 (XI2_I3_I5_n1 VSS) capacitor c=4.421E-18
    I_C3127 (XI2_I3_I40_n1 VSS) capacitor c=5.431E-18
    I_C3128 (XI2_I3_I77_n1 VSS) capacitor c=7.331E-18
    I_C3129 (XI2_I3_I41_n1 VSS) capacitor c=3.756E-18
    I_C3130 (XI2_I3_I44_n1 VSS) capacitor c=1.084E-17
    I_C3131 (XI2_I3_I28_n1 VSS) capacitor c=2.580E-18
    I_C3132 (XI2_I3_I32_n1 VSS) capacitor c=4.239E-18
    I_C3133 (XI2_I3_I20_n1 VSS) capacitor c=3.392E-18
    I_C3134 (XI2_I3_I16_n1 VSS) capacitor c=3.525E-18
    I_C3135 (XI1_I202_n1 VSS) capacitor c=4.754E-18
    I_C3136 (XI2_I3_I4_n1 VSS) capacitor c=4.218E-18
    I_C3137 (XI2_I3_I8_n1 VSS) capacitor c=5.190E-18
    I_C3138 (XI1_I198_n1 VSS) capacitor c=9.823E-22
    I_C3139 (XI2_I4_I8_n1 VSS) capacitor c=2.309E-19
    I_C3140 (XI1_I120_I29_XP_n1 VSS) capacitor c=5.417E-18
    I_C3141 (XI1_I120_I31_XP_n1 VSS) capacitor c=4.223E-19
    I_C3142 (XI1_I120_I3_n1 VSS) capacitor c=2.939E-18
    I_C3143 (XI1_I120_I1_n1 VSS) capacitor c=2.458E-18
    I_C3144 (XI1_I0_n1 VSS) capacitor c=4.672E-18
    I_C3145 (XI2_I3_I11_n1 VSS) capacitor c=2.493E-18
    I_C3146 (XI2_I3_I3_n1 VSS) capacitor c=2.592E-19
    I_C3147 (XI2_I3_I23_n1 VSS) capacitor c=5.109E-18
    I_C3148 (XI2_I3_I35_n1 VSS) capacitor c=5.004E-19
    I_C3149 (XI2_I3_I51_n1 VSS) capacitor c=2.257E-18
    I_C3150 (XI2_I3_I50_n1 VSS) capacitor c=1.125E-18
    I_C3151 (XI1_I120_I6_n1 VSS) capacitor c=7.165E-20
    I_C3152 (XI1_I20_n1 VSS) capacitor c=2.501E-18
    I_C3153 (XI2_I2_I0_n1 VSS) capacitor c=3.215E-18
    I_C3154 (XI2_I3_I19_n1 VSS) capacitor c=8.634E-19
    I_C3155 (XI2_I3_I15_n1 VSS) capacitor c=4.557E-18
    I_C3156 (XI2_I2_I6_n1 VSS) capacitor c=2.517E-18
    I_C3157 (XI2_I3_I14_n1 VSS) capacitor c=3.096E-19
    I_C3158 (XI2_I3_I54_n1 VSS) capacitor c=2.828E-19
    I_C3159 (XI2_I3_I49_n1 VSS) capacitor c=4.575E-18
    I_C3160 (XI2_I3_I48_n1 VSS) capacitor c=4.022E-18
    I_C3161 (XI2_I2_I12_n1 VSS) capacitor c=5.907E-18
    I_C3162 (XI2_I2_I24_n1 VSS) capacitor c=3.560E-18
    I_C3163 (XI1_I120_I7_n1 VSS) capacitor c=2.224E-18
    I_C3164 (XI1_I120_I5_n1 VSS) capacitor c=4.177E-18
    I_C3165 (XI1_I108_I1_n1 VSS) capacitor c=1.853E-18
    I_C3166 (XI1_I96_I0_n1 VSS) capacitor c=4.980E-18
    I_C3167 (XI1_I84_I0_n1 VSS) capacitor c=3.433E-18
    I_C3168 (XI1_I60_I0_n1 VSS) capacitor c=5.237E-18
    I_C3169 (XI2_I3_I1_n1 VSS) capacitor c=2.309E-18
    I_C3170 (XI2_I3_I6_n1 VSS) capacitor c=1.686E-18
    I_C3171 (XI2_I3_I0_n1 VSS) capacitor c=4.093E-18
    I_C3172 (XI2_I3_I13_n1 VSS) capacitor c=3.830E-18
    I_C3173 (XI2_I3_I18_n1 VSS) capacitor c=6.347E-18
    I_C3174 (XI2_I3_I12_n1 VSS) capacitor c=4.355E-18
    I_C3175 (XI2_I3_I27_n1 VSS) capacitor c=1.022E-18
    I_C3176 (XI2_I3_I24_n1 VSS) capacitor c=4.518E-19
    I_C3177 (XI2_I3_I31_n1 VSS) capacitor c=3.659E-18
    I_C3178 (XI2_I3_I26_n1 VSS) capacitor c=1.403E-18
    I_C3179 (XI1_I108_I28_XP_n1 VSS) capacitor c=2.312E-19
    I_C3180 (XI1_I108_I2_n1 VSS) capacitor c=2.406E-19
    I_C3181 (XI1_I72_I0_n1 VSS) capacitor c=3.146E-18
    I_C3182 (XI1_I48_I0_n1 VSS) capacitor c=6.822E-20
    I_C3183 (XI1_I48_I2_n1 VSS) capacitor c=1.887E-18
    I_C3184 (XI2_I3_I25_n1 VSS) capacitor c=9.229E-18
    I_C3185 (XI1_I48_I3_n1 VSS) capacitor c=9.287E-18
    I_C3186 (XI1_I108_I29_XP_n1 VSS) capacitor c=5.803E-18
    I_C3187 (XI1_I108_I30_XP_n1 VSS) capacitor c=5.951E-19
    I_C3188 (XI1_I108_I3_n1 VSS) capacitor c=7.184E-19
    I_C3189 (XI1_I96_I2_n1 VSS) capacitor c=5.150E-18
    I_C3190 (XI1_I84_I1_n1 VSS) capacitor c=4.595E-19
    I_C3191 (XI1_I84_I2_n1 VSS) capacitor c=3.715E-18
    I_C3192 (XI1_I72_I1_n1 VSS) capacitor c=1.729E-18
    I_C3193 (XI1_I72_I2_n1 VSS) capacitor c=4.666E-18
    I_C3194 (XI1_I60_I1_n1 VSS) capacitor c=3.895E-18
    I_C3195 (XI1_I60_I2_n1 VSS) capacitor c=8.848E-19
    I_C3196 (XI1_I48_I1_n1 VSS) capacitor c=3.029E-18
    I_C3197 (XI1_I108_I31_XP_n1 VSS) capacitor c=1.618E-18
    I_C3198 (XI1_I108_I4_n1 VSS) capacitor c=4.826E-19
    I_C3199 (XI1_I96_I3_n1 VSS) capacitor c=7.197E-19
    I_C3200 (XI1_I84_I28_XP_n1 VSS) capacitor c=3.709E-18
    I_C3201 (XI1_I84_I3_n1 VSS) capacitor c=1.648E-18
    I_C3202 (XI1_I72_I28_XP_n1 VSS) capacitor c=3.891E-18
    I_C3203 (XI1_I72_I3_n1 VSS) capacitor c=7.454E-18
    I_C3204 (XI1_I60_I28_XP_n1 VSS) capacitor c=7.132E-18
    I_C3205 (XI1_I60_I3_n1 VSS) capacitor c=3.246E-18
    I_C3206 (XI1_I48_I28_XP_n1 VSS) capacitor c=3.731E-18
    I_C3207 (XI1_I48_I4_n1 VSS) capacitor c=1.636E-18
    I_C3208 (XI1_I108_I5_n1 VSS) capacitor c=5.004E-19
    I_C3209 (XI1_I96_I28_XP_n1 VSS) capacitor c=1.112E-18
    I_C3210 (XI1_I84_I4_n1 VSS) capacitor c=5.989E-18
    I_C3211 (XI1_I72_I4_n1 VSS) capacitor c=3.334E-18
    I_C3212 (XI1_I60_I30_XP_n1 VSS) capacitor c=3.082E-18
    I_C3213 (XI1_I60_I4_n1 VSS) capacitor c=1.573E-18
    I_C3214 (XI1_I48_I30_XP_n1 VSS) capacitor c=8.007E-18
    I_C3215 (XI1_I48_I29_XP_n1 VSS) capacitor c=6.701E-18
    I_C3216 (XI1_I108_I6_n1 VSS) capacitor c=3.311E-19
    I_C3217 (XI1_I96_I29_XP_n1 VSS) capacitor c=1.407E-17
    I_C3218 (XI1_I96_I30_XP_n1 VSS) capacitor c=2.565E-18
    I_C3219 (XI1_I96_I4_n1 VSS) capacitor c=1.029E-18
    I_C3220 (XI1_I84_I29_XP_n1 VSS) capacitor c=3.075E-19
    I_C3221 (XI1_I84_I5_n1 VSS) capacitor c=1.018E-17
    I_C3222 (XI1_I72_I6_n1 VSS) capacitor c=2.598E-20
    I_C3223 (XI1_I72_I5_n1 VSS) capacitor c=5.951E-19
    I_C3224 (XI1_I60_I5_n1 VSS) capacitor c=3.820E-19
    I_C3225 (XI1_I48_I5_n1 VSS) capacitor c=1.147E-19
    I_C3226 (XI1_I108_I7_n1 VSS) capacitor c=2.072E-18
    I_C3227 (XI1_I96_I31_XP_n1 VSS) capacitor c=3.526E-18
    I_C3228 (XI1_I84_I31_XP_n1 VSS) capacitor c=5.713E-18
    I_C3229 (XI1_I84_I7_n1 VSS) capacitor c=1.350E-18
    I_C3230 (XI1_I84_I6_n1 VSS) capacitor c=4.241E-18
    I_C3231 (XI1_I72_I29_XP_n1 VSS) capacitor c=2.558E-18
    I_C3232 (XI1_I72_I31_XP_n1 VSS) capacitor c=3.401E-19
    I_C3233 (XI1_I60_I29_XP_n1 VSS) capacitor c=2.045E-18
    I_C3234 (XI1_I60_I31_XP_n1 VSS) capacitor c=4.178E-18
    I_C3235 (XI1_I60_I6_n1 VSS) capacitor c=2.904E-18
    I_C3236 (XI1_I48_I6_n1 VSS) capacitor c=3.880E-18
    I_C3237 (XI1_I48_I31_XP_n1 VSS) capacitor c=2.820E-18
    I_C3238 (XI1_I96_I7_n1 VSS) capacitor c=3.591E-18
    I_C3239 (XI1_I72_I7_n1 VSS) capacitor c=1.500E-18
    I_C3240 (XI1_I60_I7_n1 VSS) capacitor c=2.235E-18
    I_C3241 (XI1_I48_I7_n1 VSS) capacitor c=3.172E-19
    I_C3242 (XI2_I4_I7_p1 VSS) capacitor c=6.220E-18
    I_C3243 (XI0_I77_I25_XP_p1 VSS) capacitor c=6.576E-18
    I_C3244 (XI2_I4_I6_p1 VSS) capacitor c=4.704E-18
    I_C3245 (XI2_I4_I5_p1 VSS) capacitor c=1.129E-17
    I_C3246 (XI2_I4_I13_p1 VSS) capacitor c=2.701E-18
    I_C3247 (XI0_I77_I24_XP_p1 VSS) capacitor c=1.900E-19
    I_C3248 (XI0_I77_I23_XP_p1 VSS) capacitor c=8.393E-18
    I_C3249 (XI2_I0_I17_p1 VSS) capacitor c=1.054E-17
    I_C3250 (XI2_I0_I16_p1 VSS) capacitor c=1.750E-17
    I_C3251 (XI2_I0_I15_p1 VSS) capacitor c=8.186E-18
    I_C3252 (XI2_I0_I14_p1 VSS) capacitor c=1.184E-17
    I_C3253 (XI0_I77_I22_XP_p1 VSS) capacitor c=7.099E-18
    I_C3254 (XI0_I77_I21_XP_p1 VSS) capacitor c=3.266E-18
    I_C3255 (XI2_I2_I44_p1 VSS) capacitor c=1.284E-18
    I_C3256 (XI2_I3_I93_p1 VSS) capacitor c=3.254E-18
    I_C3257 (XI2_I0_I11_p1 VSS) capacitor c=1.178E-17
    I_C3258 (XI2_I0_I12_p1 VSS) capacitor c=2.990E-19
    I_C3259 (XI1_I152_I25_XP_p1 VSS) capacitor c=1.519E-17
    I_C3260 (XI1_I152_I23_XP_p1 VSS) capacitor c=9.208E-18
    I_C3261 (XI1_I152_I21_XP_p1 VSS) capacitor c=2.210E-18
    I_C3262 (XI2_I4_I4_p1 VSS) capacitor c=9.905E-18
    I_C3263 (XI0_I77_I20_XP_p1 VSS) capacitor c=5.947E-18
    I_C3264 (XI2_I3_I81_p1 VSS) capacitor c=3.148E-18
    I_C3265 (XI2_I3_I69_p1 VSS) capacitor c=3.918E-18
    I_C3266 (XI2_I3_I45_p1 VSS) capacitor c=2.086E-18
    I_C3267 (XI2_I2_I32_p1 VSS) capacitor c=5.062E-18
    I_C3268 (XI1_I152_I24_XP_p1 VSS) capacitor c=6.091E-18
    I_C3269 (XI1_I152_I22_XP_p1 VSS) capacitor c=9.161E-18
    I_C3270 (XI1_I152_I20_XP_p1 VSS) capacitor c=2.044E-17
    I_C3271 (XI2_I2_I38_p1 VSS) capacitor c=1.914E-18
    I_C3272 (XI2_I1_I8_I25_XP_p1 VSS) capacitor c=5.201E-18
    I_C3273 (XI2_I1_I8_I24_XP_p1 VSS) capacitor c=5.384E-18
    I_C3274 (XI1_I132_I25_XP_p1 VSS) capacitor c=1.661E-18
    I_C3275 (XI1_I132_I23_XP_p1 VSS) capacitor c=1.545E-18
    I_C3276 (XI1_I132_I21_XP_p1 VSS) capacitor c=3.226E-18
    I_C3277 (XI2_I4_I3_p1 VSS) capacitor c=5.232E-18
    I_C3278 (XI2_I1_I8_I23_XP_p1 VSS) capacitor c=6.048E-18
    I_C3279 (XI1_I132_I24_XP_p1 VSS) capacitor c=1.216E-17
    I_C3280 (XI1_I132_I22_XP_p1 VSS) capacitor c=6.622E-18
    I_C3281 (XI1_I132_I20_XP_p1 VSS) capacitor c=9.072E-18
    I_C3282 (XI2_I4_I2_p1 VSS) capacitor c=4.386E-18
    I_C3283 (XI2_I1_I8_I22_XP_p1 VSS) capacitor c=7.234E-18
    I_C3284 (XI1_I197_p1 VSS) capacitor c=7.554E-18
    I_C3285 (XI2_I4_I12_p1 VSS) capacitor c=1.371E-17
    I_C3286 (XI1_I196_p1 VSS) capacitor c=8.488E-18
    I_C3287 (XI1_I203_p1 VSS) capacitor c=8.836E-18
    I_C3288 (XI2_I1_I8_I20_XP_p1 VSS) capacitor c=1.022E-17
    I_C3289 (XI1_I120_I24_XP_p1 VSS) capacitor c=8.148E-18
    I_C3290 (XI1_I120_I20_XP_p1 VSS) capacitor c=6.237E-18
    I_C3291 (XI1_I194_p1 VSS) capacitor c=1.593E-18
    I_C3292 (XI1_I200_p1 VSS) capacitor c=7.190E-18
    I_C3293 (XI1_I195_p1 VSS) capacitor c=6.117E-18
    I_C3294 (XI2_I4_I1_p1 VSS) capacitor c=4.870E-18
    I_C3295 (XI1_I120_I25_XP_p1 VSS) capacitor c=1.157E-17
    I_C3296 (XI1_I120_I23_XP_p1 VSS) capacitor c=3.969E-18
    I_C3297 (XI1_I120_I22_XP_p1 VSS) capacitor c=1.141E-18
    I_C3298 (XI1_I120_I21_XP_p1 VSS) capacitor c=9.226E-18
    I_C3299 (XI2_I3_I9_p1 VSS) capacitor c=1.208E-17
    I_C3300 (XI2_I4_I0_p1 VSS) capacitor c=3.907E-18
    I_C3301 (XI2_I3_I21_p1 VSS) capacitor c=9.058E-18
    I_C3302 (XI2_I3_I57_p1 VSS) capacitor c=1.531E-17
    I_C3303 (XI2_I2_I2_p1 VSS) capacitor c=1.235E-17
    I_C3304 (XI2_I3_I33_p1 VSS) capacitor c=7.641E-19
    I_C3305 (XI1_I108_I20_XP_p1 VSS) capacitor c=7.700E-18
    I_C3306 (XI2_I2_I14_p1 VSS) capacitor c=1.144E-17
    I_C3307 (XI1_I108_I21_XP_p1 VSS) capacitor c=7.754E-18
    I_C3308 (XI1_I84_I20_XP_p1 VSS) capacitor c=4.352E-18
    I_C3309 (XI1_I72_I20_XP_p1 VSS) capacitor c=6.257E-18
    I_C3310 (XI1_I108_I23_XP_p1 VSS) capacitor c=1.289E-17
    I_C3311 (XI1_I96_I20_XP_p1 VSS) capacitor c=2.213E-17
    I_C3312 (XI1_I84_I21_XP_p1 VSS) capacitor c=3.937E-18
    I_C3313 (XI1_I72_I21_XP_p1 VSS) capacitor c=2.873E-18
    I_C3314 (XI1_I60_I20_XP_p1 VSS) capacitor c=5.941E-19
    I_C3315 (XI1_I60_I21_XP_p1 VSS) capacitor c=3.371E-18
    I_C3316 (XI1_I48_I21_XP_p1 VSS) capacitor c=1.262E-17
    I_C3317 (XI1_I48_I22_XP_p1 VSS) capacitor c=3.624E-18
    I_C3318 (XI1_I96_I21_XP_p1 VSS) capacitor c=2.560E-18
    I_C3319 (XI1_I96_I22_XP_p1 VSS) capacitor c=4.516E-18
    I_C3320 (XI1_I84_I22_XP_p1 VSS) capacitor c=5.660E-18
    I_C3321 (XI1_I72_I22_XP_p1 VSS) capacitor c=5.278E-18
    I_C3322 (XI1_I60_I22_XP_p1 VSS) capacitor c=1.154E-17
    I_C3323 (XI1_I48_I24_XP_p1 VSS) capacitor c=1.082E-17
    I_C3324 (XI1_I48_I23_XP_p1 VSS) capacitor c=2.285E-18
    I_C3325 (XI1_I96_I23_XP_p1 VSS) capacitor c=1.019E-17
    I_C3326 (XI1_I96_I24_XP_p1 VSS) capacitor c=3.658E-18
    I_C3327 (XI1_I84_I23_XP_p1 VSS) capacitor c=3.252E-18
    I_C3328 (XI1_I84_I24_XP_p1 VSS) capacitor c=3.807E-18
    I_C3329 (XI1_I72_I24_XP_p1 VSS) capacitor c=1.534E-17
    I_C3330 (XI1_I72_I23_XP_p1 VSS) capacitor c=1.172E-17
    I_C3331 (XI1_I60_I24_XP_p1 VSS) capacitor c=6.484E-18
    I_C3332 (XI1_I60_I23_XP_p1 VSS) capacitor c=6.787E-18
    I_C3333 (XI1_I96_I25_XP_p1 VSS) capacitor c=3.835E-18
    I_C3334 (XI1_I84_I25_XP_p1 VSS) capacitor c=5.724E-18
    I_C3335 (XI1_I72_I25_XP_p1 VSS) capacitor c=7.138E-18
    I_C3336 (XI1_I60_I25_XP_p1 VSS) capacitor c=1.309E-17
    I_C3337 (XI1_I48_I25_XP_p1 VSS) capacitor c=5.461E-18
    I_C3338 (XI0_I53_bp5 VSS) capacitor c=3.853E-16
    I_C3339 (XI0_I53_bp4 VSS) capacitor c=8.331E-16
    I_C3340 (XI0_I53_bp3 VSS) capacitor c=6.044E-16
    I_C3341 (XI0_I53_bp2 VSS) capacitor c=3.281E-16
    I_C3342 (XI0_I53_bp1 VSS) capacitor c=8.020E-18
    I_C3343 (XI0_I53_ap4 VSS) capacitor c=5.532E-16
    I_C3344 (XI0_I53_ap5 VSS) capacitor c=8.374E-16
    I_C3345 (XI0_I53_ap3 VSS) capacitor c=7.555E-16
    I_C3346 (XI0_I53_ap1 VSS) capacitor c=1.310E-17
    I_C3347 (XI0_I53_ap2 VSS) capacitor c=6.692E-16
    I_C3348 (XI0_I53_bn5 VSS) capacitor c=4.452E-16
    I_C3349 (XI0_I53_bn3 VSS) capacitor c=4.542E-16
    I_C3350 (XI0_I53_bn4 VSS) capacitor c=9.674E-16
    I_C3351 (XI0_I53_bn2 VSS) capacitor c=4.159E-16
    I_C3352 (XI0_I53_an5 VSS) capacitor c=7.035E-16
    I_C3353 (XI0_I53_an4 VSS) capacitor c=7.315E-16
    I_C3354 (XI0_I53_an3 VSS) capacitor c=6.570E-16
    I_C3355 (XI0_I53_an1 VSS) capacitor c=4.945E-18
    I_C3356 (XI0_I53_an2 VSS) capacitor c=4.292E-16
    I_C3357 (XI0_I53_bsn VSS) capacitor c=1.333E-15
    I_C3358 (XI0_I53_bcon VSS) capacitor c=2.180E-15
    I_C3359 (XI0_I53_s1 VSS) capacitor c=2.623E-15
    I_C3360 (XI0_I53_asn VSS) capacitor c=1.554E-15
    I_C3361 (XI0_I53_acon VSS) capacitor c=2.295E-15
    I_C3362 (XI0_I54_bp5 VSS) capacitor c=3.788E-16
    I_C3363 (XI0_I54_bp4 VSS) capacitor c=8.353E-16
    I_C3364 (XI0_I54_bp3 VSS) capacitor c=6.189E-16
    I_C3365 (XI0_I54_bp2 VSS) capacitor c=3.233E-16
    I_C3366 (XI0_I54_bp1 VSS) capacitor c=2.224E-18
    I_C3367 (XI0_I54_ap4 VSS) capacitor c=5.153E-16
    I_C3368 (XI0_I54_ap5 VSS) capacitor c=7.716E-16
    I_C3369 (XI0_I54_ap3 VSS) capacitor c=7.795E-16
    I_C3370 (XI0_I54_ap1 VSS) capacitor c=1.218E-17
    I_C3371 (XI0_I54_ap2 VSS) capacitor c=6.564E-16
    I_C3372 (XI0_I54_bn5 VSS) capacitor c=4.478E-16
    I_C3373 (XI0_I54_bn3 VSS) capacitor c=4.330E-16
    I_C3374 (XI0_I54_bn4 VSS) capacitor c=7.586E-16
    I_C3375 (XI0_I54_bn2 VSS) capacitor c=4.233E-16
    I_C3376 (XI0_I54_bn1 VSS) capacitor c=3.820E-19
    I_C3377 (XI0_I54_an5 VSS) capacitor c=6.918E-16
    I_C3378 (XI0_I54_an4 VSS) capacitor c=7.685E-16
    I_C3379 (XI0_I54_an3 VSS) capacitor c=7.209E-16
    I_C3380 (XI0_I54_an1 VSS) capacitor c=5.047E-18
    I_C3381 (XI0_I54_an2 VSS) capacitor c=4.820E-16
    I_C3382 (XI0_I54_bsn VSS) capacitor c=1.333E-15
    I_C3383 (XI0_I54_bcon VSS) capacitor c=2.165E-15
    I_C3384 (XI0_I54_s1 VSS) capacitor c=2.604E-15
    I_C3385 (XI0_I54_asn VSS) capacitor c=1.644E-15
    I_C3386 (XI0_I54_acon VSS) capacitor c=2.302E-15
    I_C3387 (XI0_I52_bp5 VSS) capacitor c=3.936E-16
    I_C3388 (XI0_I52_bp4 VSS) capacitor c=8.281E-16
    I_C3389 (XI0_I52_bp3 VSS) capacitor c=6.340E-16
    I_C3390 (XI0_I52_bp2 VSS) capacitor c=3.473E-16
    I_C3391 (XI0_I52_bp1 VSS) capacitor c=5.154E-18
    I_C3392 (XI0_I52_ap4 VSS) capacitor c=5.227E-16
    I_C3393 (XI0_I52_ap5 VSS) capacitor c=7.391E-16
    I_C3394 (XI0_I52_ap3 VSS) capacitor c=7.582E-16
    I_C3395 (XI0_I52_ap1 VSS) capacitor c=1.310E-17
    I_C3396 (XI0_I52_ap2 VSS) capacitor c=6.464E-16
    I_C3397 (XI0_I52_bn5 VSS) capacitor c=4.382E-16
    I_C3398 (XI0_I52_bn3 VSS) capacitor c=4.337E-16
    I_C3399 (XI0_I52_bn4 VSS) capacitor c=8.088E-16
    I_C3400 (XI0_I52_bn2 VSS) capacitor c=4.148E-16
    I_C3401 (XI0_I52_bn1 VSS) capacitor c=2.865E-19
    I_C3402 (XI0_I52_an5 VSS) capacitor c=7.147E-16
    I_C3403 (XI0_I52_an4 VSS) capacitor c=7.483E-16
    I_C3404 (XI0_I52_an3 VSS) capacitor c=6.537E-16
    I_C3405 (XI0_I52_an1 VSS) capacitor c=3.718E-18
    I_C3406 (XI0_I52_an2 VSS) capacitor c=4.228E-16
    I_C3407 (XI0_I52_bsn VSS) capacitor c=1.359E-15
    I_C3408 (XI0_I52_bcon VSS) capacitor c=2.149E-15
    I_C3409 (XI0_I52_s1 VSS) capacitor c=2.627E-15
    I_C3410 (XI0_I52_asn VSS) capacitor c=1.588E-15
    I_C3411 (XI0_I52_acon VSS) capacitor c=2.266E-15
    I_C3412 (XI0_I51_bp5 VSS) capacitor c=3.757E-16
    I_C3413 (XI0_I51_bp4 VSS) capacitor c=8.169E-16
    I_C3414 (XI0_I51_bp3 VSS) capacitor c=6.211E-16
    I_C3415 (XI0_I51_bp2 VSS) capacitor c=3.489E-16
    I_C3416 (XI0_I51_ap4 VSS) capacitor c=5.217E-16
    I_C3417 (XI0_I51_ap5 VSS) capacitor c=7.129E-16
    I_C3418 (XI0_I51_ap3 VSS) capacitor c=7.780E-16
    I_C3419 (XI0_I51_ap1 VSS) capacitor c=9.335E-18
    I_C3420 (XI0_I51_ap2 VSS) capacitor c=6.762E-16
    I_C3421 (XI0_I51_bn5 VSS) capacitor c=4.420E-16
    I_C3422 (XI0_I51_bn3 VSS) capacitor c=4.585E-16
    I_C3423 (XI0_I51_bn4 VSS) capacitor c=7.892E-16
    I_C3424 (XI0_I51_bn2 VSS) capacitor c=4.213E-16
    I_C3425 (XI0_I51_bn1 VSS) capacitor c=1.774E-19
    I_C3426 (XI0_I51_an5 VSS) capacitor c=6.787E-16
    I_C3427 (XI0_I51_an4 VSS) capacitor c=7.630E-16
    I_C3428 (XI0_I51_an3 VSS) capacitor c=6.828E-16
    I_C3429 (XI0_I51_an1 VSS) capacitor c=2.835E-18
    I_C3430 (XI0_I51_an2 VSS) capacitor c=4.875E-16
    I_C3431 (XI0_I51_bsn VSS) capacitor c=1.351E-15
    I_C3432 (XI0_I51_bcon VSS) capacitor c=2.174E-15
    I_C3433 (XI0_I51_s1 VSS) capacitor c=2.644E-15
    I_C3434 (XI0_I51_asn VSS) capacitor c=1.776E-15
    I_C3435 (XI0_I51_acon VSS) capacitor c=2.336E-15
    I_C3436 (XI0_I50_bp5 VSS) capacitor c=4.033E-16
    I_C3437 (XI0_I50_bp4 VSS) capacitor c=8.169E-16
    I_C3438 (XI0_I50_bp3 VSS) capacitor c=6.168E-16
    I_C3439 (XI0_I50_bp2 VSS) capacitor c=3.163E-16
    I_C3440 (XI0_I50_bp1 VSS) capacitor c=5.636E-18
    I_C3441 (XI0_I50_ap4 VSS) capacitor c=5.174E-16
    I_C3442 (XI0_I50_ap5 VSS) capacitor c=7.318E-16
    I_C3443 (XI0_I50_ap3 VSS) capacitor c=7.657E-16
    I_C3444 (XI0_I50_ap1 VSS) capacitor c=1.199E-17
    I_C3445 (XI0_I50_ap2 VSS) capacitor c=7.008E-16
    I_C3446 (XI0_I50_bn5 VSS) capacitor c=4.638E-16
    I_C3447 (XI0_I50_bn3 VSS) capacitor c=4.485E-16
    I_C3448 (XI0_I50_bn4 VSS) capacitor c=7.755E-16
    I_C3449 (XI0_I50_bn2 VSS) capacitor c=4.167E-16
    I_C3450 (XI0_I50_an5 VSS) capacitor c=6.836E-16
    I_C3451 (XI0_I50_an4 VSS) capacitor c=8.042E-16
    I_C3452 (XI0_I50_an3 VSS) capacitor c=6.800E-16
    I_C3453 (XI0_I50_an1 VSS) capacitor c=3.718E-18
    I_C3454 (XI0_I50_an2 VSS) capacitor c=4.945E-16
    I_C3455 (XI0_I50_bsn VSS) capacitor c=1.376E-15
    I_C3456 (XI0_I50_bcon VSS) capacitor c=2.176E-15
    I_C3457 (XI0_I50_s1 VSS) capacitor c=2.587E-15
    I_C3458 (XI0_I50_asn VSS) capacitor c=1.713E-15
    I_C3459 (XI0_I50_acon VSS) capacitor c=2.315E-15
    I_C3460 (XI0_I49_bp5 VSS) capacitor c=3.923E-16
    I_C3461 (XI0_I49_bp4 VSS) capacitor c=8.321E-16
    I_C3462 (XI0_I49_bp3 VSS) capacitor c=6.305E-16
    I_C3463 (XI0_I49_bp2 VSS) capacitor c=3.310E-16
    I_C3464 (XI0_I49_bp1 VSS) capacitor c=3.162E-18
    I_C3465 (XI0_I49_ap4 VSS) capacitor c=5.145E-16
    I_C3466 (XI0_I49_ap5 VSS) capacitor c=7.379E-16
    I_C3467 (XI0_I49_ap3 VSS) capacitor c=7.605E-16
    I_C3468 (XI0_I49_ap1 VSS) capacitor c=7.808E-18
    I_C3469 (XI0_I49_ap2 VSS) capacitor c=6.797E-16
    I_C3470 (XI0_I49_bn5 VSS) capacitor c=4.433E-16
    I_C3471 (XI0_I49_bn3 VSS) capacitor c=4.259E-16
    I_C3472 (XI0_I49_bn4 VSS) capacitor c=7.458E-16
    I_C3473 (XI0_I49_bn2 VSS) capacitor c=4.187E-16
    I_C3474 (XI0_I49_bn1 VSS) capacitor c=2.411E-19
    I_C3475 (XI0_I49_an5 VSS) capacitor c=6.915E-16
    I_C3476 (XI0_I49_an4 VSS) capacitor c=7.880E-16
    I_C3477 (XI0_I49_an3 VSS) capacitor c=6.906E-16
    I_C3478 (XI0_I49_an1 VSS) capacitor c=3.347E-18
    I_C3479 (XI0_I49_an2 VSS) capacitor c=4.709E-16
    I_C3480 (XI0_I49_bsn VSS) capacitor c=1.326E-15
    I_C3481 (XI0_I49_bcon VSS) capacitor c=2.150E-15
    I_C3482 (XI0_I49_s1 VSS) capacitor c=2.601E-15
    I_C3483 (XI0_I49_asn VSS) capacitor c=1.671E-15
    I_C3484 (XI0_I49_acon VSS) capacitor c=2.306E-15
    I_C3485 (XI0_I48_bp5 VSS) capacitor c=3.865E-16
    I_C3486 (XI0_I48_bp4 VSS) capacitor c=8.344E-16
    I_C3487 (XI0_I48_bp3 VSS) capacitor c=6.000E-16
    I_C3488 (XI0_I48_bp2 VSS) capacitor c=3.386E-16
    I_C3489 (XI0_I48_bp1 VSS) capacitor c=3.087E-19
    I_C3490 (XI0_I48_ap4 VSS) capacitor c=5.348E-16
    I_C3491 (XI0_I48_ap5 VSS) capacitor c=7.833E-16
    I_C3492 (XI0_I48_ap3 VSS) capacitor c=7.738E-16
    I_C3493 (XI0_I48_ap1 VSS) capacitor c=1.039E-17
    I_C3494 (XI0_I48_ap2 VSS) capacitor c=6.563E-16
    I_C3495 (XI0_I48_bn5 VSS) capacitor c=4.451E-16
    I_C3496 (XI0_I48_bn3 VSS) capacitor c=4.514E-16
    I_C3497 (XI0_I48_bn4 VSS) capacitor c=8.097E-16
    I_C3498 (XI0_I48_bn2 VSS) capacitor c=4.296E-16
    I_C3499 (XI0_I48_bn1 VSS) capacitor c=9.551E-20
    I_C3500 (XI0_I48_an5 VSS) capacitor c=7.105E-16
    I_C3501 (XI0_I48_an4 VSS) capacitor c=7.600E-16
    I_C3502 (XI0_I48_an3 VSS) capacitor c=6.915E-16
    I_C3503 (XI0_I48_an1 VSS) capacitor c=6.176E-18
    I_C3504 (XI0_I48_an2 VSS) capacitor c=4.295E-16
    I_C3505 (XI0_I48_bsn VSS) capacitor c=1.289E-15
    I_C3506 (XI0_I48_bcon VSS) capacitor c=2.152E-15
    I_C3507 (XI0_I48_s1 VSS) capacitor c=2.637E-15
    I_C3508 (XI0_I48_asn VSS) capacitor c=1.677E-15
    I_C3509 (XI0_I48_acon VSS) capacitor c=2.283E-15
    I_C3510 (XI0_I33_ap1 VSS) capacitor c=4.468E-16
    I_C3511 (XI0_I33_cp VSS) capacitor c=7.874E-18
    I_C3512 (XI0_I33_bp1 VSS) capacitor c=7.102E-16
    I_C3513 (XI0_I33_an2 VSS) capacitor c=6.779E-18
    I_C3514 (XI0_I33_an1 VSS) capacitor c=5.314E-16
    I_C3515 (XI0_I33_bn1 VSS) capacitor c=3.835E-18
    I_C3516 (XI0_I33_bn2 VSS) capacitor c=6.881E-18
    I_C3517 (XI0_I33_abn VSS) capacitor c=1.071E-15
    I_C3518 (XI0_I33_aan VSS) capacitor c=1.177E-15
    I_C3519 (XI0_I33_e VSS) capacitor c=1.333E-15
    I_C3520 (XI0_I33_bbn VSS) capacitor c=1.011E-15
    I_C3521 (XI0_I33_ban VSS) capacitor c=6.654E-16
    I_C3522 (XI0_I22_ap1 VSS) capacitor c=4.521E-16
    I_C3523 (XI0_I22_cp VSS) capacitor c=1.059E-17
    I_C3524 (XI0_I22_bp1 VSS) capacitor c=6.566E-16
    I_C3525 (XI0_I22_an2 VSS) capacitor c=5.660E-18
    I_C3526 (XI0_I22_an1 VSS) capacitor c=5.552E-16
    I_C3527 (XI0_I22_bn1 VSS) capacitor c=7.411E-18
    I_C3528 (XI0_I22_bn2 VSS) capacitor c=7.919E-18
    I_C3529 (XI0_I22_abn VSS) capacitor c=1.042E-15
    I_C3530 (XI0_I22_aan VSS) capacitor c=1.168E-15
    I_C3531 (XI0_I22_e VSS) capacitor c=1.323E-15
    I_C3532 (XI0_I22_bbn VSS) capacitor c=1.023E-15
    I_C3533 (XI0_I22_ban VSS) capacitor c=6.594E-16
    I_C3534 (XI0_I11_ap1 VSS) capacitor c=4.447E-16
    I_C3535 (XI0_I11_cp VSS) capacitor c=1.166E-17
    I_C3536 (XI0_I11_bp1 VSS) capacitor c=6.964E-16
    I_C3537 (XI0_I11_an2 VSS) capacitor c=5.783E-18
    I_C3538 (XI0_I11_an1 VSS) capacitor c=5.392E-16
    I_C3539 (XI0_I11_bn1 VSS) capacitor c=4.368E-18
    I_C3540 (XI0_I11_bn2 VSS) capacitor c=5.975E-18
    I_C3541 (XI0_I11_abn VSS) capacitor c=1.111E-15
    I_C3542 (XI0_I11_aan VSS) capacitor c=1.175E-15
    I_C3543 (XI0_I11_e VSS) capacitor c=1.377E-15
    I_C3544 (XI0_I11_bbn VSS) capacitor c=1.019E-15
    I_C3545 (XI0_I11_ban VSS) capacitor c=6.428E-16
    I_C3546 (XI0_I0_ap1 VSS) capacitor c=4.431E-16
    I_C3547 (XI0_I0_cp VSS) capacitor c=7.321E-18
    I_C3548 (XI0_I0_bp1 VSS) capacitor c=6.604E-16
    I_C3549 (XI0_I0_an2 VSS) capacitor c=6.579E-18
    I_C3550 (XI0_I0_an1 VSS) capacitor c=5.371E-16
    I_C3551 (XI0_I0_bn1 VSS) capacitor c=3.718E-18
    I_C3552 (XI0_I0_bn2 VSS) capacitor c=6.652E-18
    I_C3553 (XI0_I0_abn VSS) capacitor c=1.031E-15
    I_C3554 (XI0_I0_aan VSS) capacitor c=1.157E-15
    I_C3555 (XI0_I0_e VSS) capacitor c=1.343E-15
    I_C3556 (XI0_I0_bbn VSS) capacitor c=1.014E-15
    I_C3557 (XI0_I0_ban VSS) capacitor c=6.802E-16
    I_C3558 (XI0_I77_I41_p1 VSS) capacitor c=5.618E-16
    I_C3559 (XI0_I77_I41_n1 VSS) capacitor c=1.057E-18
    I_C3560 (XI0_I77_I41_n2 VSS) capacitor c=8.848E-18
    I_C3561 (XI0_I77_I41_An VSS) capacitor c=9.819E-16
    I_C3562 (XI0_I77_I41_Bn VSS) capacitor c=7.931E-16
    I_C3563 (XI1_I152_I41_p1 VSS) capacitor c=5.683E-16
    I_C3564 (XI1_I152_I41_n2 VSS) capacitor c=7.793E-18
    I_C3565 (XI1_I152_I41_An VSS) capacitor c=9.561E-16
    I_C3566 (XI1_I152_I41_Bn VSS) capacitor c=7.596E-16
    I_C3567 (XI0_I77_I40_p1 VSS) capacitor c=5.201E-16
    I_C3568 (XI0_I77_I40_n1 VSS) capacitor c=4.639E-18
    I_C3569 (XI0_I77_I40_n2 VSS) capacitor c=7.083E-18
    I_C3570 (XI0_I77_I40_An VSS) capacitor c=9.937E-16
    I_C3571 (XI0_I77_I40_Bn VSS) capacitor c=7.420E-16
    I_C3572 (XI2_I2_I46_p1 VSS) capacitor c=5.447E-16
    I_C3573 (XI2_I2_I46_n1 VSS) capacitor c=2.772E-18
    I_C3574 (XI2_I2_I46_n2 VSS) capacitor c=7.833E-18
    I_C3575 (XI2_I2_I46_An VSS) capacitor c=1.010E-15
    I_C3576 (XI2_I2_I46_Bn VSS) capacitor c=7.736E-16
    I_C3577 (XI2_I2_I34_p1 VSS) capacitor c=5.507E-16
    I_C3578 (XI2_I2_I34_n2 VSS) capacitor c=9.163E-18
    I_C3579 (XI2_I2_I34_An VSS) capacitor c=9.769E-16
    I_C3580 (XI2_I2_I34_Bn VSS) capacitor c=7.790E-16
    I_C3581 (XI1_I152_I40_p1 VSS) capacitor c=5.423E-16
    I_C3582 (XI1_I152_I40_n1 VSS) capacitor c=3.837E-19
    I_C3583 (XI1_I152_I40_n2 VSS) capacitor c=7.087E-18
    I_C3584 (XI1_I152_I40_An VSS) capacitor c=1.009E-15
    I_C3585 (XI1_I152_I40_Bn VSS) capacitor c=7.951E-16
    I_C3586 (XI2_I1_I7_p1 VSS) capacitor c=5.951E-16
    I_C3587 (XI2_I1_I7_n1 VSS) capacitor c=7.310E-19
    I_C3588 (XI2_I1_I7_n2 VSS) capacitor c=7.325E-18
    I_C3589 (XI2_I1_I7_An VSS) capacitor c=1.015E-15
    I_C3590 (XI2_I1_I7_Bn VSS) capacitor c=8.321E-16
    I_C3591 (XI2_I2_I40_p1 VSS) capacitor c=5.568E-16
    I_C3592 (XI2_I2_I40_n1 VSS) capacitor c=3.411E-19
    I_C3593 (XI2_I2_I40_n2 VSS) capacitor c=8.133E-18
    I_C3594 (XI2_I2_I40_An VSS) capacitor c=1.020E-15
    I_C3595 (XI2_I2_I40_Bn VSS) capacitor c=8.070E-16
    I_C3596 (XI2_I1_I6_p1 VSS) capacitor c=5.286E-16
    I_C3597 (XI2_I1_I6_n2 VSS) capacitor c=7.639E-18
    I_C3598 (XI2_I1_I6_An VSS) capacitor c=9.926E-16
    I_C3599 (XI2_I1_I6_Bn VSS) capacitor c=7.908E-16
    I_C3600 (XI2_I2_I22_p1 VSS) capacitor c=5.670E-16
    I_C3601 (XI2_I2_I22_n2 VSS) capacitor c=7.887E-18
    I_C3602 (XI2_I2_I22_An VSS) capacitor c=9.842E-16
    I_C3603 (XI2_I2_I22_Bn VSS) capacitor c=7.905E-16
    I_C3604 (XI2_I1_I5_p1 VSS) capacitor c=5.553E-16
    I_C3605 (XI2_I1_I5_n2 VSS) capacitor c=7.157E-18
    I_C3606 (XI2_I1_I5_An VSS) capacitor c=9.919E-16
    I_C3607 (XI2_I1_I5_Bn VSS) capacitor c=7.955E-16
    I_C3608 (XI1_I132_I41_p1 VSS) capacitor c=5.157E-16
    I_C3609 (XI1_I132_I41_n2 VSS) capacitor c=9.727E-18
    I_C3610 (XI1_I132_I41_An VSS) capacitor c=1.020E-15
    I_C3611 (XI1_I132_I41_Bn VSS) capacitor c=8.425E-16
    I_C3612 (XI1_I132_I40_p1 VSS) capacitor c=5.865E-16
    I_C3613 (XI1_I132_I40_n1 VSS) capacitor c=1.157E-18
    I_C3614 (XI1_I132_I40_n2 VSS) capacitor c=5.548E-18
    I_C3615 (XI1_I132_I40_An VSS) capacitor c=1.022E-15
    I_C3616 (XI1_I132_I40_Bn VSS) capacitor c=8.144E-16
    I_C3617 (XI2_I1_I3_p1 VSS) capacitor c=5.075E-16
    I_C3618 (XI2_I1_I3_n2 VSS) capacitor c=1.045E-17
    I_C3619 (XI2_I1_I3_An VSS) capacitor c=9.718E-16
    I_C3620 (XI2_I1_I3_Bn VSS) capacitor c=7.628E-16
    I_C3621 (XI1_I131_p1 VSS) capacitor c=5.783E-16
    I_C3622 (XI1_I131_n1 VSS) capacitor c=3.820E-19
    I_C3623 (XI1_I131_n2 VSS) capacitor c=9.053E-18
    I_C3624 (XI1_I131_An VSS) capacitor c=1.033E-15
    I_C3625 (XI1_I131_Bn VSS) capacitor c=7.824E-16
    I_C3626 (XI1_I134_p1 VSS) capacitor c=5.455E-16
    I_C3627 (XI1_I134_n1 VSS) capacitor c=1.092E-18
    I_C3628 (XI1_I134_n2 VSS) capacitor c=9.065E-18
    I_C3629 (XI1_I134_An VSS) capacitor c=9.918E-16
    I_C3630 (XI1_I134_Bn VSS) capacitor c=7.836E-16
    I_C3631 (XI2_I4_I18_p1 VSS) capacitor c=5.502E-16
    I_C3632 (XI2_I4_I18_n1 VSS) capacitor c=3.820E-19
    I_C3633 (XI2_I4_I18_n2 VSS) capacitor c=8.152E-18
    I_C3634 (XI2_I4_I18_An VSS) capacitor c=9.678E-16
    I_C3635 (XI2_I4_I18_Bn VSS) capacitor c=7.694E-16
    I_C3636 (XI1_I124_p1 VSS) capacitor c=5.142E-16
    I_C3637 (XI1_I124_n2 VSS) capacitor c=8.414E-18
    I_C3638 (XI1_I124_An VSS) capacitor c=9.825E-16
    I_C3639 (XI1_I124_Bn VSS) capacitor c=7.804E-16
    I_C3640 (XI2_I1_I8_I41_p1 VSS) capacitor c=5.640E-16
    I_C3641 (XI2_I1_I8_I41_n1 VSS) capacitor c=7.639E-19
    I_C3642 (XI2_I1_I8_I41_n2 VSS) capacitor c=6.772E-18
    I_C3643 (XI2_I1_I8_I41_An VSS) capacitor c=1.009E-15
    I_C3644 (XI2_I1_I8_I41_Bn VSS) capacitor c=8.119E-16
    I_C3645 (XI2_I1_I8_I40_p1 VSS) capacitor c=5.578E-16
    I_C3646 (XI2_I1_I8_I40_n1 VSS) capacitor c=8.580E-19
    I_C3647 (XI2_I1_I8_I40_n2 VSS) capacitor c=6.760E-18
    I_C3648 (XI2_I1_I8_I40_An VSS) capacitor c=9.756E-16
    I_C3649 (XI2_I1_I8_I40_Bn VSS) capacitor c=8.143E-16
    I_C3650 (XI2_I1_I4_p1 VSS) capacitor c=5.686E-16
    I_C3651 (XI2_I1_I4_n1 VSS) capacitor c=1.070E-18
    I_C3652 (XI2_I1_I4_n2 VSS) capacitor c=7.186E-18
    I_C3653 (XI2_I1_I4_An VSS) capacitor c=1.021E-15
    I_C3654 (XI2_I1_I4_Bn VSS) capacitor c=8.093E-16
    I_C3655 (XI1_I133_p1 VSS) capacitor c=5.589E-16
    I_C3656 (XI1_I133_n1 VSS) capacitor c=3.820E-19
    I_C3657 (XI1_I133_n2 VSS) capacitor c=8.611E-18
    I_C3658 (XI1_I133_An VSS) capacitor c=9.935E-16
    I_C3659 (XI1_I133_Bn VSS) capacitor c=7.887E-16
    I_C3660 (XI1_I130_p1 VSS) capacitor c=5.340E-16
    I_C3661 (XI1_I130_n1 VSS) capacitor c=3.820E-19
    I_C3662 (XI1_I130_n2 VSS) capacitor c=5.700E-18
    I_C3663 (XI1_I130_An VSS) capacitor c=9.749E-16
    I_C3664 (XI1_I130_Bn VSS) capacitor c=7.820E-16
    I_C3665 (XI1_I129_p1 VSS) capacitor c=5.576E-16
    I_C3666 (XI1_I129_n1 VSS) capacitor c=1.739E-19
    I_C3667 (XI1_I129_n2 VSS) capacitor c=8.357E-18
    I_C3668 (XI1_I129_An VSS) capacitor c=9.947E-16
    I_C3669 (XI1_I129_Bn VSS) capacitor c=7.980E-16
    I_C3670 (XI1_I128_p1 VSS) capacitor c=5.815E-16
    I_C3671 (XI1_I128_n1 VSS) capacitor c=1.262E-17
    I_C3672 (XI1_I128_n2 VSS) capacitor c=9.862E-18
    I_C3673 (XI1_I128_An VSS) capacitor c=1.018E-15
    I_C3674 (XI1_I128_Bn VSS) capacitor c=8.073E-16
    I_C3675 (XI1_I127_p1 VSS) capacitor c=5.621E-16
    I_C3676 (XI1_I127_n2 VSS) capacitor c=6.218E-18
    I_C3677 (XI1_I127_An VSS) capacitor c=9.870E-16
    I_C3678 (XI1_I127_Bn VSS) capacitor c=7.648E-16
    I_C3679 (XI1_I126_p1 VSS) capacitor c=5.310E-16
    I_C3680 (XI1_I126_n1 VSS) capacitor c=1.291E-18
    I_C3681 (XI1_I126_n2 VSS) capacitor c=7.679E-18
    I_C3682 (XI1_I126_An VSS) capacitor c=9.934E-16
    I_C3683 (XI1_I126_Bn VSS) capacitor c=7.667E-16
    I_C3684 (XI1_I125_p1 VSS) capacitor c=5.675E-16
    I_C3685 (XI1_I125_n1 VSS) capacitor c=1.718E-18
    I_C3686 (XI1_I125_n2 VSS) capacitor c=1.177E-17
    I_C3687 (XI1_I125_An VSS) capacitor c=9.637E-16
    I_C3688 (XI1_I125_Bn VSS) capacitor c=7.728E-16
    I_C3689 (XI2_I1_I0_p1 VSS) capacitor c=5.521E-16
    I_C3690 (XI2_I1_I0_n1 VSS) capacitor c=3.602E-18
    I_C3691 (XI2_I1_I0_n2 VSS) capacitor c=5.583E-18
    I_C3692 (XI2_I1_I0_An VSS) capacitor c=1.001E-15
    I_C3693 (XI2_I1_I0_Bn VSS) capacitor c=7.758E-16
    I_C3694 (XI1_I122_p1 VSS) capacitor c=5.318E-16
    I_C3695 (XI1_I122_n2 VSS) capacitor c=6.705E-18
    I_C3696 (XI1_I122_An VSS) capacitor c=9.404E-16
    I_C3697 (XI1_I122_Bn VSS) capacitor c=7.775E-16
    I_C3698 (XI1_I120_I41_p1 VSS) capacitor c=5.657E-16
    I_C3699 (XI1_I120_I41_n1 VSS) capacitor c=3.820E-19
    I_C3700 (XI1_I120_I41_n2 VSS) capacitor c=8.398E-18
    I_C3701 (XI1_I120_I41_An VSS) capacitor c=9.830E-16
    I_C3702 (XI1_I120_I41_Bn VSS) capacitor c=7.825E-16
    I_C3703 (XI1_I120_I40_p1 VSS) capacitor c=5.320E-16
    I_C3704 (XI1_I120_I40_n1 VSS) capacitor c=4.582E-18
    I_C3705 (XI1_I120_I40_n2 VSS) capacitor c=5.059E-18
    I_C3706 (XI1_I120_I40_An VSS) capacitor c=9.762E-16
    I_C3707 (XI1_I120_I40_Bn VSS) capacitor c=7.762E-16
    I_C3708 (XI2_I1_I1_p1 VSS) capacitor c=5.794E-16
    I_C3709 (XI2_I1_I1_n2 VSS) capacitor c=7.930E-18
    I_C3710 (XI2_I1_I1_An VSS) capacitor c=9.761E-16
    I_C3711 (XI2_I1_I1_Bn VSS) capacitor c=7.852E-16
    I_C3712 (XI2_I2_I28_p1 VSS) capacitor c=5.821E-16
    I_C3713 (XI2_I2_I28_n2 VSS) capacitor c=9.005E-18
    I_C3714 (XI2_I2_I28_An VSS) capacitor c=1.002E-15
    I_C3715 (XI2_I2_I28_Bn VSS) capacitor c=7.979E-16
    I_C3716 (XI2_I1_I2_p1 VSS) capacitor c=5.664E-16
    I_C3717 (XI2_I1_I2_n2 VSS) capacitor c=6.395E-18
    I_C3718 (XI2_I1_I2_An VSS) capacitor c=9.730E-16
    I_C3719 (XI2_I1_I2_Bn VSS) capacitor c=7.861E-16
    I_C3720 (XI1_I114_p1 VSS) capacitor c=5.431E-16
    I_C3721 (XI1_I114_n2 VSS) capacitor c=8.478E-18
    I_C3722 (XI1_I114_An VSS) capacitor c=1.001E-15
    I_C3723 (XI1_I114_Bn VSS) capacitor c=7.579E-16
    I_C3724 (XI1_I113_p1 VSS) capacitor c=5.506E-16
    I_C3725 (XI1_I113_n2 VSS) capacitor c=7.253E-18
    I_C3726 (XI1_I113_An VSS) capacitor c=9.814E-16
    I_C3727 (XI1_I113_Bn VSS) capacitor c=8.074E-16
    I_C3728 (XI1_I112_p1 VSS) capacitor c=5.481E-16
    I_C3729 (XI1_I112_n1 VSS) capacitor c=1.438E-18
    I_C3730 (XI1_I112_n2 VSS) capacitor c=7.625E-18
    I_C3731 (XI1_I112_An VSS) capacitor c=9.886E-16
    I_C3732 (XI1_I112_Bn VSS) capacitor c=7.439E-16
    I_C3733 (XI2_I2_I10_p1 VSS) capacitor c=5.658E-16
    I_C3734 (XI2_I2_I10_n2 VSS) capacitor c=6.957E-18
    I_C3735 (XI2_I2_I10_An VSS) capacitor c=1.024E-15
    I_C3736 (XI2_I2_I10_Bn VSS) capacitor c=8.308E-16
    I_C3737 (XI1_I116_p1 VSS) capacitor c=5.717E-16
    I_C3738 (XI1_I116_n1 VSS) capacitor c=4.682E-18
    I_C3739 (XI1_I116_n2 VSS) capacitor c=7.022E-18
    I_C3740 (XI1_I116_An VSS) capacitor c=9.523E-16
    I_C3741 (XI1_I116_Bn VSS) capacitor c=7.876E-16
    I_C3742 (XI1_I115_p1 VSS) capacitor c=5.338E-16
    I_C3743 (XI1_I115_n1 VSS) capacitor c=9.551E-20
    I_C3744 (XI1_I115_n2 VSS) capacitor c=4.803E-18
    I_C3745 (XI1_I115_An VSS) capacitor c=1.039E-15
    I_C3746 (XI1_I115_Bn VSS) capacitor c=8.265E-16
    I_C3747 (XI1_I100_p1 VSS) capacitor c=5.596E-16
    I_C3748 (XI1_I100_n2 VSS) capacitor c=1.083E-17
    I_C3749 (XI1_I100_An VSS) capacitor c=9.689E-16
    I_C3750 (XI1_I100_Bn VSS) capacitor c=7.936E-16
    I_C3751 (XI1_I153_p1 VSS) capacitor c=5.016E-16
    I_C3752 (XI1_I153_n2 VSS) capacitor c=1.163E-17
    I_C3753 (XI1_I153_An VSS) capacitor c=9.801E-16
    I_C3754 (XI1_I153_Bn VSS) capacitor c=7.715E-16
    I_C3755 (XI2_I2_I4_p1 VSS) capacitor c=5.906E-16
    I_C3756 (XI2_I2_I4_n1 VSS) capacitor c=3.404E-18
    I_C3757 (XI2_I2_I4_n2 VSS) capacitor c=6.319E-18
    I_C3758 (XI2_I2_I4_An VSS) capacitor c=9.980E-16
    I_C3759 (XI2_I2_I4_Bn VSS) capacitor c=7.830E-16
    I_C3760 (XI1_I119_p1 VSS) capacitor c=5.625E-16
    I_C3761 (XI1_I119_n2 VSS) capacitor c=8.829E-18
    I_C3762 (XI1_I119_An VSS) capacitor c=9.676E-16
    I_C3763 (XI1_I119_Bn VSS) capacitor c=7.959E-16
    I_C3764 (XI1_I118_p1 VSS) capacitor c=5.733E-16
    I_C3765 (XI1_I118_n2 VSS) capacitor c=7.462E-18
    I_C3766 (XI1_I118_An VSS) capacitor c=9.693E-16
    I_C3767 (XI1_I118_Bn VSS) capacitor c=7.908E-16
    I_C3768 (XI1_I117_p1 VSS) capacitor c=5.533E-16
    I_C3769 (XI1_I117_n1 VSS) capacitor c=9.653E-18
    I_C3770 (XI1_I117_n2 VSS) capacitor c=5.096E-18
    I_C3771 (XI1_I117_An VSS) capacitor c=1.040E-15
    I_C3772 (XI1_I117_Bn VSS) capacitor c=8.054E-16
    I_C3773 (XI1_I108_I40_p1 VSS) capacitor c=5.642E-16
    I_C3774 (XI1_I108_I40_n1 VSS) capacitor c=4.623E-19
    I_C3775 (XI1_I108_I40_n2 VSS) capacitor c=8.379E-18
    I_C3776 (XI1_I108_I40_An VSS) capacitor c=9.598E-16
    I_C3777 (XI1_I108_I40_Bn VSS) capacitor c=7.871E-16
    I_C3778 (XI1_I101_p1 VSS) capacitor c=5.201E-16
    I_C3779 (XI1_I101_n2 VSS) capacitor c=5.232E-18
    I_C3780 (XI1_I101_An VSS) capacitor c=9.400E-16
    I_C3781 (XI1_I101_Bn VSS) capacitor c=8.190E-16
    I_C3782 (XI1_I64_p1 VSS) capacitor c=6.030E-16
    I_C3783 (XI1_I64_n2 VSS) capacitor c=6.169E-18
    I_C3784 (XI1_I64_An VSS) capacitor c=9.876E-16
    I_C3785 (XI1_I64_Bn VSS) capacitor c=8.073E-16
    I_C3786 (XI1_I52_p1 VSS) capacitor c=5.796E-16
    I_C3787 (XI1_I52_n1 VSS) capacitor c=3.134E-18
    I_C3788 (XI1_I52_n2 VSS) capacitor c=6.703E-18
    I_C3789 (XI1_I52_An VSS) capacitor c=1.003E-15
    I_C3790 (XI1_I52_Bn VSS) capacitor c=7.812E-16
    I_C3791 (XI1_I40_p1 VSS) capacitor c=5.247E-16
    I_C3792 (XI1_I40_n1 VSS) capacitor c=5.996E-18
    I_C3793 (XI1_I40_n2 VSS) capacitor c=6.657E-18
    I_C3794 (XI1_I40_An VSS) capacitor c=1.012E-15
    I_C3795 (XI1_I40_Bn VSS) capacitor c=8.419E-16
    I_C3796 (XI2_I2_I16_p1 VSS) capacitor c=5.485E-16
    I_C3797 (XI2_I2_I16_n2 VSS) capacitor c=6.495E-18
    I_C3798 (XI2_I2_I16_An VSS) capacitor c=9.883E-16
    I_C3799 (XI2_I2_I16_Bn VSS) capacitor c=7.952E-16
    I_C3800 (XI1_I121_p1 VSS) capacitor c=5.293E-16
    I_C3801 (XI1_I121_n1 VSS) capacitor c=3.820E-19
    I_C3802 (XI1_I121_n2 VSS) capacitor c=9.169E-18
    I_C3803 (XI1_I121_An VSS) capacitor c=9.660E-16
    I_C3804 (XI1_I121_Bn VSS) capacitor c=7.656E-16
    I_C3805 (XI1_I108_I41_p1 VSS) capacitor c=5.758E-16
    I_C3806 (XI1_I108_I41_n1 VSS) capacitor c=4.890E-19
    I_C3807 (XI1_I108_I41_n2 VSS) capacitor c=6.808E-18
    I_C3808 (XI1_I108_I41_An VSS) capacitor c=9.857E-16
    I_C3809 (XI1_I108_I41_Bn VSS) capacitor c=7.747E-16
    I_C3810 (XI1_I102_p1 VSS) capacitor c=5.949E-16
    I_C3811 (XI1_I102_n1 VSS) capacitor c=4.134E-19
    I_C3812 (XI1_I102_n2 VSS) capacitor c=5.715E-18
    I_C3813 (XI1_I102_An VSS) capacitor c=9.686E-16
    I_C3814 (XI1_I102_Bn VSS) capacitor c=7.676E-16
    I_C3815 (XI1_I90_p1 VSS) capacitor c=5.307E-16
    I_C3816 (XI1_I90_n2 VSS) capacitor c=5.445E-18
    I_C3817 (XI1_I90_An VSS) capacitor c=1.007E-15
    I_C3818 (XI1_I90_Bn VSS) capacitor c=7.791E-16
    I_C3819 (XI1_I89_p1 VSS) capacitor c=6.105E-16
    I_C3820 (XI1_I89_n2 VSS) capacitor c=7.815E-18
    I_C3821 (XI1_I89_An VSS) capacitor c=9.578E-16
    I_C3822 (XI1_I89_Bn VSS) capacitor c=7.796E-16
    I_C3823 (XI1_I88_p1 VSS) capacitor c=5.331E-16
    I_C3824 (XI1_I88_n2 VSS) capacitor c=8.288E-18
    I_C3825 (XI1_I88_An VSS) capacitor c=9.925E-16
    I_C3826 (XI1_I88_Bn VSS) capacitor c=8.072E-16
    I_C3827 (XI1_I77_p1 VSS) capacitor c=5.920E-16
    I_C3828 (XI1_I77_n2 VSS) capacitor c=5.458E-18
    I_C3829 (XI1_I77_An VSS) capacitor c=9.733E-16
    I_C3830 (XI1_I77_Bn VSS) capacitor c=8.394E-16
    I_C3831 (XI1_I78_p1 VSS) capacitor c=5.806E-16
    I_C3832 (XI1_I78_n2 VSS) capacitor c=6.488E-18
    I_C3833 (XI1_I78_An VSS) capacitor c=9.928E-16
    I_C3834 (XI1_I78_Bn VSS) capacitor c=7.928E-16
    I_C3835 (XI1_I76_p1 VSS) capacitor c=5.238E-16
    I_C3836 (XI1_I76_n2 VSS) capacitor c=9.136E-18
    I_C3837 (XI1_I76_An VSS) capacitor c=9.587E-16
    I_C3838 (XI1_I76_Bn VSS) capacitor c=8.055E-16
    I_C3839 (XI1_I65_p1 VSS) capacitor c=5.606E-16
    I_C3840 (XI1_I65_n2 VSS) capacitor c=8.059E-18
    I_C3841 (XI1_I65_An VSS) capacitor c=1.010E-15
    I_C3842 (XI1_I65_Bn VSS) capacitor c=8.202E-16
    I_C3843 (XI1_I66_p1 VSS) capacitor c=5.779E-16
    I_C3844 (XI1_I66_n1 VSS) capacitor c=3.990E-18
    I_C3845 (XI1_I66_n2 VSS) capacitor c=7.657E-18
    I_C3846 (XI1_I66_An VSS) capacitor c=9.882E-16
    I_C3847 (XI1_I66_Bn VSS) capacitor c=8.372E-16
    I_C3848 (XI1_I53_p1 VSS) capacitor c=5.905E-16
    I_C3849 (XI1_I53_n1 VSS) capacitor c=3.753E-19
    I_C3850 (XI1_I53_n2 VSS) capacitor c=9.896E-18
    I_C3851 (XI1_I53_An VSS) capacitor c=1.004E-15
    I_C3852 (XI1_I53_Bn VSS) capacitor c=8.072E-16
    I_C3853 (XI1_I54_p1 VSS) capacitor c=5.652E-16
    I_C3854 (XI1_I54_n1 VSS) capacitor c=3.820E-19
    I_C3855 (XI1_I54_n2 VSS) capacitor c=1.043E-17
    I_C3856 (XI1_I54_An VSS) capacitor c=9.616E-16
    I_C3857 (XI1_I54_Bn VSS) capacitor c=8.022E-16
    I_C3858 (XI1_I43_p1 VSS) capacitor c=5.475E-16
    I_C3859 (XI1_I43_n1 VSS) capacitor c=3.422E-19
    I_C3860 (XI1_I43_n2 VSS) capacitor c=6.496E-18
    I_C3861 (XI1_I43_An VSS) capacitor c=9.759E-16
    I_C3862 (XI1_I43_Bn VSS) capacitor c=8.190E-16
    I_C3863 (XI1_I41_p1 VSS) capacitor c=5.494E-16
    I_C3864 (XI1_I41_n2 VSS) capacitor c=8.264E-18
    I_C3865 (XI1_I41_An VSS) capacitor c=9.869E-16
    I_C3866 (XI1_I41_Bn VSS) capacitor c=8.014E-16
    I_C3867 (XI1_I42_p1 VSS) capacitor c=5.093E-16
    I_C3868 (XI1_I42_n2 VSS) capacitor c=9.190E-18
    I_C3869 (XI1_I42_An VSS) capacitor c=9.375E-16
    I_C3870 (XI1_I42_Bn VSS) capacitor c=7.984E-16
    I_C3871 (XI1_I103_p1 VSS) capacitor c=5.716E-16
    I_C3872 (XI1_I103_n2 VSS) capacitor c=4.617E-18
    I_C3873 (XI1_I103_An VSS) capacitor c=1.012E-15
    I_C3874 (XI1_I103_Bn VSS) capacitor c=7.992E-16
    I_C3875 (XI1_I91_p1 VSS) capacitor c=5.323E-16
    I_C3876 (XI1_I91_n2 VSS) capacitor c=6.931E-18
    I_C3877 (XI1_I91_An VSS) capacitor c=9.746E-16
    I_C3878 (XI1_I91_Bn VSS) capacitor c=7.765E-16
    I_C3879 (XI1_I79_p1 VSS) capacitor c=5.615E-16
    I_C3880 (XI1_I79_n2 VSS) capacitor c=5.963E-18
    I_C3881 (XI1_I79_An VSS) capacitor c=9.536E-16
    I_C3882 (XI1_I79_Bn VSS) capacitor c=7.770E-16
    I_C3883 (XI1_I67_p1 VSS) capacitor c=5.614E-16
    I_C3884 (XI1_I67_n1 VSS) capacitor c=3.408E-18
    I_C3885 (XI1_I67_n2 VSS) capacitor c=6.216E-18
    I_C3886 (XI1_I67_An VSS) capacitor c=9.884E-16
    I_C3887 (XI1_I67_Bn VSS) capacitor c=7.778E-16
    I_C3888 (XI1_I55_p1 VSS) capacitor c=5.403E-16
    I_C3889 (XI1_I55_n1 VSS) capacitor c=1.838E-18
    I_C3890 (XI1_I55_n2 VSS) capacitor c=7.680E-18
    I_C3891 (XI1_I55_An VSS) capacitor c=9.967E-16
    I_C3892 (XI1_I55_Bn VSS) capacitor c=7.758E-16
    I_C3893 (XI1_I104_p1 VSS) capacitor c=5.373E-16
    I_C3894 (XI1_I104_n2 VSS) capacitor c=5.534E-18
    I_C3895 (XI1_I104_An VSS) capacitor c=9.675E-16
    I_C3896 (XI1_I104_Bn VSS) capacitor c=7.746E-16
    I_C3897 (XI1_I96_I40_p1 VSS) capacitor c=5.669E-16
    I_C3898 (XI1_I96_I40_n2 VSS) capacitor c=1.012E-17
    I_C3899 (XI1_I96_I40_An VSS) capacitor c=9.811E-16
    I_C3900 (XI1_I96_I40_Bn VSS) capacitor c=8.107E-16
    I_C3901 (XI1_I80_p1 VSS) capacitor c=5.325E-16
    I_C3902 (XI1_I80_n2 VSS) capacitor c=8.454E-18
    I_C3903 (XI1_I80_An VSS) capacitor c=9.646E-16
    I_C3904 (XI1_I80_Bn VSS) capacitor c=7.688E-16
    I_C3905 (XI1_I68_p1 VSS) capacitor c=5.490E-16
    I_C3906 (XI1_I68_n2 VSS) capacitor c=5.861E-18
    I_C3907 (XI1_I68_An VSS) capacitor c=9.725E-16
    I_C3908 (XI1_I68_Bn VSS) capacitor c=8.123E-16
    I_C3909 (XI1_I44_p1 VSS) capacitor c=5.296E-16
    I_C3910 (XI1_I44_n1 VSS) capacitor c=1.611E-18
    I_C3911 (XI1_I44_n2 VSS) capacitor c=6.929E-18
    I_C3912 (XI1_I44_An VSS) capacitor c=9.562E-16
    I_C3913 (XI1_I44_Bn VSS) capacitor c=8.096E-16
    I_C3914 (XI1_I56_p1 VSS) capacitor c=5.630E-16
    I_C3915 (XI1_I56_n1 VSS) capacitor c=7.607E-19
    I_C3916 (XI1_I56_n2 VSS) capacitor c=7.809E-18
    I_C3917 (XI1_I56_An VSS) capacitor c=9.572E-16
    I_C3918 (XI1_I56_Bn VSS) capacitor c=7.991E-16
    I_C3919 (XI1_I110_p1 VSS) capacitor c=5.824E-16
    I_C3920 (XI1_I110_n1 VSS) capacitor c=6.377E-18
    I_C3921 (XI1_I110_n2 VSS) capacitor c=7.766E-18
    I_C3922 (XI1_I110_An VSS) capacitor c=9.794E-16
    I_C3923 (XI1_I110_Bn VSS) capacitor c=7.941E-16
    I_C3924 (XI1_I96_I41_p1 VSS) capacitor c=5.435E-16
    I_C3925 (XI1_I96_I41_n2 VSS) capacitor c=1.043E-17
    I_C3926 (XI1_I96_I41_An VSS) capacitor c=9.382E-16
    I_C3927 (XI1_I96_I41_Bn VSS) capacitor c=7.877E-16
    I_C3928 (XI1_I92_p1 VSS) capacitor c=5.374E-16
    I_C3929 (XI1_I92_n2 VSS) capacitor c=5.652E-18
    I_C3930 (XI1_I92_An VSS) capacitor c=9.343E-16
    I_C3931 (XI1_I92_Bn VSS) capacitor c=7.897E-16
    I_C3932 (XI1_I84_I40_p1 VSS) capacitor c=5.518E-16
    I_C3933 (XI1_I84_I40_n1 VSS) capacitor c=3.820E-19
    I_C3934 (XI1_I84_I40_n2 VSS) capacitor c=6.027E-18
    I_C3935 (XI1_I84_I40_An VSS) capacitor c=1.014E-15
    I_C3936 (XI1_I84_I40_Bn VSS) capacitor c=8.156E-16
    I_C3937 (XI1_I72_I40_p1 VSS) capacitor c=5.560E-16
    I_C3938 (XI1_I72_I40_n2 VSS) capacitor c=5.508E-18
    I_C3939 (XI1_I72_I40_An VSS) capacitor c=9.683E-16
    I_C3940 (XI1_I72_I40_Bn VSS) capacitor c=8.041E-16
    I_C3941 (XI1_I69_p1 VSS) capacitor c=5.610E-16
    I_C3942 (XI1_I69_n1 VSS) capacitor c=4.093E-20
    I_C3943 (XI1_I69_n2 VSS) capacitor c=7.776E-18
    I_C3944 (XI1_I69_An VSS) capacitor c=9.569E-16
    I_C3945 (XI1_I69_Bn VSS) capacitor c=7.739E-16
    I_C3946 (XI1_I60_I40_p1 VSS) capacitor c=5.541E-16
    I_C3947 (XI1_I60_I40_n1 VSS) capacitor c=1.120E-19
    I_C3948 (XI1_I60_I40_n2 VSS) capacitor c=2.050E-18
    I_C3949 (XI1_I60_I40_An VSS) capacitor c=9.675E-16
    I_C3950 (XI1_I60_I40_Bn VSS) capacitor c=7.869E-16
    I_C3951 (XI1_I57_p1 VSS) capacitor c=5.181E-16
    I_C3952 (XI1_I57_n1 VSS) capacitor c=1.739E-19
    I_C3953 (XI1_I57_n2 VSS) capacitor c=5.148E-18
    I_C3954 (XI1_I57_An VSS) capacitor c=9.670E-16
    I_C3955 (XI1_I57_Bn VSS) capacitor c=7.642E-16
    I_C3956 (XI1_I48_I40_p1 VSS) capacitor c=5.329E-16
    I_C3957 (XI1_I48_I40_n2 VSS) capacitor c=9.200E-18
    I_C3958 (XI1_I48_I40_An VSS) capacitor c=1.001E-15
    I_C3959 (XI1_I48_I40_Bn VSS) capacitor c=7.571E-16
    I_C3960 (XI1_I105_p1 VSS) capacitor c=5.619E-16
    I_C3961 (XI1_I105_n1 VSS) capacitor c=2.176E-18
    I_C3962 (XI1_I105_n2 VSS) capacitor c=4.955E-18
    I_C3963 (XI1_I105_An VSS) capacitor c=9.969E-16
    I_C3964 (XI1_I105_Bn VSS) capacitor c=8.148E-16
    I_C3965 (XI1_I93_p1 VSS) capacitor c=5.990E-16
    I_C3966 (XI1_I93_n1 VSS) capacitor c=1.429E-18
    I_C3967 (XI1_I93_n2 VSS) capacitor c=7.632E-18
    I_C3968 (XI1_I93_An VSS) capacitor c=9.881E-16
    I_C3969 (XI1_I93_Bn VSS) capacitor c=7.696E-16
    I_C3970 (XI1_I81_p1 VSS) capacitor c=6.347E-16
    I_C3971 (XI1_I81_n2 VSS) capacitor c=7.242E-18
    I_C3972 (XI1_I81_An VSS) capacitor c=9.856E-16
    I_C3973 (XI1_I81_Bn VSS) capacitor c=8.119E-16
    I_C3974 (XI1_I72_I41_p1 VSS) capacitor c=5.503E-16
    I_C3975 (XI1_I72_I41_n2 VSS) capacitor c=9.170E-18
    I_C3976 (XI1_I72_I41_An VSS) capacitor c=1.017E-15
    I_C3977 (XI1_I72_I41_Bn VSS) capacitor c=7.998E-16
    I_C3978 (XI1_I60_I41_p1 VSS) capacitor c=5.716E-16
    I_C3979 (XI1_I60_I41_n2 VSS) capacitor c=8.905E-18
    I_C3980 (XI1_I60_I41_An VSS) capacitor c=9.684E-16
    I_C3981 (XI1_I60_I41_Bn VSS) capacitor c=8.178E-16
    I_C3982 (XI1_I45_p1 VSS) capacitor c=5.483E-16
    I_C3983 (XI1_I45_n2 VSS) capacitor c=8.058E-18
    I_C3984 (XI1_I45_An VSS) capacitor c=9.560E-16
    I_C3985 (XI1_I45_Bn VSS) capacitor c=8.297E-16
    I_C3986 (XI1_I48_I41_p1 VSS) capacitor c=5.226E-16
    I_C3987 (XI1_I48_I41_n1 VSS) capacitor c=1.710E-19
    I_C3988 (XI1_I48_I41_n2 VSS) capacitor c=1.043E-17
    I_C3989 (XI1_I48_I41_An VSS) capacitor c=9.964E-16
    I_C3990 (XI1_I48_I41_Bn VSS) capacitor c=8.018E-16
    I_C3991 (XI1_I106_p1 VSS) capacitor c=5.710E-16
    I_C3992 (XI1_I106_n2 VSS) capacitor c=6.977E-18
    I_C3993 (XI1_I106_An VSS) capacitor c=9.876E-16
    I_C3994 (XI1_I106_Bn VSS) capacitor c=7.566E-16
    I_C3995 (XI1_I109_p1 VSS) capacitor c=5.321E-16
    I_C3996 (XI1_I109_n2 VSS) capacitor c=5.918E-18
    I_C3997 (XI1_I109_An VSS) capacitor c=9.649E-16
    I_C3998 (XI1_I109_Bn VSS) capacitor c=7.913E-16
    I_C3999 (XI1_I94_p1 VSS) capacitor c=5.783E-16
    I_C4000 (XI1_I94_n1 VSS) capacitor c=9.393E-20
    I_C4001 (XI1_I94_n2 VSS) capacitor c=7.533E-18
    I_C4002 (XI1_I94_An VSS) capacitor c=9.962E-16
    I_C4003 (XI1_I94_Bn VSS) capacitor c=8.021E-16
    I_C4004 (XI1_I84_I41_p1 VSS) capacitor c=5.354E-16
    I_C4005 (XI1_I84_I41_n1 VSS) capacitor c=2.378E-18
    I_C4006 (XI1_I84_I41_n2 VSS) capacitor c=8.090E-18
    I_C4007 (XI1_I84_I41_An VSS) capacitor c=9.899E-16
    I_C4008 (XI1_I84_I41_Bn VSS) capacitor c=7.916E-16
    I_C4009 (XI1_I70_p1 VSS) capacitor c=5.507E-16
    I_C4010 (XI1_I70_n2 VSS) capacitor c=7.696E-18
    I_C4011 (XI1_I70_An VSS) capacitor c=9.560E-16
    I_C4012 (XI1_I70_Bn VSS) capacitor c=7.556E-16
    I_C4013 (XI1_I58_p1 VSS) capacitor c=5.899E-16
    I_C4014 (XI1_I58_n1 VSS) capacitor c=4.890E-19
    I_C4015 (XI1_I58_n2 VSS) capacitor c=7.607E-18
    I_C4016 (XI1_I58_An VSS) capacitor c=9.724E-16
    I_C4017 (XI1_I58_Bn VSS) capacitor c=7.725E-16
    I_C4018 (XI1_I46_p1 VSS) capacitor c=6.127E-16
    I_C4019 (XI1_I46_n2 VSS) capacitor c=8.778E-18
    I_C4020 (XI1_I46_An VSS) capacitor c=9.540E-16
    I_C4021 (XI1_I46_Bn VSS) capacitor c=8.119E-16
    I_C4022 (XI1_I50_p1 VSS) capacitor c=5.193E-16
    I_C4023 (XI1_I50_n1 VSS) capacitor c=6.778E-18
    I_C4024 (XI1_I50_n2 VSS) capacitor c=8.698E-18
    I_C4025 (XI1_I50_An VSS) capacitor c=9.923E-16
    I_C4026 (XI1_I50_Bn VSS) capacitor c=7.677E-16
    I_C4027 (XI1_I107_p1 VSS) capacitor c=5.064E-16
    I_C4028 (XI1_I107_n2 VSS) capacitor c=1.150E-17
    I_C4029 (XI1_I107_An VSS) capacitor c=9.509E-16
    I_C4030 (XI1_I107_Bn VSS) capacitor c=7.587E-16
    I_C4031 (XI1_I98_p1 VSS) capacitor c=5.758E-16
    I_C4032 (XI1_I98_n1 VSS) capacitor c=2.047E-19
    I_C4033 (XI1_I98_n2 VSS) capacitor c=8.666E-18
    I_C4034 (XI1_I98_An VSS) capacitor c=9.837E-16
    I_C4035 (XI1_I98_Bn VSS) capacitor c=7.339E-16
    I_C4036 (XI1_I95_p1 VSS) capacitor c=5.157E-16
    I_C4037 (XI1_I95_n2 VSS) capacitor c=7.690E-18
    I_C4038 (XI1_I95_An VSS) capacitor c=9.598E-16
    I_C4039 (XI1_I95_Bn VSS) capacitor c=7.913E-16
    I_C4040 (XI1_I97_p1 VSS) capacitor c=5.161E-16
    I_C4041 (XI1_I97_n1 VSS) capacitor c=2.942E-18
    I_C4042 (XI1_I97_n2 VSS) capacitor c=9.143E-18
    I_C4043 (XI1_I97_An VSS) capacitor c=9.901E-16
    I_C4044 (XI1_I97_Bn VSS) capacitor c=7.811E-16
    I_C4045 (XI1_I86_p1 VSS) capacitor c=5.687E-16
    I_C4046 (XI1_I86_n2 VSS) capacitor c=5.756E-18
    I_C4047 (XI1_I86_An VSS) capacitor c=1.004E-15
    I_C4048 (XI1_I86_Bn VSS) capacitor c=8.289E-16
    I_C4049 (XI1_I83_p1 VSS) capacitor c=5.218E-16
    I_C4050 (XI1_I83_n1 VSS) capacitor c=3.820E-19
    I_C4051 (XI1_I83_n2 VSS) capacitor c=8.185E-18
    I_C4052 (XI1_I83_An VSS) capacitor c=1.023E-15
    I_C4053 (XI1_I83_Bn VSS) capacitor c=8.142E-16
    I_C4054 (XI1_I85_p1 VSS) capacitor c=5.433E-16
    I_C4055 (XI1_I85_n1 VSS) capacitor c=3.695E-19
    I_C4056 (XI1_I85_n2 VSS) capacitor c=7.818E-18
    I_C4057 (XI1_I85_An VSS) capacitor c=9.752E-16
    I_C4058 (XI1_I85_Bn VSS) capacitor c=7.996E-16
    I_C4059 (XI1_I82_p1 VSS) capacitor c=5.546E-16
    I_C4060 (XI1_I82_n1 VSS) capacitor c=1.622E-18
    I_C4061 (XI1_I82_n2 VSS) capacitor c=7.308E-18
    I_C4062 (XI1_I82_An VSS) capacitor c=9.948E-16
    I_C4063 (XI1_I82_Bn VSS) capacitor c=7.991E-16
    I_C4064 (XI1_I74_p1 VSS) capacitor c=4.999E-16
    I_C4065 (XI1_I74_n2 VSS) capacitor c=9.881E-18
    I_C4066 (XI1_I74_An VSS) capacitor c=9.432E-16
    I_C4067 (XI1_I74_Bn VSS) capacitor c=7.706E-16
    I_C4068 (XI1_I71_p1 VSS) capacitor c=5.949E-16
    I_C4069 (XI1_I71_n2 VSS) capacitor c=8.324E-18
    I_C4070 (XI1_I71_An VSS) capacitor c=9.375E-16
    I_C4071 (XI1_I71_Bn VSS) capacitor c=8.226E-16
    I_C4072 (XI1_I73_p1 VSS) capacitor c=5.659E-16
    I_C4073 (XI1_I73_n1 VSS) capacitor c=4.890E-19
    I_C4074 (XI1_I73_n2 VSS) capacitor c=5.680E-18
    I_C4075 (XI1_I73_An VSS) capacitor c=9.970E-16
    I_C4076 (XI1_I73_Bn VSS) capacitor c=7.856E-16
    I_C4077 (XI1_I62_p1 VSS) capacitor c=5.654E-16
    I_C4078 (XI1_I62_n1 VSS) capacitor c=2.419E-18
    I_C4079 (XI1_I62_n2 VSS) capacitor c=5.163E-18
    I_C4080 (XI1_I62_An VSS) capacitor c=1.009E-15
    I_C4081 (XI1_I62_Bn VSS) capacitor c=7.937E-16
    I_C4082 (XI1_I59_p1 VSS) capacitor c=5.956E-16
    I_C4083 (XI1_I59_n2 VSS) capacitor c=7.819E-18
    I_C4084 (XI1_I59_An VSS) capacitor c=9.573E-16
    I_C4085 (XI1_I59_Bn VSS) capacitor c=7.944E-16
    I_C4086 (XI1_I61_p1 VSS) capacitor c=5.303E-16
    I_C4087 (XI1_I61_n2 VSS) capacitor c=8.309E-18
    I_C4088 (XI1_I61_An VSS) capacitor c=9.720E-16
    I_C4089 (XI1_I61_Bn VSS) capacitor c=7.583E-16
    I_C4090 (XI1_I47_p1 VSS) capacitor c=5.975E-16
    I_C4091 (XI1_I47_n2 VSS) capacitor c=6.238E-18
    I_C4092 (XI1_I47_An VSS) capacitor c=9.539E-16
    I_C4093 (XI1_I47_Bn VSS) capacitor c=8.252E-16
    I_C4094 (XI1_I49_p1 VSS) capacitor c=5.000E-16
    I_C4095 (XI1_I49_n2 VSS) capacitor c=1.031E-17
    I_C4096 (XI1_I49_An VSS) capacitor c=9.648E-16
    I_C4097 (XI1_I49_Bn VSS) capacitor c=7.828E-16
ends ALU_TOPK
