// ALU_TOPK sau layout (RCX), corner SS
simulator lang=spectre
include "/home/buet/cadence/gpdk090_v4.6/models/spectre/gpdk090.scs" section=SS
include "../../cells/A/cells_A.scs"
include "ALU_TOPK_rcx.scs"
include "../../blocks/ALU_TOP/tb/tb_ALU_TOPK_slow.scs"
