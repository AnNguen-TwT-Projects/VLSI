// DIV32_p1, corner SS
simulator lang=spectre
include "/home/buet/cadence/gpdk090_v4.6/models/spectre/gpdk090.scs" section=SS
include "../../tang1_cell/cells.scs"
include "../ALU_32bit.scs"
include "tb_DIV32_p1_slow.scs"
