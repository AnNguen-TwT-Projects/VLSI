// CORE32_p0, corner FF
simulator lang=spectre
include "/home/buet/cadence/gpdk090_v4.6/models/spectre/gpdk090.scs" section=FF
include "../../tang1_cell/cells.scs"
include "../ALU_32bit.scs"
include "tb_CORE32_p0.scs"
