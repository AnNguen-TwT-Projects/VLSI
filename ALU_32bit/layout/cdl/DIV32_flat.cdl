* DIV32 phang xuong cell la

.SUBCKT AOI21_X1 A1 A2 B Y VDD VSS
MN0 Y A1 n1 VSS nmos1v w=0.24u l=0.1u
MN1 n1 A2 VSS VSS nmos1v w=0.24u l=0.1u
MN2 Y B VSS VSS nmos1v w=0.12u l=0.1u
MP0 p1 A1 VDD VDD pmos1v w=0.48u l=0.1u
MP1 p1 A2 VDD VDD pmos1v w=0.48u l=0.1u
MP2 Y B p1 VDD pmos1v w=0.48u l=0.1u
.ENDS AOI21_X1

.SUBCKT INV_X1 A Y VDD VSS
MN0 Y A VSS VSS nmos1v w=0.12u l=0.1u
MP0 Y A VDD VDD pmos1v w=0.24u l=0.1u
.ENDS INV_X1

.SUBCKT INV_X4 A Y VDD VSS
MN1 Y A VSS VSS nmos1v w=0.48u l=0.1u
MP2 Y A VDD VDD pmos1v w=0.96u l=0.1u
.ENDS INV_X4

.SUBCKT NAND2_X1 A B Y VDD VSS
MN0 Y A n1 VSS nmos1v w=0.24u l=0.1u
MN1 n1 B VSS VSS nmos1v w=0.24u l=0.1u
MP0 Y A VDD VDD pmos1v w=0.24u l=0.1u
MP1 Y B VDD VDD pmos1v w=0.24u l=0.1u
.ENDS NAND2_X1

.SUBCKT NOR2_X1 A B Y VDD VSS
MN0 Y A VSS VSS nmos1v w=0.12u l=0.1u
MN1 Y B VSS VSS nmos1v w=0.12u l=0.1u
MP0 p1 A VDD VDD pmos1v w=0.48u l=0.1u
MP1 Y B p1 VDD pmos1v w=0.48u l=0.1u
.ENDS NOR2_X1

.SUBCKT OAI21_X1 A1 A2 B Y VDD VSS
MN0 Y A1 n1 VSS nmos1v w=0.24u l=0.1u
MN1 Y A2 n1 VSS nmos1v w=0.24u l=0.1u
MN2 n1 B VSS VSS nmos1v w=0.24u l=0.1u
MP0 p1 A1 VDD VDD pmos1v w=0.48u l=0.1u
MP1 Y A2 p1 VDD pmos1v w=0.48u l=0.1u
MP2 Y B VDD VDD pmos1v w=0.24u l=0.1u
.ENDS OAI21_X1

.SUBCKT XNOR2_X1 A B Y VDD VSS
MN0 An A VSS VSS nmos1v w=0.12u l=0.1u
MP0 An A VDD VDD pmos1v w=0.24u l=0.1u
MN1 Bn B VSS VSS nmos1v w=0.12u l=0.1u
MP1 Bn B VDD VDD pmos1v w=0.24u l=0.1u
MN2 Y A n1 VSS nmos1v w=0.24u l=0.1u
MN3 n1 Bn VSS VSS nmos1v w=0.24u l=0.1u
MN4 Y An n2 VSS nmos1v w=0.24u l=0.1u
MN5 n2 B VSS VSS nmos1v w=0.24u l=0.1u
MP2 p1 A VDD VDD pmos1v w=0.48u l=0.1u
MP3 p1 Bn VDD VDD pmos1v w=0.48u l=0.1u
MP4 Y An p1 VDD pmos1v w=0.48u l=0.1u
MP5 Y B p1 VDD pmos1v w=0.48u l=0.1u
.ENDS XNOR2_X1

.SUBCKT XOR2_X1 A B Y VDD VSS
MN0 An A VSS VSS nmos1v w=0.12u l=0.1u
MP0 An A VDD VDD pmos1v w=0.24u l=0.1u
MN1 Bn B VSS VSS nmos1v w=0.12u l=0.1u
MP1 Bn B VDD VDD pmos1v w=0.24u l=0.1u
MN2 Y A n1 VSS nmos1v w=0.24u l=0.1u
MN3 n1 B VSS VSS nmos1v w=0.24u l=0.1u
MN4 Y An n2 VSS nmos1v w=0.24u l=0.1u
MN5 n2 Bn VSS VSS nmos1v w=0.24u l=0.1u
MP2 p1 A VDD VDD pmos1v w=0.48u l=0.1u
MP3 p1 B VDD VDD pmos1v w=0.48u l=0.1u
MP4 Y An p1 VDD pmos1v w=0.48u l=0.1u
MP5 Y Bn p1 VDD pmos1v w=0.48u l=0.1u
.ENDS XOR2_X1

.SUBCKT DIV32 A_0 A_1 A_2 A_3 A_4 A_5 A_6 A_7 A_8 A_9 A_10 A_11 A_12 A_13 A_14 A_15 A_16 A_17 A_18 A_19 A_20 A_21 A_22 A_23 A_24 A_25 A_26 A_27 A_28 A_29 A_30 A_31 B_0 B_1 B_2 B_3 B_4 B_5 B_6 B_7 B_8 B_9 B_10 B_11 B_12 B_13 B_14 B_15 B_16 B_17 B_18 B_19 B_20 B_21 B_22 B_23 B_24 B_25 B_26 B_27 B_28 B_29 B_30 B_31 Q_0 Q_1 Q_2 Q_3 Q_4 Q_5 Q_6 Q_7 Q_8 Q_9 Q_10 Q_11 Q_12 Q_13 Q_14 Q_15 Q_16 Q_17 Q_18 Q_19 Q_20 Q_21 Q_22 Q_23 Q_24 Q_25 Q_26 Q_27 Q_28 Q_29 Q_30 Q_31 R_0 R_1 R_2 R_3 R_4 R_5 R_6 R_7 R_8 R_9 R_10 R_11 R_12 R_13 R_14 R_15 R_16 R_17 R_18 R_19 R_20 R_21 R_22 R_23 R_24 R_25 R_26 R_27 R_28 R_29 R_30 R_31 V DZ VDD VSS
XI0 A_31 A_31_b0 VDD VSS INV_X1
XI1 A_31_b0 A_31_b1_0 VDD VSS INV_X4
XI2 A_31_b1_0 A_31_b2_0 VDD VSS INV_X4
XI3 A_31_b1_0 A_31_b2_1 VDD VSS INV_X4
XI4 A_31_b1_0 A_31_b2_2 VDD VSS INV_X4
XI5 A_31_b2_0 A_31_b3_0 VDD VSS INV_X4
XI6 A_31_b2_0 A_31_b3_1 VDD VSS INV_X4
XI7 A_31_b2_0 A_31_b3_2 VDD VSS INV_X4
XI8 A_31_b2_0 A_31_b3_3 VDD VSS INV_X4
XI9 A_31_b2_1 A_31_b3_4 VDD VSS INV_X4
XI10 A_31_b2_1 A_31_b3_5 VDD VSS INV_X4
XI11 A_31_b2_1 A_31_b3_6 VDD VSS INV_X4
XI12 A_31_b2_1 A_31_b3_7 VDD VSS INV_X4
XI13 A_31_b2_2 A_31_b3_8 VDD VSS INV_X4
XI14 A_31_b2_2 A_31_b3_9 VDD VSS INV_X4
XI15 A_31_b2_2 A_31_b3_10 VDD VSS INV_X4
XI16 B_31 B_31_b0 VDD VSS INV_X1
XI17 B_31_b0 B_31_b1_0 VDD VSS INV_X4
XI18 B_31_b1_0 B_31_b2_0 VDD VSS INV_X4
XI19 B_31_b1_0 B_31_b2_1 VDD VSS INV_X4
XI20 B_31_b2_0 B_31_b3_0 VDD VSS INV_X4
XI21 B_31_b2_0 B_31_b3_1 VDD VSS INV_X4
XI22 B_31_b2_0 B_31_b3_2 VDD VSS INV_X4
XI23 B_31_b2_1 B_31_b3_3 VDD VSS INV_X4
XI24 B_31_b2_1 B_31_b3_4 VDD VSS INV_X4
XI25 B_31_b2_1 B_31_b3_5 VDD VSS INV_X4
XI26 B_0 B_0_b0 VDD VSS INV_X1
XI27 B_0_b0 B_0_b1_0 VDD VSS INV_X4
XI28 B_0_b1_0 B_0_b2_0 VDD VSS INV_X4
XI29 B_0_b1_0 B_0_b2_1 VDD VSS INV_X4
XI30 B_0_b2_0 B_0_b3_0 VDD VSS INV_X4
XI31 B_0_b2_0 B_0_b3_1 VDD VSS INV_X4
XI32 B_0_b2_0 B_0_b3_2 VDD VSS INV_X4
XI33 B_0_b2_1 B_0_b3_3 VDD VSS INV_X4
XI34 B_0_b2_1 B_0_b3_4 VDD VSS INV_X4
XI35 B_0_b2_1 B_0_b3_5 VDD VSS INV_X4
XI36 A_31_b3_0 A_0 nakn1 VDD VSS NAND2_X1
XI37 A_1 nakn1 aa1 VDD VSS XNOR2_X1
XI38 nakn1 nak1 VDD VSS INV_X1
XI39 A_31_b3_0 A_1 nak1 nakn2 VDD VSS AOI21_X1
XI40 A_2 nakn2 aa2 VDD VSS XNOR2_X1
XI41 nakn2 nak2 VDD VSS INV_X1
XI42 A_31_b3_0 A_2 nak2 nakn3 VDD VSS AOI21_X1
XI43 A_3 nakn3 aa3 VDD VSS XNOR2_X1
XI44 nakn3 nak3 VDD VSS INV_X1
XI45 A_31_b3_0 A_3 nak3 nakn4 VDD VSS AOI21_X1
XI46 A_4 nakn4 aa4 VDD VSS XNOR2_X1
XI47 nakn4 nak4 VDD VSS INV_X1
XI48 A_31_b3_0 A_4 nak4 nakn5 VDD VSS AOI21_X1
XI49 A_5 nakn5 aa5 VDD VSS XNOR2_X1
XI50 nakn5 nak5 VDD VSS INV_X1
XI51 A_31_b3_0 A_5 nak5 nakn6 VDD VSS AOI21_X1
XI52 A_6 nakn6 aa6 VDD VSS XNOR2_X1
XI53 nakn6 nak6 VDD VSS INV_X1
XI54 A_31_b3_1 A_6 nak6 nakn7 VDD VSS AOI21_X1
XI55 A_7 nakn7 aa7 VDD VSS XNOR2_X1
XI56 nakn7 nak7 VDD VSS INV_X1
XI57 A_31_b3_1 A_7 nak7 nakn8 VDD VSS AOI21_X1
XI58 A_8 nakn8 aa8 VDD VSS XNOR2_X1
XI59 nakn8 nak8 VDD VSS INV_X1
XI60 A_31_b3_1 A_8 nak8 nakn9 VDD VSS AOI21_X1
XI61 A_9 nakn9 aa9 VDD VSS XNOR2_X1
XI62 nakn9 nak9 VDD VSS INV_X1
XI63 A_31_b3_1 A_9 nak9 nakn10 VDD VSS AOI21_X1
XI64 A_10 nakn10 aa10 VDD VSS XNOR2_X1
XI65 nakn10 nak10 VDD VSS INV_X1
XI66 A_31_b3_1 A_10 nak10 nakn11 VDD VSS AOI21_X1
XI67 A_11 nakn11 aa11 VDD VSS XNOR2_X1
XI68 nakn11 nak11 VDD VSS INV_X1
XI69 A_31_b3_1 A_11 nak11 nakn12 VDD VSS AOI21_X1
XI70 A_12 nakn12 aa12 VDD VSS XNOR2_X1
XI71 nakn12 nak12 VDD VSS INV_X1
XI72 A_31_b3_2 A_12 nak12 nakn13 VDD VSS AOI21_X1
XI73 A_13 nakn13 aa13 VDD VSS XNOR2_X1
XI74 nakn13 nak13 VDD VSS INV_X1
XI75 A_31_b3_2 A_13 nak13 nakn14 VDD VSS AOI21_X1
XI76 A_14 nakn14 aa14 VDD VSS XNOR2_X1
XI77 nakn14 nak14 VDD VSS INV_X1
XI78 A_31_b3_2 A_14 nak14 nakn15 VDD VSS AOI21_X1
XI79 A_15 nakn15 aa15 VDD VSS XNOR2_X1
XI80 nakn15 nak15 VDD VSS INV_X1
XI81 A_31_b3_2 A_15 nak15 nakn16 VDD VSS AOI21_X1
XI82 A_16 nakn16 aa16 VDD VSS XNOR2_X1
XI83 nakn16 nak16 VDD VSS INV_X1
XI84 A_31_b3_2 A_16 nak16 nakn17 VDD VSS AOI21_X1
XI85 A_17 nakn17 aa17 VDD VSS XNOR2_X1
XI86 nakn17 nak17 VDD VSS INV_X1
XI87 A_31_b3_2 A_17 nak17 nakn18 VDD VSS AOI21_X1
XI88 A_18 nakn18 aa18 VDD VSS XNOR2_X1
XI89 nakn18 nak18 VDD VSS INV_X1
XI90 A_31_b3_3 A_18 nak18 nakn19 VDD VSS AOI21_X1
XI91 A_19 nakn19 aa19 VDD VSS XNOR2_X1
XI92 nakn19 nak19 VDD VSS INV_X1
XI93 A_31_b3_3 A_19 nak19 nakn20 VDD VSS AOI21_X1
XI94 A_20 nakn20 aa20 VDD VSS XNOR2_X1
XI95 nakn20 nak20 VDD VSS INV_X1
XI96 A_31_b3_3 A_20 nak20 nakn21 VDD VSS AOI21_X1
XI97 A_21 nakn21 aa21 VDD VSS XNOR2_X1
XI98 nakn21 nak21 VDD VSS INV_X1
XI99 A_31_b3_3 A_21 nak21 nakn22 VDD VSS AOI21_X1
XI100 A_22 nakn22 aa22 VDD VSS XNOR2_X1
XI101 nakn22 nak22 VDD VSS INV_X1
XI102 A_31_b3_3 A_22 nak22 nakn23 VDD VSS AOI21_X1
XI103 A_23 nakn23 aa23 VDD VSS XNOR2_X1
XI104 nakn23 nak23 VDD VSS INV_X1
XI105 A_31_b3_3 A_23 nak23 nakn24 VDD VSS AOI21_X1
XI106 A_24 nakn24 aa24 VDD VSS XNOR2_X1
XI107 nakn24 nak24 VDD VSS INV_X1
XI108 A_31_b3_4 A_24 nak24 nakn25 VDD VSS AOI21_X1
XI109 A_25 nakn25 aa25 VDD VSS XNOR2_X1
XI110 nakn25 nak25 VDD VSS INV_X1
XI111 A_31_b3_4 A_25 nak25 nakn26 VDD VSS AOI21_X1
XI112 A_26 nakn26 aa26 VDD VSS XNOR2_X1
XI113 nakn26 nak26 VDD VSS INV_X1
XI114 A_31_b3_4 A_26 nak26 nakn27 VDD VSS AOI21_X1
XI115 A_27 nakn27 aa27 VDD VSS XNOR2_X1
XI116 nakn27 nak27 VDD VSS INV_X1
XI117 A_31_b3_4 A_27 nak27 nakn28 VDD VSS AOI21_X1
XI118 A_28 nakn28 aa28 VDD VSS XNOR2_X1
XI119 nakn28 nak28 VDD VSS INV_X1
XI120 A_31_b3_4 A_28 nak28 nakn29 VDD VSS AOI21_X1
XI121 A_29 nakn29 aa29 VDD VSS XNOR2_X1
XI122 nakn29 nak29 VDD VSS INV_X1
XI123 A_31_b3_4 A_29 nak29 nakn30 VDD VSS AOI21_X1
XI124 A_30 nakn30 aa30 VDD VSS XNOR2_X1
XI125 nakn30 nak30 VDD VSS INV_X1
XI126 A_31_b3_5 A_30 nak30 nakn31 VDD VSS AOI21_X1
XI127 A_31_b3_5 nakn31 aa31 VDD VSS XNOR2_X1
XI128 B_31_b3_0 B_0_b3_0 nbkn1 VDD VSS NAND2_X1
XI129 B_1 nbkn1 dd1 VDD VSS XNOR2_X1
XI130 dd1 dd1_b0 VDD VSS INV_X1
XI131 dd1_b0 dd1_b1_0 VDD VSS INV_X4
XI132 dd1_b1_0 dd1_b2_0 VDD VSS INV_X4
XI133 dd1_b1_0 dd1_b2_1 VDD VSS INV_X4
XI134 dd1_b2_0 dd1_b3_0 VDD VSS INV_X4
XI135 dd1_b2_0 dd1_b3_1 VDD VSS INV_X4
XI136 dd1_b2_0 dd1_b3_2 VDD VSS INV_X4
XI137 dd1_b2_1 dd1_b3_3 VDD VSS INV_X4
XI138 dd1_b2_1 dd1_b3_4 VDD VSS INV_X4
XI139 dd1_b2_1 dd1_b3_5 VDD VSS INV_X4
XI140 nbkn1 nbk1 VDD VSS INV_X1
XI141 B_31_b3_0 B_1 nbk1 nbkn2 VDD VSS AOI21_X1
XI142 B_2 nbkn2 dd2 VDD VSS XNOR2_X1
XI143 dd2 dd2_b0 VDD VSS INV_X1
XI144 dd2_b0 dd2_b1_0 VDD VSS INV_X4
XI145 dd2_b1_0 dd2_b2_0 VDD VSS INV_X4
XI146 dd2_b1_0 dd2_b2_1 VDD VSS INV_X4
XI147 dd2_b2_0 dd2_b3_0 VDD VSS INV_X4
XI148 dd2_b2_0 dd2_b3_1 VDD VSS INV_X4
XI149 dd2_b2_0 dd2_b3_2 VDD VSS INV_X4
XI150 dd2_b2_1 dd2_b3_3 VDD VSS INV_X4
XI151 dd2_b2_1 dd2_b3_4 VDD VSS INV_X4
XI152 dd2_b2_1 dd2_b3_5 VDD VSS INV_X4
XI153 nbkn2 nbk2 VDD VSS INV_X1
XI154 B_31_b3_0 B_2 nbk2 nbkn3 VDD VSS AOI21_X1
XI155 B_3 nbkn3 dd3 VDD VSS XNOR2_X1
XI156 dd3 dd3_b0 VDD VSS INV_X1
XI157 dd3_b0 dd3_b1_0 VDD VSS INV_X4
XI158 dd3_b1_0 dd3_b2_0 VDD VSS INV_X4
XI159 dd3_b1_0 dd3_b2_1 VDD VSS INV_X4
XI160 dd3_b2_0 dd3_b3_0 VDD VSS INV_X4
XI161 dd3_b2_0 dd3_b3_1 VDD VSS INV_X4
XI162 dd3_b2_0 dd3_b3_2 VDD VSS INV_X4
XI163 dd3_b2_1 dd3_b3_3 VDD VSS INV_X4
XI164 dd3_b2_1 dd3_b3_4 VDD VSS INV_X4
XI165 dd3_b2_1 dd3_b3_5 VDD VSS INV_X4
XI166 nbkn3 nbk3 VDD VSS INV_X1
XI167 B_31_b3_0 B_3 nbk3 nbkn4 VDD VSS AOI21_X1
XI168 B_4 nbkn4 dd4 VDD VSS XNOR2_X1
XI169 dd4 dd4_b0 VDD VSS INV_X1
XI170 dd4_b0 dd4_b1_0 VDD VSS INV_X4
XI171 dd4_b1_0 dd4_b2_0 VDD VSS INV_X4
XI172 dd4_b1_0 dd4_b2_1 VDD VSS INV_X4
XI173 dd4_b2_0 dd4_b3_0 VDD VSS INV_X4
XI174 dd4_b2_0 dd4_b3_1 VDD VSS INV_X4
XI175 dd4_b2_0 dd4_b3_2 VDD VSS INV_X4
XI176 dd4_b2_1 dd4_b3_3 VDD VSS INV_X4
XI177 dd4_b2_1 dd4_b3_4 VDD VSS INV_X4
XI178 dd4_b2_1 dd4_b3_5 VDD VSS INV_X4
XI179 nbkn4 nbk4 VDD VSS INV_X1
XI180 B_31_b3_0 B_4 nbk4 nbkn5 VDD VSS AOI21_X1
XI181 B_5 nbkn5 dd5 VDD VSS XNOR2_X1
XI182 dd5 dd5_b0 VDD VSS INV_X1
XI183 dd5_b0 dd5_b1_0 VDD VSS INV_X4
XI184 dd5_b1_0 dd5_b2_0 VDD VSS INV_X4
XI185 dd5_b1_0 dd5_b2_1 VDD VSS INV_X4
XI186 dd5_b2_0 dd5_b3_0 VDD VSS INV_X4
XI187 dd5_b2_0 dd5_b3_1 VDD VSS INV_X4
XI188 dd5_b2_0 dd5_b3_2 VDD VSS INV_X4
XI189 dd5_b2_1 dd5_b3_3 VDD VSS INV_X4
XI190 dd5_b2_1 dd5_b3_4 VDD VSS INV_X4
XI191 dd5_b2_1 dd5_b3_5 VDD VSS INV_X4
XI192 nbkn5 nbk5 VDD VSS INV_X1
XI193 B_31_b3_0 B_5 nbk5 nbkn6 VDD VSS AOI21_X1
XI194 B_6 nbkn6 dd6 VDD VSS XNOR2_X1
XI195 dd6 dd6_b0 VDD VSS INV_X1
XI196 dd6_b0 dd6_b1_0 VDD VSS INV_X4
XI197 dd6_b1_0 dd6_b2_0 VDD VSS INV_X4
XI198 dd6_b1_0 dd6_b2_1 VDD VSS INV_X4
XI199 dd6_b2_0 dd6_b3_0 VDD VSS INV_X4
XI200 dd6_b2_0 dd6_b3_1 VDD VSS INV_X4
XI201 dd6_b2_0 dd6_b3_2 VDD VSS INV_X4
XI202 dd6_b2_1 dd6_b3_3 VDD VSS INV_X4
XI203 dd6_b2_1 dd6_b3_4 VDD VSS INV_X4
XI204 dd6_b2_1 dd6_b3_5 VDD VSS INV_X4
XI205 nbkn6 nbk6 VDD VSS INV_X1
XI206 B_31_b3_1 B_6 nbk6 nbkn7 VDD VSS AOI21_X1
XI207 B_7 nbkn7 dd7 VDD VSS XNOR2_X1
XI208 dd7 dd7_b0 VDD VSS INV_X1
XI209 dd7_b0 dd7_b1_0 VDD VSS INV_X4
XI210 dd7_b1_0 dd7_b2_0 VDD VSS INV_X4
XI211 dd7_b1_0 dd7_b2_1 VDD VSS INV_X4
XI212 dd7_b2_0 dd7_b3_0 VDD VSS INV_X4
XI213 dd7_b2_0 dd7_b3_1 VDD VSS INV_X4
XI214 dd7_b2_0 dd7_b3_2 VDD VSS INV_X4
XI215 dd7_b2_1 dd7_b3_3 VDD VSS INV_X4
XI216 dd7_b2_1 dd7_b3_4 VDD VSS INV_X4
XI217 dd7_b2_1 dd7_b3_5 VDD VSS INV_X4
XI218 nbkn7 nbk7 VDD VSS INV_X1
XI219 B_31_b3_1 B_7 nbk7 nbkn8 VDD VSS AOI21_X1
XI220 B_8 nbkn8 dd8 VDD VSS XNOR2_X1
XI221 dd8 dd8_b0 VDD VSS INV_X1
XI222 dd8_b0 dd8_b1_0 VDD VSS INV_X4
XI223 dd8_b1_0 dd8_b2_0 VDD VSS INV_X4
XI224 dd8_b1_0 dd8_b2_1 VDD VSS INV_X4
XI225 dd8_b2_0 dd8_b3_0 VDD VSS INV_X4
XI226 dd8_b2_0 dd8_b3_1 VDD VSS INV_X4
XI227 dd8_b2_0 dd8_b3_2 VDD VSS INV_X4
XI228 dd8_b2_1 dd8_b3_3 VDD VSS INV_X4
XI229 dd8_b2_1 dd8_b3_4 VDD VSS INV_X4
XI230 dd8_b2_1 dd8_b3_5 VDD VSS INV_X4
XI231 nbkn8 nbk8 VDD VSS INV_X1
XI232 B_31_b3_1 B_8 nbk8 nbkn9 VDD VSS AOI21_X1
XI233 B_9 nbkn9 dd9 VDD VSS XNOR2_X1
XI234 dd9 dd9_b0 VDD VSS INV_X1
XI235 dd9_b0 dd9_b1_0 VDD VSS INV_X4
XI236 dd9_b1_0 dd9_b2_0 VDD VSS INV_X4
XI237 dd9_b1_0 dd9_b2_1 VDD VSS INV_X4
XI238 dd9_b2_0 dd9_b3_0 VDD VSS INV_X4
XI239 dd9_b2_0 dd9_b3_1 VDD VSS INV_X4
XI240 dd9_b2_0 dd9_b3_2 VDD VSS INV_X4
XI241 dd9_b2_1 dd9_b3_3 VDD VSS INV_X4
XI242 dd9_b2_1 dd9_b3_4 VDD VSS INV_X4
XI243 dd9_b2_1 dd9_b3_5 VDD VSS INV_X4
XI244 nbkn9 nbk9 VDD VSS INV_X1
XI245 B_31_b3_1 B_9 nbk9 nbkn10 VDD VSS AOI21_X1
XI246 B_10 nbkn10 dd10 VDD VSS XNOR2_X1
XI247 dd10 dd10_b0 VDD VSS INV_X1
XI248 dd10_b0 dd10_b1_0 VDD VSS INV_X4
XI249 dd10_b1_0 dd10_b2_0 VDD VSS INV_X4
XI250 dd10_b1_0 dd10_b2_1 VDD VSS INV_X4
XI251 dd10_b2_0 dd10_b3_0 VDD VSS INV_X4
XI252 dd10_b2_0 dd10_b3_1 VDD VSS INV_X4
XI253 dd10_b2_0 dd10_b3_2 VDD VSS INV_X4
XI254 dd10_b2_1 dd10_b3_3 VDD VSS INV_X4
XI255 dd10_b2_1 dd10_b3_4 VDD VSS INV_X4
XI256 dd10_b2_1 dd10_b3_5 VDD VSS INV_X4
XI257 nbkn10 nbk10 VDD VSS INV_X1
XI258 B_31_b3_1 B_10 nbk10 nbkn11 VDD VSS AOI21_X1
XI259 B_11 nbkn11 dd11 VDD VSS XNOR2_X1
XI260 dd11 dd11_b0 VDD VSS INV_X1
XI261 dd11_b0 dd11_b1_0 VDD VSS INV_X4
XI262 dd11_b1_0 dd11_b2_0 VDD VSS INV_X4
XI263 dd11_b1_0 dd11_b2_1 VDD VSS INV_X4
XI264 dd11_b2_0 dd11_b3_0 VDD VSS INV_X4
XI265 dd11_b2_0 dd11_b3_1 VDD VSS INV_X4
XI266 dd11_b2_0 dd11_b3_2 VDD VSS INV_X4
XI267 dd11_b2_1 dd11_b3_3 VDD VSS INV_X4
XI268 dd11_b2_1 dd11_b3_4 VDD VSS INV_X4
XI269 dd11_b2_1 dd11_b3_5 VDD VSS INV_X4
XI270 nbkn11 nbk11 VDD VSS INV_X1
XI271 B_31_b3_1 B_11 nbk11 nbkn12 VDD VSS AOI21_X1
XI272 B_12 nbkn12 dd12 VDD VSS XNOR2_X1
XI273 dd12 dd12_b0 VDD VSS INV_X1
XI274 dd12_b0 dd12_b1_0 VDD VSS INV_X4
XI275 dd12_b1_0 dd12_b2_0 VDD VSS INV_X4
XI276 dd12_b1_0 dd12_b2_1 VDD VSS INV_X4
XI277 dd12_b2_0 dd12_b3_0 VDD VSS INV_X4
XI278 dd12_b2_0 dd12_b3_1 VDD VSS INV_X4
XI279 dd12_b2_0 dd12_b3_2 VDD VSS INV_X4
XI280 dd12_b2_1 dd12_b3_3 VDD VSS INV_X4
XI281 dd12_b2_1 dd12_b3_4 VDD VSS INV_X4
XI282 dd12_b2_1 dd12_b3_5 VDD VSS INV_X4
XI283 nbkn12 nbk12 VDD VSS INV_X1
XI284 B_31_b3_2 B_12 nbk12 nbkn13 VDD VSS AOI21_X1
XI285 B_13 nbkn13 dd13 VDD VSS XNOR2_X1
XI286 dd13 dd13_b0 VDD VSS INV_X1
XI287 dd13_b0 dd13_b1_0 VDD VSS INV_X4
XI288 dd13_b1_0 dd13_b2_0 VDD VSS INV_X4
XI289 dd13_b1_0 dd13_b2_1 VDD VSS INV_X4
XI290 dd13_b2_0 dd13_b3_0 VDD VSS INV_X4
XI291 dd13_b2_0 dd13_b3_1 VDD VSS INV_X4
XI292 dd13_b2_0 dd13_b3_2 VDD VSS INV_X4
XI293 dd13_b2_1 dd13_b3_3 VDD VSS INV_X4
XI294 dd13_b2_1 dd13_b3_4 VDD VSS INV_X4
XI295 dd13_b2_1 dd13_b3_5 VDD VSS INV_X4
XI296 nbkn13 nbk13 VDD VSS INV_X1
XI297 B_31_b3_2 B_13 nbk13 nbkn14 VDD VSS AOI21_X1
XI298 B_14 nbkn14 dd14 VDD VSS XNOR2_X1
XI299 dd14 dd14_b0 VDD VSS INV_X1
XI300 dd14_b0 dd14_b1_0 VDD VSS INV_X4
XI301 dd14_b1_0 dd14_b2_0 VDD VSS INV_X4
XI302 dd14_b1_0 dd14_b2_1 VDD VSS INV_X4
XI303 dd14_b2_0 dd14_b3_0 VDD VSS INV_X4
XI304 dd14_b2_0 dd14_b3_1 VDD VSS INV_X4
XI305 dd14_b2_0 dd14_b3_2 VDD VSS INV_X4
XI306 dd14_b2_1 dd14_b3_3 VDD VSS INV_X4
XI307 dd14_b2_1 dd14_b3_4 VDD VSS INV_X4
XI308 dd14_b2_1 dd14_b3_5 VDD VSS INV_X4
XI309 nbkn14 nbk14 VDD VSS INV_X1
XI310 B_31_b3_2 B_14 nbk14 nbkn15 VDD VSS AOI21_X1
XI311 B_15 nbkn15 dd15 VDD VSS XNOR2_X1
XI312 dd15 dd15_b0 VDD VSS INV_X1
XI313 dd15_b0 dd15_b1_0 VDD VSS INV_X4
XI314 dd15_b1_0 dd15_b2_0 VDD VSS INV_X4
XI315 dd15_b1_0 dd15_b2_1 VDD VSS INV_X4
XI316 dd15_b2_0 dd15_b3_0 VDD VSS INV_X4
XI317 dd15_b2_0 dd15_b3_1 VDD VSS INV_X4
XI318 dd15_b2_0 dd15_b3_2 VDD VSS INV_X4
XI319 dd15_b2_1 dd15_b3_3 VDD VSS INV_X4
XI320 dd15_b2_1 dd15_b3_4 VDD VSS INV_X4
XI321 dd15_b2_1 dd15_b3_5 VDD VSS INV_X4
XI322 nbkn15 nbk15 VDD VSS INV_X1
XI323 B_31_b3_2 B_15 nbk15 nbkn16 VDD VSS AOI21_X1
XI324 B_16 nbkn16 dd16 VDD VSS XNOR2_X1
XI325 dd16 dd16_b0 VDD VSS INV_X1
XI326 dd16_b0 dd16_b1_0 VDD VSS INV_X4
XI327 dd16_b1_0 dd16_b2_0 VDD VSS INV_X4
XI328 dd16_b1_0 dd16_b2_1 VDD VSS INV_X4
XI329 dd16_b2_0 dd16_b3_0 VDD VSS INV_X4
XI330 dd16_b2_0 dd16_b3_1 VDD VSS INV_X4
XI331 dd16_b2_0 dd16_b3_2 VDD VSS INV_X4
XI332 dd16_b2_1 dd16_b3_3 VDD VSS INV_X4
XI333 dd16_b2_1 dd16_b3_4 VDD VSS INV_X4
XI334 dd16_b2_1 dd16_b3_5 VDD VSS INV_X4
XI335 nbkn16 nbk16 VDD VSS INV_X1
XI336 B_31_b3_2 B_16 nbk16 nbkn17 VDD VSS AOI21_X1
XI337 B_17 nbkn17 dd17 VDD VSS XNOR2_X1
XI338 dd17 dd17_b0 VDD VSS INV_X1
XI339 dd17_b0 dd17_b1_0 VDD VSS INV_X4
XI340 dd17_b1_0 dd17_b2_0 VDD VSS INV_X4
XI341 dd17_b1_0 dd17_b2_1 VDD VSS INV_X4
XI342 dd17_b2_0 dd17_b3_0 VDD VSS INV_X4
XI343 dd17_b2_0 dd17_b3_1 VDD VSS INV_X4
XI344 dd17_b2_0 dd17_b3_2 VDD VSS INV_X4
XI345 dd17_b2_1 dd17_b3_3 VDD VSS INV_X4
XI346 dd17_b2_1 dd17_b3_4 VDD VSS INV_X4
XI347 dd17_b2_1 dd17_b3_5 VDD VSS INV_X4
XI348 nbkn17 nbk17 VDD VSS INV_X1
XI349 B_31_b3_3 B_17 nbk17 nbkn18 VDD VSS AOI21_X1
XI350 B_18 nbkn18 dd18 VDD VSS XNOR2_X1
XI351 dd18 dd18_b0 VDD VSS INV_X1
XI352 dd18_b0 dd18_b1_0 VDD VSS INV_X4
XI353 dd18_b1_0 dd18_b2_0 VDD VSS INV_X4
XI354 dd18_b1_0 dd18_b2_1 VDD VSS INV_X4
XI355 dd18_b2_0 dd18_b3_0 VDD VSS INV_X4
XI356 dd18_b2_0 dd18_b3_1 VDD VSS INV_X4
XI357 dd18_b2_0 dd18_b3_2 VDD VSS INV_X4
XI358 dd18_b2_1 dd18_b3_3 VDD VSS INV_X4
XI359 dd18_b2_1 dd18_b3_4 VDD VSS INV_X4
XI360 dd18_b2_1 dd18_b3_5 VDD VSS INV_X4
XI361 nbkn18 nbk18 VDD VSS INV_X1
XI362 B_31_b3_3 B_18 nbk18 nbkn19 VDD VSS AOI21_X1
XI363 B_19 nbkn19 dd19 VDD VSS XNOR2_X1
XI364 dd19 dd19_b0 VDD VSS INV_X1
XI365 dd19_b0 dd19_b1_0 VDD VSS INV_X4
XI366 dd19_b1_0 dd19_b2_0 VDD VSS INV_X4
XI367 dd19_b1_0 dd19_b2_1 VDD VSS INV_X4
XI368 dd19_b2_0 dd19_b3_0 VDD VSS INV_X4
XI369 dd19_b2_0 dd19_b3_1 VDD VSS INV_X4
XI370 dd19_b2_0 dd19_b3_2 VDD VSS INV_X4
XI371 dd19_b2_1 dd19_b3_3 VDD VSS INV_X4
XI372 dd19_b2_1 dd19_b3_4 VDD VSS INV_X4
XI373 dd19_b2_1 dd19_b3_5 VDD VSS INV_X4
XI374 nbkn19 nbk19 VDD VSS INV_X1
XI375 B_31_b3_3 B_19 nbk19 nbkn20 VDD VSS AOI21_X1
XI376 B_20 nbkn20 dd20 VDD VSS XNOR2_X1
XI377 dd20 dd20_b0 VDD VSS INV_X1
XI378 dd20_b0 dd20_b1_0 VDD VSS INV_X4
XI379 dd20_b1_0 dd20_b2_0 VDD VSS INV_X4
XI380 dd20_b1_0 dd20_b2_1 VDD VSS INV_X4
XI381 dd20_b2_0 dd20_b3_0 VDD VSS INV_X4
XI382 dd20_b2_0 dd20_b3_1 VDD VSS INV_X4
XI383 dd20_b2_0 dd20_b3_2 VDD VSS INV_X4
XI384 dd20_b2_1 dd20_b3_3 VDD VSS INV_X4
XI385 dd20_b2_1 dd20_b3_4 VDD VSS INV_X4
XI386 dd20_b2_1 dd20_b3_5 VDD VSS INV_X4
XI387 nbkn20 nbk20 VDD VSS INV_X1
XI388 B_31_b3_3 B_20 nbk20 nbkn21 VDD VSS AOI21_X1
XI389 B_21 nbkn21 dd21 VDD VSS XNOR2_X1
XI390 dd21 dd21_b0 VDD VSS INV_X1
XI391 dd21_b0 dd21_b1_0 VDD VSS INV_X4
XI392 dd21_b1_0 dd21_b2_0 VDD VSS INV_X4
XI393 dd21_b1_0 dd21_b2_1 VDD VSS INV_X4
XI394 dd21_b2_0 dd21_b3_0 VDD VSS INV_X4
XI395 dd21_b2_0 dd21_b3_1 VDD VSS INV_X4
XI396 dd21_b2_0 dd21_b3_2 VDD VSS INV_X4
XI397 dd21_b2_1 dd21_b3_3 VDD VSS INV_X4
XI398 dd21_b2_1 dd21_b3_4 VDD VSS INV_X4
XI399 dd21_b2_1 dd21_b3_5 VDD VSS INV_X4
XI400 nbkn21 nbk21 VDD VSS INV_X1
XI401 B_31_b3_3 B_21 nbk21 nbkn22 VDD VSS AOI21_X1
XI402 B_22 nbkn22 dd22 VDD VSS XNOR2_X1
XI403 dd22 dd22_b0 VDD VSS INV_X1
XI404 dd22_b0 dd22_b1_0 VDD VSS INV_X4
XI405 dd22_b1_0 dd22_b2_0 VDD VSS INV_X4
XI406 dd22_b1_0 dd22_b2_1 VDD VSS INV_X4
XI407 dd22_b2_0 dd22_b3_0 VDD VSS INV_X4
XI408 dd22_b2_0 dd22_b3_1 VDD VSS INV_X4
XI409 dd22_b2_0 dd22_b3_2 VDD VSS INV_X4
XI410 dd22_b2_1 dd22_b3_3 VDD VSS INV_X4
XI411 dd22_b2_1 dd22_b3_4 VDD VSS INV_X4
XI412 dd22_b2_1 dd22_b3_5 VDD VSS INV_X4
XI413 nbkn22 nbk22 VDD VSS INV_X1
XI414 B_31_b3_3 B_22 nbk22 nbkn23 VDD VSS AOI21_X1
XI415 B_23 nbkn23 dd23 VDD VSS XNOR2_X1
XI416 dd23 dd23_b0 VDD VSS INV_X1
XI417 dd23_b0 dd23_b1_0 VDD VSS INV_X4
XI418 dd23_b1_0 dd23_b2_0 VDD VSS INV_X4
XI419 dd23_b1_0 dd23_b2_1 VDD VSS INV_X4
XI420 dd23_b2_0 dd23_b3_0 VDD VSS INV_X4
XI421 dd23_b2_0 dd23_b3_1 VDD VSS INV_X4
XI422 dd23_b2_0 dd23_b3_2 VDD VSS INV_X4
XI423 dd23_b2_1 dd23_b3_3 VDD VSS INV_X4
XI424 dd23_b2_1 dd23_b3_4 VDD VSS INV_X4
XI425 dd23_b2_1 dd23_b3_5 VDD VSS INV_X4
XI426 nbkn23 nbk23 VDD VSS INV_X1
XI427 B_31_b3_4 B_23 nbk23 nbkn24 VDD VSS AOI21_X1
XI428 B_24 nbkn24 dd24 VDD VSS XNOR2_X1
XI429 dd24 dd24_b0 VDD VSS INV_X1
XI430 dd24_b0 dd24_b1_0 VDD VSS INV_X4
XI431 dd24_b1_0 dd24_b2_0 VDD VSS INV_X4
XI432 dd24_b1_0 dd24_b2_1 VDD VSS INV_X4
XI433 dd24_b2_0 dd24_b3_0 VDD VSS INV_X4
XI434 dd24_b2_0 dd24_b3_1 VDD VSS INV_X4
XI435 dd24_b2_0 dd24_b3_2 VDD VSS INV_X4
XI436 dd24_b2_1 dd24_b3_3 VDD VSS INV_X4
XI437 dd24_b2_1 dd24_b3_4 VDD VSS INV_X4
XI438 dd24_b2_1 dd24_b3_5 VDD VSS INV_X4
XI439 nbkn24 nbk24 VDD VSS INV_X1
XI440 B_31_b3_4 B_24 nbk24 nbkn25 VDD VSS AOI21_X1
XI441 B_25 nbkn25 dd25 VDD VSS XNOR2_X1
XI442 dd25 dd25_b0 VDD VSS INV_X1
XI443 dd25_b0 dd25_b1_0 VDD VSS INV_X4
XI444 dd25_b1_0 dd25_b2_0 VDD VSS INV_X4
XI445 dd25_b1_0 dd25_b2_1 VDD VSS INV_X4
XI446 dd25_b2_0 dd25_b3_0 VDD VSS INV_X4
XI447 dd25_b2_0 dd25_b3_1 VDD VSS INV_X4
XI448 dd25_b2_0 dd25_b3_2 VDD VSS INV_X4
XI449 dd25_b2_1 dd25_b3_3 VDD VSS INV_X4
XI450 dd25_b2_1 dd25_b3_4 VDD VSS INV_X4
XI451 dd25_b2_1 dd25_b3_5 VDD VSS INV_X4
XI452 nbkn25 nbk25 VDD VSS INV_X1
XI453 B_31_b3_4 B_25 nbk25 nbkn26 VDD VSS AOI21_X1
XI454 B_26 nbkn26 dd26 VDD VSS XNOR2_X1
XI455 dd26 dd26_b0 VDD VSS INV_X1
XI456 dd26_b0 dd26_b1_0 VDD VSS INV_X4
XI457 dd26_b1_0 dd26_b2_0 VDD VSS INV_X4
XI458 dd26_b1_0 dd26_b2_1 VDD VSS INV_X4
XI459 dd26_b2_0 dd26_b3_0 VDD VSS INV_X4
XI460 dd26_b2_0 dd26_b3_1 VDD VSS INV_X4
XI461 dd26_b2_0 dd26_b3_2 VDD VSS INV_X4
XI462 dd26_b2_1 dd26_b3_3 VDD VSS INV_X4
XI463 dd26_b2_1 dd26_b3_4 VDD VSS INV_X4
XI464 dd26_b2_1 dd26_b3_5 VDD VSS INV_X4
XI465 nbkn26 nbk26 VDD VSS INV_X1
XI466 B_31_b3_4 B_26 nbk26 nbkn27 VDD VSS AOI21_X1
XI467 B_27 nbkn27 dd27 VDD VSS XNOR2_X1
XI468 dd27 dd27_b0 VDD VSS INV_X1
XI469 dd27_b0 dd27_b1_0 VDD VSS INV_X4
XI470 dd27_b1_0 dd27_b2_0 VDD VSS INV_X4
XI471 dd27_b1_0 dd27_b2_1 VDD VSS INV_X4
XI472 dd27_b2_0 dd27_b3_0 VDD VSS INV_X4
XI473 dd27_b2_0 dd27_b3_1 VDD VSS INV_X4
XI474 dd27_b2_0 dd27_b3_2 VDD VSS INV_X4
XI475 dd27_b2_1 dd27_b3_3 VDD VSS INV_X4
XI476 dd27_b2_1 dd27_b3_4 VDD VSS INV_X4
XI477 dd27_b2_1 dd27_b3_5 VDD VSS INV_X4
XI478 nbkn27 nbk27 VDD VSS INV_X1
XI479 B_31_b3_4 B_27 nbk27 nbkn28 VDD VSS AOI21_X1
XI480 B_28 nbkn28 dd28 VDD VSS XNOR2_X1
XI481 dd28 dd28_b0 VDD VSS INV_X1
XI482 dd28_b0 dd28_b1_0 VDD VSS INV_X4
XI483 dd28_b1_0 dd28_b2_0 VDD VSS INV_X4
XI484 dd28_b1_0 dd28_b2_1 VDD VSS INV_X4
XI485 dd28_b2_0 dd28_b3_0 VDD VSS INV_X4
XI486 dd28_b2_0 dd28_b3_1 VDD VSS INV_X4
XI487 dd28_b2_0 dd28_b3_2 VDD VSS INV_X4
XI488 dd28_b2_1 dd28_b3_3 VDD VSS INV_X4
XI489 dd28_b2_1 dd28_b3_4 VDD VSS INV_X4
XI490 dd28_b2_1 dd28_b3_5 VDD VSS INV_X4
XI491 nbkn28 nbk28 VDD VSS INV_X1
XI492 B_31_b3_4 B_28 nbk28 nbkn29 VDD VSS AOI21_X1
XI493 B_29 nbkn29 dd29 VDD VSS XNOR2_X1
XI494 dd29 dd29_b0 VDD VSS INV_X1
XI495 dd29_b0 dd29_b1_0 VDD VSS INV_X4
XI496 dd29_b1_0 dd29_b2_0 VDD VSS INV_X4
XI497 dd29_b1_0 dd29_b2_1 VDD VSS INV_X4
XI498 dd29_b2_0 dd29_b3_0 VDD VSS INV_X4
XI499 dd29_b2_0 dd29_b3_1 VDD VSS INV_X4
XI500 dd29_b2_0 dd29_b3_2 VDD VSS INV_X4
XI501 dd29_b2_1 dd29_b3_3 VDD VSS INV_X4
XI502 dd29_b2_1 dd29_b3_4 VDD VSS INV_X4
XI503 dd29_b2_1 dd29_b3_5 VDD VSS INV_X4
XI504 nbkn29 nbk29 VDD VSS INV_X1
XI505 B_31_b3_5 B_29 nbk29 nbkn30 VDD VSS AOI21_X1
XI506 B_30 nbkn30 dd30 VDD VSS XNOR2_X1
XI507 dd30 dd30_b0 VDD VSS INV_X1
XI508 dd30_b0 dd30_b1_0 VDD VSS INV_X4
XI509 dd30_b1_0 dd30_b2_0 VDD VSS INV_X4
XI510 dd30_b1_0 dd30_b2_1 VDD VSS INV_X4
XI511 dd30_b2_0 dd30_b3_0 VDD VSS INV_X4
XI512 dd30_b2_0 dd30_b3_1 VDD VSS INV_X4
XI513 dd30_b2_0 dd30_b3_2 VDD VSS INV_X4
XI514 dd30_b2_1 dd30_b3_3 VDD VSS INV_X4
XI515 dd30_b2_1 dd30_b3_4 VDD VSS INV_X4
XI516 dd30_b2_1 dd30_b3_5 VDD VSS INV_X4
XI517 nbkn30 nbk30 VDD VSS INV_X1
XI518 B_31_b3_5 B_30 nbk30 nbkn31 VDD VSS AOI21_X1
XI519 B_31_b3_5 nbkn31 dd31 VDD VSS XNOR2_X1
XI520 dd31 dd31_b0 VDD VSS INV_X1
XI521 dd31_b0 dd31_b1_0 VDD VSS INV_X4
XI522 dd31_b1_0 dd31_b2_0 VDD VSS INV_X4
XI523 dd31_b1_0 dd31_b2_1 VDD VSS INV_X4
XI524 dd31_b2_0 dd31_b3_0 VDD VSS INV_X4
XI525 dd31_b2_0 dd31_b3_1 VDD VSS INV_X4
XI526 dd31_b2_0 dd31_b3_2 VDD VSS INV_X4
XI527 dd31_b2_1 dd31_b3_3 VDD VSS INV_X4
XI528 dd31_b2_1 dd31_b3_4 VDD VSS INV_X4
XI529 dd31_b2_1 dd31_b3_5 VDD VSS INV_X4
XI530 B_0_b3_0 VDD b0_0 VDD VSS XOR2_X1
XI531 dd1_b3_0 VDD b0_1 VDD VSS XOR2_X1
XI532 dd2_b3_0 VDD b0_2 VDD VSS XOR2_X1
XI533 dd3_b3_0 VDD b0_3 VDD VSS XOR2_X1
XI534 dd4_b3_0 VDD b0_4 VDD VSS XOR2_X1
XI535 dd5_b3_0 VDD b0_5 VDD VSS XOR2_X1
XI536 dd6_b3_0 VDD b0_6 VDD VSS XOR2_X1
XI537 dd7_b3_0 VDD b0_7 VDD VSS XOR2_X1
XI538 dd8_b3_0 VDD b0_8 VDD VSS XOR2_X1
XI539 dd9_b3_0 VDD b0_9 VDD VSS XOR2_X1
XI540 dd10_b3_0 VDD b0_10 VDD VSS XOR2_X1
XI541 dd11_b3_0 VDD b0_11 VDD VSS XOR2_X1
XI542 dd12_b3_0 VDD b0_12 VDD VSS XOR2_X1
XI543 dd13_b3_0 VDD b0_13 VDD VSS XOR2_X1
XI544 dd14_b3_0 VDD b0_14 VDD VSS XOR2_X1
XI545 dd15_b3_0 VDD b0_15 VDD VSS XOR2_X1
XI546 dd16_b3_0 VDD b0_16 VDD VSS XOR2_X1
XI547 dd17_b3_0 VDD b0_17 VDD VSS XOR2_X1
XI548 dd18_b3_0 VDD b0_18 VDD VSS XOR2_X1
XI549 dd19_b3_0 VDD b0_19 VDD VSS XOR2_X1
XI550 dd20_b3_0 VDD b0_20 VDD VSS XOR2_X1
XI551 dd21_b3_0 VDD b0_21 VDD VSS XOR2_X1
XI552 dd22_b3_0 VDD b0_22 VDD VSS XOR2_X1
XI553 dd23_b3_0 VDD b0_23 VDD VSS XOR2_X1
XI554 dd24_b3_0 VDD b0_24 VDD VSS XOR2_X1
XI555 dd25_b3_0 VDD b0_25 VDD VSS XOR2_X1
XI556 dd26_b3_0 VDD b0_26 VDD VSS XOR2_X1
XI557 dd27_b3_0 VDD b0_27 VDD VSS XOR2_X1
XI558 dd28_b3_0 VDD b0_28 VDD VSS XOR2_X1
XI559 dd29_b3_0 VDD b0_29 VDD VSS XOR2_X1
XI560 dd30_b3_0 VDD b0_30 VDD VSS XOR2_X1
XI561 dd31_b3_0 VDD b0_31 VDD VSS XOR2_X1
XI562_I0 aa31 b0_0 I562_gn0 VDD VSS NAND2_X1
XI562_I1 VSS b0_1 I562_gn1 VDD VSS NAND2_X1
XI562_I2 VSS b0_2 I562_gn2 VDD VSS NAND2_X1
XI562_I3 VSS b0_3 I562_gn3 VDD VSS NAND2_X1
XI562_I4 VSS b0_4 I562_gn4 VDD VSS NAND2_X1
XI562_I5 VSS b0_5 I562_gn5 VDD VSS NAND2_X1
XI562_I6 VSS b0_6 I562_gn6 VDD VSS NAND2_X1
XI562_I7 VSS b0_7 I562_gn7 VDD VSS NAND2_X1
XI562_I8 VSS b0_8 I562_gn8 VDD VSS NAND2_X1
XI562_I9 VSS b0_9 I562_gn9 VDD VSS NAND2_X1
XI562_I10 VSS b0_10 I562_gn10 VDD VSS NAND2_X1
XI562_I11 VSS b0_11 I562_gn11 VDD VSS NAND2_X1
XI562_I12 VSS b0_12 I562_gn12 VDD VSS NAND2_X1
XI562_I13 VSS b0_13 I562_gn13 VDD VSS NAND2_X1
XI562_I14 VSS b0_14 I562_gn14 VDD VSS NAND2_X1
XI562_I15 VSS b0_15 I562_gn15 VDD VSS NAND2_X1
XI562_I16 VSS b0_16 I562_gn16 VDD VSS NAND2_X1
XI562_I17 VSS b0_17 I562_gn17 VDD VSS NAND2_X1
XI562_I18 VSS b0_18 I562_gn18 VDD VSS NAND2_X1
XI562_I19 VSS b0_19 I562_gn19 VDD VSS NAND2_X1
XI562_I20 VSS b0_20 I562_gn20 VDD VSS NAND2_X1
XI562_I21 VSS b0_21 I562_gn21 VDD VSS NAND2_X1
XI562_I22 VSS b0_22 I562_gn22 VDD VSS NAND2_X1
XI562_I23 VSS b0_23 I562_gn23 VDD VSS NAND2_X1
XI562_I24 VSS b0_24 I562_gn24 VDD VSS NAND2_X1
XI562_I25 VSS b0_25 I562_gn25 VDD VSS NAND2_X1
XI562_I26 VSS b0_26 I562_gn26 VDD VSS NAND2_X1
XI562_I27 VSS b0_27 I562_gn27 VDD VSS NAND2_X1
XI562_I28 VSS b0_28 I562_gn28 VDD VSS NAND2_X1
XI562_I29 VSS b0_29 I562_gn29 VDD VSS NAND2_X1
XI562_I30 VSS b0_30 I562_gn30 VDD VSS NAND2_X1
XI562_I31 VSS b0_31 I562_gn31 VDD VSS NAND2_X1
XI562_I32 aa31 b0_0 I562_pn0 VDD VSS XNOR2_X1
XI562_I33 VSS b0_1 I562_pn1 VDD VSS XNOR2_X1
XI562_I34 VSS b0_2 I562_pn2 VDD VSS XNOR2_X1
XI562_I35 VSS b0_3 I562_pn3 VDD VSS XNOR2_X1
XI562_I36 VSS b0_4 I562_pn4 VDD VSS XNOR2_X1
XI562_I37 VSS b0_5 I562_pn5 VDD VSS XNOR2_X1
XI562_I38 VSS b0_6 I562_pn6 VDD VSS XNOR2_X1
XI562_I39 VSS b0_7 I562_pn7 VDD VSS XNOR2_X1
XI562_I40 VSS b0_8 I562_pn8 VDD VSS XNOR2_X1
XI562_I41 VSS b0_9 I562_pn9 VDD VSS XNOR2_X1
XI562_I42 VSS b0_10 I562_pn10 VDD VSS XNOR2_X1
XI562_I43 VSS b0_11 I562_pn11 VDD VSS XNOR2_X1
XI562_I44 VSS b0_12 I562_pn12 VDD VSS XNOR2_X1
XI562_I45 VSS b0_13 I562_pn13 VDD VSS XNOR2_X1
XI562_I46 VSS b0_14 I562_pn14 VDD VSS XNOR2_X1
XI562_I47 VSS b0_15 I562_pn15 VDD VSS XNOR2_X1
XI562_I48 VSS b0_16 I562_pn16 VDD VSS XNOR2_X1
XI562_I49 VSS b0_17 I562_pn17 VDD VSS XNOR2_X1
XI562_I50 VSS b0_18 I562_pn18 VDD VSS XNOR2_X1
XI562_I51 VSS b0_19 I562_pn19 VDD VSS XNOR2_X1
XI562_I52 VSS b0_20 I562_pn20 VDD VSS XNOR2_X1
XI562_I53 VSS b0_21 I562_pn21 VDD VSS XNOR2_X1
XI562_I54 VSS b0_22 I562_pn22 VDD VSS XNOR2_X1
XI562_I55 VSS b0_23 I562_pn23 VDD VSS XNOR2_X1
XI562_I56 VSS b0_24 I562_pn24 VDD VSS XNOR2_X1
XI562_I57 VSS b0_25 I562_pn25 VDD VSS XNOR2_X1
XI562_I58 VSS b0_26 I562_pn26 VDD VSS XNOR2_X1
XI562_I59 VSS b0_27 I562_pn27 VDD VSS XNOR2_X1
XI562_I60 VSS b0_28 I562_pn28 VDD VSS XNOR2_X1
XI562_I61 VSS b0_29 I562_pn29 VDD VSS XNOR2_X1
XI562_I62 VSS b0_30 I562_pn30 VDD VSS XNOR2_X1
XI562_I63 VSS b0_31 I562_pn31 VDD VSS XNOR2_X1
XI562_I64 VDD I562_cinn VDD VSS INV_X1
XI562_I65_XG I562_pn0 I562_cinn I562_gn0 I562_G0_0 VDD VSS OAI21_X1
XI562_I66 I562_G0_0 I562_G0_0n VDD VSS INV_X1
XI562_I67_XG I562_pn1 I562_G0_0n I562_gn1 I562_G1_0 VDD VSS OAI21_X1
XI562_I68_XG I562_pn2 I562_gn1 I562_gn2 I562_G2_1 VDD VSS OAI21_X1
XI562_I68_XP I562_pn2 I562_pn1 I562_P2_1 VDD VSS NOR2_X1
XI562_I69_XG I562_pn3 I562_gn2 I562_gn3 I562_G3_2 VDD VSS OAI21_X1
XI562_I69_XP I562_pn3 I562_pn2 I562_P3_2 VDD VSS NOR2_X1
XI562_I70_XG I562_pn4 I562_gn3 I562_gn4 I562_G4_3 VDD VSS OAI21_X1
XI562_I70_XP I562_pn4 I562_pn3 I562_P4_3 VDD VSS NOR2_X1
XI562_I71_XG I562_pn5 I562_gn4 I562_gn5 I562_G5_4 VDD VSS OAI21_X1
XI562_I71_XP I562_pn5 I562_pn4 I562_P5_4 VDD VSS NOR2_X1
XI562_I72_XG I562_pn6 I562_gn5 I562_gn6 I562_G6_5 VDD VSS OAI21_X1
XI562_I72_XP I562_pn6 I562_pn5 I562_P6_5 VDD VSS NOR2_X1
XI562_I73_XG I562_pn7 I562_gn6 I562_gn7 I562_G7_6 VDD VSS OAI21_X1
XI562_I73_XP I562_pn7 I562_pn6 I562_P7_6 VDD VSS NOR2_X1
XI562_I74_XG I562_pn8 I562_gn7 I562_gn8 I562_G8_7 VDD VSS OAI21_X1
XI562_I74_XP I562_pn8 I562_pn7 I562_P8_7 VDD VSS NOR2_X1
XI562_I75_XG I562_pn9 I562_gn8 I562_gn9 I562_G9_8 VDD VSS OAI21_X1
XI562_I75_XP I562_pn9 I562_pn8 I562_P9_8 VDD VSS NOR2_X1
XI562_I76_XG I562_pn10 I562_gn9 I562_gn10 I562_G10_9 VDD VSS OAI21_X1
XI562_I76_XP I562_pn10 I562_pn9 I562_P10_9 VDD VSS NOR2_X1
XI562_I77_XG I562_pn11 I562_gn10 I562_gn11 I562_G11_10 VDD VSS OAI21_X1
XI562_I77_XP I562_pn11 I562_pn10 I562_P11_10 VDD VSS NOR2_X1
XI562_I78_XG I562_pn12 I562_gn11 I562_gn12 I562_G12_11 VDD VSS OAI21_X1
XI562_I78_XP I562_pn12 I562_pn11 I562_P12_11 VDD VSS NOR2_X1
XI562_I79_XG I562_pn13 I562_gn12 I562_gn13 I562_G13_12 VDD VSS OAI21_X1
XI562_I79_XP I562_pn13 I562_pn12 I562_P13_12 VDD VSS NOR2_X1
XI562_I80_XG I562_pn14 I562_gn13 I562_gn14 I562_G14_13 VDD VSS OAI21_X1
XI562_I80_XP I562_pn14 I562_pn13 I562_P14_13 VDD VSS NOR2_X1
XI562_I81_XG I562_pn15 I562_gn14 I562_gn15 I562_G15_14 VDD VSS OAI21_X1
XI562_I81_XP I562_pn15 I562_pn14 I562_P15_14 VDD VSS NOR2_X1
XI562_I82_XG I562_pn16 I562_gn15 I562_gn16 I562_G16_15 VDD VSS OAI21_X1
XI562_I82_XP I562_pn16 I562_pn15 I562_P16_15 VDD VSS NOR2_X1
XI562_I83_XG I562_pn17 I562_gn16 I562_gn17 I562_G17_16 VDD VSS OAI21_X1
XI562_I83_XP I562_pn17 I562_pn16 I562_P17_16 VDD VSS NOR2_X1
XI562_I84_XG I562_pn18 I562_gn17 I562_gn18 I562_G18_17 VDD VSS OAI21_X1
XI562_I84_XP I562_pn18 I562_pn17 I562_P18_17 VDD VSS NOR2_X1
XI562_I85_XG I562_pn19 I562_gn18 I562_gn19 I562_G19_18 VDD VSS OAI21_X1
XI562_I85_XP I562_pn19 I562_pn18 I562_P19_18 VDD VSS NOR2_X1
XI562_I86_XG I562_pn20 I562_gn19 I562_gn20 I562_G20_19 VDD VSS OAI21_X1
XI562_I86_XP I562_pn20 I562_pn19 I562_P20_19 VDD VSS NOR2_X1
XI562_I87_XG I562_pn21 I562_gn20 I562_gn21 I562_G21_20 VDD VSS OAI21_X1
XI562_I87_XP I562_pn21 I562_pn20 I562_P21_20 VDD VSS NOR2_X1
XI562_I88_XG I562_pn22 I562_gn21 I562_gn22 I562_G22_21 VDD VSS OAI21_X1
XI562_I88_XP I562_pn22 I562_pn21 I562_P22_21 VDD VSS NOR2_X1
XI562_I89_XG I562_pn23 I562_gn22 I562_gn23 I562_G23_22 VDD VSS OAI21_X1
XI562_I89_XP I562_pn23 I562_pn22 I562_P23_22 VDD VSS NOR2_X1
XI562_I90_XG I562_pn24 I562_gn23 I562_gn24 I562_G24_23 VDD VSS OAI21_X1
XI562_I90_XP I562_pn24 I562_pn23 I562_P24_23 VDD VSS NOR2_X1
XI562_I91_XG I562_pn25 I562_gn24 I562_gn25 I562_G25_24 VDD VSS OAI21_X1
XI562_I91_XP I562_pn25 I562_pn24 I562_P25_24 VDD VSS NOR2_X1
XI562_I92_XG I562_pn26 I562_gn25 I562_gn26 I562_G26_25 VDD VSS OAI21_X1
XI562_I92_XP I562_pn26 I562_pn25 I562_P26_25 VDD VSS NOR2_X1
XI562_I93_XG I562_pn27 I562_gn26 I562_gn27 I562_G27_26 VDD VSS OAI21_X1
XI562_I93_XP I562_pn27 I562_pn26 I562_P27_26 VDD VSS NOR2_X1
XI562_I94_XG I562_pn28 I562_gn27 I562_gn28 I562_G28_27 VDD VSS OAI21_X1
XI562_I94_XP I562_pn28 I562_pn27 I562_P28_27 VDD VSS NOR2_X1
XI562_I95_XG I562_pn29 I562_gn28 I562_gn29 I562_G29_28 VDD VSS OAI21_X1
XI562_I95_XP I562_pn29 I562_pn28 I562_P29_28 VDD VSS NOR2_X1
XI562_I96_XG I562_pn30 I562_gn29 I562_gn30 I562_G30_29 VDD VSS OAI21_X1
XI562_I96_XP I562_pn30 I562_pn29 I562_P30_29 VDD VSS NOR2_X1
XI562_I97_XG I562_pn31 I562_gn30 I562_gn31 I562_G31_30 VDD VSS OAI21_X1
XI562_I97_XP I562_pn31 I562_pn30 I562_P31_30 VDD VSS NOR2_X1
XI562_I98_XG I562_P2_1 I562_G0_0 I562_G2_1 I562_G2_0n VDD VSS AOI21_X1
XI562_I99_XG I562_P3_2 I562_G1_0 I562_G3_2 I562_G3_0n VDD VSS AOI21_X1
XI562_I100_XG I562_P4_3 I562_G2_1 I562_G4_3 I562_G4_1n VDD VSS AOI21_X1
XI562_I100_XP I562_P4_3 I562_P2_1 I562_P4_1n VDD VSS NAND2_X1
XI562_I101_XG I562_P5_4 I562_G3_2 I562_G5_4 I562_G5_2n VDD VSS AOI21_X1
XI562_I101_XP I562_P5_4 I562_P3_2 I562_P5_2n VDD VSS NAND2_X1
XI562_I102_XG I562_P6_5 I562_G4_3 I562_G6_5 I562_G6_3n VDD VSS AOI21_X1
XI562_I102_XP I562_P6_5 I562_P4_3 I562_P6_3n VDD VSS NAND2_X1
XI562_I103_XG I562_P7_6 I562_G5_4 I562_G7_6 I562_G7_4n VDD VSS AOI21_X1
XI562_I103_XP I562_P7_6 I562_P5_4 I562_P7_4n VDD VSS NAND2_X1
XI562_I104_XG I562_P8_7 I562_G6_5 I562_G8_7 I562_G8_5n VDD VSS AOI21_X1
XI562_I104_XP I562_P8_7 I562_P6_5 I562_P8_5n VDD VSS NAND2_X1
XI562_I105_XG I562_P9_8 I562_G7_6 I562_G9_8 I562_G9_6n VDD VSS AOI21_X1
XI562_I105_XP I562_P9_8 I562_P7_6 I562_P9_6n VDD VSS NAND2_X1
XI562_I106_XG I562_P10_9 I562_G8_7 I562_G10_9 I562_G10_7n VDD VSS AOI21_X1
XI562_I106_XP I562_P10_9 I562_P8_7 I562_P10_7n VDD VSS NAND2_X1
XI562_I107_XG I562_P11_10 I562_G9_8 I562_G11_10 I562_G11_8n VDD VSS AOI21_X1
XI562_I107_XP I562_P11_10 I562_P9_8 I562_P11_8n VDD VSS NAND2_X1
XI562_I108_XG I562_P12_11 I562_G10_9 I562_G12_11 I562_G12_9n VDD VSS AOI21_X1
XI562_I108_XP I562_P12_11 I562_P10_9 I562_P12_9n VDD VSS NAND2_X1
XI562_I109_XG I562_P13_12 I562_G11_10 I562_G13_12 I562_G13_10n VDD VSS AOI21_X1
XI562_I109_XP I562_P13_12 I562_P11_10 I562_P13_10n VDD VSS NAND2_X1
XI562_I110_XG I562_P14_13 I562_G12_11 I562_G14_13 I562_G14_11n VDD VSS AOI21_X1
XI562_I110_XP I562_P14_13 I562_P12_11 I562_P14_11n VDD VSS NAND2_X1
XI562_I111_XG I562_P15_14 I562_G13_12 I562_G15_14 I562_G15_12n VDD VSS AOI21_X1
XI562_I111_XP I562_P15_14 I562_P13_12 I562_P15_12n VDD VSS NAND2_X1
XI562_I112_XG I562_P16_15 I562_G14_13 I562_G16_15 I562_G16_13n VDD VSS AOI21_X1
XI562_I112_XP I562_P16_15 I562_P14_13 I562_P16_13n VDD VSS NAND2_X1
XI562_I113_XG I562_P17_16 I562_G15_14 I562_G17_16 I562_G17_14n VDD VSS AOI21_X1
XI562_I113_XP I562_P17_16 I562_P15_14 I562_P17_14n VDD VSS NAND2_X1
XI562_I114_XG I562_P18_17 I562_G16_15 I562_G18_17 I562_G18_15n VDD VSS AOI21_X1
XI562_I114_XP I562_P18_17 I562_P16_15 I562_P18_15n VDD VSS NAND2_X1
XI562_I115_XG I562_P19_18 I562_G17_16 I562_G19_18 I562_G19_16n VDD VSS AOI21_X1
XI562_I115_XP I562_P19_18 I562_P17_16 I562_P19_16n VDD VSS NAND2_X1
XI562_I116_XG I562_P20_19 I562_G18_17 I562_G20_19 I562_G20_17n VDD VSS AOI21_X1
XI562_I116_XP I562_P20_19 I562_P18_17 I562_P20_17n VDD VSS NAND2_X1
XI562_I117_XG I562_P21_20 I562_G19_18 I562_G21_20 I562_G21_18n VDD VSS AOI21_X1
XI562_I117_XP I562_P21_20 I562_P19_18 I562_P21_18n VDD VSS NAND2_X1
XI562_I118_XG I562_P22_21 I562_G20_19 I562_G22_21 I562_G22_19n VDD VSS AOI21_X1
XI562_I118_XP I562_P22_21 I562_P20_19 I562_P22_19n VDD VSS NAND2_X1
XI562_I119_XG I562_P23_22 I562_G21_20 I562_G23_22 I562_G23_20n VDD VSS AOI21_X1
XI562_I119_XP I562_P23_22 I562_P21_20 I562_P23_20n VDD VSS NAND2_X1
XI562_I120_XG I562_P24_23 I562_G22_21 I562_G24_23 I562_G24_21n VDD VSS AOI21_X1
XI562_I120_XP I562_P24_23 I562_P22_21 I562_P24_21n VDD VSS NAND2_X1
XI562_I121_XG I562_P25_24 I562_G23_22 I562_G25_24 I562_G25_22n VDD VSS AOI21_X1
XI562_I121_XP I562_P25_24 I562_P23_22 I562_P25_22n VDD VSS NAND2_X1
XI562_I122_XG I562_P26_25 I562_G24_23 I562_G26_25 I562_G26_23n VDD VSS AOI21_X1
XI562_I122_XP I562_P26_25 I562_P24_23 I562_P26_23n VDD VSS NAND2_X1
XI562_I123_XG I562_P27_26 I562_G25_24 I562_G27_26 I562_G27_24n VDD VSS AOI21_X1
XI562_I123_XP I562_P27_26 I562_P25_24 I562_P27_24n VDD VSS NAND2_X1
XI562_I124_XG I562_P28_27 I562_G26_25 I562_G28_27 I562_G28_25n VDD VSS AOI21_X1
XI562_I124_XP I562_P28_27 I562_P26_25 I562_P28_25n VDD VSS NAND2_X1
XI562_I125_XG I562_P29_28 I562_G27_26 I562_G29_28 I562_G29_26n VDD VSS AOI21_X1
XI562_I125_XP I562_P29_28 I562_P27_26 I562_P29_26n VDD VSS NAND2_X1
XI562_I126_XG I562_P30_29 I562_G28_27 I562_G30_29 I562_G30_27n VDD VSS AOI21_X1
XI562_I126_XP I562_P30_29 I562_P28_27 I562_P30_27n VDD VSS NAND2_X1
XI562_I127_XG I562_P31_30 I562_G29_28 I562_G31_30 I562_G31_28n VDD VSS AOI21_X1
XI562_I127_XP I562_P31_30 I562_P29_28 I562_P31_28n VDD VSS NAND2_X1
XI562_I128_XG I562_P4_1n I562_G0_0n I562_G4_1n I562_G4_0 VDD VSS OAI21_X1
XI562_I129 I562_G1_0 I562_G1_0n VDD VSS INV_X1
XI562_I130_XG I562_P5_2n I562_G1_0n I562_G5_2n I562_G5_0 VDD VSS OAI21_X1
XI562_I131_XG I562_P6_3n I562_G2_0n I562_G6_3n I562_G6_0 VDD VSS OAI21_X1
XI562_I132_XG I562_P7_4n I562_G3_0n I562_G7_4n I562_G7_0 VDD VSS OAI21_X1
XI562_I133_XG I562_P8_5n I562_G4_1n I562_G8_5n I562_G8_1 VDD VSS OAI21_X1
XI562_I133_XP I562_P8_5n I562_P4_1n I562_P8_1 VDD VSS NOR2_X1
XI562_I134_XG I562_P9_6n I562_G5_2n I562_G9_6n I562_G9_2 VDD VSS OAI21_X1
XI562_I134_XP I562_P9_6n I562_P5_2n I562_P9_2 VDD VSS NOR2_X1
XI562_I135_XG I562_P10_7n I562_G6_3n I562_G10_7n I562_G10_3 VDD VSS OAI21_X1
XI562_I135_XP I562_P10_7n I562_P6_3n I562_P10_3 VDD VSS NOR2_X1
XI562_I136_XG I562_P11_8n I562_G7_4n I562_G11_8n I562_G11_4 VDD VSS OAI21_X1
XI562_I136_XP I562_P11_8n I562_P7_4n I562_P11_4 VDD VSS NOR2_X1
XI562_I137_XG I562_P12_9n I562_G8_5n I562_G12_9n I562_G12_5 VDD VSS OAI21_X1
XI562_I137_XP I562_P12_9n I562_P8_5n I562_P12_5 VDD VSS NOR2_X1
XI562_I138_XG I562_P13_10n I562_G9_6n I562_G13_10n I562_G13_6 VDD VSS OAI21_X1
XI562_I138_XP I562_P13_10n I562_P9_6n I562_P13_6 VDD VSS NOR2_X1
XI562_I139_XG I562_P14_11n I562_G10_7n I562_G14_11n I562_G14_7 VDD VSS OAI21_X1
XI562_I139_XP I562_P14_11n I562_P10_7n I562_P14_7 VDD VSS NOR2_X1
XI562_I140_XG I562_P15_12n I562_G11_8n I562_G15_12n I562_G15_8 VDD VSS OAI21_X1
XI562_I140_XP I562_P15_12n I562_P11_8n I562_P15_8 VDD VSS NOR2_X1
XI562_I141_XG I562_P16_13n I562_G12_9n I562_G16_13n I562_G16_9 VDD VSS OAI21_X1
XI562_I141_XP I562_P16_13n I562_P12_9n I562_P16_9 VDD VSS NOR2_X1
XI562_I142_XG I562_P17_14n I562_G13_10n I562_G17_14n I562_G17_10 VDD VSS OAI21_X1
XI562_I142_XP I562_P17_14n I562_P13_10n I562_P17_10 VDD VSS NOR2_X1
XI562_I143_XG I562_P18_15n I562_G14_11n I562_G18_15n I562_G18_11 VDD VSS OAI21_X1
XI562_I143_XP I562_P18_15n I562_P14_11n I562_P18_11 VDD VSS NOR2_X1
XI562_I144_XG I562_P19_16n I562_G15_12n I562_G19_16n I562_G19_12 VDD VSS OAI21_X1
XI562_I144_XP I562_P19_16n I562_P15_12n I562_P19_12 VDD VSS NOR2_X1
XI562_I145_XG I562_P20_17n I562_G16_13n I562_G20_17n I562_G20_13 VDD VSS OAI21_X1
XI562_I145_XP I562_P20_17n I562_P16_13n I562_P20_13 VDD VSS NOR2_X1
XI562_I146_XG I562_P21_18n I562_G17_14n I562_G21_18n I562_G21_14 VDD VSS OAI21_X1
XI562_I146_XP I562_P21_18n I562_P17_14n I562_P21_14 VDD VSS NOR2_X1
XI562_I147_XG I562_P22_19n I562_G18_15n I562_G22_19n I562_G22_15 VDD VSS OAI21_X1
XI562_I147_XP I562_P22_19n I562_P18_15n I562_P22_15 VDD VSS NOR2_X1
XI562_I148_XG I562_P23_20n I562_G19_16n I562_G23_20n I562_G23_16 VDD VSS OAI21_X1
XI562_I148_XP I562_P23_20n I562_P19_16n I562_P23_16 VDD VSS NOR2_X1
XI562_I149_XG I562_P24_21n I562_G20_17n I562_G24_21n I562_G24_17 VDD VSS OAI21_X1
XI562_I149_XP I562_P24_21n I562_P20_17n I562_P24_17 VDD VSS NOR2_X1
XI562_I150_XG I562_P25_22n I562_G21_18n I562_G25_22n I562_G25_18 VDD VSS OAI21_X1
XI562_I150_XP I562_P25_22n I562_P21_18n I562_P25_18 VDD VSS NOR2_X1
XI562_I151_XG I562_P26_23n I562_G22_19n I562_G26_23n I562_G26_19 VDD VSS OAI21_X1
XI562_I151_XP I562_P26_23n I562_P22_19n I562_P26_19 VDD VSS NOR2_X1
XI562_I152_XG I562_P27_24n I562_G23_20n I562_G27_24n I562_G27_20 VDD VSS OAI21_X1
XI562_I152_XP I562_P27_24n I562_P23_20n I562_P27_20 VDD VSS NOR2_X1
XI562_I153_XG I562_P28_25n I562_G24_21n I562_G28_25n I562_G28_21 VDD VSS OAI21_X1
XI562_I153_XP I562_P28_25n I562_P24_21n I562_P28_21 VDD VSS NOR2_X1
XI562_I154_XG I562_P29_26n I562_G25_22n I562_G29_26n I562_G29_22 VDD VSS OAI21_X1
XI562_I154_XP I562_P29_26n I562_P25_22n I562_P29_22 VDD VSS NOR2_X1
XI562_I155_XG I562_P30_27n I562_G26_23n I562_G30_27n I562_G30_23 VDD VSS OAI21_X1
XI562_I155_XP I562_P30_27n I562_P26_23n I562_P30_23 VDD VSS NOR2_X1
XI562_I156_XG I562_P31_28n I562_G27_24n I562_G31_28n I562_G31_24 VDD VSS OAI21_X1
XI562_I156_XP I562_P31_28n I562_P27_24n I562_P31_24 VDD VSS NOR2_X1
XI562_I157_XG I562_P8_1 I562_G0_0 I562_G8_1 I562_G8_0n VDD VSS AOI21_X1
XI562_I158_XG I562_P9_2 I562_G1_0 I562_G9_2 I562_G9_0n VDD VSS AOI21_X1
XI562_I159 I562_G2_0n I562_G2_0np VDD VSS INV_X1
XI562_I160_XG I562_P10_3 I562_G2_0np I562_G10_3 I562_G10_0n VDD VSS AOI21_X1
XI562_I161 I562_G3_0n I562_G3_0np VDD VSS INV_X1
XI562_I162_XG I562_P11_4 I562_G3_0np I562_G11_4 I562_G11_0n VDD VSS AOI21_X1
XI562_I163_XG I562_P12_5 I562_G4_0 I562_G12_5 I562_G12_0n VDD VSS AOI21_X1
XI562_I164_XG I562_P13_6 I562_G5_0 I562_G13_6 I562_G13_0n VDD VSS AOI21_X1
XI562_I165_XG I562_P14_7 I562_G6_0 I562_G14_7 I562_G14_0n VDD VSS AOI21_X1
XI562_I166_XG I562_P15_8 I562_G7_0 I562_G15_8 I562_G15_0n VDD VSS AOI21_X1
XI562_I167_XG I562_P16_9 I562_G8_1 I562_G16_9 I562_G16_1n VDD VSS AOI21_X1
XI562_I167_XP I562_P16_9 I562_P8_1 I562_P16_1n VDD VSS NAND2_X1
XI562_I168_XG I562_P17_10 I562_G9_2 I562_G17_10 I562_G17_2n VDD VSS AOI21_X1
XI562_I168_XP I562_P17_10 I562_P9_2 I562_P17_2n VDD VSS NAND2_X1
XI562_I169_XG I562_P18_11 I562_G10_3 I562_G18_11 I562_G18_3n VDD VSS AOI21_X1
XI562_I169_XP I562_P18_11 I562_P10_3 I562_P18_3n VDD VSS NAND2_X1
XI562_I170_XG I562_P19_12 I562_G11_4 I562_G19_12 I562_G19_4n VDD VSS AOI21_X1
XI562_I170_XP I562_P19_12 I562_P11_4 I562_P19_4n VDD VSS NAND2_X1
XI562_I171_XG I562_P20_13 I562_G12_5 I562_G20_13 I562_G20_5n VDD VSS AOI21_X1
XI562_I171_XP I562_P20_13 I562_P12_5 I562_P20_5n VDD VSS NAND2_X1
XI562_I172_XG I562_P21_14 I562_G13_6 I562_G21_14 I562_G21_6n VDD VSS AOI21_X1
XI562_I172_XP I562_P21_14 I562_P13_6 I562_P21_6n VDD VSS NAND2_X1
XI562_I173_XG I562_P22_15 I562_G14_7 I562_G22_15 I562_G22_7n VDD VSS AOI21_X1
XI562_I173_XP I562_P22_15 I562_P14_7 I562_P22_7n VDD VSS NAND2_X1
XI562_I174_XG I562_P23_16 I562_G15_8 I562_G23_16 I562_G23_8n VDD VSS AOI21_X1
XI562_I174_XP I562_P23_16 I562_P15_8 I562_P23_8n VDD VSS NAND2_X1
XI562_I175_XG I562_P24_17 I562_G16_9 I562_G24_17 I562_G24_9n VDD VSS AOI21_X1
XI562_I175_XP I562_P24_17 I562_P16_9 I562_P24_9n VDD VSS NAND2_X1
XI562_I176_XG I562_P25_18 I562_G17_10 I562_G25_18 I562_G25_10n VDD VSS AOI21_X1
XI562_I176_XP I562_P25_18 I562_P17_10 I562_P25_10n VDD VSS NAND2_X1
XI562_I177_XG I562_P26_19 I562_G18_11 I562_G26_19 I562_G26_11n VDD VSS AOI21_X1
XI562_I177_XP I562_P26_19 I562_P18_11 I562_P26_11n VDD VSS NAND2_X1
XI562_I178_XG I562_P27_20 I562_G19_12 I562_G27_20 I562_G27_12n VDD VSS AOI21_X1
XI562_I178_XP I562_P27_20 I562_P19_12 I562_P27_12n VDD VSS NAND2_X1
XI562_I179_XG I562_P28_21 I562_G20_13 I562_G28_21 I562_G28_13n VDD VSS AOI21_X1
XI562_I179_XP I562_P28_21 I562_P20_13 I562_P28_13n VDD VSS NAND2_X1
XI562_I180_XG I562_P29_22 I562_G21_14 I562_G29_22 I562_G29_14n VDD VSS AOI21_X1
XI562_I180_XP I562_P29_22 I562_P21_14 I562_P29_14n VDD VSS NAND2_X1
XI562_I181_XG I562_P30_23 I562_G22_15 I562_G30_23 I562_G30_15n VDD VSS AOI21_X1
XI562_I181_XP I562_P30_23 I562_P22_15 I562_P30_15n VDD VSS NAND2_X1
XI562_I182_XG I562_P31_24 I562_G23_16 I562_G31_24 I562_G31_16n VDD VSS AOI21_X1
XI562_I182_XP I562_P31_24 I562_P23_16 I562_P31_16n VDD VSS NAND2_X1
XI562_I183_XG I562_P16_1n I562_G0_0n I562_G16_1n I562_G16_0 VDD VSS OAI21_X1
XI562_I184_XG I562_P17_2n I562_G1_0n I562_G17_2n I562_G17_0 VDD VSS OAI21_X1
XI562_I185_XG I562_P18_3n I562_G2_0n I562_G18_3n I562_G18_0 VDD VSS OAI21_X1
XI562_I186_XG I562_P19_4n I562_G3_0n I562_G19_4n I562_G19_0 VDD VSS OAI21_X1
XI562_I187 I562_G4_0 I562_G4_0n VDD VSS INV_X1
XI562_I188_XG I562_P20_5n I562_G4_0n I562_G20_5n I562_G20_0 VDD VSS OAI21_X1
XI562_I189 I562_G5_0 I562_G5_0n VDD VSS INV_X1
XI562_I190_XG I562_P21_6n I562_G5_0n I562_G21_6n I562_G21_0 VDD VSS OAI21_X1
XI562_I191 I562_G6_0 I562_G6_0n VDD VSS INV_X1
XI562_I192_XG I562_P22_7n I562_G6_0n I562_G22_7n I562_G22_0 VDD VSS OAI21_X1
XI562_I193 I562_G7_0 I562_G7_0n VDD VSS INV_X1
XI562_I194_XG I562_P23_8n I562_G7_0n I562_G23_8n I562_G23_0 VDD VSS OAI21_X1
XI562_I195_XG I562_P24_9n I562_G8_0n I562_G24_9n I562_G24_0 VDD VSS OAI21_X1
XI562_I196_XG I562_P25_10n I562_G9_0n I562_G25_10n I562_G25_0 VDD VSS OAI21_X1
XI562_I197_XG I562_P26_11n I562_G10_0n I562_G26_11n I562_G26_0 VDD VSS OAI21_X1
XI562_I198_XG I562_P27_12n I562_G11_0n I562_G27_12n I562_G27_0 VDD VSS OAI21_X1
XI562_I199_XG I562_P28_13n I562_G12_0n I562_G28_13n I562_G28_0 VDD VSS OAI21_X1
XI562_I200_XG I562_P29_14n I562_G13_0n I562_G29_14n I562_G29_0 VDD VSS OAI21_X1
XI562_I201_XG I562_P30_15n I562_G14_0n I562_G30_15n c0_m VDD VSS OAI21_X1
XI562_I202_XG I562_P31_16n I562_G15_0n I562_G31_16n c0_o VDD VSS OAI21_X1
XI562_I203 I562_pn0 VDD p0_0 VDD VSS XNOR2_X1
XI562_I204 I562_pn1 I562_G0_0 p0_1 VDD VSS XNOR2_X1
XI562_I205 I562_pn2 I562_G1_0 p0_2 VDD VSS XNOR2_X1
XI562_I206 I562_pn3 I562_G2_0n p0_3 VDD VSS XOR2_X1
XI562_I207 I562_pn4 I562_G3_0n p0_4 VDD VSS XOR2_X1
XI562_I208 I562_pn5 I562_G4_0 p0_5 VDD VSS XNOR2_X1
XI562_I209 I562_pn6 I562_G5_0 p0_6 VDD VSS XNOR2_X1
XI562_I210 I562_pn7 I562_G6_0 p0_7 VDD VSS XNOR2_X1
XI562_I211 I562_pn8 I562_G7_0 p0_8 VDD VSS XNOR2_X1
XI562_I212 I562_pn9 I562_G8_0n p0_9 VDD VSS XOR2_X1
XI562_I213 I562_pn10 I562_G9_0n p0_10 VDD VSS XOR2_X1
XI562_I214 I562_pn11 I562_G10_0n p0_11 VDD VSS XOR2_X1
XI562_I215 I562_pn12 I562_G11_0n p0_12 VDD VSS XOR2_X1
XI562_I216 I562_pn13 I562_G12_0n p0_13 VDD VSS XOR2_X1
XI562_I217 I562_pn14 I562_G13_0n p0_14 VDD VSS XOR2_X1
XI562_I218 I562_pn15 I562_G14_0n p0_15 VDD VSS XOR2_X1
XI562_I219 I562_pn16 I562_G15_0n p0_16 VDD VSS XOR2_X1
XI562_I220 I562_pn17 I562_G16_0 p0_17 VDD VSS XNOR2_X1
XI562_I221 I562_pn18 I562_G17_0 p0_18 VDD VSS XNOR2_X1
XI562_I222 I562_pn19 I562_G18_0 p0_19 VDD VSS XNOR2_X1
XI562_I223 I562_pn20 I562_G19_0 p0_20 VDD VSS XNOR2_X1
XI562_I224 I562_pn21 I562_G20_0 p0_21 VDD VSS XNOR2_X1
XI562_I225 I562_pn22 I562_G21_0 p0_22 VDD VSS XNOR2_X1
XI562_I226 I562_pn23 I562_G22_0 p0_23 VDD VSS XNOR2_X1
XI562_I227 I562_pn24 I562_G23_0 p0_24 VDD VSS XNOR2_X1
XI562_I228 I562_pn25 I562_G24_0 p0_25 VDD VSS XNOR2_X1
XI562_I229 I562_pn26 I562_G25_0 p0_26 VDD VSS XNOR2_X1
XI562_I230 I562_pn27 I562_G26_0 p0_27 VDD VSS XNOR2_X1
XI562_I231 I562_pn28 I562_G27_0 p0_28 VDD VSS XNOR2_X1
XI562_I232 I562_pn29 I562_G28_0 p0_29 VDD VSS XNOR2_X1
XI562_I233 I562_pn30 I562_G29_0 p0_30 VDD VSS XNOR2_X1
XI562_I234 I562_pn31 c0_m p0_31 VDD VSS XNOR2_X1
XI563 VSS VDD h0 VDD VSS XOR2_X1
XI564 h0 c0_o p0_32 VDD VSS XOR2_X1
XI565 p0_32 qu31 VDD VSS INV_X4
XI566 qu31 qu31_b0 VDD VSS INV_X1
XI567 qu31_b0 qu31_b1_0 VDD VSS INV_X4
XI568 qu31_b1_0 qu31_b2_0 VDD VSS INV_X4
XI569 qu31_b1_0 qu31_b2_1 VDD VSS INV_X4
XI570 qu31_b2_0 qu31_b3_0 VDD VSS INV_X4
XI571 qu31_b2_0 qu31_b3_1 VDD VSS INV_X4
XI572 qu31_b2_0 qu31_b3_2 VDD VSS INV_X4
XI573 qu31_b2_1 qu31_b3_3 VDD VSS INV_X4
XI574 qu31_b2_1 qu31_b3_4 VDD VSS INV_X4
XI575 qu31_b2_1 qu31_b3_5 VDD VSS INV_X4
XI576 B_0_b3_0 qu31_b3_0 b1_0 VDD VSS XOR2_X1
XI577 dd1_b3_0 qu31_b3_0 b1_1 VDD VSS XOR2_X1
XI578 dd2_b3_0 qu31_b3_0 b1_2 VDD VSS XOR2_X1
XI579 dd3_b3_0 qu31_b3_0 b1_3 VDD VSS XOR2_X1
XI580 dd4_b3_0 qu31_b3_0 b1_4 VDD VSS XOR2_X1
XI581 dd5_b3_0 qu31_b3_0 b1_5 VDD VSS XOR2_X1
XI582 dd6_b3_0 qu31_b3_1 b1_6 VDD VSS XOR2_X1
XI583 dd7_b3_0 qu31_b3_1 b1_7 VDD VSS XOR2_X1
XI584 dd8_b3_0 qu31_b3_1 b1_8 VDD VSS XOR2_X1
XI585 dd9_b3_0 qu31_b3_1 b1_9 VDD VSS XOR2_X1
XI586 dd10_b3_0 qu31_b3_1 b1_10 VDD VSS XOR2_X1
XI587 dd11_b3_0 qu31_b3_1 b1_11 VDD VSS XOR2_X1
XI588 dd12_b3_0 qu31_b3_2 b1_12 VDD VSS XOR2_X1
XI589 dd13_b3_0 qu31_b3_2 b1_13 VDD VSS XOR2_X1
XI590 dd14_b3_0 qu31_b3_2 b1_14 VDD VSS XOR2_X1
XI591 dd15_b3_0 qu31_b3_2 b1_15 VDD VSS XOR2_X1
XI592 dd16_b3_0 qu31_b3_2 b1_16 VDD VSS XOR2_X1
XI593 dd17_b3_0 qu31_b3_2 b1_17 VDD VSS XOR2_X1
XI594 dd18_b3_0 qu31_b3_3 b1_18 VDD VSS XOR2_X1
XI595 dd19_b3_0 qu31_b3_3 b1_19 VDD VSS XOR2_X1
XI596 dd20_b3_0 qu31_b3_3 b1_20 VDD VSS XOR2_X1
XI597 dd21_b3_0 qu31_b3_3 b1_21 VDD VSS XOR2_X1
XI598 dd22_b3_0 qu31_b3_3 b1_22 VDD VSS XOR2_X1
XI599 dd23_b3_0 qu31_b3_3 b1_23 VDD VSS XOR2_X1
XI600 dd24_b3_0 qu31_b3_4 b1_24 VDD VSS XOR2_X1
XI601 dd25_b3_0 qu31_b3_4 b1_25 VDD VSS XOR2_X1
XI602 dd26_b3_0 qu31_b3_4 b1_26 VDD VSS XOR2_X1
XI603 dd27_b3_0 qu31_b3_4 b1_27 VDD VSS XOR2_X1
XI604 dd28_b3_0 qu31_b3_4 b1_28 VDD VSS XOR2_X1
XI605 dd29_b3_0 qu31_b3_4 b1_29 VDD VSS XOR2_X1
XI606 dd30_b3_0 qu31_b3_5 b1_30 VDD VSS XOR2_X1
XI607 dd31_b3_0 qu31_b3_5 b1_31 VDD VSS XOR2_X1
XI608_I0 aa30 b1_0 I608_gn0 VDD VSS NAND2_X1
XI608_I1 p0_0 b1_1 I608_gn1 VDD VSS NAND2_X1
XI608_I2 p0_1 b1_2 I608_gn2 VDD VSS NAND2_X1
XI608_I3 p0_2 b1_3 I608_gn3 VDD VSS NAND2_X1
XI608_I4 p0_3 b1_4 I608_gn4 VDD VSS NAND2_X1
XI608_I5 p0_4 b1_5 I608_gn5 VDD VSS NAND2_X1
XI608_I6 p0_5 b1_6 I608_gn6 VDD VSS NAND2_X1
XI608_I7 p0_6 b1_7 I608_gn7 VDD VSS NAND2_X1
XI608_I8 p0_7 b1_8 I608_gn8 VDD VSS NAND2_X1
XI608_I9 p0_8 b1_9 I608_gn9 VDD VSS NAND2_X1
XI608_I10 p0_9 b1_10 I608_gn10 VDD VSS NAND2_X1
XI608_I11 p0_10 b1_11 I608_gn11 VDD VSS NAND2_X1
XI608_I12 p0_11 b1_12 I608_gn12 VDD VSS NAND2_X1
XI608_I13 p0_12 b1_13 I608_gn13 VDD VSS NAND2_X1
XI608_I14 p0_13 b1_14 I608_gn14 VDD VSS NAND2_X1
XI608_I15 p0_14 b1_15 I608_gn15 VDD VSS NAND2_X1
XI608_I16 p0_15 b1_16 I608_gn16 VDD VSS NAND2_X1
XI608_I17 p0_16 b1_17 I608_gn17 VDD VSS NAND2_X1
XI608_I18 p0_17 b1_18 I608_gn18 VDD VSS NAND2_X1
XI608_I19 p0_18 b1_19 I608_gn19 VDD VSS NAND2_X1
XI608_I20 p0_19 b1_20 I608_gn20 VDD VSS NAND2_X1
XI608_I21 p0_20 b1_21 I608_gn21 VDD VSS NAND2_X1
XI608_I22 p0_21 b1_22 I608_gn22 VDD VSS NAND2_X1
XI608_I23 p0_22 b1_23 I608_gn23 VDD VSS NAND2_X1
XI608_I24 p0_23 b1_24 I608_gn24 VDD VSS NAND2_X1
XI608_I25 p0_24 b1_25 I608_gn25 VDD VSS NAND2_X1
XI608_I26 p0_25 b1_26 I608_gn26 VDD VSS NAND2_X1
XI608_I27 p0_26 b1_27 I608_gn27 VDD VSS NAND2_X1
XI608_I28 p0_27 b1_28 I608_gn28 VDD VSS NAND2_X1
XI608_I29 p0_28 b1_29 I608_gn29 VDD VSS NAND2_X1
XI608_I30 p0_29 b1_30 I608_gn30 VDD VSS NAND2_X1
XI608_I31 p0_30 b1_31 I608_gn31 VDD VSS NAND2_X1
XI608_I32 aa30 b1_0 I608_pn0 VDD VSS XNOR2_X1
XI608_I33 p0_0 b1_1 I608_pn1 VDD VSS XNOR2_X1
XI608_I34 p0_1 b1_2 I608_pn2 VDD VSS XNOR2_X1
XI608_I35 p0_2 b1_3 I608_pn3 VDD VSS XNOR2_X1
XI608_I36 p0_3 b1_4 I608_pn4 VDD VSS XNOR2_X1
XI608_I37 p0_4 b1_5 I608_pn5 VDD VSS XNOR2_X1
XI608_I38 p0_5 b1_6 I608_pn6 VDD VSS XNOR2_X1
XI608_I39 p0_6 b1_7 I608_pn7 VDD VSS XNOR2_X1
XI608_I40 p0_7 b1_8 I608_pn8 VDD VSS XNOR2_X1
XI608_I41 p0_8 b1_9 I608_pn9 VDD VSS XNOR2_X1
XI608_I42 p0_9 b1_10 I608_pn10 VDD VSS XNOR2_X1
XI608_I43 p0_10 b1_11 I608_pn11 VDD VSS XNOR2_X1
XI608_I44 p0_11 b1_12 I608_pn12 VDD VSS XNOR2_X1
XI608_I45 p0_12 b1_13 I608_pn13 VDD VSS XNOR2_X1
XI608_I46 p0_13 b1_14 I608_pn14 VDD VSS XNOR2_X1
XI608_I47 p0_14 b1_15 I608_pn15 VDD VSS XNOR2_X1
XI608_I48 p0_15 b1_16 I608_pn16 VDD VSS XNOR2_X1
XI608_I49 p0_16 b1_17 I608_pn17 VDD VSS XNOR2_X1
XI608_I50 p0_17 b1_18 I608_pn18 VDD VSS XNOR2_X1
XI608_I51 p0_18 b1_19 I608_pn19 VDD VSS XNOR2_X1
XI608_I52 p0_19 b1_20 I608_pn20 VDD VSS XNOR2_X1
XI608_I53 p0_20 b1_21 I608_pn21 VDD VSS XNOR2_X1
XI608_I54 p0_21 b1_22 I608_pn22 VDD VSS XNOR2_X1
XI608_I55 p0_22 b1_23 I608_pn23 VDD VSS XNOR2_X1
XI608_I56 p0_23 b1_24 I608_pn24 VDD VSS XNOR2_X1
XI608_I57 p0_24 b1_25 I608_pn25 VDD VSS XNOR2_X1
XI608_I58 p0_25 b1_26 I608_pn26 VDD VSS XNOR2_X1
XI608_I59 p0_26 b1_27 I608_pn27 VDD VSS XNOR2_X1
XI608_I60 p0_27 b1_28 I608_pn28 VDD VSS XNOR2_X1
XI608_I61 p0_28 b1_29 I608_pn29 VDD VSS XNOR2_X1
XI608_I62 p0_29 b1_30 I608_pn30 VDD VSS XNOR2_X1
XI608_I63 p0_30 b1_31 I608_pn31 VDD VSS XNOR2_X1
XI608_I64 qu31_b3_5 I608_cinn VDD VSS INV_X1
XI608_I65_XG I608_pn0 I608_cinn I608_gn0 I608_G0_0 VDD VSS OAI21_X1
XI608_I66 I608_G0_0 I608_G0_0n VDD VSS INV_X1
XI608_I67_XG I608_pn1 I608_G0_0n I608_gn1 I608_G1_0 VDD VSS OAI21_X1
XI608_I68_XG I608_pn2 I608_gn1 I608_gn2 I608_G2_1 VDD VSS OAI21_X1
XI608_I68_XP I608_pn2 I608_pn1 I608_P2_1 VDD VSS NOR2_X1
XI608_I69_XG I608_pn3 I608_gn2 I608_gn3 I608_G3_2 VDD VSS OAI21_X1
XI608_I69_XP I608_pn3 I608_pn2 I608_P3_2 VDD VSS NOR2_X1
XI608_I70_XG I608_pn4 I608_gn3 I608_gn4 I608_G4_3 VDD VSS OAI21_X1
XI608_I70_XP I608_pn4 I608_pn3 I608_P4_3 VDD VSS NOR2_X1
XI608_I71_XG I608_pn5 I608_gn4 I608_gn5 I608_G5_4 VDD VSS OAI21_X1
XI608_I71_XP I608_pn5 I608_pn4 I608_P5_4 VDD VSS NOR2_X1
XI608_I72_XG I608_pn6 I608_gn5 I608_gn6 I608_G6_5 VDD VSS OAI21_X1
XI608_I72_XP I608_pn6 I608_pn5 I608_P6_5 VDD VSS NOR2_X1
XI608_I73_XG I608_pn7 I608_gn6 I608_gn7 I608_G7_6 VDD VSS OAI21_X1
XI608_I73_XP I608_pn7 I608_pn6 I608_P7_6 VDD VSS NOR2_X1
XI608_I74_XG I608_pn8 I608_gn7 I608_gn8 I608_G8_7 VDD VSS OAI21_X1
XI608_I74_XP I608_pn8 I608_pn7 I608_P8_7 VDD VSS NOR2_X1
XI608_I75_XG I608_pn9 I608_gn8 I608_gn9 I608_G9_8 VDD VSS OAI21_X1
XI608_I75_XP I608_pn9 I608_pn8 I608_P9_8 VDD VSS NOR2_X1
XI608_I76_XG I608_pn10 I608_gn9 I608_gn10 I608_G10_9 VDD VSS OAI21_X1
XI608_I76_XP I608_pn10 I608_pn9 I608_P10_9 VDD VSS NOR2_X1
XI608_I77_XG I608_pn11 I608_gn10 I608_gn11 I608_G11_10 VDD VSS OAI21_X1
XI608_I77_XP I608_pn11 I608_pn10 I608_P11_10 VDD VSS NOR2_X1
XI608_I78_XG I608_pn12 I608_gn11 I608_gn12 I608_G12_11 VDD VSS OAI21_X1
XI608_I78_XP I608_pn12 I608_pn11 I608_P12_11 VDD VSS NOR2_X1
XI608_I79_XG I608_pn13 I608_gn12 I608_gn13 I608_G13_12 VDD VSS OAI21_X1
XI608_I79_XP I608_pn13 I608_pn12 I608_P13_12 VDD VSS NOR2_X1
XI608_I80_XG I608_pn14 I608_gn13 I608_gn14 I608_G14_13 VDD VSS OAI21_X1
XI608_I80_XP I608_pn14 I608_pn13 I608_P14_13 VDD VSS NOR2_X1
XI608_I81_XG I608_pn15 I608_gn14 I608_gn15 I608_G15_14 VDD VSS OAI21_X1
XI608_I81_XP I608_pn15 I608_pn14 I608_P15_14 VDD VSS NOR2_X1
XI608_I82_XG I608_pn16 I608_gn15 I608_gn16 I608_G16_15 VDD VSS OAI21_X1
XI608_I82_XP I608_pn16 I608_pn15 I608_P16_15 VDD VSS NOR2_X1
XI608_I83_XG I608_pn17 I608_gn16 I608_gn17 I608_G17_16 VDD VSS OAI21_X1
XI608_I83_XP I608_pn17 I608_pn16 I608_P17_16 VDD VSS NOR2_X1
XI608_I84_XG I608_pn18 I608_gn17 I608_gn18 I608_G18_17 VDD VSS OAI21_X1
XI608_I84_XP I608_pn18 I608_pn17 I608_P18_17 VDD VSS NOR2_X1
XI608_I85_XG I608_pn19 I608_gn18 I608_gn19 I608_G19_18 VDD VSS OAI21_X1
XI608_I85_XP I608_pn19 I608_pn18 I608_P19_18 VDD VSS NOR2_X1
XI608_I86_XG I608_pn20 I608_gn19 I608_gn20 I608_G20_19 VDD VSS OAI21_X1
XI608_I86_XP I608_pn20 I608_pn19 I608_P20_19 VDD VSS NOR2_X1
XI608_I87_XG I608_pn21 I608_gn20 I608_gn21 I608_G21_20 VDD VSS OAI21_X1
XI608_I87_XP I608_pn21 I608_pn20 I608_P21_20 VDD VSS NOR2_X1
XI608_I88_XG I608_pn22 I608_gn21 I608_gn22 I608_G22_21 VDD VSS OAI21_X1
XI608_I88_XP I608_pn22 I608_pn21 I608_P22_21 VDD VSS NOR2_X1
XI608_I89_XG I608_pn23 I608_gn22 I608_gn23 I608_G23_22 VDD VSS OAI21_X1
XI608_I89_XP I608_pn23 I608_pn22 I608_P23_22 VDD VSS NOR2_X1
XI608_I90_XG I608_pn24 I608_gn23 I608_gn24 I608_G24_23 VDD VSS OAI21_X1
XI608_I90_XP I608_pn24 I608_pn23 I608_P24_23 VDD VSS NOR2_X1
XI608_I91_XG I608_pn25 I608_gn24 I608_gn25 I608_G25_24 VDD VSS OAI21_X1
XI608_I91_XP I608_pn25 I608_pn24 I608_P25_24 VDD VSS NOR2_X1
XI608_I92_XG I608_pn26 I608_gn25 I608_gn26 I608_G26_25 VDD VSS OAI21_X1
XI608_I92_XP I608_pn26 I608_pn25 I608_P26_25 VDD VSS NOR2_X1
XI608_I93_XG I608_pn27 I608_gn26 I608_gn27 I608_G27_26 VDD VSS OAI21_X1
XI608_I93_XP I608_pn27 I608_pn26 I608_P27_26 VDD VSS NOR2_X1
XI608_I94_XG I608_pn28 I608_gn27 I608_gn28 I608_G28_27 VDD VSS OAI21_X1
XI608_I94_XP I608_pn28 I608_pn27 I608_P28_27 VDD VSS NOR2_X1
XI608_I95_XG I608_pn29 I608_gn28 I608_gn29 I608_G29_28 VDD VSS OAI21_X1
XI608_I95_XP I608_pn29 I608_pn28 I608_P29_28 VDD VSS NOR2_X1
XI608_I96_XG I608_pn30 I608_gn29 I608_gn30 I608_G30_29 VDD VSS OAI21_X1
XI608_I96_XP I608_pn30 I608_pn29 I608_P30_29 VDD VSS NOR2_X1
XI608_I97_XG I608_pn31 I608_gn30 I608_gn31 I608_G31_30 VDD VSS OAI21_X1
XI608_I97_XP I608_pn31 I608_pn30 I608_P31_30 VDD VSS NOR2_X1
XI608_I98_XG I608_P2_1 I608_G0_0 I608_G2_1 I608_G2_0n VDD VSS AOI21_X1
XI608_I99_XG I608_P3_2 I608_G1_0 I608_G3_2 I608_G3_0n VDD VSS AOI21_X1
XI608_I100_XG I608_P4_3 I608_G2_1 I608_G4_3 I608_G4_1n VDD VSS AOI21_X1
XI608_I100_XP I608_P4_3 I608_P2_1 I608_P4_1n VDD VSS NAND2_X1
XI608_I101_XG I608_P5_4 I608_G3_2 I608_G5_4 I608_G5_2n VDD VSS AOI21_X1
XI608_I101_XP I608_P5_4 I608_P3_2 I608_P5_2n VDD VSS NAND2_X1
XI608_I102_XG I608_P6_5 I608_G4_3 I608_G6_5 I608_G6_3n VDD VSS AOI21_X1
XI608_I102_XP I608_P6_5 I608_P4_3 I608_P6_3n VDD VSS NAND2_X1
XI608_I103_XG I608_P7_6 I608_G5_4 I608_G7_6 I608_G7_4n VDD VSS AOI21_X1
XI608_I103_XP I608_P7_6 I608_P5_4 I608_P7_4n VDD VSS NAND2_X1
XI608_I104_XG I608_P8_7 I608_G6_5 I608_G8_7 I608_G8_5n VDD VSS AOI21_X1
XI608_I104_XP I608_P8_7 I608_P6_5 I608_P8_5n VDD VSS NAND2_X1
XI608_I105_XG I608_P9_8 I608_G7_6 I608_G9_8 I608_G9_6n VDD VSS AOI21_X1
XI608_I105_XP I608_P9_8 I608_P7_6 I608_P9_6n VDD VSS NAND2_X1
XI608_I106_XG I608_P10_9 I608_G8_7 I608_G10_9 I608_G10_7n VDD VSS AOI21_X1
XI608_I106_XP I608_P10_9 I608_P8_7 I608_P10_7n VDD VSS NAND2_X1
XI608_I107_XG I608_P11_10 I608_G9_8 I608_G11_10 I608_G11_8n VDD VSS AOI21_X1
XI608_I107_XP I608_P11_10 I608_P9_8 I608_P11_8n VDD VSS NAND2_X1
XI608_I108_XG I608_P12_11 I608_G10_9 I608_G12_11 I608_G12_9n VDD VSS AOI21_X1
XI608_I108_XP I608_P12_11 I608_P10_9 I608_P12_9n VDD VSS NAND2_X1
XI608_I109_XG I608_P13_12 I608_G11_10 I608_G13_12 I608_G13_10n VDD VSS AOI21_X1
XI608_I109_XP I608_P13_12 I608_P11_10 I608_P13_10n VDD VSS NAND2_X1
XI608_I110_XG I608_P14_13 I608_G12_11 I608_G14_13 I608_G14_11n VDD VSS AOI21_X1
XI608_I110_XP I608_P14_13 I608_P12_11 I608_P14_11n VDD VSS NAND2_X1
XI608_I111_XG I608_P15_14 I608_G13_12 I608_G15_14 I608_G15_12n VDD VSS AOI21_X1
XI608_I111_XP I608_P15_14 I608_P13_12 I608_P15_12n VDD VSS NAND2_X1
XI608_I112_XG I608_P16_15 I608_G14_13 I608_G16_15 I608_G16_13n VDD VSS AOI21_X1
XI608_I112_XP I608_P16_15 I608_P14_13 I608_P16_13n VDD VSS NAND2_X1
XI608_I113_XG I608_P17_16 I608_G15_14 I608_G17_16 I608_G17_14n VDD VSS AOI21_X1
XI608_I113_XP I608_P17_16 I608_P15_14 I608_P17_14n VDD VSS NAND2_X1
XI608_I114_XG I608_P18_17 I608_G16_15 I608_G18_17 I608_G18_15n VDD VSS AOI21_X1
XI608_I114_XP I608_P18_17 I608_P16_15 I608_P18_15n VDD VSS NAND2_X1
XI608_I115_XG I608_P19_18 I608_G17_16 I608_G19_18 I608_G19_16n VDD VSS AOI21_X1
XI608_I115_XP I608_P19_18 I608_P17_16 I608_P19_16n VDD VSS NAND2_X1
XI608_I116_XG I608_P20_19 I608_G18_17 I608_G20_19 I608_G20_17n VDD VSS AOI21_X1
XI608_I116_XP I608_P20_19 I608_P18_17 I608_P20_17n VDD VSS NAND2_X1
XI608_I117_XG I608_P21_20 I608_G19_18 I608_G21_20 I608_G21_18n VDD VSS AOI21_X1
XI608_I117_XP I608_P21_20 I608_P19_18 I608_P21_18n VDD VSS NAND2_X1
XI608_I118_XG I608_P22_21 I608_G20_19 I608_G22_21 I608_G22_19n VDD VSS AOI21_X1
XI608_I118_XP I608_P22_21 I608_P20_19 I608_P22_19n VDD VSS NAND2_X1
XI608_I119_XG I608_P23_22 I608_G21_20 I608_G23_22 I608_G23_20n VDD VSS AOI21_X1
XI608_I119_XP I608_P23_22 I608_P21_20 I608_P23_20n VDD VSS NAND2_X1
XI608_I120_XG I608_P24_23 I608_G22_21 I608_G24_23 I608_G24_21n VDD VSS AOI21_X1
XI608_I120_XP I608_P24_23 I608_P22_21 I608_P24_21n VDD VSS NAND2_X1
XI608_I121_XG I608_P25_24 I608_G23_22 I608_G25_24 I608_G25_22n VDD VSS AOI21_X1
XI608_I121_XP I608_P25_24 I608_P23_22 I608_P25_22n VDD VSS NAND2_X1
XI608_I122_XG I608_P26_25 I608_G24_23 I608_G26_25 I608_G26_23n VDD VSS AOI21_X1
XI608_I122_XP I608_P26_25 I608_P24_23 I608_P26_23n VDD VSS NAND2_X1
XI608_I123_XG I608_P27_26 I608_G25_24 I608_G27_26 I608_G27_24n VDD VSS AOI21_X1
XI608_I123_XP I608_P27_26 I608_P25_24 I608_P27_24n VDD VSS NAND2_X1
XI608_I124_XG I608_P28_27 I608_G26_25 I608_G28_27 I608_G28_25n VDD VSS AOI21_X1
XI608_I124_XP I608_P28_27 I608_P26_25 I608_P28_25n VDD VSS NAND2_X1
XI608_I125_XG I608_P29_28 I608_G27_26 I608_G29_28 I608_G29_26n VDD VSS AOI21_X1
XI608_I125_XP I608_P29_28 I608_P27_26 I608_P29_26n VDD VSS NAND2_X1
XI608_I126_XG I608_P30_29 I608_G28_27 I608_G30_29 I608_G30_27n VDD VSS AOI21_X1
XI608_I126_XP I608_P30_29 I608_P28_27 I608_P30_27n VDD VSS NAND2_X1
XI608_I127_XG I608_P31_30 I608_G29_28 I608_G31_30 I608_G31_28n VDD VSS AOI21_X1
XI608_I127_XP I608_P31_30 I608_P29_28 I608_P31_28n VDD VSS NAND2_X1
XI608_I128_XG I608_P4_1n I608_G0_0n I608_G4_1n I608_G4_0 VDD VSS OAI21_X1
XI608_I129 I608_G1_0 I608_G1_0n VDD VSS INV_X1
XI608_I130_XG I608_P5_2n I608_G1_0n I608_G5_2n I608_G5_0 VDD VSS OAI21_X1
XI608_I131_XG I608_P6_3n I608_G2_0n I608_G6_3n I608_G6_0 VDD VSS OAI21_X1
XI608_I132_XG I608_P7_4n I608_G3_0n I608_G7_4n I608_G7_0 VDD VSS OAI21_X1
XI608_I133_XG I608_P8_5n I608_G4_1n I608_G8_5n I608_G8_1 VDD VSS OAI21_X1
XI608_I133_XP I608_P8_5n I608_P4_1n I608_P8_1 VDD VSS NOR2_X1
XI608_I134_XG I608_P9_6n I608_G5_2n I608_G9_6n I608_G9_2 VDD VSS OAI21_X1
XI608_I134_XP I608_P9_6n I608_P5_2n I608_P9_2 VDD VSS NOR2_X1
XI608_I135_XG I608_P10_7n I608_G6_3n I608_G10_7n I608_G10_3 VDD VSS OAI21_X1
XI608_I135_XP I608_P10_7n I608_P6_3n I608_P10_3 VDD VSS NOR2_X1
XI608_I136_XG I608_P11_8n I608_G7_4n I608_G11_8n I608_G11_4 VDD VSS OAI21_X1
XI608_I136_XP I608_P11_8n I608_P7_4n I608_P11_4 VDD VSS NOR2_X1
XI608_I137_XG I608_P12_9n I608_G8_5n I608_G12_9n I608_G12_5 VDD VSS OAI21_X1
XI608_I137_XP I608_P12_9n I608_P8_5n I608_P12_5 VDD VSS NOR2_X1
XI608_I138_XG I608_P13_10n I608_G9_6n I608_G13_10n I608_G13_6 VDD VSS OAI21_X1
XI608_I138_XP I608_P13_10n I608_P9_6n I608_P13_6 VDD VSS NOR2_X1
XI608_I139_XG I608_P14_11n I608_G10_7n I608_G14_11n I608_G14_7 VDD VSS OAI21_X1
XI608_I139_XP I608_P14_11n I608_P10_7n I608_P14_7 VDD VSS NOR2_X1
XI608_I140_XG I608_P15_12n I608_G11_8n I608_G15_12n I608_G15_8 VDD VSS OAI21_X1
XI608_I140_XP I608_P15_12n I608_P11_8n I608_P15_8 VDD VSS NOR2_X1
XI608_I141_XG I608_P16_13n I608_G12_9n I608_G16_13n I608_G16_9 VDD VSS OAI21_X1
XI608_I141_XP I608_P16_13n I608_P12_9n I608_P16_9 VDD VSS NOR2_X1
XI608_I142_XG I608_P17_14n I608_G13_10n I608_G17_14n I608_G17_10 VDD VSS OAI21_X1
XI608_I142_XP I608_P17_14n I608_P13_10n I608_P17_10 VDD VSS NOR2_X1
XI608_I143_XG I608_P18_15n I608_G14_11n I608_G18_15n I608_G18_11 VDD VSS OAI21_X1
XI608_I143_XP I608_P18_15n I608_P14_11n I608_P18_11 VDD VSS NOR2_X1
XI608_I144_XG I608_P19_16n I608_G15_12n I608_G19_16n I608_G19_12 VDD VSS OAI21_X1
XI608_I144_XP I608_P19_16n I608_P15_12n I608_P19_12 VDD VSS NOR2_X1
XI608_I145_XG I608_P20_17n I608_G16_13n I608_G20_17n I608_G20_13 VDD VSS OAI21_X1
XI608_I145_XP I608_P20_17n I608_P16_13n I608_P20_13 VDD VSS NOR2_X1
XI608_I146_XG I608_P21_18n I608_G17_14n I608_G21_18n I608_G21_14 VDD VSS OAI21_X1
XI608_I146_XP I608_P21_18n I608_P17_14n I608_P21_14 VDD VSS NOR2_X1
XI608_I147_XG I608_P22_19n I608_G18_15n I608_G22_19n I608_G22_15 VDD VSS OAI21_X1
XI608_I147_XP I608_P22_19n I608_P18_15n I608_P22_15 VDD VSS NOR2_X1
XI608_I148_XG I608_P23_20n I608_G19_16n I608_G23_20n I608_G23_16 VDD VSS OAI21_X1
XI608_I148_XP I608_P23_20n I608_P19_16n I608_P23_16 VDD VSS NOR2_X1
XI608_I149_XG I608_P24_21n I608_G20_17n I608_G24_21n I608_G24_17 VDD VSS OAI21_X1
XI608_I149_XP I608_P24_21n I608_P20_17n I608_P24_17 VDD VSS NOR2_X1
XI608_I150_XG I608_P25_22n I608_G21_18n I608_G25_22n I608_G25_18 VDD VSS OAI21_X1
XI608_I150_XP I608_P25_22n I608_P21_18n I608_P25_18 VDD VSS NOR2_X1
XI608_I151_XG I608_P26_23n I608_G22_19n I608_G26_23n I608_G26_19 VDD VSS OAI21_X1
XI608_I151_XP I608_P26_23n I608_P22_19n I608_P26_19 VDD VSS NOR2_X1
XI608_I152_XG I608_P27_24n I608_G23_20n I608_G27_24n I608_G27_20 VDD VSS OAI21_X1
XI608_I152_XP I608_P27_24n I608_P23_20n I608_P27_20 VDD VSS NOR2_X1
XI608_I153_XG I608_P28_25n I608_G24_21n I608_G28_25n I608_G28_21 VDD VSS OAI21_X1
XI608_I153_XP I608_P28_25n I608_P24_21n I608_P28_21 VDD VSS NOR2_X1
XI608_I154_XG I608_P29_26n I608_G25_22n I608_G29_26n I608_G29_22 VDD VSS OAI21_X1
XI608_I154_XP I608_P29_26n I608_P25_22n I608_P29_22 VDD VSS NOR2_X1
XI608_I155_XG I608_P30_27n I608_G26_23n I608_G30_27n I608_G30_23 VDD VSS OAI21_X1
XI608_I155_XP I608_P30_27n I608_P26_23n I608_P30_23 VDD VSS NOR2_X1
XI608_I156_XG I608_P31_28n I608_G27_24n I608_G31_28n I608_G31_24 VDD VSS OAI21_X1
XI608_I156_XP I608_P31_28n I608_P27_24n I608_P31_24 VDD VSS NOR2_X1
XI608_I157_XG I608_P8_1 I608_G0_0 I608_G8_1 I608_G8_0n VDD VSS AOI21_X1
XI608_I158_XG I608_P9_2 I608_G1_0 I608_G9_2 I608_G9_0n VDD VSS AOI21_X1
XI608_I159 I608_G2_0n I608_G2_0np VDD VSS INV_X1
XI608_I160_XG I608_P10_3 I608_G2_0np I608_G10_3 I608_G10_0n VDD VSS AOI21_X1
XI608_I161 I608_G3_0n I608_G3_0np VDD VSS INV_X1
XI608_I162_XG I608_P11_4 I608_G3_0np I608_G11_4 I608_G11_0n VDD VSS AOI21_X1
XI608_I163_XG I608_P12_5 I608_G4_0 I608_G12_5 I608_G12_0n VDD VSS AOI21_X1
XI608_I164_XG I608_P13_6 I608_G5_0 I608_G13_6 I608_G13_0n VDD VSS AOI21_X1
XI608_I165_XG I608_P14_7 I608_G6_0 I608_G14_7 I608_G14_0n VDD VSS AOI21_X1
XI608_I166_XG I608_P15_8 I608_G7_0 I608_G15_8 I608_G15_0n VDD VSS AOI21_X1
XI608_I167_XG I608_P16_9 I608_G8_1 I608_G16_9 I608_G16_1n VDD VSS AOI21_X1
XI608_I167_XP I608_P16_9 I608_P8_1 I608_P16_1n VDD VSS NAND2_X1
XI608_I168_XG I608_P17_10 I608_G9_2 I608_G17_10 I608_G17_2n VDD VSS AOI21_X1
XI608_I168_XP I608_P17_10 I608_P9_2 I608_P17_2n VDD VSS NAND2_X1
XI608_I169_XG I608_P18_11 I608_G10_3 I608_G18_11 I608_G18_3n VDD VSS AOI21_X1
XI608_I169_XP I608_P18_11 I608_P10_3 I608_P18_3n VDD VSS NAND2_X1
XI608_I170_XG I608_P19_12 I608_G11_4 I608_G19_12 I608_G19_4n VDD VSS AOI21_X1
XI608_I170_XP I608_P19_12 I608_P11_4 I608_P19_4n VDD VSS NAND2_X1
XI608_I171_XG I608_P20_13 I608_G12_5 I608_G20_13 I608_G20_5n VDD VSS AOI21_X1
XI608_I171_XP I608_P20_13 I608_P12_5 I608_P20_5n VDD VSS NAND2_X1
XI608_I172_XG I608_P21_14 I608_G13_6 I608_G21_14 I608_G21_6n VDD VSS AOI21_X1
XI608_I172_XP I608_P21_14 I608_P13_6 I608_P21_6n VDD VSS NAND2_X1
XI608_I173_XG I608_P22_15 I608_G14_7 I608_G22_15 I608_G22_7n VDD VSS AOI21_X1
XI608_I173_XP I608_P22_15 I608_P14_7 I608_P22_7n VDD VSS NAND2_X1
XI608_I174_XG I608_P23_16 I608_G15_8 I608_G23_16 I608_G23_8n VDD VSS AOI21_X1
XI608_I174_XP I608_P23_16 I608_P15_8 I608_P23_8n VDD VSS NAND2_X1
XI608_I175_XG I608_P24_17 I608_G16_9 I608_G24_17 I608_G24_9n VDD VSS AOI21_X1
XI608_I175_XP I608_P24_17 I608_P16_9 I608_P24_9n VDD VSS NAND2_X1
XI608_I176_XG I608_P25_18 I608_G17_10 I608_G25_18 I608_G25_10n VDD VSS AOI21_X1
XI608_I176_XP I608_P25_18 I608_P17_10 I608_P25_10n VDD VSS NAND2_X1
XI608_I177_XG I608_P26_19 I608_G18_11 I608_G26_19 I608_G26_11n VDD VSS AOI21_X1
XI608_I177_XP I608_P26_19 I608_P18_11 I608_P26_11n VDD VSS NAND2_X1
XI608_I178_XG I608_P27_20 I608_G19_12 I608_G27_20 I608_G27_12n VDD VSS AOI21_X1
XI608_I178_XP I608_P27_20 I608_P19_12 I608_P27_12n VDD VSS NAND2_X1
XI608_I179_XG I608_P28_21 I608_G20_13 I608_G28_21 I608_G28_13n VDD VSS AOI21_X1
XI608_I179_XP I608_P28_21 I608_P20_13 I608_P28_13n VDD VSS NAND2_X1
XI608_I180_XG I608_P29_22 I608_G21_14 I608_G29_22 I608_G29_14n VDD VSS AOI21_X1
XI608_I180_XP I608_P29_22 I608_P21_14 I608_P29_14n VDD VSS NAND2_X1
XI608_I181_XG I608_P30_23 I608_G22_15 I608_G30_23 I608_G30_15n VDD VSS AOI21_X1
XI608_I181_XP I608_P30_23 I608_P22_15 I608_P30_15n VDD VSS NAND2_X1
XI608_I182_XG I608_P31_24 I608_G23_16 I608_G31_24 I608_G31_16n VDD VSS AOI21_X1
XI608_I182_XP I608_P31_24 I608_P23_16 I608_P31_16n VDD VSS NAND2_X1
XI608_I183_XG I608_P16_1n I608_G0_0n I608_G16_1n I608_G16_0 VDD VSS OAI21_X1
XI608_I184_XG I608_P17_2n I608_G1_0n I608_G17_2n I608_G17_0 VDD VSS OAI21_X1
XI608_I185_XG I608_P18_3n I608_G2_0n I608_G18_3n I608_G18_0 VDD VSS OAI21_X1
XI608_I186_XG I608_P19_4n I608_G3_0n I608_G19_4n I608_G19_0 VDD VSS OAI21_X1
XI608_I187 I608_G4_0 I608_G4_0n VDD VSS INV_X1
XI608_I188_XG I608_P20_5n I608_G4_0n I608_G20_5n I608_G20_0 VDD VSS OAI21_X1
XI608_I189 I608_G5_0 I608_G5_0n VDD VSS INV_X1
XI608_I190_XG I608_P21_6n I608_G5_0n I608_G21_6n I608_G21_0 VDD VSS OAI21_X1
XI608_I191 I608_G6_0 I608_G6_0n VDD VSS INV_X1
XI608_I192_XG I608_P22_7n I608_G6_0n I608_G22_7n I608_G22_0 VDD VSS OAI21_X1
XI608_I193 I608_G7_0 I608_G7_0n VDD VSS INV_X1
XI608_I194_XG I608_P23_8n I608_G7_0n I608_G23_8n I608_G23_0 VDD VSS OAI21_X1
XI608_I195_XG I608_P24_9n I608_G8_0n I608_G24_9n I608_G24_0 VDD VSS OAI21_X1
XI608_I196_XG I608_P25_10n I608_G9_0n I608_G25_10n I608_G25_0 VDD VSS OAI21_X1
XI608_I197_XG I608_P26_11n I608_G10_0n I608_G26_11n I608_G26_0 VDD VSS OAI21_X1
XI608_I198_XG I608_P27_12n I608_G11_0n I608_G27_12n I608_G27_0 VDD VSS OAI21_X1
XI608_I199_XG I608_P28_13n I608_G12_0n I608_G28_13n I608_G28_0 VDD VSS OAI21_X1
XI608_I200_XG I608_P29_14n I608_G13_0n I608_G29_14n I608_G29_0 VDD VSS OAI21_X1
XI608_I201_XG I608_P30_15n I608_G14_0n I608_G30_15n c1_m VDD VSS OAI21_X1
XI608_I202_XG I608_P31_16n I608_G15_0n I608_G31_16n c1_o VDD VSS OAI21_X1
XI608_I203 I608_pn0 qu31_b3_5 p1_0 VDD VSS XNOR2_X1
XI608_I204 I608_pn1 I608_G0_0 p1_1 VDD VSS XNOR2_X1
XI608_I205 I608_pn2 I608_G1_0 p1_2 VDD VSS XNOR2_X1
XI608_I206 I608_pn3 I608_G2_0n p1_3 VDD VSS XOR2_X1
XI608_I207 I608_pn4 I608_G3_0n p1_4 VDD VSS XOR2_X1
XI608_I208 I608_pn5 I608_G4_0 p1_5 VDD VSS XNOR2_X1
XI608_I209 I608_pn6 I608_G5_0 p1_6 VDD VSS XNOR2_X1
XI608_I210 I608_pn7 I608_G6_0 p1_7 VDD VSS XNOR2_X1
XI608_I211 I608_pn8 I608_G7_0 p1_8 VDD VSS XNOR2_X1
XI608_I212 I608_pn9 I608_G8_0n p1_9 VDD VSS XOR2_X1
XI608_I213 I608_pn10 I608_G9_0n p1_10 VDD VSS XOR2_X1
XI608_I214 I608_pn11 I608_G10_0n p1_11 VDD VSS XOR2_X1
XI608_I215 I608_pn12 I608_G11_0n p1_12 VDD VSS XOR2_X1
XI608_I216 I608_pn13 I608_G12_0n p1_13 VDD VSS XOR2_X1
XI608_I217 I608_pn14 I608_G13_0n p1_14 VDD VSS XOR2_X1
XI608_I218 I608_pn15 I608_G14_0n p1_15 VDD VSS XOR2_X1
XI608_I219 I608_pn16 I608_G15_0n p1_16 VDD VSS XOR2_X1
XI608_I220 I608_pn17 I608_G16_0 p1_17 VDD VSS XNOR2_X1
XI608_I221 I608_pn18 I608_G17_0 p1_18 VDD VSS XNOR2_X1
XI608_I222 I608_pn19 I608_G18_0 p1_19 VDD VSS XNOR2_X1
XI608_I223 I608_pn20 I608_G19_0 p1_20 VDD VSS XNOR2_X1
XI608_I224 I608_pn21 I608_G20_0 p1_21 VDD VSS XNOR2_X1
XI608_I225 I608_pn22 I608_G21_0 p1_22 VDD VSS XNOR2_X1
XI608_I226 I608_pn23 I608_G22_0 p1_23 VDD VSS XNOR2_X1
XI608_I227 I608_pn24 I608_G23_0 p1_24 VDD VSS XNOR2_X1
XI608_I228 I608_pn25 I608_G24_0 p1_25 VDD VSS XNOR2_X1
XI608_I229 I608_pn26 I608_G25_0 p1_26 VDD VSS XNOR2_X1
XI608_I230 I608_pn27 I608_G26_0 p1_27 VDD VSS XNOR2_X1
XI608_I231 I608_pn28 I608_G27_0 p1_28 VDD VSS XNOR2_X1
XI608_I232 I608_pn29 I608_G28_0 p1_29 VDD VSS XNOR2_X1
XI608_I233 I608_pn30 I608_G29_0 p1_30 VDD VSS XNOR2_X1
XI608_I234 I608_pn31 c1_m p1_31 VDD VSS XNOR2_X1
XI609 p0_31 qu31_b3_5 h1 VDD VSS XOR2_X1
XI610 h1 c1_o p1_32 VDD VSS XOR2_X1
XI611 p1_32 qu30 VDD VSS INV_X4
XI612 qu30 qu30_b0 VDD VSS INV_X1
XI613 qu30_b0 qu30_b1_0 VDD VSS INV_X4
XI614 qu30_b1_0 qu30_b2_0 VDD VSS INV_X4
XI615 qu30_b1_0 qu30_b2_1 VDD VSS INV_X4
XI616 qu30_b2_0 qu30_b3_0 VDD VSS INV_X4
XI617 qu30_b2_0 qu30_b3_1 VDD VSS INV_X4
XI618 qu30_b2_0 qu30_b3_2 VDD VSS INV_X4
XI619 qu30_b2_1 qu30_b3_3 VDD VSS INV_X4
XI620 qu30_b2_1 qu30_b3_4 VDD VSS INV_X4
XI621 qu30_b2_1 qu30_b3_5 VDD VSS INV_X4
XI622 B_0_b3_0 qu30_b3_0 b2_0 VDD VSS XOR2_X1
XI623 dd1_b3_0 qu30_b3_0 b2_1 VDD VSS XOR2_X1
XI624 dd2_b3_0 qu30_b3_0 b2_2 VDD VSS XOR2_X1
XI625 dd3_b3_0 qu30_b3_0 b2_3 VDD VSS XOR2_X1
XI626 dd4_b3_0 qu30_b3_0 b2_4 VDD VSS XOR2_X1
XI627 dd5_b3_0 qu30_b3_0 b2_5 VDD VSS XOR2_X1
XI628 dd6_b3_0 qu30_b3_1 b2_6 VDD VSS XOR2_X1
XI629 dd7_b3_0 qu30_b3_1 b2_7 VDD VSS XOR2_X1
XI630 dd8_b3_0 qu30_b3_1 b2_8 VDD VSS XOR2_X1
XI631 dd9_b3_0 qu30_b3_1 b2_9 VDD VSS XOR2_X1
XI632 dd10_b3_0 qu30_b3_1 b2_10 VDD VSS XOR2_X1
XI633 dd11_b3_0 qu30_b3_1 b2_11 VDD VSS XOR2_X1
XI634 dd12_b3_0 qu30_b3_2 b2_12 VDD VSS XOR2_X1
XI635 dd13_b3_0 qu30_b3_2 b2_13 VDD VSS XOR2_X1
XI636 dd14_b3_0 qu30_b3_2 b2_14 VDD VSS XOR2_X1
XI637 dd15_b3_0 qu30_b3_2 b2_15 VDD VSS XOR2_X1
XI638 dd16_b3_0 qu30_b3_2 b2_16 VDD VSS XOR2_X1
XI639 dd17_b3_0 qu30_b3_2 b2_17 VDD VSS XOR2_X1
XI640 dd18_b3_0 qu30_b3_3 b2_18 VDD VSS XOR2_X1
XI641 dd19_b3_0 qu30_b3_3 b2_19 VDD VSS XOR2_X1
XI642 dd20_b3_0 qu30_b3_3 b2_20 VDD VSS XOR2_X1
XI643 dd21_b3_0 qu30_b3_3 b2_21 VDD VSS XOR2_X1
XI644 dd22_b3_0 qu30_b3_3 b2_22 VDD VSS XOR2_X1
XI645 dd23_b3_0 qu30_b3_3 b2_23 VDD VSS XOR2_X1
XI646 dd24_b3_0 qu30_b3_4 b2_24 VDD VSS XOR2_X1
XI647 dd25_b3_0 qu30_b3_4 b2_25 VDD VSS XOR2_X1
XI648 dd26_b3_0 qu30_b3_4 b2_26 VDD VSS XOR2_X1
XI649 dd27_b3_0 qu30_b3_4 b2_27 VDD VSS XOR2_X1
XI650 dd28_b3_0 qu30_b3_4 b2_28 VDD VSS XOR2_X1
XI651 dd29_b3_0 qu30_b3_4 b2_29 VDD VSS XOR2_X1
XI652 dd30_b3_0 qu30_b3_5 b2_30 VDD VSS XOR2_X1
XI653 dd31_b3_0 qu30_b3_5 b2_31 VDD VSS XOR2_X1
XI654_I0 aa29 b2_0 I654_gn0 VDD VSS NAND2_X1
XI654_I1 p1_0 b2_1 I654_gn1 VDD VSS NAND2_X1
XI654_I2 p1_1 b2_2 I654_gn2 VDD VSS NAND2_X1
XI654_I3 p1_2 b2_3 I654_gn3 VDD VSS NAND2_X1
XI654_I4 p1_3 b2_4 I654_gn4 VDD VSS NAND2_X1
XI654_I5 p1_4 b2_5 I654_gn5 VDD VSS NAND2_X1
XI654_I6 p1_5 b2_6 I654_gn6 VDD VSS NAND2_X1
XI654_I7 p1_6 b2_7 I654_gn7 VDD VSS NAND2_X1
XI654_I8 p1_7 b2_8 I654_gn8 VDD VSS NAND2_X1
XI654_I9 p1_8 b2_9 I654_gn9 VDD VSS NAND2_X1
XI654_I10 p1_9 b2_10 I654_gn10 VDD VSS NAND2_X1
XI654_I11 p1_10 b2_11 I654_gn11 VDD VSS NAND2_X1
XI654_I12 p1_11 b2_12 I654_gn12 VDD VSS NAND2_X1
XI654_I13 p1_12 b2_13 I654_gn13 VDD VSS NAND2_X1
XI654_I14 p1_13 b2_14 I654_gn14 VDD VSS NAND2_X1
XI654_I15 p1_14 b2_15 I654_gn15 VDD VSS NAND2_X1
XI654_I16 p1_15 b2_16 I654_gn16 VDD VSS NAND2_X1
XI654_I17 p1_16 b2_17 I654_gn17 VDD VSS NAND2_X1
XI654_I18 p1_17 b2_18 I654_gn18 VDD VSS NAND2_X1
XI654_I19 p1_18 b2_19 I654_gn19 VDD VSS NAND2_X1
XI654_I20 p1_19 b2_20 I654_gn20 VDD VSS NAND2_X1
XI654_I21 p1_20 b2_21 I654_gn21 VDD VSS NAND2_X1
XI654_I22 p1_21 b2_22 I654_gn22 VDD VSS NAND2_X1
XI654_I23 p1_22 b2_23 I654_gn23 VDD VSS NAND2_X1
XI654_I24 p1_23 b2_24 I654_gn24 VDD VSS NAND2_X1
XI654_I25 p1_24 b2_25 I654_gn25 VDD VSS NAND2_X1
XI654_I26 p1_25 b2_26 I654_gn26 VDD VSS NAND2_X1
XI654_I27 p1_26 b2_27 I654_gn27 VDD VSS NAND2_X1
XI654_I28 p1_27 b2_28 I654_gn28 VDD VSS NAND2_X1
XI654_I29 p1_28 b2_29 I654_gn29 VDD VSS NAND2_X1
XI654_I30 p1_29 b2_30 I654_gn30 VDD VSS NAND2_X1
XI654_I31 p1_30 b2_31 I654_gn31 VDD VSS NAND2_X1
XI654_I32 aa29 b2_0 I654_pn0 VDD VSS XNOR2_X1
XI654_I33 p1_0 b2_1 I654_pn1 VDD VSS XNOR2_X1
XI654_I34 p1_1 b2_2 I654_pn2 VDD VSS XNOR2_X1
XI654_I35 p1_2 b2_3 I654_pn3 VDD VSS XNOR2_X1
XI654_I36 p1_3 b2_4 I654_pn4 VDD VSS XNOR2_X1
XI654_I37 p1_4 b2_5 I654_pn5 VDD VSS XNOR2_X1
XI654_I38 p1_5 b2_6 I654_pn6 VDD VSS XNOR2_X1
XI654_I39 p1_6 b2_7 I654_pn7 VDD VSS XNOR2_X1
XI654_I40 p1_7 b2_8 I654_pn8 VDD VSS XNOR2_X1
XI654_I41 p1_8 b2_9 I654_pn9 VDD VSS XNOR2_X1
XI654_I42 p1_9 b2_10 I654_pn10 VDD VSS XNOR2_X1
XI654_I43 p1_10 b2_11 I654_pn11 VDD VSS XNOR2_X1
XI654_I44 p1_11 b2_12 I654_pn12 VDD VSS XNOR2_X1
XI654_I45 p1_12 b2_13 I654_pn13 VDD VSS XNOR2_X1
XI654_I46 p1_13 b2_14 I654_pn14 VDD VSS XNOR2_X1
XI654_I47 p1_14 b2_15 I654_pn15 VDD VSS XNOR2_X1
XI654_I48 p1_15 b2_16 I654_pn16 VDD VSS XNOR2_X1
XI654_I49 p1_16 b2_17 I654_pn17 VDD VSS XNOR2_X1
XI654_I50 p1_17 b2_18 I654_pn18 VDD VSS XNOR2_X1
XI654_I51 p1_18 b2_19 I654_pn19 VDD VSS XNOR2_X1
XI654_I52 p1_19 b2_20 I654_pn20 VDD VSS XNOR2_X1
XI654_I53 p1_20 b2_21 I654_pn21 VDD VSS XNOR2_X1
XI654_I54 p1_21 b2_22 I654_pn22 VDD VSS XNOR2_X1
XI654_I55 p1_22 b2_23 I654_pn23 VDD VSS XNOR2_X1
XI654_I56 p1_23 b2_24 I654_pn24 VDD VSS XNOR2_X1
XI654_I57 p1_24 b2_25 I654_pn25 VDD VSS XNOR2_X1
XI654_I58 p1_25 b2_26 I654_pn26 VDD VSS XNOR2_X1
XI654_I59 p1_26 b2_27 I654_pn27 VDD VSS XNOR2_X1
XI654_I60 p1_27 b2_28 I654_pn28 VDD VSS XNOR2_X1
XI654_I61 p1_28 b2_29 I654_pn29 VDD VSS XNOR2_X1
XI654_I62 p1_29 b2_30 I654_pn30 VDD VSS XNOR2_X1
XI654_I63 p1_30 b2_31 I654_pn31 VDD VSS XNOR2_X1
XI654_I64 qu30_b3_5 I654_cinn VDD VSS INV_X1
XI654_I65_XG I654_pn0 I654_cinn I654_gn0 I654_G0_0 VDD VSS OAI21_X1
XI654_I66 I654_G0_0 I654_G0_0n VDD VSS INV_X1
XI654_I67_XG I654_pn1 I654_G0_0n I654_gn1 I654_G1_0 VDD VSS OAI21_X1
XI654_I68_XG I654_pn2 I654_gn1 I654_gn2 I654_G2_1 VDD VSS OAI21_X1
XI654_I68_XP I654_pn2 I654_pn1 I654_P2_1 VDD VSS NOR2_X1
XI654_I69_XG I654_pn3 I654_gn2 I654_gn3 I654_G3_2 VDD VSS OAI21_X1
XI654_I69_XP I654_pn3 I654_pn2 I654_P3_2 VDD VSS NOR2_X1
XI654_I70_XG I654_pn4 I654_gn3 I654_gn4 I654_G4_3 VDD VSS OAI21_X1
XI654_I70_XP I654_pn4 I654_pn3 I654_P4_3 VDD VSS NOR2_X1
XI654_I71_XG I654_pn5 I654_gn4 I654_gn5 I654_G5_4 VDD VSS OAI21_X1
XI654_I71_XP I654_pn5 I654_pn4 I654_P5_4 VDD VSS NOR2_X1
XI654_I72_XG I654_pn6 I654_gn5 I654_gn6 I654_G6_5 VDD VSS OAI21_X1
XI654_I72_XP I654_pn6 I654_pn5 I654_P6_5 VDD VSS NOR2_X1
XI654_I73_XG I654_pn7 I654_gn6 I654_gn7 I654_G7_6 VDD VSS OAI21_X1
XI654_I73_XP I654_pn7 I654_pn6 I654_P7_6 VDD VSS NOR2_X1
XI654_I74_XG I654_pn8 I654_gn7 I654_gn8 I654_G8_7 VDD VSS OAI21_X1
XI654_I74_XP I654_pn8 I654_pn7 I654_P8_7 VDD VSS NOR2_X1
XI654_I75_XG I654_pn9 I654_gn8 I654_gn9 I654_G9_8 VDD VSS OAI21_X1
XI654_I75_XP I654_pn9 I654_pn8 I654_P9_8 VDD VSS NOR2_X1
XI654_I76_XG I654_pn10 I654_gn9 I654_gn10 I654_G10_9 VDD VSS OAI21_X1
XI654_I76_XP I654_pn10 I654_pn9 I654_P10_9 VDD VSS NOR2_X1
XI654_I77_XG I654_pn11 I654_gn10 I654_gn11 I654_G11_10 VDD VSS OAI21_X1
XI654_I77_XP I654_pn11 I654_pn10 I654_P11_10 VDD VSS NOR2_X1
XI654_I78_XG I654_pn12 I654_gn11 I654_gn12 I654_G12_11 VDD VSS OAI21_X1
XI654_I78_XP I654_pn12 I654_pn11 I654_P12_11 VDD VSS NOR2_X1
XI654_I79_XG I654_pn13 I654_gn12 I654_gn13 I654_G13_12 VDD VSS OAI21_X1
XI654_I79_XP I654_pn13 I654_pn12 I654_P13_12 VDD VSS NOR2_X1
XI654_I80_XG I654_pn14 I654_gn13 I654_gn14 I654_G14_13 VDD VSS OAI21_X1
XI654_I80_XP I654_pn14 I654_pn13 I654_P14_13 VDD VSS NOR2_X1
XI654_I81_XG I654_pn15 I654_gn14 I654_gn15 I654_G15_14 VDD VSS OAI21_X1
XI654_I81_XP I654_pn15 I654_pn14 I654_P15_14 VDD VSS NOR2_X1
XI654_I82_XG I654_pn16 I654_gn15 I654_gn16 I654_G16_15 VDD VSS OAI21_X1
XI654_I82_XP I654_pn16 I654_pn15 I654_P16_15 VDD VSS NOR2_X1
XI654_I83_XG I654_pn17 I654_gn16 I654_gn17 I654_G17_16 VDD VSS OAI21_X1
XI654_I83_XP I654_pn17 I654_pn16 I654_P17_16 VDD VSS NOR2_X1
XI654_I84_XG I654_pn18 I654_gn17 I654_gn18 I654_G18_17 VDD VSS OAI21_X1
XI654_I84_XP I654_pn18 I654_pn17 I654_P18_17 VDD VSS NOR2_X1
XI654_I85_XG I654_pn19 I654_gn18 I654_gn19 I654_G19_18 VDD VSS OAI21_X1
XI654_I85_XP I654_pn19 I654_pn18 I654_P19_18 VDD VSS NOR2_X1
XI654_I86_XG I654_pn20 I654_gn19 I654_gn20 I654_G20_19 VDD VSS OAI21_X1
XI654_I86_XP I654_pn20 I654_pn19 I654_P20_19 VDD VSS NOR2_X1
XI654_I87_XG I654_pn21 I654_gn20 I654_gn21 I654_G21_20 VDD VSS OAI21_X1
XI654_I87_XP I654_pn21 I654_pn20 I654_P21_20 VDD VSS NOR2_X1
XI654_I88_XG I654_pn22 I654_gn21 I654_gn22 I654_G22_21 VDD VSS OAI21_X1
XI654_I88_XP I654_pn22 I654_pn21 I654_P22_21 VDD VSS NOR2_X1
XI654_I89_XG I654_pn23 I654_gn22 I654_gn23 I654_G23_22 VDD VSS OAI21_X1
XI654_I89_XP I654_pn23 I654_pn22 I654_P23_22 VDD VSS NOR2_X1
XI654_I90_XG I654_pn24 I654_gn23 I654_gn24 I654_G24_23 VDD VSS OAI21_X1
XI654_I90_XP I654_pn24 I654_pn23 I654_P24_23 VDD VSS NOR2_X1
XI654_I91_XG I654_pn25 I654_gn24 I654_gn25 I654_G25_24 VDD VSS OAI21_X1
XI654_I91_XP I654_pn25 I654_pn24 I654_P25_24 VDD VSS NOR2_X1
XI654_I92_XG I654_pn26 I654_gn25 I654_gn26 I654_G26_25 VDD VSS OAI21_X1
XI654_I92_XP I654_pn26 I654_pn25 I654_P26_25 VDD VSS NOR2_X1
XI654_I93_XG I654_pn27 I654_gn26 I654_gn27 I654_G27_26 VDD VSS OAI21_X1
XI654_I93_XP I654_pn27 I654_pn26 I654_P27_26 VDD VSS NOR2_X1
XI654_I94_XG I654_pn28 I654_gn27 I654_gn28 I654_G28_27 VDD VSS OAI21_X1
XI654_I94_XP I654_pn28 I654_pn27 I654_P28_27 VDD VSS NOR2_X1
XI654_I95_XG I654_pn29 I654_gn28 I654_gn29 I654_G29_28 VDD VSS OAI21_X1
XI654_I95_XP I654_pn29 I654_pn28 I654_P29_28 VDD VSS NOR2_X1
XI654_I96_XG I654_pn30 I654_gn29 I654_gn30 I654_G30_29 VDD VSS OAI21_X1
XI654_I96_XP I654_pn30 I654_pn29 I654_P30_29 VDD VSS NOR2_X1
XI654_I97_XG I654_pn31 I654_gn30 I654_gn31 I654_G31_30 VDD VSS OAI21_X1
XI654_I97_XP I654_pn31 I654_pn30 I654_P31_30 VDD VSS NOR2_X1
XI654_I98_XG I654_P2_1 I654_G0_0 I654_G2_1 I654_G2_0n VDD VSS AOI21_X1
XI654_I99_XG I654_P3_2 I654_G1_0 I654_G3_2 I654_G3_0n VDD VSS AOI21_X1
XI654_I100_XG I654_P4_3 I654_G2_1 I654_G4_3 I654_G4_1n VDD VSS AOI21_X1
XI654_I100_XP I654_P4_3 I654_P2_1 I654_P4_1n VDD VSS NAND2_X1
XI654_I101_XG I654_P5_4 I654_G3_2 I654_G5_4 I654_G5_2n VDD VSS AOI21_X1
XI654_I101_XP I654_P5_4 I654_P3_2 I654_P5_2n VDD VSS NAND2_X1
XI654_I102_XG I654_P6_5 I654_G4_3 I654_G6_5 I654_G6_3n VDD VSS AOI21_X1
XI654_I102_XP I654_P6_5 I654_P4_3 I654_P6_3n VDD VSS NAND2_X1
XI654_I103_XG I654_P7_6 I654_G5_4 I654_G7_6 I654_G7_4n VDD VSS AOI21_X1
XI654_I103_XP I654_P7_6 I654_P5_4 I654_P7_4n VDD VSS NAND2_X1
XI654_I104_XG I654_P8_7 I654_G6_5 I654_G8_7 I654_G8_5n VDD VSS AOI21_X1
XI654_I104_XP I654_P8_7 I654_P6_5 I654_P8_5n VDD VSS NAND2_X1
XI654_I105_XG I654_P9_8 I654_G7_6 I654_G9_8 I654_G9_6n VDD VSS AOI21_X1
XI654_I105_XP I654_P9_8 I654_P7_6 I654_P9_6n VDD VSS NAND2_X1
XI654_I106_XG I654_P10_9 I654_G8_7 I654_G10_9 I654_G10_7n VDD VSS AOI21_X1
XI654_I106_XP I654_P10_9 I654_P8_7 I654_P10_7n VDD VSS NAND2_X1
XI654_I107_XG I654_P11_10 I654_G9_8 I654_G11_10 I654_G11_8n VDD VSS AOI21_X1
XI654_I107_XP I654_P11_10 I654_P9_8 I654_P11_8n VDD VSS NAND2_X1
XI654_I108_XG I654_P12_11 I654_G10_9 I654_G12_11 I654_G12_9n VDD VSS AOI21_X1
XI654_I108_XP I654_P12_11 I654_P10_9 I654_P12_9n VDD VSS NAND2_X1
XI654_I109_XG I654_P13_12 I654_G11_10 I654_G13_12 I654_G13_10n VDD VSS AOI21_X1
XI654_I109_XP I654_P13_12 I654_P11_10 I654_P13_10n VDD VSS NAND2_X1
XI654_I110_XG I654_P14_13 I654_G12_11 I654_G14_13 I654_G14_11n VDD VSS AOI21_X1
XI654_I110_XP I654_P14_13 I654_P12_11 I654_P14_11n VDD VSS NAND2_X1
XI654_I111_XG I654_P15_14 I654_G13_12 I654_G15_14 I654_G15_12n VDD VSS AOI21_X1
XI654_I111_XP I654_P15_14 I654_P13_12 I654_P15_12n VDD VSS NAND2_X1
XI654_I112_XG I654_P16_15 I654_G14_13 I654_G16_15 I654_G16_13n VDD VSS AOI21_X1
XI654_I112_XP I654_P16_15 I654_P14_13 I654_P16_13n VDD VSS NAND2_X1
XI654_I113_XG I654_P17_16 I654_G15_14 I654_G17_16 I654_G17_14n VDD VSS AOI21_X1
XI654_I113_XP I654_P17_16 I654_P15_14 I654_P17_14n VDD VSS NAND2_X1
XI654_I114_XG I654_P18_17 I654_G16_15 I654_G18_17 I654_G18_15n VDD VSS AOI21_X1
XI654_I114_XP I654_P18_17 I654_P16_15 I654_P18_15n VDD VSS NAND2_X1
XI654_I115_XG I654_P19_18 I654_G17_16 I654_G19_18 I654_G19_16n VDD VSS AOI21_X1
XI654_I115_XP I654_P19_18 I654_P17_16 I654_P19_16n VDD VSS NAND2_X1
XI654_I116_XG I654_P20_19 I654_G18_17 I654_G20_19 I654_G20_17n VDD VSS AOI21_X1
XI654_I116_XP I654_P20_19 I654_P18_17 I654_P20_17n VDD VSS NAND2_X1
XI654_I117_XG I654_P21_20 I654_G19_18 I654_G21_20 I654_G21_18n VDD VSS AOI21_X1
XI654_I117_XP I654_P21_20 I654_P19_18 I654_P21_18n VDD VSS NAND2_X1
XI654_I118_XG I654_P22_21 I654_G20_19 I654_G22_21 I654_G22_19n VDD VSS AOI21_X1
XI654_I118_XP I654_P22_21 I654_P20_19 I654_P22_19n VDD VSS NAND2_X1
XI654_I119_XG I654_P23_22 I654_G21_20 I654_G23_22 I654_G23_20n VDD VSS AOI21_X1
XI654_I119_XP I654_P23_22 I654_P21_20 I654_P23_20n VDD VSS NAND2_X1
XI654_I120_XG I654_P24_23 I654_G22_21 I654_G24_23 I654_G24_21n VDD VSS AOI21_X1
XI654_I120_XP I654_P24_23 I654_P22_21 I654_P24_21n VDD VSS NAND2_X1
XI654_I121_XG I654_P25_24 I654_G23_22 I654_G25_24 I654_G25_22n VDD VSS AOI21_X1
XI654_I121_XP I654_P25_24 I654_P23_22 I654_P25_22n VDD VSS NAND2_X1
XI654_I122_XG I654_P26_25 I654_G24_23 I654_G26_25 I654_G26_23n VDD VSS AOI21_X1
XI654_I122_XP I654_P26_25 I654_P24_23 I654_P26_23n VDD VSS NAND2_X1
XI654_I123_XG I654_P27_26 I654_G25_24 I654_G27_26 I654_G27_24n VDD VSS AOI21_X1
XI654_I123_XP I654_P27_26 I654_P25_24 I654_P27_24n VDD VSS NAND2_X1
XI654_I124_XG I654_P28_27 I654_G26_25 I654_G28_27 I654_G28_25n VDD VSS AOI21_X1
XI654_I124_XP I654_P28_27 I654_P26_25 I654_P28_25n VDD VSS NAND2_X1
XI654_I125_XG I654_P29_28 I654_G27_26 I654_G29_28 I654_G29_26n VDD VSS AOI21_X1
XI654_I125_XP I654_P29_28 I654_P27_26 I654_P29_26n VDD VSS NAND2_X1
XI654_I126_XG I654_P30_29 I654_G28_27 I654_G30_29 I654_G30_27n VDD VSS AOI21_X1
XI654_I126_XP I654_P30_29 I654_P28_27 I654_P30_27n VDD VSS NAND2_X1
XI654_I127_XG I654_P31_30 I654_G29_28 I654_G31_30 I654_G31_28n VDD VSS AOI21_X1
XI654_I127_XP I654_P31_30 I654_P29_28 I654_P31_28n VDD VSS NAND2_X1
XI654_I128_XG I654_P4_1n I654_G0_0n I654_G4_1n I654_G4_0 VDD VSS OAI21_X1
XI654_I129 I654_G1_0 I654_G1_0n VDD VSS INV_X1
XI654_I130_XG I654_P5_2n I654_G1_0n I654_G5_2n I654_G5_0 VDD VSS OAI21_X1
XI654_I131_XG I654_P6_3n I654_G2_0n I654_G6_3n I654_G6_0 VDD VSS OAI21_X1
XI654_I132_XG I654_P7_4n I654_G3_0n I654_G7_4n I654_G7_0 VDD VSS OAI21_X1
XI654_I133_XG I654_P8_5n I654_G4_1n I654_G8_5n I654_G8_1 VDD VSS OAI21_X1
XI654_I133_XP I654_P8_5n I654_P4_1n I654_P8_1 VDD VSS NOR2_X1
XI654_I134_XG I654_P9_6n I654_G5_2n I654_G9_6n I654_G9_2 VDD VSS OAI21_X1
XI654_I134_XP I654_P9_6n I654_P5_2n I654_P9_2 VDD VSS NOR2_X1
XI654_I135_XG I654_P10_7n I654_G6_3n I654_G10_7n I654_G10_3 VDD VSS OAI21_X1
XI654_I135_XP I654_P10_7n I654_P6_3n I654_P10_3 VDD VSS NOR2_X1
XI654_I136_XG I654_P11_8n I654_G7_4n I654_G11_8n I654_G11_4 VDD VSS OAI21_X1
XI654_I136_XP I654_P11_8n I654_P7_4n I654_P11_4 VDD VSS NOR2_X1
XI654_I137_XG I654_P12_9n I654_G8_5n I654_G12_9n I654_G12_5 VDD VSS OAI21_X1
XI654_I137_XP I654_P12_9n I654_P8_5n I654_P12_5 VDD VSS NOR2_X1
XI654_I138_XG I654_P13_10n I654_G9_6n I654_G13_10n I654_G13_6 VDD VSS OAI21_X1
XI654_I138_XP I654_P13_10n I654_P9_6n I654_P13_6 VDD VSS NOR2_X1
XI654_I139_XG I654_P14_11n I654_G10_7n I654_G14_11n I654_G14_7 VDD VSS OAI21_X1
XI654_I139_XP I654_P14_11n I654_P10_7n I654_P14_7 VDD VSS NOR2_X1
XI654_I140_XG I654_P15_12n I654_G11_8n I654_G15_12n I654_G15_8 VDD VSS OAI21_X1
XI654_I140_XP I654_P15_12n I654_P11_8n I654_P15_8 VDD VSS NOR2_X1
XI654_I141_XG I654_P16_13n I654_G12_9n I654_G16_13n I654_G16_9 VDD VSS OAI21_X1
XI654_I141_XP I654_P16_13n I654_P12_9n I654_P16_9 VDD VSS NOR2_X1
XI654_I142_XG I654_P17_14n I654_G13_10n I654_G17_14n I654_G17_10 VDD VSS OAI21_X1
XI654_I142_XP I654_P17_14n I654_P13_10n I654_P17_10 VDD VSS NOR2_X1
XI654_I143_XG I654_P18_15n I654_G14_11n I654_G18_15n I654_G18_11 VDD VSS OAI21_X1
XI654_I143_XP I654_P18_15n I654_P14_11n I654_P18_11 VDD VSS NOR2_X1
XI654_I144_XG I654_P19_16n I654_G15_12n I654_G19_16n I654_G19_12 VDD VSS OAI21_X1
XI654_I144_XP I654_P19_16n I654_P15_12n I654_P19_12 VDD VSS NOR2_X1
XI654_I145_XG I654_P20_17n I654_G16_13n I654_G20_17n I654_G20_13 VDD VSS OAI21_X1
XI654_I145_XP I654_P20_17n I654_P16_13n I654_P20_13 VDD VSS NOR2_X1
XI654_I146_XG I654_P21_18n I654_G17_14n I654_G21_18n I654_G21_14 VDD VSS OAI21_X1
XI654_I146_XP I654_P21_18n I654_P17_14n I654_P21_14 VDD VSS NOR2_X1
XI654_I147_XG I654_P22_19n I654_G18_15n I654_G22_19n I654_G22_15 VDD VSS OAI21_X1
XI654_I147_XP I654_P22_19n I654_P18_15n I654_P22_15 VDD VSS NOR2_X1
XI654_I148_XG I654_P23_20n I654_G19_16n I654_G23_20n I654_G23_16 VDD VSS OAI21_X1
XI654_I148_XP I654_P23_20n I654_P19_16n I654_P23_16 VDD VSS NOR2_X1
XI654_I149_XG I654_P24_21n I654_G20_17n I654_G24_21n I654_G24_17 VDD VSS OAI21_X1
XI654_I149_XP I654_P24_21n I654_P20_17n I654_P24_17 VDD VSS NOR2_X1
XI654_I150_XG I654_P25_22n I654_G21_18n I654_G25_22n I654_G25_18 VDD VSS OAI21_X1
XI654_I150_XP I654_P25_22n I654_P21_18n I654_P25_18 VDD VSS NOR2_X1
XI654_I151_XG I654_P26_23n I654_G22_19n I654_G26_23n I654_G26_19 VDD VSS OAI21_X1
XI654_I151_XP I654_P26_23n I654_P22_19n I654_P26_19 VDD VSS NOR2_X1
XI654_I152_XG I654_P27_24n I654_G23_20n I654_G27_24n I654_G27_20 VDD VSS OAI21_X1
XI654_I152_XP I654_P27_24n I654_P23_20n I654_P27_20 VDD VSS NOR2_X1
XI654_I153_XG I654_P28_25n I654_G24_21n I654_G28_25n I654_G28_21 VDD VSS OAI21_X1
XI654_I153_XP I654_P28_25n I654_P24_21n I654_P28_21 VDD VSS NOR2_X1
XI654_I154_XG I654_P29_26n I654_G25_22n I654_G29_26n I654_G29_22 VDD VSS OAI21_X1
XI654_I154_XP I654_P29_26n I654_P25_22n I654_P29_22 VDD VSS NOR2_X1
XI654_I155_XG I654_P30_27n I654_G26_23n I654_G30_27n I654_G30_23 VDD VSS OAI21_X1
XI654_I155_XP I654_P30_27n I654_P26_23n I654_P30_23 VDD VSS NOR2_X1
XI654_I156_XG I654_P31_28n I654_G27_24n I654_G31_28n I654_G31_24 VDD VSS OAI21_X1
XI654_I156_XP I654_P31_28n I654_P27_24n I654_P31_24 VDD VSS NOR2_X1
XI654_I157_XG I654_P8_1 I654_G0_0 I654_G8_1 I654_G8_0n VDD VSS AOI21_X1
XI654_I158_XG I654_P9_2 I654_G1_0 I654_G9_2 I654_G9_0n VDD VSS AOI21_X1
XI654_I159 I654_G2_0n I654_G2_0np VDD VSS INV_X1
XI654_I160_XG I654_P10_3 I654_G2_0np I654_G10_3 I654_G10_0n VDD VSS AOI21_X1
XI654_I161 I654_G3_0n I654_G3_0np VDD VSS INV_X1
XI654_I162_XG I654_P11_4 I654_G3_0np I654_G11_4 I654_G11_0n VDD VSS AOI21_X1
XI654_I163_XG I654_P12_5 I654_G4_0 I654_G12_5 I654_G12_0n VDD VSS AOI21_X1
XI654_I164_XG I654_P13_6 I654_G5_0 I654_G13_6 I654_G13_0n VDD VSS AOI21_X1
XI654_I165_XG I654_P14_7 I654_G6_0 I654_G14_7 I654_G14_0n VDD VSS AOI21_X1
XI654_I166_XG I654_P15_8 I654_G7_0 I654_G15_8 I654_G15_0n VDD VSS AOI21_X1
XI654_I167_XG I654_P16_9 I654_G8_1 I654_G16_9 I654_G16_1n VDD VSS AOI21_X1
XI654_I167_XP I654_P16_9 I654_P8_1 I654_P16_1n VDD VSS NAND2_X1
XI654_I168_XG I654_P17_10 I654_G9_2 I654_G17_10 I654_G17_2n VDD VSS AOI21_X1
XI654_I168_XP I654_P17_10 I654_P9_2 I654_P17_2n VDD VSS NAND2_X1
XI654_I169_XG I654_P18_11 I654_G10_3 I654_G18_11 I654_G18_3n VDD VSS AOI21_X1
XI654_I169_XP I654_P18_11 I654_P10_3 I654_P18_3n VDD VSS NAND2_X1
XI654_I170_XG I654_P19_12 I654_G11_4 I654_G19_12 I654_G19_4n VDD VSS AOI21_X1
XI654_I170_XP I654_P19_12 I654_P11_4 I654_P19_4n VDD VSS NAND2_X1
XI654_I171_XG I654_P20_13 I654_G12_5 I654_G20_13 I654_G20_5n VDD VSS AOI21_X1
XI654_I171_XP I654_P20_13 I654_P12_5 I654_P20_5n VDD VSS NAND2_X1
XI654_I172_XG I654_P21_14 I654_G13_6 I654_G21_14 I654_G21_6n VDD VSS AOI21_X1
XI654_I172_XP I654_P21_14 I654_P13_6 I654_P21_6n VDD VSS NAND2_X1
XI654_I173_XG I654_P22_15 I654_G14_7 I654_G22_15 I654_G22_7n VDD VSS AOI21_X1
XI654_I173_XP I654_P22_15 I654_P14_7 I654_P22_7n VDD VSS NAND2_X1
XI654_I174_XG I654_P23_16 I654_G15_8 I654_G23_16 I654_G23_8n VDD VSS AOI21_X1
XI654_I174_XP I654_P23_16 I654_P15_8 I654_P23_8n VDD VSS NAND2_X1
XI654_I175_XG I654_P24_17 I654_G16_9 I654_G24_17 I654_G24_9n VDD VSS AOI21_X1
XI654_I175_XP I654_P24_17 I654_P16_9 I654_P24_9n VDD VSS NAND2_X1
XI654_I176_XG I654_P25_18 I654_G17_10 I654_G25_18 I654_G25_10n VDD VSS AOI21_X1
XI654_I176_XP I654_P25_18 I654_P17_10 I654_P25_10n VDD VSS NAND2_X1
XI654_I177_XG I654_P26_19 I654_G18_11 I654_G26_19 I654_G26_11n VDD VSS AOI21_X1
XI654_I177_XP I654_P26_19 I654_P18_11 I654_P26_11n VDD VSS NAND2_X1
XI654_I178_XG I654_P27_20 I654_G19_12 I654_G27_20 I654_G27_12n VDD VSS AOI21_X1
XI654_I178_XP I654_P27_20 I654_P19_12 I654_P27_12n VDD VSS NAND2_X1
XI654_I179_XG I654_P28_21 I654_G20_13 I654_G28_21 I654_G28_13n VDD VSS AOI21_X1
XI654_I179_XP I654_P28_21 I654_P20_13 I654_P28_13n VDD VSS NAND2_X1
XI654_I180_XG I654_P29_22 I654_G21_14 I654_G29_22 I654_G29_14n VDD VSS AOI21_X1
XI654_I180_XP I654_P29_22 I654_P21_14 I654_P29_14n VDD VSS NAND2_X1
XI654_I181_XG I654_P30_23 I654_G22_15 I654_G30_23 I654_G30_15n VDD VSS AOI21_X1
XI654_I181_XP I654_P30_23 I654_P22_15 I654_P30_15n VDD VSS NAND2_X1
XI654_I182_XG I654_P31_24 I654_G23_16 I654_G31_24 I654_G31_16n VDD VSS AOI21_X1
XI654_I182_XP I654_P31_24 I654_P23_16 I654_P31_16n VDD VSS NAND2_X1
XI654_I183_XG I654_P16_1n I654_G0_0n I654_G16_1n I654_G16_0 VDD VSS OAI21_X1
XI654_I184_XG I654_P17_2n I654_G1_0n I654_G17_2n I654_G17_0 VDD VSS OAI21_X1
XI654_I185_XG I654_P18_3n I654_G2_0n I654_G18_3n I654_G18_0 VDD VSS OAI21_X1
XI654_I186_XG I654_P19_4n I654_G3_0n I654_G19_4n I654_G19_0 VDD VSS OAI21_X1
XI654_I187 I654_G4_0 I654_G4_0n VDD VSS INV_X1
XI654_I188_XG I654_P20_5n I654_G4_0n I654_G20_5n I654_G20_0 VDD VSS OAI21_X1
XI654_I189 I654_G5_0 I654_G5_0n VDD VSS INV_X1
XI654_I190_XG I654_P21_6n I654_G5_0n I654_G21_6n I654_G21_0 VDD VSS OAI21_X1
XI654_I191 I654_G6_0 I654_G6_0n VDD VSS INV_X1
XI654_I192_XG I654_P22_7n I654_G6_0n I654_G22_7n I654_G22_0 VDD VSS OAI21_X1
XI654_I193 I654_G7_0 I654_G7_0n VDD VSS INV_X1
XI654_I194_XG I654_P23_8n I654_G7_0n I654_G23_8n I654_G23_0 VDD VSS OAI21_X1
XI654_I195_XG I654_P24_9n I654_G8_0n I654_G24_9n I654_G24_0 VDD VSS OAI21_X1
XI654_I196_XG I654_P25_10n I654_G9_0n I654_G25_10n I654_G25_0 VDD VSS OAI21_X1
XI654_I197_XG I654_P26_11n I654_G10_0n I654_G26_11n I654_G26_0 VDD VSS OAI21_X1
XI654_I198_XG I654_P27_12n I654_G11_0n I654_G27_12n I654_G27_0 VDD VSS OAI21_X1
XI654_I199_XG I654_P28_13n I654_G12_0n I654_G28_13n I654_G28_0 VDD VSS OAI21_X1
XI654_I200_XG I654_P29_14n I654_G13_0n I654_G29_14n I654_G29_0 VDD VSS OAI21_X1
XI654_I201_XG I654_P30_15n I654_G14_0n I654_G30_15n c2_m VDD VSS OAI21_X1
XI654_I202_XG I654_P31_16n I654_G15_0n I654_G31_16n c2_o VDD VSS OAI21_X1
XI654_I203 I654_pn0 qu30_b3_5 p2_0 VDD VSS XNOR2_X1
XI654_I204 I654_pn1 I654_G0_0 p2_1 VDD VSS XNOR2_X1
XI654_I205 I654_pn2 I654_G1_0 p2_2 VDD VSS XNOR2_X1
XI654_I206 I654_pn3 I654_G2_0n p2_3 VDD VSS XOR2_X1
XI654_I207 I654_pn4 I654_G3_0n p2_4 VDD VSS XOR2_X1
XI654_I208 I654_pn5 I654_G4_0 p2_5 VDD VSS XNOR2_X1
XI654_I209 I654_pn6 I654_G5_0 p2_6 VDD VSS XNOR2_X1
XI654_I210 I654_pn7 I654_G6_0 p2_7 VDD VSS XNOR2_X1
XI654_I211 I654_pn8 I654_G7_0 p2_8 VDD VSS XNOR2_X1
XI654_I212 I654_pn9 I654_G8_0n p2_9 VDD VSS XOR2_X1
XI654_I213 I654_pn10 I654_G9_0n p2_10 VDD VSS XOR2_X1
XI654_I214 I654_pn11 I654_G10_0n p2_11 VDD VSS XOR2_X1
XI654_I215 I654_pn12 I654_G11_0n p2_12 VDD VSS XOR2_X1
XI654_I216 I654_pn13 I654_G12_0n p2_13 VDD VSS XOR2_X1
XI654_I217 I654_pn14 I654_G13_0n p2_14 VDD VSS XOR2_X1
XI654_I218 I654_pn15 I654_G14_0n p2_15 VDD VSS XOR2_X1
XI654_I219 I654_pn16 I654_G15_0n p2_16 VDD VSS XOR2_X1
XI654_I220 I654_pn17 I654_G16_0 p2_17 VDD VSS XNOR2_X1
XI654_I221 I654_pn18 I654_G17_0 p2_18 VDD VSS XNOR2_X1
XI654_I222 I654_pn19 I654_G18_0 p2_19 VDD VSS XNOR2_X1
XI654_I223 I654_pn20 I654_G19_0 p2_20 VDD VSS XNOR2_X1
XI654_I224 I654_pn21 I654_G20_0 p2_21 VDD VSS XNOR2_X1
XI654_I225 I654_pn22 I654_G21_0 p2_22 VDD VSS XNOR2_X1
XI654_I226 I654_pn23 I654_G22_0 p2_23 VDD VSS XNOR2_X1
XI654_I227 I654_pn24 I654_G23_0 p2_24 VDD VSS XNOR2_X1
XI654_I228 I654_pn25 I654_G24_0 p2_25 VDD VSS XNOR2_X1
XI654_I229 I654_pn26 I654_G25_0 p2_26 VDD VSS XNOR2_X1
XI654_I230 I654_pn27 I654_G26_0 p2_27 VDD VSS XNOR2_X1
XI654_I231 I654_pn28 I654_G27_0 p2_28 VDD VSS XNOR2_X1
XI654_I232 I654_pn29 I654_G28_0 p2_29 VDD VSS XNOR2_X1
XI654_I233 I654_pn30 I654_G29_0 p2_30 VDD VSS XNOR2_X1
XI654_I234 I654_pn31 c2_m p2_31 VDD VSS XNOR2_X1
XI655 p1_31 qu30_b3_5 h2 VDD VSS XOR2_X1
XI656 h2 c2_o p2_32 VDD VSS XOR2_X1
XI657 p2_32 qu29 VDD VSS INV_X4
XI658 qu29 qu29_b0 VDD VSS INV_X1
XI659 qu29_b0 qu29_b1_0 VDD VSS INV_X4
XI660 qu29_b1_0 qu29_b2_0 VDD VSS INV_X4
XI661 qu29_b1_0 qu29_b2_1 VDD VSS INV_X4
XI662 qu29_b2_0 qu29_b3_0 VDD VSS INV_X4
XI663 qu29_b2_0 qu29_b3_1 VDD VSS INV_X4
XI664 qu29_b2_0 qu29_b3_2 VDD VSS INV_X4
XI665 qu29_b2_1 qu29_b3_3 VDD VSS INV_X4
XI666 qu29_b2_1 qu29_b3_4 VDD VSS INV_X4
XI667 qu29_b2_1 qu29_b3_5 VDD VSS INV_X4
XI668 B_0_b3_0 qu29_b3_0 b3_0 VDD VSS XOR2_X1
XI669 dd1_b3_0 qu29_b3_0 b3_1 VDD VSS XOR2_X1
XI670 dd2_b3_0 qu29_b3_0 b3_2 VDD VSS XOR2_X1
XI671 dd3_b3_0 qu29_b3_0 b3_3 VDD VSS XOR2_X1
XI672 dd4_b3_0 qu29_b3_0 b3_4 VDD VSS XOR2_X1
XI673 dd5_b3_0 qu29_b3_0 b3_5 VDD VSS XOR2_X1
XI674 dd6_b3_0 qu29_b3_1 b3_6 VDD VSS XOR2_X1
XI675 dd7_b3_0 qu29_b3_1 b3_7 VDD VSS XOR2_X1
XI676 dd8_b3_0 qu29_b3_1 b3_8 VDD VSS XOR2_X1
XI677 dd9_b3_0 qu29_b3_1 b3_9 VDD VSS XOR2_X1
XI678 dd10_b3_0 qu29_b3_1 b3_10 VDD VSS XOR2_X1
XI679 dd11_b3_0 qu29_b3_1 b3_11 VDD VSS XOR2_X1
XI680 dd12_b3_0 qu29_b3_2 b3_12 VDD VSS XOR2_X1
XI681 dd13_b3_0 qu29_b3_2 b3_13 VDD VSS XOR2_X1
XI682 dd14_b3_0 qu29_b3_2 b3_14 VDD VSS XOR2_X1
XI683 dd15_b3_0 qu29_b3_2 b3_15 VDD VSS XOR2_X1
XI684 dd16_b3_0 qu29_b3_2 b3_16 VDD VSS XOR2_X1
XI685 dd17_b3_0 qu29_b3_2 b3_17 VDD VSS XOR2_X1
XI686 dd18_b3_0 qu29_b3_3 b3_18 VDD VSS XOR2_X1
XI687 dd19_b3_0 qu29_b3_3 b3_19 VDD VSS XOR2_X1
XI688 dd20_b3_0 qu29_b3_3 b3_20 VDD VSS XOR2_X1
XI689 dd21_b3_0 qu29_b3_3 b3_21 VDD VSS XOR2_X1
XI690 dd22_b3_0 qu29_b3_3 b3_22 VDD VSS XOR2_X1
XI691 dd23_b3_0 qu29_b3_3 b3_23 VDD VSS XOR2_X1
XI692 dd24_b3_0 qu29_b3_4 b3_24 VDD VSS XOR2_X1
XI693 dd25_b3_0 qu29_b3_4 b3_25 VDD VSS XOR2_X1
XI694 dd26_b3_0 qu29_b3_4 b3_26 VDD VSS XOR2_X1
XI695 dd27_b3_0 qu29_b3_4 b3_27 VDD VSS XOR2_X1
XI696 dd28_b3_0 qu29_b3_4 b3_28 VDD VSS XOR2_X1
XI697 dd29_b3_0 qu29_b3_4 b3_29 VDD VSS XOR2_X1
XI698 dd30_b3_0 qu29_b3_5 b3_30 VDD VSS XOR2_X1
XI699 dd31_b3_0 qu29_b3_5 b3_31 VDD VSS XOR2_X1
XI700_I0 aa28 b3_0 I700_gn0 VDD VSS NAND2_X1
XI700_I1 p2_0 b3_1 I700_gn1 VDD VSS NAND2_X1
XI700_I2 p2_1 b3_2 I700_gn2 VDD VSS NAND2_X1
XI700_I3 p2_2 b3_3 I700_gn3 VDD VSS NAND2_X1
XI700_I4 p2_3 b3_4 I700_gn4 VDD VSS NAND2_X1
XI700_I5 p2_4 b3_5 I700_gn5 VDD VSS NAND2_X1
XI700_I6 p2_5 b3_6 I700_gn6 VDD VSS NAND2_X1
XI700_I7 p2_6 b3_7 I700_gn7 VDD VSS NAND2_X1
XI700_I8 p2_7 b3_8 I700_gn8 VDD VSS NAND2_X1
XI700_I9 p2_8 b3_9 I700_gn9 VDD VSS NAND2_X1
XI700_I10 p2_9 b3_10 I700_gn10 VDD VSS NAND2_X1
XI700_I11 p2_10 b3_11 I700_gn11 VDD VSS NAND2_X1
XI700_I12 p2_11 b3_12 I700_gn12 VDD VSS NAND2_X1
XI700_I13 p2_12 b3_13 I700_gn13 VDD VSS NAND2_X1
XI700_I14 p2_13 b3_14 I700_gn14 VDD VSS NAND2_X1
XI700_I15 p2_14 b3_15 I700_gn15 VDD VSS NAND2_X1
XI700_I16 p2_15 b3_16 I700_gn16 VDD VSS NAND2_X1
XI700_I17 p2_16 b3_17 I700_gn17 VDD VSS NAND2_X1
XI700_I18 p2_17 b3_18 I700_gn18 VDD VSS NAND2_X1
XI700_I19 p2_18 b3_19 I700_gn19 VDD VSS NAND2_X1
XI700_I20 p2_19 b3_20 I700_gn20 VDD VSS NAND2_X1
XI700_I21 p2_20 b3_21 I700_gn21 VDD VSS NAND2_X1
XI700_I22 p2_21 b3_22 I700_gn22 VDD VSS NAND2_X1
XI700_I23 p2_22 b3_23 I700_gn23 VDD VSS NAND2_X1
XI700_I24 p2_23 b3_24 I700_gn24 VDD VSS NAND2_X1
XI700_I25 p2_24 b3_25 I700_gn25 VDD VSS NAND2_X1
XI700_I26 p2_25 b3_26 I700_gn26 VDD VSS NAND2_X1
XI700_I27 p2_26 b3_27 I700_gn27 VDD VSS NAND2_X1
XI700_I28 p2_27 b3_28 I700_gn28 VDD VSS NAND2_X1
XI700_I29 p2_28 b3_29 I700_gn29 VDD VSS NAND2_X1
XI700_I30 p2_29 b3_30 I700_gn30 VDD VSS NAND2_X1
XI700_I31 p2_30 b3_31 I700_gn31 VDD VSS NAND2_X1
XI700_I32 aa28 b3_0 I700_pn0 VDD VSS XNOR2_X1
XI700_I33 p2_0 b3_1 I700_pn1 VDD VSS XNOR2_X1
XI700_I34 p2_1 b3_2 I700_pn2 VDD VSS XNOR2_X1
XI700_I35 p2_2 b3_3 I700_pn3 VDD VSS XNOR2_X1
XI700_I36 p2_3 b3_4 I700_pn4 VDD VSS XNOR2_X1
XI700_I37 p2_4 b3_5 I700_pn5 VDD VSS XNOR2_X1
XI700_I38 p2_5 b3_6 I700_pn6 VDD VSS XNOR2_X1
XI700_I39 p2_6 b3_7 I700_pn7 VDD VSS XNOR2_X1
XI700_I40 p2_7 b3_8 I700_pn8 VDD VSS XNOR2_X1
XI700_I41 p2_8 b3_9 I700_pn9 VDD VSS XNOR2_X1
XI700_I42 p2_9 b3_10 I700_pn10 VDD VSS XNOR2_X1
XI700_I43 p2_10 b3_11 I700_pn11 VDD VSS XNOR2_X1
XI700_I44 p2_11 b3_12 I700_pn12 VDD VSS XNOR2_X1
XI700_I45 p2_12 b3_13 I700_pn13 VDD VSS XNOR2_X1
XI700_I46 p2_13 b3_14 I700_pn14 VDD VSS XNOR2_X1
XI700_I47 p2_14 b3_15 I700_pn15 VDD VSS XNOR2_X1
XI700_I48 p2_15 b3_16 I700_pn16 VDD VSS XNOR2_X1
XI700_I49 p2_16 b3_17 I700_pn17 VDD VSS XNOR2_X1
XI700_I50 p2_17 b3_18 I700_pn18 VDD VSS XNOR2_X1
XI700_I51 p2_18 b3_19 I700_pn19 VDD VSS XNOR2_X1
XI700_I52 p2_19 b3_20 I700_pn20 VDD VSS XNOR2_X1
XI700_I53 p2_20 b3_21 I700_pn21 VDD VSS XNOR2_X1
XI700_I54 p2_21 b3_22 I700_pn22 VDD VSS XNOR2_X1
XI700_I55 p2_22 b3_23 I700_pn23 VDD VSS XNOR2_X1
XI700_I56 p2_23 b3_24 I700_pn24 VDD VSS XNOR2_X1
XI700_I57 p2_24 b3_25 I700_pn25 VDD VSS XNOR2_X1
XI700_I58 p2_25 b3_26 I700_pn26 VDD VSS XNOR2_X1
XI700_I59 p2_26 b3_27 I700_pn27 VDD VSS XNOR2_X1
XI700_I60 p2_27 b3_28 I700_pn28 VDD VSS XNOR2_X1
XI700_I61 p2_28 b3_29 I700_pn29 VDD VSS XNOR2_X1
XI700_I62 p2_29 b3_30 I700_pn30 VDD VSS XNOR2_X1
XI700_I63 p2_30 b3_31 I700_pn31 VDD VSS XNOR2_X1
XI700_I64 qu29_b3_5 I700_cinn VDD VSS INV_X1
XI700_I65_XG I700_pn0 I700_cinn I700_gn0 I700_G0_0 VDD VSS OAI21_X1
XI700_I66 I700_G0_0 I700_G0_0n VDD VSS INV_X1
XI700_I67_XG I700_pn1 I700_G0_0n I700_gn1 I700_G1_0 VDD VSS OAI21_X1
XI700_I68_XG I700_pn2 I700_gn1 I700_gn2 I700_G2_1 VDD VSS OAI21_X1
XI700_I68_XP I700_pn2 I700_pn1 I700_P2_1 VDD VSS NOR2_X1
XI700_I69_XG I700_pn3 I700_gn2 I700_gn3 I700_G3_2 VDD VSS OAI21_X1
XI700_I69_XP I700_pn3 I700_pn2 I700_P3_2 VDD VSS NOR2_X1
XI700_I70_XG I700_pn4 I700_gn3 I700_gn4 I700_G4_3 VDD VSS OAI21_X1
XI700_I70_XP I700_pn4 I700_pn3 I700_P4_3 VDD VSS NOR2_X1
XI700_I71_XG I700_pn5 I700_gn4 I700_gn5 I700_G5_4 VDD VSS OAI21_X1
XI700_I71_XP I700_pn5 I700_pn4 I700_P5_4 VDD VSS NOR2_X1
XI700_I72_XG I700_pn6 I700_gn5 I700_gn6 I700_G6_5 VDD VSS OAI21_X1
XI700_I72_XP I700_pn6 I700_pn5 I700_P6_5 VDD VSS NOR2_X1
XI700_I73_XG I700_pn7 I700_gn6 I700_gn7 I700_G7_6 VDD VSS OAI21_X1
XI700_I73_XP I700_pn7 I700_pn6 I700_P7_6 VDD VSS NOR2_X1
XI700_I74_XG I700_pn8 I700_gn7 I700_gn8 I700_G8_7 VDD VSS OAI21_X1
XI700_I74_XP I700_pn8 I700_pn7 I700_P8_7 VDD VSS NOR2_X1
XI700_I75_XG I700_pn9 I700_gn8 I700_gn9 I700_G9_8 VDD VSS OAI21_X1
XI700_I75_XP I700_pn9 I700_pn8 I700_P9_8 VDD VSS NOR2_X1
XI700_I76_XG I700_pn10 I700_gn9 I700_gn10 I700_G10_9 VDD VSS OAI21_X1
XI700_I76_XP I700_pn10 I700_pn9 I700_P10_9 VDD VSS NOR2_X1
XI700_I77_XG I700_pn11 I700_gn10 I700_gn11 I700_G11_10 VDD VSS OAI21_X1
XI700_I77_XP I700_pn11 I700_pn10 I700_P11_10 VDD VSS NOR2_X1
XI700_I78_XG I700_pn12 I700_gn11 I700_gn12 I700_G12_11 VDD VSS OAI21_X1
XI700_I78_XP I700_pn12 I700_pn11 I700_P12_11 VDD VSS NOR2_X1
XI700_I79_XG I700_pn13 I700_gn12 I700_gn13 I700_G13_12 VDD VSS OAI21_X1
XI700_I79_XP I700_pn13 I700_pn12 I700_P13_12 VDD VSS NOR2_X1
XI700_I80_XG I700_pn14 I700_gn13 I700_gn14 I700_G14_13 VDD VSS OAI21_X1
XI700_I80_XP I700_pn14 I700_pn13 I700_P14_13 VDD VSS NOR2_X1
XI700_I81_XG I700_pn15 I700_gn14 I700_gn15 I700_G15_14 VDD VSS OAI21_X1
XI700_I81_XP I700_pn15 I700_pn14 I700_P15_14 VDD VSS NOR2_X1
XI700_I82_XG I700_pn16 I700_gn15 I700_gn16 I700_G16_15 VDD VSS OAI21_X1
XI700_I82_XP I700_pn16 I700_pn15 I700_P16_15 VDD VSS NOR2_X1
XI700_I83_XG I700_pn17 I700_gn16 I700_gn17 I700_G17_16 VDD VSS OAI21_X1
XI700_I83_XP I700_pn17 I700_pn16 I700_P17_16 VDD VSS NOR2_X1
XI700_I84_XG I700_pn18 I700_gn17 I700_gn18 I700_G18_17 VDD VSS OAI21_X1
XI700_I84_XP I700_pn18 I700_pn17 I700_P18_17 VDD VSS NOR2_X1
XI700_I85_XG I700_pn19 I700_gn18 I700_gn19 I700_G19_18 VDD VSS OAI21_X1
XI700_I85_XP I700_pn19 I700_pn18 I700_P19_18 VDD VSS NOR2_X1
XI700_I86_XG I700_pn20 I700_gn19 I700_gn20 I700_G20_19 VDD VSS OAI21_X1
XI700_I86_XP I700_pn20 I700_pn19 I700_P20_19 VDD VSS NOR2_X1
XI700_I87_XG I700_pn21 I700_gn20 I700_gn21 I700_G21_20 VDD VSS OAI21_X1
XI700_I87_XP I700_pn21 I700_pn20 I700_P21_20 VDD VSS NOR2_X1
XI700_I88_XG I700_pn22 I700_gn21 I700_gn22 I700_G22_21 VDD VSS OAI21_X1
XI700_I88_XP I700_pn22 I700_pn21 I700_P22_21 VDD VSS NOR2_X1
XI700_I89_XG I700_pn23 I700_gn22 I700_gn23 I700_G23_22 VDD VSS OAI21_X1
XI700_I89_XP I700_pn23 I700_pn22 I700_P23_22 VDD VSS NOR2_X1
XI700_I90_XG I700_pn24 I700_gn23 I700_gn24 I700_G24_23 VDD VSS OAI21_X1
XI700_I90_XP I700_pn24 I700_pn23 I700_P24_23 VDD VSS NOR2_X1
XI700_I91_XG I700_pn25 I700_gn24 I700_gn25 I700_G25_24 VDD VSS OAI21_X1
XI700_I91_XP I700_pn25 I700_pn24 I700_P25_24 VDD VSS NOR2_X1
XI700_I92_XG I700_pn26 I700_gn25 I700_gn26 I700_G26_25 VDD VSS OAI21_X1
XI700_I92_XP I700_pn26 I700_pn25 I700_P26_25 VDD VSS NOR2_X1
XI700_I93_XG I700_pn27 I700_gn26 I700_gn27 I700_G27_26 VDD VSS OAI21_X1
XI700_I93_XP I700_pn27 I700_pn26 I700_P27_26 VDD VSS NOR2_X1
XI700_I94_XG I700_pn28 I700_gn27 I700_gn28 I700_G28_27 VDD VSS OAI21_X1
XI700_I94_XP I700_pn28 I700_pn27 I700_P28_27 VDD VSS NOR2_X1
XI700_I95_XG I700_pn29 I700_gn28 I700_gn29 I700_G29_28 VDD VSS OAI21_X1
XI700_I95_XP I700_pn29 I700_pn28 I700_P29_28 VDD VSS NOR2_X1
XI700_I96_XG I700_pn30 I700_gn29 I700_gn30 I700_G30_29 VDD VSS OAI21_X1
XI700_I96_XP I700_pn30 I700_pn29 I700_P30_29 VDD VSS NOR2_X1
XI700_I97_XG I700_pn31 I700_gn30 I700_gn31 I700_G31_30 VDD VSS OAI21_X1
XI700_I97_XP I700_pn31 I700_pn30 I700_P31_30 VDD VSS NOR2_X1
XI700_I98_XG I700_P2_1 I700_G0_0 I700_G2_1 I700_G2_0n VDD VSS AOI21_X1
XI700_I99_XG I700_P3_2 I700_G1_0 I700_G3_2 I700_G3_0n VDD VSS AOI21_X1
XI700_I100_XG I700_P4_3 I700_G2_1 I700_G4_3 I700_G4_1n VDD VSS AOI21_X1
XI700_I100_XP I700_P4_3 I700_P2_1 I700_P4_1n VDD VSS NAND2_X1
XI700_I101_XG I700_P5_4 I700_G3_2 I700_G5_4 I700_G5_2n VDD VSS AOI21_X1
XI700_I101_XP I700_P5_4 I700_P3_2 I700_P5_2n VDD VSS NAND2_X1
XI700_I102_XG I700_P6_5 I700_G4_3 I700_G6_5 I700_G6_3n VDD VSS AOI21_X1
XI700_I102_XP I700_P6_5 I700_P4_3 I700_P6_3n VDD VSS NAND2_X1
XI700_I103_XG I700_P7_6 I700_G5_4 I700_G7_6 I700_G7_4n VDD VSS AOI21_X1
XI700_I103_XP I700_P7_6 I700_P5_4 I700_P7_4n VDD VSS NAND2_X1
XI700_I104_XG I700_P8_7 I700_G6_5 I700_G8_7 I700_G8_5n VDD VSS AOI21_X1
XI700_I104_XP I700_P8_7 I700_P6_5 I700_P8_5n VDD VSS NAND2_X1
XI700_I105_XG I700_P9_8 I700_G7_6 I700_G9_8 I700_G9_6n VDD VSS AOI21_X1
XI700_I105_XP I700_P9_8 I700_P7_6 I700_P9_6n VDD VSS NAND2_X1
XI700_I106_XG I700_P10_9 I700_G8_7 I700_G10_9 I700_G10_7n VDD VSS AOI21_X1
XI700_I106_XP I700_P10_9 I700_P8_7 I700_P10_7n VDD VSS NAND2_X1
XI700_I107_XG I700_P11_10 I700_G9_8 I700_G11_10 I700_G11_8n VDD VSS AOI21_X1
XI700_I107_XP I700_P11_10 I700_P9_8 I700_P11_8n VDD VSS NAND2_X1
XI700_I108_XG I700_P12_11 I700_G10_9 I700_G12_11 I700_G12_9n VDD VSS AOI21_X1
XI700_I108_XP I700_P12_11 I700_P10_9 I700_P12_9n VDD VSS NAND2_X1
XI700_I109_XG I700_P13_12 I700_G11_10 I700_G13_12 I700_G13_10n VDD VSS AOI21_X1
XI700_I109_XP I700_P13_12 I700_P11_10 I700_P13_10n VDD VSS NAND2_X1
XI700_I110_XG I700_P14_13 I700_G12_11 I700_G14_13 I700_G14_11n VDD VSS AOI21_X1
XI700_I110_XP I700_P14_13 I700_P12_11 I700_P14_11n VDD VSS NAND2_X1
XI700_I111_XG I700_P15_14 I700_G13_12 I700_G15_14 I700_G15_12n VDD VSS AOI21_X1
XI700_I111_XP I700_P15_14 I700_P13_12 I700_P15_12n VDD VSS NAND2_X1
XI700_I112_XG I700_P16_15 I700_G14_13 I700_G16_15 I700_G16_13n VDD VSS AOI21_X1
XI700_I112_XP I700_P16_15 I700_P14_13 I700_P16_13n VDD VSS NAND2_X1
XI700_I113_XG I700_P17_16 I700_G15_14 I700_G17_16 I700_G17_14n VDD VSS AOI21_X1
XI700_I113_XP I700_P17_16 I700_P15_14 I700_P17_14n VDD VSS NAND2_X1
XI700_I114_XG I700_P18_17 I700_G16_15 I700_G18_17 I700_G18_15n VDD VSS AOI21_X1
XI700_I114_XP I700_P18_17 I700_P16_15 I700_P18_15n VDD VSS NAND2_X1
XI700_I115_XG I700_P19_18 I700_G17_16 I700_G19_18 I700_G19_16n VDD VSS AOI21_X1
XI700_I115_XP I700_P19_18 I700_P17_16 I700_P19_16n VDD VSS NAND2_X1
XI700_I116_XG I700_P20_19 I700_G18_17 I700_G20_19 I700_G20_17n VDD VSS AOI21_X1
XI700_I116_XP I700_P20_19 I700_P18_17 I700_P20_17n VDD VSS NAND2_X1
XI700_I117_XG I700_P21_20 I700_G19_18 I700_G21_20 I700_G21_18n VDD VSS AOI21_X1
XI700_I117_XP I700_P21_20 I700_P19_18 I700_P21_18n VDD VSS NAND2_X1
XI700_I118_XG I700_P22_21 I700_G20_19 I700_G22_21 I700_G22_19n VDD VSS AOI21_X1
XI700_I118_XP I700_P22_21 I700_P20_19 I700_P22_19n VDD VSS NAND2_X1
XI700_I119_XG I700_P23_22 I700_G21_20 I700_G23_22 I700_G23_20n VDD VSS AOI21_X1
XI700_I119_XP I700_P23_22 I700_P21_20 I700_P23_20n VDD VSS NAND2_X1
XI700_I120_XG I700_P24_23 I700_G22_21 I700_G24_23 I700_G24_21n VDD VSS AOI21_X1
XI700_I120_XP I700_P24_23 I700_P22_21 I700_P24_21n VDD VSS NAND2_X1
XI700_I121_XG I700_P25_24 I700_G23_22 I700_G25_24 I700_G25_22n VDD VSS AOI21_X1
XI700_I121_XP I700_P25_24 I700_P23_22 I700_P25_22n VDD VSS NAND2_X1
XI700_I122_XG I700_P26_25 I700_G24_23 I700_G26_25 I700_G26_23n VDD VSS AOI21_X1
XI700_I122_XP I700_P26_25 I700_P24_23 I700_P26_23n VDD VSS NAND2_X1
XI700_I123_XG I700_P27_26 I700_G25_24 I700_G27_26 I700_G27_24n VDD VSS AOI21_X1
XI700_I123_XP I700_P27_26 I700_P25_24 I700_P27_24n VDD VSS NAND2_X1
XI700_I124_XG I700_P28_27 I700_G26_25 I700_G28_27 I700_G28_25n VDD VSS AOI21_X1
XI700_I124_XP I700_P28_27 I700_P26_25 I700_P28_25n VDD VSS NAND2_X1
XI700_I125_XG I700_P29_28 I700_G27_26 I700_G29_28 I700_G29_26n VDD VSS AOI21_X1
XI700_I125_XP I700_P29_28 I700_P27_26 I700_P29_26n VDD VSS NAND2_X1
XI700_I126_XG I700_P30_29 I700_G28_27 I700_G30_29 I700_G30_27n VDD VSS AOI21_X1
XI700_I126_XP I700_P30_29 I700_P28_27 I700_P30_27n VDD VSS NAND2_X1
XI700_I127_XG I700_P31_30 I700_G29_28 I700_G31_30 I700_G31_28n VDD VSS AOI21_X1
XI700_I127_XP I700_P31_30 I700_P29_28 I700_P31_28n VDD VSS NAND2_X1
XI700_I128_XG I700_P4_1n I700_G0_0n I700_G4_1n I700_G4_0 VDD VSS OAI21_X1
XI700_I129 I700_G1_0 I700_G1_0n VDD VSS INV_X1
XI700_I130_XG I700_P5_2n I700_G1_0n I700_G5_2n I700_G5_0 VDD VSS OAI21_X1
XI700_I131_XG I700_P6_3n I700_G2_0n I700_G6_3n I700_G6_0 VDD VSS OAI21_X1
XI700_I132_XG I700_P7_4n I700_G3_0n I700_G7_4n I700_G7_0 VDD VSS OAI21_X1
XI700_I133_XG I700_P8_5n I700_G4_1n I700_G8_5n I700_G8_1 VDD VSS OAI21_X1
XI700_I133_XP I700_P8_5n I700_P4_1n I700_P8_1 VDD VSS NOR2_X1
XI700_I134_XG I700_P9_6n I700_G5_2n I700_G9_6n I700_G9_2 VDD VSS OAI21_X1
XI700_I134_XP I700_P9_6n I700_P5_2n I700_P9_2 VDD VSS NOR2_X1
XI700_I135_XG I700_P10_7n I700_G6_3n I700_G10_7n I700_G10_3 VDD VSS OAI21_X1
XI700_I135_XP I700_P10_7n I700_P6_3n I700_P10_3 VDD VSS NOR2_X1
XI700_I136_XG I700_P11_8n I700_G7_4n I700_G11_8n I700_G11_4 VDD VSS OAI21_X1
XI700_I136_XP I700_P11_8n I700_P7_4n I700_P11_4 VDD VSS NOR2_X1
XI700_I137_XG I700_P12_9n I700_G8_5n I700_G12_9n I700_G12_5 VDD VSS OAI21_X1
XI700_I137_XP I700_P12_9n I700_P8_5n I700_P12_5 VDD VSS NOR2_X1
XI700_I138_XG I700_P13_10n I700_G9_6n I700_G13_10n I700_G13_6 VDD VSS OAI21_X1
XI700_I138_XP I700_P13_10n I700_P9_6n I700_P13_6 VDD VSS NOR2_X1
XI700_I139_XG I700_P14_11n I700_G10_7n I700_G14_11n I700_G14_7 VDD VSS OAI21_X1
XI700_I139_XP I700_P14_11n I700_P10_7n I700_P14_7 VDD VSS NOR2_X1
XI700_I140_XG I700_P15_12n I700_G11_8n I700_G15_12n I700_G15_8 VDD VSS OAI21_X1
XI700_I140_XP I700_P15_12n I700_P11_8n I700_P15_8 VDD VSS NOR2_X1
XI700_I141_XG I700_P16_13n I700_G12_9n I700_G16_13n I700_G16_9 VDD VSS OAI21_X1
XI700_I141_XP I700_P16_13n I700_P12_9n I700_P16_9 VDD VSS NOR2_X1
XI700_I142_XG I700_P17_14n I700_G13_10n I700_G17_14n I700_G17_10 VDD VSS OAI21_X1
XI700_I142_XP I700_P17_14n I700_P13_10n I700_P17_10 VDD VSS NOR2_X1
XI700_I143_XG I700_P18_15n I700_G14_11n I700_G18_15n I700_G18_11 VDD VSS OAI21_X1
XI700_I143_XP I700_P18_15n I700_P14_11n I700_P18_11 VDD VSS NOR2_X1
XI700_I144_XG I700_P19_16n I700_G15_12n I700_G19_16n I700_G19_12 VDD VSS OAI21_X1
XI700_I144_XP I700_P19_16n I700_P15_12n I700_P19_12 VDD VSS NOR2_X1
XI700_I145_XG I700_P20_17n I700_G16_13n I700_G20_17n I700_G20_13 VDD VSS OAI21_X1
XI700_I145_XP I700_P20_17n I700_P16_13n I700_P20_13 VDD VSS NOR2_X1
XI700_I146_XG I700_P21_18n I700_G17_14n I700_G21_18n I700_G21_14 VDD VSS OAI21_X1
XI700_I146_XP I700_P21_18n I700_P17_14n I700_P21_14 VDD VSS NOR2_X1
XI700_I147_XG I700_P22_19n I700_G18_15n I700_G22_19n I700_G22_15 VDD VSS OAI21_X1
XI700_I147_XP I700_P22_19n I700_P18_15n I700_P22_15 VDD VSS NOR2_X1
XI700_I148_XG I700_P23_20n I700_G19_16n I700_G23_20n I700_G23_16 VDD VSS OAI21_X1
XI700_I148_XP I700_P23_20n I700_P19_16n I700_P23_16 VDD VSS NOR2_X1
XI700_I149_XG I700_P24_21n I700_G20_17n I700_G24_21n I700_G24_17 VDD VSS OAI21_X1
XI700_I149_XP I700_P24_21n I700_P20_17n I700_P24_17 VDD VSS NOR2_X1
XI700_I150_XG I700_P25_22n I700_G21_18n I700_G25_22n I700_G25_18 VDD VSS OAI21_X1
XI700_I150_XP I700_P25_22n I700_P21_18n I700_P25_18 VDD VSS NOR2_X1
XI700_I151_XG I700_P26_23n I700_G22_19n I700_G26_23n I700_G26_19 VDD VSS OAI21_X1
XI700_I151_XP I700_P26_23n I700_P22_19n I700_P26_19 VDD VSS NOR2_X1
XI700_I152_XG I700_P27_24n I700_G23_20n I700_G27_24n I700_G27_20 VDD VSS OAI21_X1
XI700_I152_XP I700_P27_24n I700_P23_20n I700_P27_20 VDD VSS NOR2_X1
XI700_I153_XG I700_P28_25n I700_G24_21n I700_G28_25n I700_G28_21 VDD VSS OAI21_X1
XI700_I153_XP I700_P28_25n I700_P24_21n I700_P28_21 VDD VSS NOR2_X1
XI700_I154_XG I700_P29_26n I700_G25_22n I700_G29_26n I700_G29_22 VDD VSS OAI21_X1
XI700_I154_XP I700_P29_26n I700_P25_22n I700_P29_22 VDD VSS NOR2_X1
XI700_I155_XG I700_P30_27n I700_G26_23n I700_G30_27n I700_G30_23 VDD VSS OAI21_X1
XI700_I155_XP I700_P30_27n I700_P26_23n I700_P30_23 VDD VSS NOR2_X1
XI700_I156_XG I700_P31_28n I700_G27_24n I700_G31_28n I700_G31_24 VDD VSS OAI21_X1
XI700_I156_XP I700_P31_28n I700_P27_24n I700_P31_24 VDD VSS NOR2_X1
XI700_I157_XG I700_P8_1 I700_G0_0 I700_G8_1 I700_G8_0n VDD VSS AOI21_X1
XI700_I158_XG I700_P9_2 I700_G1_0 I700_G9_2 I700_G9_0n VDD VSS AOI21_X1
XI700_I159 I700_G2_0n I700_G2_0np VDD VSS INV_X1
XI700_I160_XG I700_P10_3 I700_G2_0np I700_G10_3 I700_G10_0n VDD VSS AOI21_X1
XI700_I161 I700_G3_0n I700_G3_0np VDD VSS INV_X1
XI700_I162_XG I700_P11_4 I700_G3_0np I700_G11_4 I700_G11_0n VDD VSS AOI21_X1
XI700_I163_XG I700_P12_5 I700_G4_0 I700_G12_5 I700_G12_0n VDD VSS AOI21_X1
XI700_I164_XG I700_P13_6 I700_G5_0 I700_G13_6 I700_G13_0n VDD VSS AOI21_X1
XI700_I165_XG I700_P14_7 I700_G6_0 I700_G14_7 I700_G14_0n VDD VSS AOI21_X1
XI700_I166_XG I700_P15_8 I700_G7_0 I700_G15_8 I700_G15_0n VDD VSS AOI21_X1
XI700_I167_XG I700_P16_9 I700_G8_1 I700_G16_9 I700_G16_1n VDD VSS AOI21_X1
XI700_I167_XP I700_P16_9 I700_P8_1 I700_P16_1n VDD VSS NAND2_X1
XI700_I168_XG I700_P17_10 I700_G9_2 I700_G17_10 I700_G17_2n VDD VSS AOI21_X1
XI700_I168_XP I700_P17_10 I700_P9_2 I700_P17_2n VDD VSS NAND2_X1
XI700_I169_XG I700_P18_11 I700_G10_3 I700_G18_11 I700_G18_3n VDD VSS AOI21_X1
XI700_I169_XP I700_P18_11 I700_P10_3 I700_P18_3n VDD VSS NAND2_X1
XI700_I170_XG I700_P19_12 I700_G11_4 I700_G19_12 I700_G19_4n VDD VSS AOI21_X1
XI700_I170_XP I700_P19_12 I700_P11_4 I700_P19_4n VDD VSS NAND2_X1
XI700_I171_XG I700_P20_13 I700_G12_5 I700_G20_13 I700_G20_5n VDD VSS AOI21_X1
XI700_I171_XP I700_P20_13 I700_P12_5 I700_P20_5n VDD VSS NAND2_X1
XI700_I172_XG I700_P21_14 I700_G13_6 I700_G21_14 I700_G21_6n VDD VSS AOI21_X1
XI700_I172_XP I700_P21_14 I700_P13_6 I700_P21_6n VDD VSS NAND2_X1
XI700_I173_XG I700_P22_15 I700_G14_7 I700_G22_15 I700_G22_7n VDD VSS AOI21_X1
XI700_I173_XP I700_P22_15 I700_P14_7 I700_P22_7n VDD VSS NAND2_X1
XI700_I174_XG I700_P23_16 I700_G15_8 I700_G23_16 I700_G23_8n VDD VSS AOI21_X1
XI700_I174_XP I700_P23_16 I700_P15_8 I700_P23_8n VDD VSS NAND2_X1
XI700_I175_XG I700_P24_17 I700_G16_9 I700_G24_17 I700_G24_9n VDD VSS AOI21_X1
XI700_I175_XP I700_P24_17 I700_P16_9 I700_P24_9n VDD VSS NAND2_X1
XI700_I176_XG I700_P25_18 I700_G17_10 I700_G25_18 I700_G25_10n VDD VSS AOI21_X1
XI700_I176_XP I700_P25_18 I700_P17_10 I700_P25_10n VDD VSS NAND2_X1
XI700_I177_XG I700_P26_19 I700_G18_11 I700_G26_19 I700_G26_11n VDD VSS AOI21_X1
XI700_I177_XP I700_P26_19 I700_P18_11 I700_P26_11n VDD VSS NAND2_X1
XI700_I178_XG I700_P27_20 I700_G19_12 I700_G27_20 I700_G27_12n VDD VSS AOI21_X1
XI700_I178_XP I700_P27_20 I700_P19_12 I700_P27_12n VDD VSS NAND2_X1
XI700_I179_XG I700_P28_21 I700_G20_13 I700_G28_21 I700_G28_13n VDD VSS AOI21_X1
XI700_I179_XP I700_P28_21 I700_P20_13 I700_P28_13n VDD VSS NAND2_X1
XI700_I180_XG I700_P29_22 I700_G21_14 I700_G29_22 I700_G29_14n VDD VSS AOI21_X1
XI700_I180_XP I700_P29_22 I700_P21_14 I700_P29_14n VDD VSS NAND2_X1
XI700_I181_XG I700_P30_23 I700_G22_15 I700_G30_23 I700_G30_15n VDD VSS AOI21_X1
XI700_I181_XP I700_P30_23 I700_P22_15 I700_P30_15n VDD VSS NAND2_X1
XI700_I182_XG I700_P31_24 I700_G23_16 I700_G31_24 I700_G31_16n VDD VSS AOI21_X1
XI700_I182_XP I700_P31_24 I700_P23_16 I700_P31_16n VDD VSS NAND2_X1
XI700_I183_XG I700_P16_1n I700_G0_0n I700_G16_1n I700_G16_0 VDD VSS OAI21_X1
XI700_I184_XG I700_P17_2n I700_G1_0n I700_G17_2n I700_G17_0 VDD VSS OAI21_X1
XI700_I185_XG I700_P18_3n I700_G2_0n I700_G18_3n I700_G18_0 VDD VSS OAI21_X1
XI700_I186_XG I700_P19_4n I700_G3_0n I700_G19_4n I700_G19_0 VDD VSS OAI21_X1
XI700_I187 I700_G4_0 I700_G4_0n VDD VSS INV_X1
XI700_I188_XG I700_P20_5n I700_G4_0n I700_G20_5n I700_G20_0 VDD VSS OAI21_X1
XI700_I189 I700_G5_0 I700_G5_0n VDD VSS INV_X1
XI700_I190_XG I700_P21_6n I700_G5_0n I700_G21_6n I700_G21_0 VDD VSS OAI21_X1
XI700_I191 I700_G6_0 I700_G6_0n VDD VSS INV_X1
XI700_I192_XG I700_P22_7n I700_G6_0n I700_G22_7n I700_G22_0 VDD VSS OAI21_X1
XI700_I193 I700_G7_0 I700_G7_0n VDD VSS INV_X1
XI700_I194_XG I700_P23_8n I700_G7_0n I700_G23_8n I700_G23_0 VDD VSS OAI21_X1
XI700_I195_XG I700_P24_9n I700_G8_0n I700_G24_9n I700_G24_0 VDD VSS OAI21_X1
XI700_I196_XG I700_P25_10n I700_G9_0n I700_G25_10n I700_G25_0 VDD VSS OAI21_X1
XI700_I197_XG I700_P26_11n I700_G10_0n I700_G26_11n I700_G26_0 VDD VSS OAI21_X1
XI700_I198_XG I700_P27_12n I700_G11_0n I700_G27_12n I700_G27_0 VDD VSS OAI21_X1
XI700_I199_XG I700_P28_13n I700_G12_0n I700_G28_13n I700_G28_0 VDD VSS OAI21_X1
XI700_I200_XG I700_P29_14n I700_G13_0n I700_G29_14n I700_G29_0 VDD VSS OAI21_X1
XI700_I201_XG I700_P30_15n I700_G14_0n I700_G30_15n c3_m VDD VSS OAI21_X1
XI700_I202_XG I700_P31_16n I700_G15_0n I700_G31_16n c3_o VDD VSS OAI21_X1
XI700_I203 I700_pn0 qu29_b3_5 p3_0 VDD VSS XNOR2_X1
XI700_I204 I700_pn1 I700_G0_0 p3_1 VDD VSS XNOR2_X1
XI700_I205 I700_pn2 I700_G1_0 p3_2 VDD VSS XNOR2_X1
XI700_I206 I700_pn3 I700_G2_0n p3_3 VDD VSS XOR2_X1
XI700_I207 I700_pn4 I700_G3_0n p3_4 VDD VSS XOR2_X1
XI700_I208 I700_pn5 I700_G4_0 p3_5 VDD VSS XNOR2_X1
XI700_I209 I700_pn6 I700_G5_0 p3_6 VDD VSS XNOR2_X1
XI700_I210 I700_pn7 I700_G6_0 p3_7 VDD VSS XNOR2_X1
XI700_I211 I700_pn8 I700_G7_0 p3_8 VDD VSS XNOR2_X1
XI700_I212 I700_pn9 I700_G8_0n p3_9 VDD VSS XOR2_X1
XI700_I213 I700_pn10 I700_G9_0n p3_10 VDD VSS XOR2_X1
XI700_I214 I700_pn11 I700_G10_0n p3_11 VDD VSS XOR2_X1
XI700_I215 I700_pn12 I700_G11_0n p3_12 VDD VSS XOR2_X1
XI700_I216 I700_pn13 I700_G12_0n p3_13 VDD VSS XOR2_X1
XI700_I217 I700_pn14 I700_G13_0n p3_14 VDD VSS XOR2_X1
XI700_I218 I700_pn15 I700_G14_0n p3_15 VDD VSS XOR2_X1
XI700_I219 I700_pn16 I700_G15_0n p3_16 VDD VSS XOR2_X1
XI700_I220 I700_pn17 I700_G16_0 p3_17 VDD VSS XNOR2_X1
XI700_I221 I700_pn18 I700_G17_0 p3_18 VDD VSS XNOR2_X1
XI700_I222 I700_pn19 I700_G18_0 p3_19 VDD VSS XNOR2_X1
XI700_I223 I700_pn20 I700_G19_0 p3_20 VDD VSS XNOR2_X1
XI700_I224 I700_pn21 I700_G20_0 p3_21 VDD VSS XNOR2_X1
XI700_I225 I700_pn22 I700_G21_0 p3_22 VDD VSS XNOR2_X1
XI700_I226 I700_pn23 I700_G22_0 p3_23 VDD VSS XNOR2_X1
XI700_I227 I700_pn24 I700_G23_0 p3_24 VDD VSS XNOR2_X1
XI700_I228 I700_pn25 I700_G24_0 p3_25 VDD VSS XNOR2_X1
XI700_I229 I700_pn26 I700_G25_0 p3_26 VDD VSS XNOR2_X1
XI700_I230 I700_pn27 I700_G26_0 p3_27 VDD VSS XNOR2_X1
XI700_I231 I700_pn28 I700_G27_0 p3_28 VDD VSS XNOR2_X1
XI700_I232 I700_pn29 I700_G28_0 p3_29 VDD VSS XNOR2_X1
XI700_I233 I700_pn30 I700_G29_0 p3_30 VDD VSS XNOR2_X1
XI700_I234 I700_pn31 c3_m p3_31 VDD VSS XNOR2_X1
XI701 p2_31 qu29_b3_5 h3 VDD VSS XOR2_X1
XI702 h3 c3_o p3_32 VDD VSS XOR2_X1
XI703 p3_32 qu28 VDD VSS INV_X4
XI704 qu28 qu28_b0 VDD VSS INV_X1
XI705 qu28_b0 qu28_b1_0 VDD VSS INV_X4
XI706 qu28_b1_0 qu28_b2_0 VDD VSS INV_X4
XI707 qu28_b1_0 qu28_b2_1 VDD VSS INV_X4
XI708 qu28_b2_0 qu28_b3_0 VDD VSS INV_X4
XI709 qu28_b2_0 qu28_b3_1 VDD VSS INV_X4
XI710 qu28_b2_0 qu28_b3_2 VDD VSS INV_X4
XI711 qu28_b2_1 qu28_b3_3 VDD VSS INV_X4
XI712 qu28_b2_1 qu28_b3_4 VDD VSS INV_X4
XI713 qu28_b2_1 qu28_b3_5 VDD VSS INV_X4
XI714 B_0_b3_0 qu28_b3_0 b4_0 VDD VSS XOR2_X1
XI715 dd1_b3_0 qu28_b3_0 b4_1 VDD VSS XOR2_X1
XI716 dd2_b3_0 qu28_b3_0 b4_2 VDD VSS XOR2_X1
XI717 dd3_b3_0 qu28_b3_0 b4_3 VDD VSS XOR2_X1
XI718 dd4_b3_0 qu28_b3_0 b4_4 VDD VSS XOR2_X1
XI719 dd5_b3_0 qu28_b3_0 b4_5 VDD VSS XOR2_X1
XI720 dd6_b3_0 qu28_b3_1 b4_6 VDD VSS XOR2_X1
XI721 dd7_b3_0 qu28_b3_1 b4_7 VDD VSS XOR2_X1
XI722 dd8_b3_0 qu28_b3_1 b4_8 VDD VSS XOR2_X1
XI723 dd9_b3_0 qu28_b3_1 b4_9 VDD VSS XOR2_X1
XI724 dd10_b3_0 qu28_b3_1 b4_10 VDD VSS XOR2_X1
XI725 dd11_b3_0 qu28_b3_1 b4_11 VDD VSS XOR2_X1
XI726 dd12_b3_0 qu28_b3_2 b4_12 VDD VSS XOR2_X1
XI727 dd13_b3_0 qu28_b3_2 b4_13 VDD VSS XOR2_X1
XI728 dd14_b3_0 qu28_b3_2 b4_14 VDD VSS XOR2_X1
XI729 dd15_b3_0 qu28_b3_2 b4_15 VDD VSS XOR2_X1
XI730 dd16_b3_0 qu28_b3_2 b4_16 VDD VSS XOR2_X1
XI731 dd17_b3_0 qu28_b3_2 b4_17 VDD VSS XOR2_X1
XI732 dd18_b3_0 qu28_b3_3 b4_18 VDD VSS XOR2_X1
XI733 dd19_b3_0 qu28_b3_3 b4_19 VDD VSS XOR2_X1
XI734 dd20_b3_0 qu28_b3_3 b4_20 VDD VSS XOR2_X1
XI735 dd21_b3_0 qu28_b3_3 b4_21 VDD VSS XOR2_X1
XI736 dd22_b3_0 qu28_b3_3 b4_22 VDD VSS XOR2_X1
XI737 dd23_b3_0 qu28_b3_3 b4_23 VDD VSS XOR2_X1
XI738 dd24_b3_0 qu28_b3_4 b4_24 VDD VSS XOR2_X1
XI739 dd25_b3_0 qu28_b3_4 b4_25 VDD VSS XOR2_X1
XI740 dd26_b3_0 qu28_b3_4 b4_26 VDD VSS XOR2_X1
XI741 dd27_b3_0 qu28_b3_4 b4_27 VDD VSS XOR2_X1
XI742 dd28_b3_0 qu28_b3_4 b4_28 VDD VSS XOR2_X1
XI743 dd29_b3_0 qu28_b3_4 b4_29 VDD VSS XOR2_X1
XI744 dd30_b3_0 qu28_b3_5 b4_30 VDD VSS XOR2_X1
XI745 dd31_b3_0 qu28_b3_5 b4_31 VDD VSS XOR2_X1
XI746_I0 aa27 b4_0 I746_gn0 VDD VSS NAND2_X1
XI746_I1 p3_0 b4_1 I746_gn1 VDD VSS NAND2_X1
XI746_I2 p3_1 b4_2 I746_gn2 VDD VSS NAND2_X1
XI746_I3 p3_2 b4_3 I746_gn3 VDD VSS NAND2_X1
XI746_I4 p3_3 b4_4 I746_gn4 VDD VSS NAND2_X1
XI746_I5 p3_4 b4_5 I746_gn5 VDD VSS NAND2_X1
XI746_I6 p3_5 b4_6 I746_gn6 VDD VSS NAND2_X1
XI746_I7 p3_6 b4_7 I746_gn7 VDD VSS NAND2_X1
XI746_I8 p3_7 b4_8 I746_gn8 VDD VSS NAND2_X1
XI746_I9 p3_8 b4_9 I746_gn9 VDD VSS NAND2_X1
XI746_I10 p3_9 b4_10 I746_gn10 VDD VSS NAND2_X1
XI746_I11 p3_10 b4_11 I746_gn11 VDD VSS NAND2_X1
XI746_I12 p3_11 b4_12 I746_gn12 VDD VSS NAND2_X1
XI746_I13 p3_12 b4_13 I746_gn13 VDD VSS NAND2_X1
XI746_I14 p3_13 b4_14 I746_gn14 VDD VSS NAND2_X1
XI746_I15 p3_14 b4_15 I746_gn15 VDD VSS NAND2_X1
XI746_I16 p3_15 b4_16 I746_gn16 VDD VSS NAND2_X1
XI746_I17 p3_16 b4_17 I746_gn17 VDD VSS NAND2_X1
XI746_I18 p3_17 b4_18 I746_gn18 VDD VSS NAND2_X1
XI746_I19 p3_18 b4_19 I746_gn19 VDD VSS NAND2_X1
XI746_I20 p3_19 b4_20 I746_gn20 VDD VSS NAND2_X1
XI746_I21 p3_20 b4_21 I746_gn21 VDD VSS NAND2_X1
XI746_I22 p3_21 b4_22 I746_gn22 VDD VSS NAND2_X1
XI746_I23 p3_22 b4_23 I746_gn23 VDD VSS NAND2_X1
XI746_I24 p3_23 b4_24 I746_gn24 VDD VSS NAND2_X1
XI746_I25 p3_24 b4_25 I746_gn25 VDD VSS NAND2_X1
XI746_I26 p3_25 b4_26 I746_gn26 VDD VSS NAND2_X1
XI746_I27 p3_26 b4_27 I746_gn27 VDD VSS NAND2_X1
XI746_I28 p3_27 b4_28 I746_gn28 VDD VSS NAND2_X1
XI746_I29 p3_28 b4_29 I746_gn29 VDD VSS NAND2_X1
XI746_I30 p3_29 b4_30 I746_gn30 VDD VSS NAND2_X1
XI746_I31 p3_30 b4_31 I746_gn31 VDD VSS NAND2_X1
XI746_I32 aa27 b4_0 I746_pn0 VDD VSS XNOR2_X1
XI746_I33 p3_0 b4_1 I746_pn1 VDD VSS XNOR2_X1
XI746_I34 p3_1 b4_2 I746_pn2 VDD VSS XNOR2_X1
XI746_I35 p3_2 b4_3 I746_pn3 VDD VSS XNOR2_X1
XI746_I36 p3_3 b4_4 I746_pn4 VDD VSS XNOR2_X1
XI746_I37 p3_4 b4_5 I746_pn5 VDD VSS XNOR2_X1
XI746_I38 p3_5 b4_6 I746_pn6 VDD VSS XNOR2_X1
XI746_I39 p3_6 b4_7 I746_pn7 VDD VSS XNOR2_X1
XI746_I40 p3_7 b4_8 I746_pn8 VDD VSS XNOR2_X1
XI746_I41 p3_8 b4_9 I746_pn9 VDD VSS XNOR2_X1
XI746_I42 p3_9 b4_10 I746_pn10 VDD VSS XNOR2_X1
XI746_I43 p3_10 b4_11 I746_pn11 VDD VSS XNOR2_X1
XI746_I44 p3_11 b4_12 I746_pn12 VDD VSS XNOR2_X1
XI746_I45 p3_12 b4_13 I746_pn13 VDD VSS XNOR2_X1
XI746_I46 p3_13 b4_14 I746_pn14 VDD VSS XNOR2_X1
XI746_I47 p3_14 b4_15 I746_pn15 VDD VSS XNOR2_X1
XI746_I48 p3_15 b4_16 I746_pn16 VDD VSS XNOR2_X1
XI746_I49 p3_16 b4_17 I746_pn17 VDD VSS XNOR2_X1
XI746_I50 p3_17 b4_18 I746_pn18 VDD VSS XNOR2_X1
XI746_I51 p3_18 b4_19 I746_pn19 VDD VSS XNOR2_X1
XI746_I52 p3_19 b4_20 I746_pn20 VDD VSS XNOR2_X1
XI746_I53 p3_20 b4_21 I746_pn21 VDD VSS XNOR2_X1
XI746_I54 p3_21 b4_22 I746_pn22 VDD VSS XNOR2_X1
XI746_I55 p3_22 b4_23 I746_pn23 VDD VSS XNOR2_X1
XI746_I56 p3_23 b4_24 I746_pn24 VDD VSS XNOR2_X1
XI746_I57 p3_24 b4_25 I746_pn25 VDD VSS XNOR2_X1
XI746_I58 p3_25 b4_26 I746_pn26 VDD VSS XNOR2_X1
XI746_I59 p3_26 b4_27 I746_pn27 VDD VSS XNOR2_X1
XI746_I60 p3_27 b4_28 I746_pn28 VDD VSS XNOR2_X1
XI746_I61 p3_28 b4_29 I746_pn29 VDD VSS XNOR2_X1
XI746_I62 p3_29 b4_30 I746_pn30 VDD VSS XNOR2_X1
XI746_I63 p3_30 b4_31 I746_pn31 VDD VSS XNOR2_X1
XI746_I64 qu28_b3_5 I746_cinn VDD VSS INV_X1
XI746_I65_XG I746_pn0 I746_cinn I746_gn0 I746_G0_0 VDD VSS OAI21_X1
XI746_I66 I746_G0_0 I746_G0_0n VDD VSS INV_X1
XI746_I67_XG I746_pn1 I746_G0_0n I746_gn1 I746_G1_0 VDD VSS OAI21_X1
XI746_I68_XG I746_pn2 I746_gn1 I746_gn2 I746_G2_1 VDD VSS OAI21_X1
XI746_I68_XP I746_pn2 I746_pn1 I746_P2_1 VDD VSS NOR2_X1
XI746_I69_XG I746_pn3 I746_gn2 I746_gn3 I746_G3_2 VDD VSS OAI21_X1
XI746_I69_XP I746_pn3 I746_pn2 I746_P3_2 VDD VSS NOR2_X1
XI746_I70_XG I746_pn4 I746_gn3 I746_gn4 I746_G4_3 VDD VSS OAI21_X1
XI746_I70_XP I746_pn4 I746_pn3 I746_P4_3 VDD VSS NOR2_X1
XI746_I71_XG I746_pn5 I746_gn4 I746_gn5 I746_G5_4 VDD VSS OAI21_X1
XI746_I71_XP I746_pn5 I746_pn4 I746_P5_4 VDD VSS NOR2_X1
XI746_I72_XG I746_pn6 I746_gn5 I746_gn6 I746_G6_5 VDD VSS OAI21_X1
XI746_I72_XP I746_pn6 I746_pn5 I746_P6_5 VDD VSS NOR2_X1
XI746_I73_XG I746_pn7 I746_gn6 I746_gn7 I746_G7_6 VDD VSS OAI21_X1
XI746_I73_XP I746_pn7 I746_pn6 I746_P7_6 VDD VSS NOR2_X1
XI746_I74_XG I746_pn8 I746_gn7 I746_gn8 I746_G8_7 VDD VSS OAI21_X1
XI746_I74_XP I746_pn8 I746_pn7 I746_P8_7 VDD VSS NOR2_X1
XI746_I75_XG I746_pn9 I746_gn8 I746_gn9 I746_G9_8 VDD VSS OAI21_X1
XI746_I75_XP I746_pn9 I746_pn8 I746_P9_8 VDD VSS NOR2_X1
XI746_I76_XG I746_pn10 I746_gn9 I746_gn10 I746_G10_9 VDD VSS OAI21_X1
XI746_I76_XP I746_pn10 I746_pn9 I746_P10_9 VDD VSS NOR2_X1
XI746_I77_XG I746_pn11 I746_gn10 I746_gn11 I746_G11_10 VDD VSS OAI21_X1
XI746_I77_XP I746_pn11 I746_pn10 I746_P11_10 VDD VSS NOR2_X1
XI746_I78_XG I746_pn12 I746_gn11 I746_gn12 I746_G12_11 VDD VSS OAI21_X1
XI746_I78_XP I746_pn12 I746_pn11 I746_P12_11 VDD VSS NOR2_X1
XI746_I79_XG I746_pn13 I746_gn12 I746_gn13 I746_G13_12 VDD VSS OAI21_X1
XI746_I79_XP I746_pn13 I746_pn12 I746_P13_12 VDD VSS NOR2_X1
XI746_I80_XG I746_pn14 I746_gn13 I746_gn14 I746_G14_13 VDD VSS OAI21_X1
XI746_I80_XP I746_pn14 I746_pn13 I746_P14_13 VDD VSS NOR2_X1
XI746_I81_XG I746_pn15 I746_gn14 I746_gn15 I746_G15_14 VDD VSS OAI21_X1
XI746_I81_XP I746_pn15 I746_pn14 I746_P15_14 VDD VSS NOR2_X1
XI746_I82_XG I746_pn16 I746_gn15 I746_gn16 I746_G16_15 VDD VSS OAI21_X1
XI746_I82_XP I746_pn16 I746_pn15 I746_P16_15 VDD VSS NOR2_X1
XI746_I83_XG I746_pn17 I746_gn16 I746_gn17 I746_G17_16 VDD VSS OAI21_X1
XI746_I83_XP I746_pn17 I746_pn16 I746_P17_16 VDD VSS NOR2_X1
XI746_I84_XG I746_pn18 I746_gn17 I746_gn18 I746_G18_17 VDD VSS OAI21_X1
XI746_I84_XP I746_pn18 I746_pn17 I746_P18_17 VDD VSS NOR2_X1
XI746_I85_XG I746_pn19 I746_gn18 I746_gn19 I746_G19_18 VDD VSS OAI21_X1
XI746_I85_XP I746_pn19 I746_pn18 I746_P19_18 VDD VSS NOR2_X1
XI746_I86_XG I746_pn20 I746_gn19 I746_gn20 I746_G20_19 VDD VSS OAI21_X1
XI746_I86_XP I746_pn20 I746_pn19 I746_P20_19 VDD VSS NOR2_X1
XI746_I87_XG I746_pn21 I746_gn20 I746_gn21 I746_G21_20 VDD VSS OAI21_X1
XI746_I87_XP I746_pn21 I746_pn20 I746_P21_20 VDD VSS NOR2_X1
XI746_I88_XG I746_pn22 I746_gn21 I746_gn22 I746_G22_21 VDD VSS OAI21_X1
XI746_I88_XP I746_pn22 I746_pn21 I746_P22_21 VDD VSS NOR2_X1
XI746_I89_XG I746_pn23 I746_gn22 I746_gn23 I746_G23_22 VDD VSS OAI21_X1
XI746_I89_XP I746_pn23 I746_pn22 I746_P23_22 VDD VSS NOR2_X1
XI746_I90_XG I746_pn24 I746_gn23 I746_gn24 I746_G24_23 VDD VSS OAI21_X1
XI746_I90_XP I746_pn24 I746_pn23 I746_P24_23 VDD VSS NOR2_X1
XI746_I91_XG I746_pn25 I746_gn24 I746_gn25 I746_G25_24 VDD VSS OAI21_X1
XI746_I91_XP I746_pn25 I746_pn24 I746_P25_24 VDD VSS NOR2_X1
XI746_I92_XG I746_pn26 I746_gn25 I746_gn26 I746_G26_25 VDD VSS OAI21_X1
XI746_I92_XP I746_pn26 I746_pn25 I746_P26_25 VDD VSS NOR2_X1
XI746_I93_XG I746_pn27 I746_gn26 I746_gn27 I746_G27_26 VDD VSS OAI21_X1
XI746_I93_XP I746_pn27 I746_pn26 I746_P27_26 VDD VSS NOR2_X1
XI746_I94_XG I746_pn28 I746_gn27 I746_gn28 I746_G28_27 VDD VSS OAI21_X1
XI746_I94_XP I746_pn28 I746_pn27 I746_P28_27 VDD VSS NOR2_X1
XI746_I95_XG I746_pn29 I746_gn28 I746_gn29 I746_G29_28 VDD VSS OAI21_X1
XI746_I95_XP I746_pn29 I746_pn28 I746_P29_28 VDD VSS NOR2_X1
XI746_I96_XG I746_pn30 I746_gn29 I746_gn30 I746_G30_29 VDD VSS OAI21_X1
XI746_I96_XP I746_pn30 I746_pn29 I746_P30_29 VDD VSS NOR2_X1
XI746_I97_XG I746_pn31 I746_gn30 I746_gn31 I746_G31_30 VDD VSS OAI21_X1
XI746_I97_XP I746_pn31 I746_pn30 I746_P31_30 VDD VSS NOR2_X1
XI746_I98_XG I746_P2_1 I746_G0_0 I746_G2_1 I746_G2_0n VDD VSS AOI21_X1
XI746_I99_XG I746_P3_2 I746_G1_0 I746_G3_2 I746_G3_0n VDD VSS AOI21_X1
XI746_I100_XG I746_P4_3 I746_G2_1 I746_G4_3 I746_G4_1n VDD VSS AOI21_X1
XI746_I100_XP I746_P4_3 I746_P2_1 I746_P4_1n VDD VSS NAND2_X1
XI746_I101_XG I746_P5_4 I746_G3_2 I746_G5_4 I746_G5_2n VDD VSS AOI21_X1
XI746_I101_XP I746_P5_4 I746_P3_2 I746_P5_2n VDD VSS NAND2_X1
XI746_I102_XG I746_P6_5 I746_G4_3 I746_G6_5 I746_G6_3n VDD VSS AOI21_X1
XI746_I102_XP I746_P6_5 I746_P4_3 I746_P6_3n VDD VSS NAND2_X1
XI746_I103_XG I746_P7_6 I746_G5_4 I746_G7_6 I746_G7_4n VDD VSS AOI21_X1
XI746_I103_XP I746_P7_6 I746_P5_4 I746_P7_4n VDD VSS NAND2_X1
XI746_I104_XG I746_P8_7 I746_G6_5 I746_G8_7 I746_G8_5n VDD VSS AOI21_X1
XI746_I104_XP I746_P8_7 I746_P6_5 I746_P8_5n VDD VSS NAND2_X1
XI746_I105_XG I746_P9_8 I746_G7_6 I746_G9_8 I746_G9_6n VDD VSS AOI21_X1
XI746_I105_XP I746_P9_8 I746_P7_6 I746_P9_6n VDD VSS NAND2_X1
XI746_I106_XG I746_P10_9 I746_G8_7 I746_G10_9 I746_G10_7n VDD VSS AOI21_X1
XI746_I106_XP I746_P10_9 I746_P8_7 I746_P10_7n VDD VSS NAND2_X1
XI746_I107_XG I746_P11_10 I746_G9_8 I746_G11_10 I746_G11_8n VDD VSS AOI21_X1
XI746_I107_XP I746_P11_10 I746_P9_8 I746_P11_8n VDD VSS NAND2_X1
XI746_I108_XG I746_P12_11 I746_G10_9 I746_G12_11 I746_G12_9n VDD VSS AOI21_X1
XI746_I108_XP I746_P12_11 I746_P10_9 I746_P12_9n VDD VSS NAND2_X1
XI746_I109_XG I746_P13_12 I746_G11_10 I746_G13_12 I746_G13_10n VDD VSS AOI21_X1
XI746_I109_XP I746_P13_12 I746_P11_10 I746_P13_10n VDD VSS NAND2_X1
XI746_I110_XG I746_P14_13 I746_G12_11 I746_G14_13 I746_G14_11n VDD VSS AOI21_X1
XI746_I110_XP I746_P14_13 I746_P12_11 I746_P14_11n VDD VSS NAND2_X1
XI746_I111_XG I746_P15_14 I746_G13_12 I746_G15_14 I746_G15_12n VDD VSS AOI21_X1
XI746_I111_XP I746_P15_14 I746_P13_12 I746_P15_12n VDD VSS NAND2_X1
XI746_I112_XG I746_P16_15 I746_G14_13 I746_G16_15 I746_G16_13n VDD VSS AOI21_X1
XI746_I112_XP I746_P16_15 I746_P14_13 I746_P16_13n VDD VSS NAND2_X1
XI746_I113_XG I746_P17_16 I746_G15_14 I746_G17_16 I746_G17_14n VDD VSS AOI21_X1
XI746_I113_XP I746_P17_16 I746_P15_14 I746_P17_14n VDD VSS NAND2_X1
XI746_I114_XG I746_P18_17 I746_G16_15 I746_G18_17 I746_G18_15n VDD VSS AOI21_X1
XI746_I114_XP I746_P18_17 I746_P16_15 I746_P18_15n VDD VSS NAND2_X1
XI746_I115_XG I746_P19_18 I746_G17_16 I746_G19_18 I746_G19_16n VDD VSS AOI21_X1
XI746_I115_XP I746_P19_18 I746_P17_16 I746_P19_16n VDD VSS NAND2_X1
XI746_I116_XG I746_P20_19 I746_G18_17 I746_G20_19 I746_G20_17n VDD VSS AOI21_X1
XI746_I116_XP I746_P20_19 I746_P18_17 I746_P20_17n VDD VSS NAND2_X1
XI746_I117_XG I746_P21_20 I746_G19_18 I746_G21_20 I746_G21_18n VDD VSS AOI21_X1
XI746_I117_XP I746_P21_20 I746_P19_18 I746_P21_18n VDD VSS NAND2_X1
XI746_I118_XG I746_P22_21 I746_G20_19 I746_G22_21 I746_G22_19n VDD VSS AOI21_X1
XI746_I118_XP I746_P22_21 I746_P20_19 I746_P22_19n VDD VSS NAND2_X1
XI746_I119_XG I746_P23_22 I746_G21_20 I746_G23_22 I746_G23_20n VDD VSS AOI21_X1
XI746_I119_XP I746_P23_22 I746_P21_20 I746_P23_20n VDD VSS NAND2_X1
XI746_I120_XG I746_P24_23 I746_G22_21 I746_G24_23 I746_G24_21n VDD VSS AOI21_X1
XI746_I120_XP I746_P24_23 I746_P22_21 I746_P24_21n VDD VSS NAND2_X1
XI746_I121_XG I746_P25_24 I746_G23_22 I746_G25_24 I746_G25_22n VDD VSS AOI21_X1
XI746_I121_XP I746_P25_24 I746_P23_22 I746_P25_22n VDD VSS NAND2_X1
XI746_I122_XG I746_P26_25 I746_G24_23 I746_G26_25 I746_G26_23n VDD VSS AOI21_X1
XI746_I122_XP I746_P26_25 I746_P24_23 I746_P26_23n VDD VSS NAND2_X1
XI746_I123_XG I746_P27_26 I746_G25_24 I746_G27_26 I746_G27_24n VDD VSS AOI21_X1
XI746_I123_XP I746_P27_26 I746_P25_24 I746_P27_24n VDD VSS NAND2_X1
XI746_I124_XG I746_P28_27 I746_G26_25 I746_G28_27 I746_G28_25n VDD VSS AOI21_X1
XI746_I124_XP I746_P28_27 I746_P26_25 I746_P28_25n VDD VSS NAND2_X1
XI746_I125_XG I746_P29_28 I746_G27_26 I746_G29_28 I746_G29_26n VDD VSS AOI21_X1
XI746_I125_XP I746_P29_28 I746_P27_26 I746_P29_26n VDD VSS NAND2_X1
XI746_I126_XG I746_P30_29 I746_G28_27 I746_G30_29 I746_G30_27n VDD VSS AOI21_X1
XI746_I126_XP I746_P30_29 I746_P28_27 I746_P30_27n VDD VSS NAND2_X1
XI746_I127_XG I746_P31_30 I746_G29_28 I746_G31_30 I746_G31_28n VDD VSS AOI21_X1
XI746_I127_XP I746_P31_30 I746_P29_28 I746_P31_28n VDD VSS NAND2_X1
XI746_I128_XG I746_P4_1n I746_G0_0n I746_G4_1n I746_G4_0 VDD VSS OAI21_X1
XI746_I129 I746_G1_0 I746_G1_0n VDD VSS INV_X1
XI746_I130_XG I746_P5_2n I746_G1_0n I746_G5_2n I746_G5_0 VDD VSS OAI21_X1
XI746_I131_XG I746_P6_3n I746_G2_0n I746_G6_3n I746_G6_0 VDD VSS OAI21_X1
XI746_I132_XG I746_P7_4n I746_G3_0n I746_G7_4n I746_G7_0 VDD VSS OAI21_X1
XI746_I133_XG I746_P8_5n I746_G4_1n I746_G8_5n I746_G8_1 VDD VSS OAI21_X1
XI746_I133_XP I746_P8_5n I746_P4_1n I746_P8_1 VDD VSS NOR2_X1
XI746_I134_XG I746_P9_6n I746_G5_2n I746_G9_6n I746_G9_2 VDD VSS OAI21_X1
XI746_I134_XP I746_P9_6n I746_P5_2n I746_P9_2 VDD VSS NOR2_X1
XI746_I135_XG I746_P10_7n I746_G6_3n I746_G10_7n I746_G10_3 VDD VSS OAI21_X1
XI746_I135_XP I746_P10_7n I746_P6_3n I746_P10_3 VDD VSS NOR2_X1
XI746_I136_XG I746_P11_8n I746_G7_4n I746_G11_8n I746_G11_4 VDD VSS OAI21_X1
XI746_I136_XP I746_P11_8n I746_P7_4n I746_P11_4 VDD VSS NOR2_X1
XI746_I137_XG I746_P12_9n I746_G8_5n I746_G12_9n I746_G12_5 VDD VSS OAI21_X1
XI746_I137_XP I746_P12_9n I746_P8_5n I746_P12_5 VDD VSS NOR2_X1
XI746_I138_XG I746_P13_10n I746_G9_6n I746_G13_10n I746_G13_6 VDD VSS OAI21_X1
XI746_I138_XP I746_P13_10n I746_P9_6n I746_P13_6 VDD VSS NOR2_X1
XI746_I139_XG I746_P14_11n I746_G10_7n I746_G14_11n I746_G14_7 VDD VSS OAI21_X1
XI746_I139_XP I746_P14_11n I746_P10_7n I746_P14_7 VDD VSS NOR2_X1
XI746_I140_XG I746_P15_12n I746_G11_8n I746_G15_12n I746_G15_8 VDD VSS OAI21_X1
XI746_I140_XP I746_P15_12n I746_P11_8n I746_P15_8 VDD VSS NOR2_X1
XI746_I141_XG I746_P16_13n I746_G12_9n I746_G16_13n I746_G16_9 VDD VSS OAI21_X1
XI746_I141_XP I746_P16_13n I746_P12_9n I746_P16_9 VDD VSS NOR2_X1
XI746_I142_XG I746_P17_14n I746_G13_10n I746_G17_14n I746_G17_10 VDD VSS OAI21_X1
XI746_I142_XP I746_P17_14n I746_P13_10n I746_P17_10 VDD VSS NOR2_X1
XI746_I143_XG I746_P18_15n I746_G14_11n I746_G18_15n I746_G18_11 VDD VSS OAI21_X1
XI746_I143_XP I746_P18_15n I746_P14_11n I746_P18_11 VDD VSS NOR2_X1
XI746_I144_XG I746_P19_16n I746_G15_12n I746_G19_16n I746_G19_12 VDD VSS OAI21_X1
XI746_I144_XP I746_P19_16n I746_P15_12n I746_P19_12 VDD VSS NOR2_X1
XI746_I145_XG I746_P20_17n I746_G16_13n I746_G20_17n I746_G20_13 VDD VSS OAI21_X1
XI746_I145_XP I746_P20_17n I746_P16_13n I746_P20_13 VDD VSS NOR2_X1
XI746_I146_XG I746_P21_18n I746_G17_14n I746_G21_18n I746_G21_14 VDD VSS OAI21_X1
XI746_I146_XP I746_P21_18n I746_P17_14n I746_P21_14 VDD VSS NOR2_X1
XI746_I147_XG I746_P22_19n I746_G18_15n I746_G22_19n I746_G22_15 VDD VSS OAI21_X1
XI746_I147_XP I746_P22_19n I746_P18_15n I746_P22_15 VDD VSS NOR2_X1
XI746_I148_XG I746_P23_20n I746_G19_16n I746_G23_20n I746_G23_16 VDD VSS OAI21_X1
XI746_I148_XP I746_P23_20n I746_P19_16n I746_P23_16 VDD VSS NOR2_X1
XI746_I149_XG I746_P24_21n I746_G20_17n I746_G24_21n I746_G24_17 VDD VSS OAI21_X1
XI746_I149_XP I746_P24_21n I746_P20_17n I746_P24_17 VDD VSS NOR2_X1
XI746_I150_XG I746_P25_22n I746_G21_18n I746_G25_22n I746_G25_18 VDD VSS OAI21_X1
XI746_I150_XP I746_P25_22n I746_P21_18n I746_P25_18 VDD VSS NOR2_X1
XI746_I151_XG I746_P26_23n I746_G22_19n I746_G26_23n I746_G26_19 VDD VSS OAI21_X1
XI746_I151_XP I746_P26_23n I746_P22_19n I746_P26_19 VDD VSS NOR2_X1
XI746_I152_XG I746_P27_24n I746_G23_20n I746_G27_24n I746_G27_20 VDD VSS OAI21_X1
XI746_I152_XP I746_P27_24n I746_P23_20n I746_P27_20 VDD VSS NOR2_X1
XI746_I153_XG I746_P28_25n I746_G24_21n I746_G28_25n I746_G28_21 VDD VSS OAI21_X1
XI746_I153_XP I746_P28_25n I746_P24_21n I746_P28_21 VDD VSS NOR2_X1
XI746_I154_XG I746_P29_26n I746_G25_22n I746_G29_26n I746_G29_22 VDD VSS OAI21_X1
XI746_I154_XP I746_P29_26n I746_P25_22n I746_P29_22 VDD VSS NOR2_X1
XI746_I155_XG I746_P30_27n I746_G26_23n I746_G30_27n I746_G30_23 VDD VSS OAI21_X1
XI746_I155_XP I746_P30_27n I746_P26_23n I746_P30_23 VDD VSS NOR2_X1
XI746_I156_XG I746_P31_28n I746_G27_24n I746_G31_28n I746_G31_24 VDD VSS OAI21_X1
XI746_I156_XP I746_P31_28n I746_P27_24n I746_P31_24 VDD VSS NOR2_X1
XI746_I157_XG I746_P8_1 I746_G0_0 I746_G8_1 I746_G8_0n VDD VSS AOI21_X1
XI746_I158_XG I746_P9_2 I746_G1_0 I746_G9_2 I746_G9_0n VDD VSS AOI21_X1
XI746_I159 I746_G2_0n I746_G2_0np VDD VSS INV_X1
XI746_I160_XG I746_P10_3 I746_G2_0np I746_G10_3 I746_G10_0n VDD VSS AOI21_X1
XI746_I161 I746_G3_0n I746_G3_0np VDD VSS INV_X1
XI746_I162_XG I746_P11_4 I746_G3_0np I746_G11_4 I746_G11_0n VDD VSS AOI21_X1
XI746_I163_XG I746_P12_5 I746_G4_0 I746_G12_5 I746_G12_0n VDD VSS AOI21_X1
XI746_I164_XG I746_P13_6 I746_G5_0 I746_G13_6 I746_G13_0n VDD VSS AOI21_X1
XI746_I165_XG I746_P14_7 I746_G6_0 I746_G14_7 I746_G14_0n VDD VSS AOI21_X1
XI746_I166_XG I746_P15_8 I746_G7_0 I746_G15_8 I746_G15_0n VDD VSS AOI21_X1
XI746_I167_XG I746_P16_9 I746_G8_1 I746_G16_9 I746_G16_1n VDD VSS AOI21_X1
XI746_I167_XP I746_P16_9 I746_P8_1 I746_P16_1n VDD VSS NAND2_X1
XI746_I168_XG I746_P17_10 I746_G9_2 I746_G17_10 I746_G17_2n VDD VSS AOI21_X1
XI746_I168_XP I746_P17_10 I746_P9_2 I746_P17_2n VDD VSS NAND2_X1
XI746_I169_XG I746_P18_11 I746_G10_3 I746_G18_11 I746_G18_3n VDD VSS AOI21_X1
XI746_I169_XP I746_P18_11 I746_P10_3 I746_P18_3n VDD VSS NAND2_X1
XI746_I170_XG I746_P19_12 I746_G11_4 I746_G19_12 I746_G19_4n VDD VSS AOI21_X1
XI746_I170_XP I746_P19_12 I746_P11_4 I746_P19_4n VDD VSS NAND2_X1
XI746_I171_XG I746_P20_13 I746_G12_5 I746_G20_13 I746_G20_5n VDD VSS AOI21_X1
XI746_I171_XP I746_P20_13 I746_P12_5 I746_P20_5n VDD VSS NAND2_X1
XI746_I172_XG I746_P21_14 I746_G13_6 I746_G21_14 I746_G21_6n VDD VSS AOI21_X1
XI746_I172_XP I746_P21_14 I746_P13_6 I746_P21_6n VDD VSS NAND2_X1
XI746_I173_XG I746_P22_15 I746_G14_7 I746_G22_15 I746_G22_7n VDD VSS AOI21_X1
XI746_I173_XP I746_P22_15 I746_P14_7 I746_P22_7n VDD VSS NAND2_X1
XI746_I174_XG I746_P23_16 I746_G15_8 I746_G23_16 I746_G23_8n VDD VSS AOI21_X1
XI746_I174_XP I746_P23_16 I746_P15_8 I746_P23_8n VDD VSS NAND2_X1
XI746_I175_XG I746_P24_17 I746_G16_9 I746_G24_17 I746_G24_9n VDD VSS AOI21_X1
XI746_I175_XP I746_P24_17 I746_P16_9 I746_P24_9n VDD VSS NAND2_X1
XI746_I176_XG I746_P25_18 I746_G17_10 I746_G25_18 I746_G25_10n VDD VSS AOI21_X1
XI746_I176_XP I746_P25_18 I746_P17_10 I746_P25_10n VDD VSS NAND2_X1
XI746_I177_XG I746_P26_19 I746_G18_11 I746_G26_19 I746_G26_11n VDD VSS AOI21_X1
XI746_I177_XP I746_P26_19 I746_P18_11 I746_P26_11n VDD VSS NAND2_X1
XI746_I178_XG I746_P27_20 I746_G19_12 I746_G27_20 I746_G27_12n VDD VSS AOI21_X1
XI746_I178_XP I746_P27_20 I746_P19_12 I746_P27_12n VDD VSS NAND2_X1
XI746_I179_XG I746_P28_21 I746_G20_13 I746_G28_21 I746_G28_13n VDD VSS AOI21_X1
XI746_I179_XP I746_P28_21 I746_P20_13 I746_P28_13n VDD VSS NAND2_X1
XI746_I180_XG I746_P29_22 I746_G21_14 I746_G29_22 I746_G29_14n VDD VSS AOI21_X1
XI746_I180_XP I746_P29_22 I746_P21_14 I746_P29_14n VDD VSS NAND2_X1
XI746_I181_XG I746_P30_23 I746_G22_15 I746_G30_23 I746_G30_15n VDD VSS AOI21_X1
XI746_I181_XP I746_P30_23 I746_P22_15 I746_P30_15n VDD VSS NAND2_X1
XI746_I182_XG I746_P31_24 I746_G23_16 I746_G31_24 I746_G31_16n VDD VSS AOI21_X1
XI746_I182_XP I746_P31_24 I746_P23_16 I746_P31_16n VDD VSS NAND2_X1
XI746_I183_XG I746_P16_1n I746_G0_0n I746_G16_1n I746_G16_0 VDD VSS OAI21_X1
XI746_I184_XG I746_P17_2n I746_G1_0n I746_G17_2n I746_G17_0 VDD VSS OAI21_X1
XI746_I185_XG I746_P18_3n I746_G2_0n I746_G18_3n I746_G18_0 VDD VSS OAI21_X1
XI746_I186_XG I746_P19_4n I746_G3_0n I746_G19_4n I746_G19_0 VDD VSS OAI21_X1
XI746_I187 I746_G4_0 I746_G4_0n VDD VSS INV_X1
XI746_I188_XG I746_P20_5n I746_G4_0n I746_G20_5n I746_G20_0 VDD VSS OAI21_X1
XI746_I189 I746_G5_0 I746_G5_0n VDD VSS INV_X1
XI746_I190_XG I746_P21_6n I746_G5_0n I746_G21_6n I746_G21_0 VDD VSS OAI21_X1
XI746_I191 I746_G6_0 I746_G6_0n VDD VSS INV_X1
XI746_I192_XG I746_P22_7n I746_G6_0n I746_G22_7n I746_G22_0 VDD VSS OAI21_X1
XI746_I193 I746_G7_0 I746_G7_0n VDD VSS INV_X1
XI746_I194_XG I746_P23_8n I746_G7_0n I746_G23_8n I746_G23_0 VDD VSS OAI21_X1
XI746_I195_XG I746_P24_9n I746_G8_0n I746_G24_9n I746_G24_0 VDD VSS OAI21_X1
XI746_I196_XG I746_P25_10n I746_G9_0n I746_G25_10n I746_G25_0 VDD VSS OAI21_X1
XI746_I197_XG I746_P26_11n I746_G10_0n I746_G26_11n I746_G26_0 VDD VSS OAI21_X1
XI746_I198_XG I746_P27_12n I746_G11_0n I746_G27_12n I746_G27_0 VDD VSS OAI21_X1
XI746_I199_XG I746_P28_13n I746_G12_0n I746_G28_13n I746_G28_0 VDD VSS OAI21_X1
XI746_I200_XG I746_P29_14n I746_G13_0n I746_G29_14n I746_G29_0 VDD VSS OAI21_X1
XI746_I201_XG I746_P30_15n I746_G14_0n I746_G30_15n c4_m VDD VSS OAI21_X1
XI746_I202_XG I746_P31_16n I746_G15_0n I746_G31_16n c4_o VDD VSS OAI21_X1
XI746_I203 I746_pn0 qu28_b3_5 p4_0 VDD VSS XNOR2_X1
XI746_I204 I746_pn1 I746_G0_0 p4_1 VDD VSS XNOR2_X1
XI746_I205 I746_pn2 I746_G1_0 p4_2 VDD VSS XNOR2_X1
XI746_I206 I746_pn3 I746_G2_0n p4_3 VDD VSS XOR2_X1
XI746_I207 I746_pn4 I746_G3_0n p4_4 VDD VSS XOR2_X1
XI746_I208 I746_pn5 I746_G4_0 p4_5 VDD VSS XNOR2_X1
XI746_I209 I746_pn6 I746_G5_0 p4_6 VDD VSS XNOR2_X1
XI746_I210 I746_pn7 I746_G6_0 p4_7 VDD VSS XNOR2_X1
XI746_I211 I746_pn8 I746_G7_0 p4_8 VDD VSS XNOR2_X1
XI746_I212 I746_pn9 I746_G8_0n p4_9 VDD VSS XOR2_X1
XI746_I213 I746_pn10 I746_G9_0n p4_10 VDD VSS XOR2_X1
XI746_I214 I746_pn11 I746_G10_0n p4_11 VDD VSS XOR2_X1
XI746_I215 I746_pn12 I746_G11_0n p4_12 VDD VSS XOR2_X1
XI746_I216 I746_pn13 I746_G12_0n p4_13 VDD VSS XOR2_X1
XI746_I217 I746_pn14 I746_G13_0n p4_14 VDD VSS XOR2_X1
XI746_I218 I746_pn15 I746_G14_0n p4_15 VDD VSS XOR2_X1
XI746_I219 I746_pn16 I746_G15_0n p4_16 VDD VSS XOR2_X1
XI746_I220 I746_pn17 I746_G16_0 p4_17 VDD VSS XNOR2_X1
XI746_I221 I746_pn18 I746_G17_0 p4_18 VDD VSS XNOR2_X1
XI746_I222 I746_pn19 I746_G18_0 p4_19 VDD VSS XNOR2_X1
XI746_I223 I746_pn20 I746_G19_0 p4_20 VDD VSS XNOR2_X1
XI746_I224 I746_pn21 I746_G20_0 p4_21 VDD VSS XNOR2_X1
XI746_I225 I746_pn22 I746_G21_0 p4_22 VDD VSS XNOR2_X1
XI746_I226 I746_pn23 I746_G22_0 p4_23 VDD VSS XNOR2_X1
XI746_I227 I746_pn24 I746_G23_0 p4_24 VDD VSS XNOR2_X1
XI746_I228 I746_pn25 I746_G24_0 p4_25 VDD VSS XNOR2_X1
XI746_I229 I746_pn26 I746_G25_0 p4_26 VDD VSS XNOR2_X1
XI746_I230 I746_pn27 I746_G26_0 p4_27 VDD VSS XNOR2_X1
XI746_I231 I746_pn28 I746_G27_0 p4_28 VDD VSS XNOR2_X1
XI746_I232 I746_pn29 I746_G28_0 p4_29 VDD VSS XNOR2_X1
XI746_I233 I746_pn30 I746_G29_0 p4_30 VDD VSS XNOR2_X1
XI746_I234 I746_pn31 c4_m p4_31 VDD VSS XNOR2_X1
XI747 p3_31 qu28_b3_5 h4 VDD VSS XOR2_X1
XI748 h4 c4_o p4_32 VDD VSS XOR2_X1
XI749 p4_32 qu27 VDD VSS INV_X4
XI750 qu27 qu27_b0 VDD VSS INV_X1
XI751 qu27_b0 qu27_b1_0 VDD VSS INV_X4
XI752 qu27_b1_0 qu27_b2_0 VDD VSS INV_X4
XI753 qu27_b1_0 qu27_b2_1 VDD VSS INV_X4
XI754 qu27_b2_0 qu27_b3_0 VDD VSS INV_X4
XI755 qu27_b2_0 qu27_b3_1 VDD VSS INV_X4
XI756 qu27_b2_0 qu27_b3_2 VDD VSS INV_X4
XI757 qu27_b2_1 qu27_b3_3 VDD VSS INV_X4
XI758 qu27_b2_1 qu27_b3_4 VDD VSS INV_X4
XI759 qu27_b2_1 qu27_b3_5 VDD VSS INV_X4
XI760 B_0_b3_1 qu27_b3_0 b5_0 VDD VSS XOR2_X1
XI761 dd1_b3_0 qu27_b3_0 b5_1 VDD VSS XOR2_X1
XI762 dd2_b3_0 qu27_b3_0 b5_2 VDD VSS XOR2_X1
XI763 dd3_b3_0 qu27_b3_0 b5_3 VDD VSS XOR2_X1
XI764 dd4_b3_0 qu27_b3_0 b5_4 VDD VSS XOR2_X1
XI765 dd5_b3_0 qu27_b3_0 b5_5 VDD VSS XOR2_X1
XI766 dd6_b3_0 qu27_b3_1 b5_6 VDD VSS XOR2_X1
XI767 dd7_b3_0 qu27_b3_1 b5_7 VDD VSS XOR2_X1
XI768 dd8_b3_0 qu27_b3_1 b5_8 VDD VSS XOR2_X1
XI769 dd9_b3_0 qu27_b3_1 b5_9 VDD VSS XOR2_X1
XI770 dd10_b3_0 qu27_b3_1 b5_10 VDD VSS XOR2_X1
XI771 dd11_b3_0 qu27_b3_1 b5_11 VDD VSS XOR2_X1
XI772 dd12_b3_0 qu27_b3_2 b5_12 VDD VSS XOR2_X1
XI773 dd13_b3_0 qu27_b3_2 b5_13 VDD VSS XOR2_X1
XI774 dd14_b3_0 qu27_b3_2 b5_14 VDD VSS XOR2_X1
XI775 dd15_b3_0 qu27_b3_2 b5_15 VDD VSS XOR2_X1
XI776 dd16_b3_0 qu27_b3_2 b5_16 VDD VSS XOR2_X1
XI777 dd17_b3_0 qu27_b3_2 b5_17 VDD VSS XOR2_X1
XI778 dd18_b3_0 qu27_b3_3 b5_18 VDD VSS XOR2_X1
XI779 dd19_b3_0 qu27_b3_3 b5_19 VDD VSS XOR2_X1
XI780 dd20_b3_0 qu27_b3_3 b5_20 VDD VSS XOR2_X1
XI781 dd21_b3_0 qu27_b3_3 b5_21 VDD VSS XOR2_X1
XI782 dd22_b3_0 qu27_b3_3 b5_22 VDD VSS XOR2_X1
XI783 dd23_b3_0 qu27_b3_3 b5_23 VDD VSS XOR2_X1
XI784 dd24_b3_0 qu27_b3_4 b5_24 VDD VSS XOR2_X1
XI785 dd25_b3_0 qu27_b3_4 b5_25 VDD VSS XOR2_X1
XI786 dd26_b3_0 qu27_b3_4 b5_26 VDD VSS XOR2_X1
XI787 dd27_b3_0 qu27_b3_4 b5_27 VDD VSS XOR2_X1
XI788 dd28_b3_0 qu27_b3_4 b5_28 VDD VSS XOR2_X1
XI789 dd29_b3_0 qu27_b3_4 b5_29 VDD VSS XOR2_X1
XI790 dd30_b3_0 qu27_b3_5 b5_30 VDD VSS XOR2_X1
XI791 dd31_b3_0 qu27_b3_5 b5_31 VDD VSS XOR2_X1
XI792_I0 aa26 b5_0 I792_gn0 VDD VSS NAND2_X1
XI792_I1 p4_0 b5_1 I792_gn1 VDD VSS NAND2_X1
XI792_I2 p4_1 b5_2 I792_gn2 VDD VSS NAND2_X1
XI792_I3 p4_2 b5_3 I792_gn3 VDD VSS NAND2_X1
XI792_I4 p4_3 b5_4 I792_gn4 VDD VSS NAND2_X1
XI792_I5 p4_4 b5_5 I792_gn5 VDD VSS NAND2_X1
XI792_I6 p4_5 b5_6 I792_gn6 VDD VSS NAND2_X1
XI792_I7 p4_6 b5_7 I792_gn7 VDD VSS NAND2_X1
XI792_I8 p4_7 b5_8 I792_gn8 VDD VSS NAND2_X1
XI792_I9 p4_8 b5_9 I792_gn9 VDD VSS NAND2_X1
XI792_I10 p4_9 b5_10 I792_gn10 VDD VSS NAND2_X1
XI792_I11 p4_10 b5_11 I792_gn11 VDD VSS NAND2_X1
XI792_I12 p4_11 b5_12 I792_gn12 VDD VSS NAND2_X1
XI792_I13 p4_12 b5_13 I792_gn13 VDD VSS NAND2_X1
XI792_I14 p4_13 b5_14 I792_gn14 VDD VSS NAND2_X1
XI792_I15 p4_14 b5_15 I792_gn15 VDD VSS NAND2_X1
XI792_I16 p4_15 b5_16 I792_gn16 VDD VSS NAND2_X1
XI792_I17 p4_16 b5_17 I792_gn17 VDD VSS NAND2_X1
XI792_I18 p4_17 b5_18 I792_gn18 VDD VSS NAND2_X1
XI792_I19 p4_18 b5_19 I792_gn19 VDD VSS NAND2_X1
XI792_I20 p4_19 b5_20 I792_gn20 VDD VSS NAND2_X1
XI792_I21 p4_20 b5_21 I792_gn21 VDD VSS NAND2_X1
XI792_I22 p4_21 b5_22 I792_gn22 VDD VSS NAND2_X1
XI792_I23 p4_22 b5_23 I792_gn23 VDD VSS NAND2_X1
XI792_I24 p4_23 b5_24 I792_gn24 VDD VSS NAND2_X1
XI792_I25 p4_24 b5_25 I792_gn25 VDD VSS NAND2_X1
XI792_I26 p4_25 b5_26 I792_gn26 VDD VSS NAND2_X1
XI792_I27 p4_26 b5_27 I792_gn27 VDD VSS NAND2_X1
XI792_I28 p4_27 b5_28 I792_gn28 VDD VSS NAND2_X1
XI792_I29 p4_28 b5_29 I792_gn29 VDD VSS NAND2_X1
XI792_I30 p4_29 b5_30 I792_gn30 VDD VSS NAND2_X1
XI792_I31 p4_30 b5_31 I792_gn31 VDD VSS NAND2_X1
XI792_I32 aa26 b5_0 I792_pn0 VDD VSS XNOR2_X1
XI792_I33 p4_0 b5_1 I792_pn1 VDD VSS XNOR2_X1
XI792_I34 p4_1 b5_2 I792_pn2 VDD VSS XNOR2_X1
XI792_I35 p4_2 b5_3 I792_pn3 VDD VSS XNOR2_X1
XI792_I36 p4_3 b5_4 I792_pn4 VDD VSS XNOR2_X1
XI792_I37 p4_4 b5_5 I792_pn5 VDD VSS XNOR2_X1
XI792_I38 p4_5 b5_6 I792_pn6 VDD VSS XNOR2_X1
XI792_I39 p4_6 b5_7 I792_pn7 VDD VSS XNOR2_X1
XI792_I40 p4_7 b5_8 I792_pn8 VDD VSS XNOR2_X1
XI792_I41 p4_8 b5_9 I792_pn9 VDD VSS XNOR2_X1
XI792_I42 p4_9 b5_10 I792_pn10 VDD VSS XNOR2_X1
XI792_I43 p4_10 b5_11 I792_pn11 VDD VSS XNOR2_X1
XI792_I44 p4_11 b5_12 I792_pn12 VDD VSS XNOR2_X1
XI792_I45 p4_12 b5_13 I792_pn13 VDD VSS XNOR2_X1
XI792_I46 p4_13 b5_14 I792_pn14 VDD VSS XNOR2_X1
XI792_I47 p4_14 b5_15 I792_pn15 VDD VSS XNOR2_X1
XI792_I48 p4_15 b5_16 I792_pn16 VDD VSS XNOR2_X1
XI792_I49 p4_16 b5_17 I792_pn17 VDD VSS XNOR2_X1
XI792_I50 p4_17 b5_18 I792_pn18 VDD VSS XNOR2_X1
XI792_I51 p4_18 b5_19 I792_pn19 VDD VSS XNOR2_X1
XI792_I52 p4_19 b5_20 I792_pn20 VDD VSS XNOR2_X1
XI792_I53 p4_20 b5_21 I792_pn21 VDD VSS XNOR2_X1
XI792_I54 p4_21 b5_22 I792_pn22 VDD VSS XNOR2_X1
XI792_I55 p4_22 b5_23 I792_pn23 VDD VSS XNOR2_X1
XI792_I56 p4_23 b5_24 I792_pn24 VDD VSS XNOR2_X1
XI792_I57 p4_24 b5_25 I792_pn25 VDD VSS XNOR2_X1
XI792_I58 p4_25 b5_26 I792_pn26 VDD VSS XNOR2_X1
XI792_I59 p4_26 b5_27 I792_pn27 VDD VSS XNOR2_X1
XI792_I60 p4_27 b5_28 I792_pn28 VDD VSS XNOR2_X1
XI792_I61 p4_28 b5_29 I792_pn29 VDD VSS XNOR2_X1
XI792_I62 p4_29 b5_30 I792_pn30 VDD VSS XNOR2_X1
XI792_I63 p4_30 b5_31 I792_pn31 VDD VSS XNOR2_X1
XI792_I64 qu27_b3_5 I792_cinn VDD VSS INV_X1
XI792_I65_XG I792_pn0 I792_cinn I792_gn0 I792_G0_0 VDD VSS OAI21_X1
XI792_I66 I792_G0_0 I792_G0_0n VDD VSS INV_X1
XI792_I67_XG I792_pn1 I792_G0_0n I792_gn1 I792_G1_0 VDD VSS OAI21_X1
XI792_I68_XG I792_pn2 I792_gn1 I792_gn2 I792_G2_1 VDD VSS OAI21_X1
XI792_I68_XP I792_pn2 I792_pn1 I792_P2_1 VDD VSS NOR2_X1
XI792_I69_XG I792_pn3 I792_gn2 I792_gn3 I792_G3_2 VDD VSS OAI21_X1
XI792_I69_XP I792_pn3 I792_pn2 I792_P3_2 VDD VSS NOR2_X1
XI792_I70_XG I792_pn4 I792_gn3 I792_gn4 I792_G4_3 VDD VSS OAI21_X1
XI792_I70_XP I792_pn4 I792_pn3 I792_P4_3 VDD VSS NOR2_X1
XI792_I71_XG I792_pn5 I792_gn4 I792_gn5 I792_G5_4 VDD VSS OAI21_X1
XI792_I71_XP I792_pn5 I792_pn4 I792_P5_4 VDD VSS NOR2_X1
XI792_I72_XG I792_pn6 I792_gn5 I792_gn6 I792_G6_5 VDD VSS OAI21_X1
XI792_I72_XP I792_pn6 I792_pn5 I792_P6_5 VDD VSS NOR2_X1
XI792_I73_XG I792_pn7 I792_gn6 I792_gn7 I792_G7_6 VDD VSS OAI21_X1
XI792_I73_XP I792_pn7 I792_pn6 I792_P7_6 VDD VSS NOR2_X1
XI792_I74_XG I792_pn8 I792_gn7 I792_gn8 I792_G8_7 VDD VSS OAI21_X1
XI792_I74_XP I792_pn8 I792_pn7 I792_P8_7 VDD VSS NOR2_X1
XI792_I75_XG I792_pn9 I792_gn8 I792_gn9 I792_G9_8 VDD VSS OAI21_X1
XI792_I75_XP I792_pn9 I792_pn8 I792_P9_8 VDD VSS NOR2_X1
XI792_I76_XG I792_pn10 I792_gn9 I792_gn10 I792_G10_9 VDD VSS OAI21_X1
XI792_I76_XP I792_pn10 I792_pn9 I792_P10_9 VDD VSS NOR2_X1
XI792_I77_XG I792_pn11 I792_gn10 I792_gn11 I792_G11_10 VDD VSS OAI21_X1
XI792_I77_XP I792_pn11 I792_pn10 I792_P11_10 VDD VSS NOR2_X1
XI792_I78_XG I792_pn12 I792_gn11 I792_gn12 I792_G12_11 VDD VSS OAI21_X1
XI792_I78_XP I792_pn12 I792_pn11 I792_P12_11 VDD VSS NOR2_X1
XI792_I79_XG I792_pn13 I792_gn12 I792_gn13 I792_G13_12 VDD VSS OAI21_X1
XI792_I79_XP I792_pn13 I792_pn12 I792_P13_12 VDD VSS NOR2_X1
XI792_I80_XG I792_pn14 I792_gn13 I792_gn14 I792_G14_13 VDD VSS OAI21_X1
XI792_I80_XP I792_pn14 I792_pn13 I792_P14_13 VDD VSS NOR2_X1
XI792_I81_XG I792_pn15 I792_gn14 I792_gn15 I792_G15_14 VDD VSS OAI21_X1
XI792_I81_XP I792_pn15 I792_pn14 I792_P15_14 VDD VSS NOR2_X1
XI792_I82_XG I792_pn16 I792_gn15 I792_gn16 I792_G16_15 VDD VSS OAI21_X1
XI792_I82_XP I792_pn16 I792_pn15 I792_P16_15 VDD VSS NOR2_X1
XI792_I83_XG I792_pn17 I792_gn16 I792_gn17 I792_G17_16 VDD VSS OAI21_X1
XI792_I83_XP I792_pn17 I792_pn16 I792_P17_16 VDD VSS NOR2_X1
XI792_I84_XG I792_pn18 I792_gn17 I792_gn18 I792_G18_17 VDD VSS OAI21_X1
XI792_I84_XP I792_pn18 I792_pn17 I792_P18_17 VDD VSS NOR2_X1
XI792_I85_XG I792_pn19 I792_gn18 I792_gn19 I792_G19_18 VDD VSS OAI21_X1
XI792_I85_XP I792_pn19 I792_pn18 I792_P19_18 VDD VSS NOR2_X1
XI792_I86_XG I792_pn20 I792_gn19 I792_gn20 I792_G20_19 VDD VSS OAI21_X1
XI792_I86_XP I792_pn20 I792_pn19 I792_P20_19 VDD VSS NOR2_X1
XI792_I87_XG I792_pn21 I792_gn20 I792_gn21 I792_G21_20 VDD VSS OAI21_X1
XI792_I87_XP I792_pn21 I792_pn20 I792_P21_20 VDD VSS NOR2_X1
XI792_I88_XG I792_pn22 I792_gn21 I792_gn22 I792_G22_21 VDD VSS OAI21_X1
XI792_I88_XP I792_pn22 I792_pn21 I792_P22_21 VDD VSS NOR2_X1
XI792_I89_XG I792_pn23 I792_gn22 I792_gn23 I792_G23_22 VDD VSS OAI21_X1
XI792_I89_XP I792_pn23 I792_pn22 I792_P23_22 VDD VSS NOR2_X1
XI792_I90_XG I792_pn24 I792_gn23 I792_gn24 I792_G24_23 VDD VSS OAI21_X1
XI792_I90_XP I792_pn24 I792_pn23 I792_P24_23 VDD VSS NOR2_X1
XI792_I91_XG I792_pn25 I792_gn24 I792_gn25 I792_G25_24 VDD VSS OAI21_X1
XI792_I91_XP I792_pn25 I792_pn24 I792_P25_24 VDD VSS NOR2_X1
XI792_I92_XG I792_pn26 I792_gn25 I792_gn26 I792_G26_25 VDD VSS OAI21_X1
XI792_I92_XP I792_pn26 I792_pn25 I792_P26_25 VDD VSS NOR2_X1
XI792_I93_XG I792_pn27 I792_gn26 I792_gn27 I792_G27_26 VDD VSS OAI21_X1
XI792_I93_XP I792_pn27 I792_pn26 I792_P27_26 VDD VSS NOR2_X1
XI792_I94_XG I792_pn28 I792_gn27 I792_gn28 I792_G28_27 VDD VSS OAI21_X1
XI792_I94_XP I792_pn28 I792_pn27 I792_P28_27 VDD VSS NOR2_X1
XI792_I95_XG I792_pn29 I792_gn28 I792_gn29 I792_G29_28 VDD VSS OAI21_X1
XI792_I95_XP I792_pn29 I792_pn28 I792_P29_28 VDD VSS NOR2_X1
XI792_I96_XG I792_pn30 I792_gn29 I792_gn30 I792_G30_29 VDD VSS OAI21_X1
XI792_I96_XP I792_pn30 I792_pn29 I792_P30_29 VDD VSS NOR2_X1
XI792_I97_XG I792_pn31 I792_gn30 I792_gn31 I792_G31_30 VDD VSS OAI21_X1
XI792_I97_XP I792_pn31 I792_pn30 I792_P31_30 VDD VSS NOR2_X1
XI792_I98_XG I792_P2_1 I792_G0_0 I792_G2_1 I792_G2_0n VDD VSS AOI21_X1
XI792_I99_XG I792_P3_2 I792_G1_0 I792_G3_2 I792_G3_0n VDD VSS AOI21_X1
XI792_I100_XG I792_P4_3 I792_G2_1 I792_G4_3 I792_G4_1n VDD VSS AOI21_X1
XI792_I100_XP I792_P4_3 I792_P2_1 I792_P4_1n VDD VSS NAND2_X1
XI792_I101_XG I792_P5_4 I792_G3_2 I792_G5_4 I792_G5_2n VDD VSS AOI21_X1
XI792_I101_XP I792_P5_4 I792_P3_2 I792_P5_2n VDD VSS NAND2_X1
XI792_I102_XG I792_P6_5 I792_G4_3 I792_G6_5 I792_G6_3n VDD VSS AOI21_X1
XI792_I102_XP I792_P6_5 I792_P4_3 I792_P6_3n VDD VSS NAND2_X1
XI792_I103_XG I792_P7_6 I792_G5_4 I792_G7_6 I792_G7_4n VDD VSS AOI21_X1
XI792_I103_XP I792_P7_6 I792_P5_4 I792_P7_4n VDD VSS NAND2_X1
XI792_I104_XG I792_P8_7 I792_G6_5 I792_G8_7 I792_G8_5n VDD VSS AOI21_X1
XI792_I104_XP I792_P8_7 I792_P6_5 I792_P8_5n VDD VSS NAND2_X1
XI792_I105_XG I792_P9_8 I792_G7_6 I792_G9_8 I792_G9_6n VDD VSS AOI21_X1
XI792_I105_XP I792_P9_8 I792_P7_6 I792_P9_6n VDD VSS NAND2_X1
XI792_I106_XG I792_P10_9 I792_G8_7 I792_G10_9 I792_G10_7n VDD VSS AOI21_X1
XI792_I106_XP I792_P10_9 I792_P8_7 I792_P10_7n VDD VSS NAND2_X1
XI792_I107_XG I792_P11_10 I792_G9_8 I792_G11_10 I792_G11_8n VDD VSS AOI21_X1
XI792_I107_XP I792_P11_10 I792_P9_8 I792_P11_8n VDD VSS NAND2_X1
XI792_I108_XG I792_P12_11 I792_G10_9 I792_G12_11 I792_G12_9n VDD VSS AOI21_X1
XI792_I108_XP I792_P12_11 I792_P10_9 I792_P12_9n VDD VSS NAND2_X1
XI792_I109_XG I792_P13_12 I792_G11_10 I792_G13_12 I792_G13_10n VDD VSS AOI21_X1
XI792_I109_XP I792_P13_12 I792_P11_10 I792_P13_10n VDD VSS NAND2_X1
XI792_I110_XG I792_P14_13 I792_G12_11 I792_G14_13 I792_G14_11n VDD VSS AOI21_X1
XI792_I110_XP I792_P14_13 I792_P12_11 I792_P14_11n VDD VSS NAND2_X1
XI792_I111_XG I792_P15_14 I792_G13_12 I792_G15_14 I792_G15_12n VDD VSS AOI21_X1
XI792_I111_XP I792_P15_14 I792_P13_12 I792_P15_12n VDD VSS NAND2_X1
XI792_I112_XG I792_P16_15 I792_G14_13 I792_G16_15 I792_G16_13n VDD VSS AOI21_X1
XI792_I112_XP I792_P16_15 I792_P14_13 I792_P16_13n VDD VSS NAND2_X1
XI792_I113_XG I792_P17_16 I792_G15_14 I792_G17_16 I792_G17_14n VDD VSS AOI21_X1
XI792_I113_XP I792_P17_16 I792_P15_14 I792_P17_14n VDD VSS NAND2_X1
XI792_I114_XG I792_P18_17 I792_G16_15 I792_G18_17 I792_G18_15n VDD VSS AOI21_X1
XI792_I114_XP I792_P18_17 I792_P16_15 I792_P18_15n VDD VSS NAND2_X1
XI792_I115_XG I792_P19_18 I792_G17_16 I792_G19_18 I792_G19_16n VDD VSS AOI21_X1
XI792_I115_XP I792_P19_18 I792_P17_16 I792_P19_16n VDD VSS NAND2_X1
XI792_I116_XG I792_P20_19 I792_G18_17 I792_G20_19 I792_G20_17n VDD VSS AOI21_X1
XI792_I116_XP I792_P20_19 I792_P18_17 I792_P20_17n VDD VSS NAND2_X1
XI792_I117_XG I792_P21_20 I792_G19_18 I792_G21_20 I792_G21_18n VDD VSS AOI21_X1
XI792_I117_XP I792_P21_20 I792_P19_18 I792_P21_18n VDD VSS NAND2_X1
XI792_I118_XG I792_P22_21 I792_G20_19 I792_G22_21 I792_G22_19n VDD VSS AOI21_X1
XI792_I118_XP I792_P22_21 I792_P20_19 I792_P22_19n VDD VSS NAND2_X1
XI792_I119_XG I792_P23_22 I792_G21_20 I792_G23_22 I792_G23_20n VDD VSS AOI21_X1
XI792_I119_XP I792_P23_22 I792_P21_20 I792_P23_20n VDD VSS NAND2_X1
XI792_I120_XG I792_P24_23 I792_G22_21 I792_G24_23 I792_G24_21n VDD VSS AOI21_X1
XI792_I120_XP I792_P24_23 I792_P22_21 I792_P24_21n VDD VSS NAND2_X1
XI792_I121_XG I792_P25_24 I792_G23_22 I792_G25_24 I792_G25_22n VDD VSS AOI21_X1
XI792_I121_XP I792_P25_24 I792_P23_22 I792_P25_22n VDD VSS NAND2_X1
XI792_I122_XG I792_P26_25 I792_G24_23 I792_G26_25 I792_G26_23n VDD VSS AOI21_X1
XI792_I122_XP I792_P26_25 I792_P24_23 I792_P26_23n VDD VSS NAND2_X1
XI792_I123_XG I792_P27_26 I792_G25_24 I792_G27_26 I792_G27_24n VDD VSS AOI21_X1
XI792_I123_XP I792_P27_26 I792_P25_24 I792_P27_24n VDD VSS NAND2_X1
XI792_I124_XG I792_P28_27 I792_G26_25 I792_G28_27 I792_G28_25n VDD VSS AOI21_X1
XI792_I124_XP I792_P28_27 I792_P26_25 I792_P28_25n VDD VSS NAND2_X1
XI792_I125_XG I792_P29_28 I792_G27_26 I792_G29_28 I792_G29_26n VDD VSS AOI21_X1
XI792_I125_XP I792_P29_28 I792_P27_26 I792_P29_26n VDD VSS NAND2_X1
XI792_I126_XG I792_P30_29 I792_G28_27 I792_G30_29 I792_G30_27n VDD VSS AOI21_X1
XI792_I126_XP I792_P30_29 I792_P28_27 I792_P30_27n VDD VSS NAND2_X1
XI792_I127_XG I792_P31_30 I792_G29_28 I792_G31_30 I792_G31_28n VDD VSS AOI21_X1
XI792_I127_XP I792_P31_30 I792_P29_28 I792_P31_28n VDD VSS NAND2_X1
XI792_I128_XG I792_P4_1n I792_G0_0n I792_G4_1n I792_G4_0 VDD VSS OAI21_X1
XI792_I129 I792_G1_0 I792_G1_0n VDD VSS INV_X1
XI792_I130_XG I792_P5_2n I792_G1_0n I792_G5_2n I792_G5_0 VDD VSS OAI21_X1
XI792_I131_XG I792_P6_3n I792_G2_0n I792_G6_3n I792_G6_0 VDD VSS OAI21_X1
XI792_I132_XG I792_P7_4n I792_G3_0n I792_G7_4n I792_G7_0 VDD VSS OAI21_X1
XI792_I133_XG I792_P8_5n I792_G4_1n I792_G8_5n I792_G8_1 VDD VSS OAI21_X1
XI792_I133_XP I792_P8_5n I792_P4_1n I792_P8_1 VDD VSS NOR2_X1
XI792_I134_XG I792_P9_6n I792_G5_2n I792_G9_6n I792_G9_2 VDD VSS OAI21_X1
XI792_I134_XP I792_P9_6n I792_P5_2n I792_P9_2 VDD VSS NOR2_X1
XI792_I135_XG I792_P10_7n I792_G6_3n I792_G10_7n I792_G10_3 VDD VSS OAI21_X1
XI792_I135_XP I792_P10_7n I792_P6_3n I792_P10_3 VDD VSS NOR2_X1
XI792_I136_XG I792_P11_8n I792_G7_4n I792_G11_8n I792_G11_4 VDD VSS OAI21_X1
XI792_I136_XP I792_P11_8n I792_P7_4n I792_P11_4 VDD VSS NOR2_X1
XI792_I137_XG I792_P12_9n I792_G8_5n I792_G12_9n I792_G12_5 VDD VSS OAI21_X1
XI792_I137_XP I792_P12_9n I792_P8_5n I792_P12_5 VDD VSS NOR2_X1
XI792_I138_XG I792_P13_10n I792_G9_6n I792_G13_10n I792_G13_6 VDD VSS OAI21_X1
XI792_I138_XP I792_P13_10n I792_P9_6n I792_P13_6 VDD VSS NOR2_X1
XI792_I139_XG I792_P14_11n I792_G10_7n I792_G14_11n I792_G14_7 VDD VSS OAI21_X1
XI792_I139_XP I792_P14_11n I792_P10_7n I792_P14_7 VDD VSS NOR2_X1
XI792_I140_XG I792_P15_12n I792_G11_8n I792_G15_12n I792_G15_8 VDD VSS OAI21_X1
XI792_I140_XP I792_P15_12n I792_P11_8n I792_P15_8 VDD VSS NOR2_X1
XI792_I141_XG I792_P16_13n I792_G12_9n I792_G16_13n I792_G16_9 VDD VSS OAI21_X1
XI792_I141_XP I792_P16_13n I792_P12_9n I792_P16_9 VDD VSS NOR2_X1
XI792_I142_XG I792_P17_14n I792_G13_10n I792_G17_14n I792_G17_10 VDD VSS OAI21_X1
XI792_I142_XP I792_P17_14n I792_P13_10n I792_P17_10 VDD VSS NOR2_X1
XI792_I143_XG I792_P18_15n I792_G14_11n I792_G18_15n I792_G18_11 VDD VSS OAI21_X1
XI792_I143_XP I792_P18_15n I792_P14_11n I792_P18_11 VDD VSS NOR2_X1
XI792_I144_XG I792_P19_16n I792_G15_12n I792_G19_16n I792_G19_12 VDD VSS OAI21_X1
XI792_I144_XP I792_P19_16n I792_P15_12n I792_P19_12 VDD VSS NOR2_X1
XI792_I145_XG I792_P20_17n I792_G16_13n I792_G20_17n I792_G20_13 VDD VSS OAI21_X1
XI792_I145_XP I792_P20_17n I792_P16_13n I792_P20_13 VDD VSS NOR2_X1
XI792_I146_XG I792_P21_18n I792_G17_14n I792_G21_18n I792_G21_14 VDD VSS OAI21_X1
XI792_I146_XP I792_P21_18n I792_P17_14n I792_P21_14 VDD VSS NOR2_X1
XI792_I147_XG I792_P22_19n I792_G18_15n I792_G22_19n I792_G22_15 VDD VSS OAI21_X1
XI792_I147_XP I792_P22_19n I792_P18_15n I792_P22_15 VDD VSS NOR2_X1
XI792_I148_XG I792_P23_20n I792_G19_16n I792_G23_20n I792_G23_16 VDD VSS OAI21_X1
XI792_I148_XP I792_P23_20n I792_P19_16n I792_P23_16 VDD VSS NOR2_X1
XI792_I149_XG I792_P24_21n I792_G20_17n I792_G24_21n I792_G24_17 VDD VSS OAI21_X1
XI792_I149_XP I792_P24_21n I792_P20_17n I792_P24_17 VDD VSS NOR2_X1
XI792_I150_XG I792_P25_22n I792_G21_18n I792_G25_22n I792_G25_18 VDD VSS OAI21_X1
XI792_I150_XP I792_P25_22n I792_P21_18n I792_P25_18 VDD VSS NOR2_X1
XI792_I151_XG I792_P26_23n I792_G22_19n I792_G26_23n I792_G26_19 VDD VSS OAI21_X1
XI792_I151_XP I792_P26_23n I792_P22_19n I792_P26_19 VDD VSS NOR2_X1
XI792_I152_XG I792_P27_24n I792_G23_20n I792_G27_24n I792_G27_20 VDD VSS OAI21_X1
XI792_I152_XP I792_P27_24n I792_P23_20n I792_P27_20 VDD VSS NOR2_X1
XI792_I153_XG I792_P28_25n I792_G24_21n I792_G28_25n I792_G28_21 VDD VSS OAI21_X1
XI792_I153_XP I792_P28_25n I792_P24_21n I792_P28_21 VDD VSS NOR2_X1
XI792_I154_XG I792_P29_26n I792_G25_22n I792_G29_26n I792_G29_22 VDD VSS OAI21_X1
XI792_I154_XP I792_P29_26n I792_P25_22n I792_P29_22 VDD VSS NOR2_X1
XI792_I155_XG I792_P30_27n I792_G26_23n I792_G30_27n I792_G30_23 VDD VSS OAI21_X1
XI792_I155_XP I792_P30_27n I792_P26_23n I792_P30_23 VDD VSS NOR2_X1
XI792_I156_XG I792_P31_28n I792_G27_24n I792_G31_28n I792_G31_24 VDD VSS OAI21_X1
XI792_I156_XP I792_P31_28n I792_P27_24n I792_P31_24 VDD VSS NOR2_X1
XI792_I157_XG I792_P8_1 I792_G0_0 I792_G8_1 I792_G8_0n VDD VSS AOI21_X1
XI792_I158_XG I792_P9_2 I792_G1_0 I792_G9_2 I792_G9_0n VDD VSS AOI21_X1
XI792_I159 I792_G2_0n I792_G2_0np VDD VSS INV_X1
XI792_I160_XG I792_P10_3 I792_G2_0np I792_G10_3 I792_G10_0n VDD VSS AOI21_X1
XI792_I161 I792_G3_0n I792_G3_0np VDD VSS INV_X1
XI792_I162_XG I792_P11_4 I792_G3_0np I792_G11_4 I792_G11_0n VDD VSS AOI21_X1
XI792_I163_XG I792_P12_5 I792_G4_0 I792_G12_5 I792_G12_0n VDD VSS AOI21_X1
XI792_I164_XG I792_P13_6 I792_G5_0 I792_G13_6 I792_G13_0n VDD VSS AOI21_X1
XI792_I165_XG I792_P14_7 I792_G6_0 I792_G14_7 I792_G14_0n VDD VSS AOI21_X1
XI792_I166_XG I792_P15_8 I792_G7_0 I792_G15_8 I792_G15_0n VDD VSS AOI21_X1
XI792_I167_XG I792_P16_9 I792_G8_1 I792_G16_9 I792_G16_1n VDD VSS AOI21_X1
XI792_I167_XP I792_P16_9 I792_P8_1 I792_P16_1n VDD VSS NAND2_X1
XI792_I168_XG I792_P17_10 I792_G9_2 I792_G17_10 I792_G17_2n VDD VSS AOI21_X1
XI792_I168_XP I792_P17_10 I792_P9_2 I792_P17_2n VDD VSS NAND2_X1
XI792_I169_XG I792_P18_11 I792_G10_3 I792_G18_11 I792_G18_3n VDD VSS AOI21_X1
XI792_I169_XP I792_P18_11 I792_P10_3 I792_P18_3n VDD VSS NAND2_X1
XI792_I170_XG I792_P19_12 I792_G11_4 I792_G19_12 I792_G19_4n VDD VSS AOI21_X1
XI792_I170_XP I792_P19_12 I792_P11_4 I792_P19_4n VDD VSS NAND2_X1
XI792_I171_XG I792_P20_13 I792_G12_5 I792_G20_13 I792_G20_5n VDD VSS AOI21_X1
XI792_I171_XP I792_P20_13 I792_P12_5 I792_P20_5n VDD VSS NAND2_X1
XI792_I172_XG I792_P21_14 I792_G13_6 I792_G21_14 I792_G21_6n VDD VSS AOI21_X1
XI792_I172_XP I792_P21_14 I792_P13_6 I792_P21_6n VDD VSS NAND2_X1
XI792_I173_XG I792_P22_15 I792_G14_7 I792_G22_15 I792_G22_7n VDD VSS AOI21_X1
XI792_I173_XP I792_P22_15 I792_P14_7 I792_P22_7n VDD VSS NAND2_X1
XI792_I174_XG I792_P23_16 I792_G15_8 I792_G23_16 I792_G23_8n VDD VSS AOI21_X1
XI792_I174_XP I792_P23_16 I792_P15_8 I792_P23_8n VDD VSS NAND2_X1
XI792_I175_XG I792_P24_17 I792_G16_9 I792_G24_17 I792_G24_9n VDD VSS AOI21_X1
XI792_I175_XP I792_P24_17 I792_P16_9 I792_P24_9n VDD VSS NAND2_X1
XI792_I176_XG I792_P25_18 I792_G17_10 I792_G25_18 I792_G25_10n VDD VSS AOI21_X1
XI792_I176_XP I792_P25_18 I792_P17_10 I792_P25_10n VDD VSS NAND2_X1
XI792_I177_XG I792_P26_19 I792_G18_11 I792_G26_19 I792_G26_11n VDD VSS AOI21_X1
XI792_I177_XP I792_P26_19 I792_P18_11 I792_P26_11n VDD VSS NAND2_X1
XI792_I178_XG I792_P27_20 I792_G19_12 I792_G27_20 I792_G27_12n VDD VSS AOI21_X1
XI792_I178_XP I792_P27_20 I792_P19_12 I792_P27_12n VDD VSS NAND2_X1
XI792_I179_XG I792_P28_21 I792_G20_13 I792_G28_21 I792_G28_13n VDD VSS AOI21_X1
XI792_I179_XP I792_P28_21 I792_P20_13 I792_P28_13n VDD VSS NAND2_X1
XI792_I180_XG I792_P29_22 I792_G21_14 I792_G29_22 I792_G29_14n VDD VSS AOI21_X1
XI792_I180_XP I792_P29_22 I792_P21_14 I792_P29_14n VDD VSS NAND2_X1
XI792_I181_XG I792_P30_23 I792_G22_15 I792_G30_23 I792_G30_15n VDD VSS AOI21_X1
XI792_I181_XP I792_P30_23 I792_P22_15 I792_P30_15n VDD VSS NAND2_X1
XI792_I182_XG I792_P31_24 I792_G23_16 I792_G31_24 I792_G31_16n VDD VSS AOI21_X1
XI792_I182_XP I792_P31_24 I792_P23_16 I792_P31_16n VDD VSS NAND2_X1
XI792_I183_XG I792_P16_1n I792_G0_0n I792_G16_1n I792_G16_0 VDD VSS OAI21_X1
XI792_I184_XG I792_P17_2n I792_G1_0n I792_G17_2n I792_G17_0 VDD VSS OAI21_X1
XI792_I185_XG I792_P18_3n I792_G2_0n I792_G18_3n I792_G18_0 VDD VSS OAI21_X1
XI792_I186_XG I792_P19_4n I792_G3_0n I792_G19_4n I792_G19_0 VDD VSS OAI21_X1
XI792_I187 I792_G4_0 I792_G4_0n VDD VSS INV_X1
XI792_I188_XG I792_P20_5n I792_G4_0n I792_G20_5n I792_G20_0 VDD VSS OAI21_X1
XI792_I189 I792_G5_0 I792_G5_0n VDD VSS INV_X1
XI792_I190_XG I792_P21_6n I792_G5_0n I792_G21_6n I792_G21_0 VDD VSS OAI21_X1
XI792_I191 I792_G6_0 I792_G6_0n VDD VSS INV_X1
XI792_I192_XG I792_P22_7n I792_G6_0n I792_G22_7n I792_G22_0 VDD VSS OAI21_X1
XI792_I193 I792_G7_0 I792_G7_0n VDD VSS INV_X1
XI792_I194_XG I792_P23_8n I792_G7_0n I792_G23_8n I792_G23_0 VDD VSS OAI21_X1
XI792_I195_XG I792_P24_9n I792_G8_0n I792_G24_9n I792_G24_0 VDD VSS OAI21_X1
XI792_I196_XG I792_P25_10n I792_G9_0n I792_G25_10n I792_G25_0 VDD VSS OAI21_X1
XI792_I197_XG I792_P26_11n I792_G10_0n I792_G26_11n I792_G26_0 VDD VSS OAI21_X1
XI792_I198_XG I792_P27_12n I792_G11_0n I792_G27_12n I792_G27_0 VDD VSS OAI21_X1
XI792_I199_XG I792_P28_13n I792_G12_0n I792_G28_13n I792_G28_0 VDD VSS OAI21_X1
XI792_I200_XG I792_P29_14n I792_G13_0n I792_G29_14n I792_G29_0 VDD VSS OAI21_X1
XI792_I201_XG I792_P30_15n I792_G14_0n I792_G30_15n c5_m VDD VSS OAI21_X1
XI792_I202_XG I792_P31_16n I792_G15_0n I792_G31_16n c5_o VDD VSS OAI21_X1
XI792_I203 I792_pn0 qu27_b3_5 p5_0 VDD VSS XNOR2_X1
XI792_I204 I792_pn1 I792_G0_0 p5_1 VDD VSS XNOR2_X1
XI792_I205 I792_pn2 I792_G1_0 p5_2 VDD VSS XNOR2_X1
XI792_I206 I792_pn3 I792_G2_0n p5_3 VDD VSS XOR2_X1
XI792_I207 I792_pn4 I792_G3_0n p5_4 VDD VSS XOR2_X1
XI792_I208 I792_pn5 I792_G4_0 p5_5 VDD VSS XNOR2_X1
XI792_I209 I792_pn6 I792_G5_0 p5_6 VDD VSS XNOR2_X1
XI792_I210 I792_pn7 I792_G6_0 p5_7 VDD VSS XNOR2_X1
XI792_I211 I792_pn8 I792_G7_0 p5_8 VDD VSS XNOR2_X1
XI792_I212 I792_pn9 I792_G8_0n p5_9 VDD VSS XOR2_X1
XI792_I213 I792_pn10 I792_G9_0n p5_10 VDD VSS XOR2_X1
XI792_I214 I792_pn11 I792_G10_0n p5_11 VDD VSS XOR2_X1
XI792_I215 I792_pn12 I792_G11_0n p5_12 VDD VSS XOR2_X1
XI792_I216 I792_pn13 I792_G12_0n p5_13 VDD VSS XOR2_X1
XI792_I217 I792_pn14 I792_G13_0n p5_14 VDD VSS XOR2_X1
XI792_I218 I792_pn15 I792_G14_0n p5_15 VDD VSS XOR2_X1
XI792_I219 I792_pn16 I792_G15_0n p5_16 VDD VSS XOR2_X1
XI792_I220 I792_pn17 I792_G16_0 p5_17 VDD VSS XNOR2_X1
XI792_I221 I792_pn18 I792_G17_0 p5_18 VDD VSS XNOR2_X1
XI792_I222 I792_pn19 I792_G18_0 p5_19 VDD VSS XNOR2_X1
XI792_I223 I792_pn20 I792_G19_0 p5_20 VDD VSS XNOR2_X1
XI792_I224 I792_pn21 I792_G20_0 p5_21 VDD VSS XNOR2_X1
XI792_I225 I792_pn22 I792_G21_0 p5_22 VDD VSS XNOR2_X1
XI792_I226 I792_pn23 I792_G22_0 p5_23 VDD VSS XNOR2_X1
XI792_I227 I792_pn24 I792_G23_0 p5_24 VDD VSS XNOR2_X1
XI792_I228 I792_pn25 I792_G24_0 p5_25 VDD VSS XNOR2_X1
XI792_I229 I792_pn26 I792_G25_0 p5_26 VDD VSS XNOR2_X1
XI792_I230 I792_pn27 I792_G26_0 p5_27 VDD VSS XNOR2_X1
XI792_I231 I792_pn28 I792_G27_0 p5_28 VDD VSS XNOR2_X1
XI792_I232 I792_pn29 I792_G28_0 p5_29 VDD VSS XNOR2_X1
XI792_I233 I792_pn30 I792_G29_0 p5_30 VDD VSS XNOR2_X1
XI792_I234 I792_pn31 c5_m p5_31 VDD VSS XNOR2_X1
XI793 p4_31 qu27_b3_5 h5 VDD VSS XOR2_X1
XI794 h5 c5_o p5_32 VDD VSS XOR2_X1
XI795 p5_32 qu26 VDD VSS INV_X4
XI796 qu26 qu26_b0 VDD VSS INV_X1
XI797 qu26_b0 qu26_b1_0 VDD VSS INV_X4
XI798 qu26_b1_0 qu26_b2_0 VDD VSS INV_X4
XI799 qu26_b1_0 qu26_b2_1 VDD VSS INV_X4
XI800 qu26_b2_0 qu26_b3_0 VDD VSS INV_X4
XI801 qu26_b2_0 qu26_b3_1 VDD VSS INV_X4
XI802 qu26_b2_0 qu26_b3_2 VDD VSS INV_X4
XI803 qu26_b2_1 qu26_b3_3 VDD VSS INV_X4
XI804 qu26_b2_1 qu26_b3_4 VDD VSS INV_X4
XI805 qu26_b2_1 qu26_b3_5 VDD VSS INV_X4
XI806 B_0_b3_1 qu26_b3_0 b6_0 VDD VSS XOR2_X1
XI807 dd1_b3_1 qu26_b3_0 b6_1 VDD VSS XOR2_X1
XI808 dd2_b3_1 qu26_b3_0 b6_2 VDD VSS XOR2_X1
XI809 dd3_b3_1 qu26_b3_0 b6_3 VDD VSS XOR2_X1
XI810 dd4_b3_1 qu26_b3_0 b6_4 VDD VSS XOR2_X1
XI811 dd5_b3_1 qu26_b3_0 b6_5 VDD VSS XOR2_X1
XI812 dd6_b3_1 qu26_b3_1 b6_6 VDD VSS XOR2_X1
XI813 dd7_b3_1 qu26_b3_1 b6_7 VDD VSS XOR2_X1
XI814 dd8_b3_1 qu26_b3_1 b6_8 VDD VSS XOR2_X1
XI815 dd9_b3_1 qu26_b3_1 b6_9 VDD VSS XOR2_X1
XI816 dd10_b3_1 qu26_b3_1 b6_10 VDD VSS XOR2_X1
XI817 dd11_b3_1 qu26_b3_1 b6_11 VDD VSS XOR2_X1
XI818 dd12_b3_1 qu26_b3_2 b6_12 VDD VSS XOR2_X1
XI819 dd13_b3_1 qu26_b3_2 b6_13 VDD VSS XOR2_X1
XI820 dd14_b3_1 qu26_b3_2 b6_14 VDD VSS XOR2_X1
XI821 dd15_b3_1 qu26_b3_2 b6_15 VDD VSS XOR2_X1
XI822 dd16_b3_1 qu26_b3_2 b6_16 VDD VSS XOR2_X1
XI823 dd17_b3_1 qu26_b3_2 b6_17 VDD VSS XOR2_X1
XI824 dd18_b3_1 qu26_b3_3 b6_18 VDD VSS XOR2_X1
XI825 dd19_b3_1 qu26_b3_3 b6_19 VDD VSS XOR2_X1
XI826 dd20_b3_1 qu26_b3_3 b6_20 VDD VSS XOR2_X1
XI827 dd21_b3_1 qu26_b3_3 b6_21 VDD VSS XOR2_X1
XI828 dd22_b3_1 qu26_b3_3 b6_22 VDD VSS XOR2_X1
XI829 dd23_b3_1 qu26_b3_3 b6_23 VDD VSS XOR2_X1
XI830 dd24_b3_1 qu26_b3_4 b6_24 VDD VSS XOR2_X1
XI831 dd25_b3_1 qu26_b3_4 b6_25 VDD VSS XOR2_X1
XI832 dd26_b3_1 qu26_b3_4 b6_26 VDD VSS XOR2_X1
XI833 dd27_b3_1 qu26_b3_4 b6_27 VDD VSS XOR2_X1
XI834 dd28_b3_1 qu26_b3_4 b6_28 VDD VSS XOR2_X1
XI835 dd29_b3_1 qu26_b3_4 b6_29 VDD VSS XOR2_X1
XI836 dd30_b3_1 qu26_b3_5 b6_30 VDD VSS XOR2_X1
XI837 dd31_b3_1 qu26_b3_5 b6_31 VDD VSS XOR2_X1
XI838_I0 aa25 b6_0 I838_gn0 VDD VSS NAND2_X1
XI838_I1 p5_0 b6_1 I838_gn1 VDD VSS NAND2_X1
XI838_I2 p5_1 b6_2 I838_gn2 VDD VSS NAND2_X1
XI838_I3 p5_2 b6_3 I838_gn3 VDD VSS NAND2_X1
XI838_I4 p5_3 b6_4 I838_gn4 VDD VSS NAND2_X1
XI838_I5 p5_4 b6_5 I838_gn5 VDD VSS NAND2_X1
XI838_I6 p5_5 b6_6 I838_gn6 VDD VSS NAND2_X1
XI838_I7 p5_6 b6_7 I838_gn7 VDD VSS NAND2_X1
XI838_I8 p5_7 b6_8 I838_gn8 VDD VSS NAND2_X1
XI838_I9 p5_8 b6_9 I838_gn9 VDD VSS NAND2_X1
XI838_I10 p5_9 b6_10 I838_gn10 VDD VSS NAND2_X1
XI838_I11 p5_10 b6_11 I838_gn11 VDD VSS NAND2_X1
XI838_I12 p5_11 b6_12 I838_gn12 VDD VSS NAND2_X1
XI838_I13 p5_12 b6_13 I838_gn13 VDD VSS NAND2_X1
XI838_I14 p5_13 b6_14 I838_gn14 VDD VSS NAND2_X1
XI838_I15 p5_14 b6_15 I838_gn15 VDD VSS NAND2_X1
XI838_I16 p5_15 b6_16 I838_gn16 VDD VSS NAND2_X1
XI838_I17 p5_16 b6_17 I838_gn17 VDD VSS NAND2_X1
XI838_I18 p5_17 b6_18 I838_gn18 VDD VSS NAND2_X1
XI838_I19 p5_18 b6_19 I838_gn19 VDD VSS NAND2_X1
XI838_I20 p5_19 b6_20 I838_gn20 VDD VSS NAND2_X1
XI838_I21 p5_20 b6_21 I838_gn21 VDD VSS NAND2_X1
XI838_I22 p5_21 b6_22 I838_gn22 VDD VSS NAND2_X1
XI838_I23 p5_22 b6_23 I838_gn23 VDD VSS NAND2_X1
XI838_I24 p5_23 b6_24 I838_gn24 VDD VSS NAND2_X1
XI838_I25 p5_24 b6_25 I838_gn25 VDD VSS NAND2_X1
XI838_I26 p5_25 b6_26 I838_gn26 VDD VSS NAND2_X1
XI838_I27 p5_26 b6_27 I838_gn27 VDD VSS NAND2_X1
XI838_I28 p5_27 b6_28 I838_gn28 VDD VSS NAND2_X1
XI838_I29 p5_28 b6_29 I838_gn29 VDD VSS NAND2_X1
XI838_I30 p5_29 b6_30 I838_gn30 VDD VSS NAND2_X1
XI838_I31 p5_30 b6_31 I838_gn31 VDD VSS NAND2_X1
XI838_I32 aa25 b6_0 I838_pn0 VDD VSS XNOR2_X1
XI838_I33 p5_0 b6_1 I838_pn1 VDD VSS XNOR2_X1
XI838_I34 p5_1 b6_2 I838_pn2 VDD VSS XNOR2_X1
XI838_I35 p5_2 b6_3 I838_pn3 VDD VSS XNOR2_X1
XI838_I36 p5_3 b6_4 I838_pn4 VDD VSS XNOR2_X1
XI838_I37 p5_4 b6_5 I838_pn5 VDD VSS XNOR2_X1
XI838_I38 p5_5 b6_6 I838_pn6 VDD VSS XNOR2_X1
XI838_I39 p5_6 b6_7 I838_pn7 VDD VSS XNOR2_X1
XI838_I40 p5_7 b6_8 I838_pn8 VDD VSS XNOR2_X1
XI838_I41 p5_8 b6_9 I838_pn9 VDD VSS XNOR2_X1
XI838_I42 p5_9 b6_10 I838_pn10 VDD VSS XNOR2_X1
XI838_I43 p5_10 b6_11 I838_pn11 VDD VSS XNOR2_X1
XI838_I44 p5_11 b6_12 I838_pn12 VDD VSS XNOR2_X1
XI838_I45 p5_12 b6_13 I838_pn13 VDD VSS XNOR2_X1
XI838_I46 p5_13 b6_14 I838_pn14 VDD VSS XNOR2_X1
XI838_I47 p5_14 b6_15 I838_pn15 VDD VSS XNOR2_X1
XI838_I48 p5_15 b6_16 I838_pn16 VDD VSS XNOR2_X1
XI838_I49 p5_16 b6_17 I838_pn17 VDD VSS XNOR2_X1
XI838_I50 p5_17 b6_18 I838_pn18 VDD VSS XNOR2_X1
XI838_I51 p5_18 b6_19 I838_pn19 VDD VSS XNOR2_X1
XI838_I52 p5_19 b6_20 I838_pn20 VDD VSS XNOR2_X1
XI838_I53 p5_20 b6_21 I838_pn21 VDD VSS XNOR2_X1
XI838_I54 p5_21 b6_22 I838_pn22 VDD VSS XNOR2_X1
XI838_I55 p5_22 b6_23 I838_pn23 VDD VSS XNOR2_X1
XI838_I56 p5_23 b6_24 I838_pn24 VDD VSS XNOR2_X1
XI838_I57 p5_24 b6_25 I838_pn25 VDD VSS XNOR2_X1
XI838_I58 p5_25 b6_26 I838_pn26 VDD VSS XNOR2_X1
XI838_I59 p5_26 b6_27 I838_pn27 VDD VSS XNOR2_X1
XI838_I60 p5_27 b6_28 I838_pn28 VDD VSS XNOR2_X1
XI838_I61 p5_28 b6_29 I838_pn29 VDD VSS XNOR2_X1
XI838_I62 p5_29 b6_30 I838_pn30 VDD VSS XNOR2_X1
XI838_I63 p5_30 b6_31 I838_pn31 VDD VSS XNOR2_X1
XI838_I64 qu26_b3_5 I838_cinn VDD VSS INV_X1
XI838_I65_XG I838_pn0 I838_cinn I838_gn0 I838_G0_0 VDD VSS OAI21_X1
XI838_I66 I838_G0_0 I838_G0_0n VDD VSS INV_X1
XI838_I67_XG I838_pn1 I838_G0_0n I838_gn1 I838_G1_0 VDD VSS OAI21_X1
XI838_I68_XG I838_pn2 I838_gn1 I838_gn2 I838_G2_1 VDD VSS OAI21_X1
XI838_I68_XP I838_pn2 I838_pn1 I838_P2_1 VDD VSS NOR2_X1
XI838_I69_XG I838_pn3 I838_gn2 I838_gn3 I838_G3_2 VDD VSS OAI21_X1
XI838_I69_XP I838_pn3 I838_pn2 I838_P3_2 VDD VSS NOR2_X1
XI838_I70_XG I838_pn4 I838_gn3 I838_gn4 I838_G4_3 VDD VSS OAI21_X1
XI838_I70_XP I838_pn4 I838_pn3 I838_P4_3 VDD VSS NOR2_X1
XI838_I71_XG I838_pn5 I838_gn4 I838_gn5 I838_G5_4 VDD VSS OAI21_X1
XI838_I71_XP I838_pn5 I838_pn4 I838_P5_4 VDD VSS NOR2_X1
XI838_I72_XG I838_pn6 I838_gn5 I838_gn6 I838_G6_5 VDD VSS OAI21_X1
XI838_I72_XP I838_pn6 I838_pn5 I838_P6_5 VDD VSS NOR2_X1
XI838_I73_XG I838_pn7 I838_gn6 I838_gn7 I838_G7_6 VDD VSS OAI21_X1
XI838_I73_XP I838_pn7 I838_pn6 I838_P7_6 VDD VSS NOR2_X1
XI838_I74_XG I838_pn8 I838_gn7 I838_gn8 I838_G8_7 VDD VSS OAI21_X1
XI838_I74_XP I838_pn8 I838_pn7 I838_P8_7 VDD VSS NOR2_X1
XI838_I75_XG I838_pn9 I838_gn8 I838_gn9 I838_G9_8 VDD VSS OAI21_X1
XI838_I75_XP I838_pn9 I838_pn8 I838_P9_8 VDD VSS NOR2_X1
XI838_I76_XG I838_pn10 I838_gn9 I838_gn10 I838_G10_9 VDD VSS OAI21_X1
XI838_I76_XP I838_pn10 I838_pn9 I838_P10_9 VDD VSS NOR2_X1
XI838_I77_XG I838_pn11 I838_gn10 I838_gn11 I838_G11_10 VDD VSS OAI21_X1
XI838_I77_XP I838_pn11 I838_pn10 I838_P11_10 VDD VSS NOR2_X1
XI838_I78_XG I838_pn12 I838_gn11 I838_gn12 I838_G12_11 VDD VSS OAI21_X1
XI838_I78_XP I838_pn12 I838_pn11 I838_P12_11 VDD VSS NOR2_X1
XI838_I79_XG I838_pn13 I838_gn12 I838_gn13 I838_G13_12 VDD VSS OAI21_X1
XI838_I79_XP I838_pn13 I838_pn12 I838_P13_12 VDD VSS NOR2_X1
XI838_I80_XG I838_pn14 I838_gn13 I838_gn14 I838_G14_13 VDD VSS OAI21_X1
XI838_I80_XP I838_pn14 I838_pn13 I838_P14_13 VDD VSS NOR2_X1
XI838_I81_XG I838_pn15 I838_gn14 I838_gn15 I838_G15_14 VDD VSS OAI21_X1
XI838_I81_XP I838_pn15 I838_pn14 I838_P15_14 VDD VSS NOR2_X1
XI838_I82_XG I838_pn16 I838_gn15 I838_gn16 I838_G16_15 VDD VSS OAI21_X1
XI838_I82_XP I838_pn16 I838_pn15 I838_P16_15 VDD VSS NOR2_X1
XI838_I83_XG I838_pn17 I838_gn16 I838_gn17 I838_G17_16 VDD VSS OAI21_X1
XI838_I83_XP I838_pn17 I838_pn16 I838_P17_16 VDD VSS NOR2_X1
XI838_I84_XG I838_pn18 I838_gn17 I838_gn18 I838_G18_17 VDD VSS OAI21_X1
XI838_I84_XP I838_pn18 I838_pn17 I838_P18_17 VDD VSS NOR2_X1
XI838_I85_XG I838_pn19 I838_gn18 I838_gn19 I838_G19_18 VDD VSS OAI21_X1
XI838_I85_XP I838_pn19 I838_pn18 I838_P19_18 VDD VSS NOR2_X1
XI838_I86_XG I838_pn20 I838_gn19 I838_gn20 I838_G20_19 VDD VSS OAI21_X1
XI838_I86_XP I838_pn20 I838_pn19 I838_P20_19 VDD VSS NOR2_X1
XI838_I87_XG I838_pn21 I838_gn20 I838_gn21 I838_G21_20 VDD VSS OAI21_X1
XI838_I87_XP I838_pn21 I838_pn20 I838_P21_20 VDD VSS NOR2_X1
XI838_I88_XG I838_pn22 I838_gn21 I838_gn22 I838_G22_21 VDD VSS OAI21_X1
XI838_I88_XP I838_pn22 I838_pn21 I838_P22_21 VDD VSS NOR2_X1
XI838_I89_XG I838_pn23 I838_gn22 I838_gn23 I838_G23_22 VDD VSS OAI21_X1
XI838_I89_XP I838_pn23 I838_pn22 I838_P23_22 VDD VSS NOR2_X1
XI838_I90_XG I838_pn24 I838_gn23 I838_gn24 I838_G24_23 VDD VSS OAI21_X1
XI838_I90_XP I838_pn24 I838_pn23 I838_P24_23 VDD VSS NOR2_X1
XI838_I91_XG I838_pn25 I838_gn24 I838_gn25 I838_G25_24 VDD VSS OAI21_X1
XI838_I91_XP I838_pn25 I838_pn24 I838_P25_24 VDD VSS NOR2_X1
XI838_I92_XG I838_pn26 I838_gn25 I838_gn26 I838_G26_25 VDD VSS OAI21_X1
XI838_I92_XP I838_pn26 I838_pn25 I838_P26_25 VDD VSS NOR2_X1
XI838_I93_XG I838_pn27 I838_gn26 I838_gn27 I838_G27_26 VDD VSS OAI21_X1
XI838_I93_XP I838_pn27 I838_pn26 I838_P27_26 VDD VSS NOR2_X1
XI838_I94_XG I838_pn28 I838_gn27 I838_gn28 I838_G28_27 VDD VSS OAI21_X1
XI838_I94_XP I838_pn28 I838_pn27 I838_P28_27 VDD VSS NOR2_X1
XI838_I95_XG I838_pn29 I838_gn28 I838_gn29 I838_G29_28 VDD VSS OAI21_X1
XI838_I95_XP I838_pn29 I838_pn28 I838_P29_28 VDD VSS NOR2_X1
XI838_I96_XG I838_pn30 I838_gn29 I838_gn30 I838_G30_29 VDD VSS OAI21_X1
XI838_I96_XP I838_pn30 I838_pn29 I838_P30_29 VDD VSS NOR2_X1
XI838_I97_XG I838_pn31 I838_gn30 I838_gn31 I838_G31_30 VDD VSS OAI21_X1
XI838_I97_XP I838_pn31 I838_pn30 I838_P31_30 VDD VSS NOR2_X1
XI838_I98_XG I838_P2_1 I838_G0_0 I838_G2_1 I838_G2_0n VDD VSS AOI21_X1
XI838_I99_XG I838_P3_2 I838_G1_0 I838_G3_2 I838_G3_0n VDD VSS AOI21_X1
XI838_I100_XG I838_P4_3 I838_G2_1 I838_G4_3 I838_G4_1n VDD VSS AOI21_X1
XI838_I100_XP I838_P4_3 I838_P2_1 I838_P4_1n VDD VSS NAND2_X1
XI838_I101_XG I838_P5_4 I838_G3_2 I838_G5_4 I838_G5_2n VDD VSS AOI21_X1
XI838_I101_XP I838_P5_4 I838_P3_2 I838_P5_2n VDD VSS NAND2_X1
XI838_I102_XG I838_P6_5 I838_G4_3 I838_G6_5 I838_G6_3n VDD VSS AOI21_X1
XI838_I102_XP I838_P6_5 I838_P4_3 I838_P6_3n VDD VSS NAND2_X1
XI838_I103_XG I838_P7_6 I838_G5_4 I838_G7_6 I838_G7_4n VDD VSS AOI21_X1
XI838_I103_XP I838_P7_6 I838_P5_4 I838_P7_4n VDD VSS NAND2_X1
XI838_I104_XG I838_P8_7 I838_G6_5 I838_G8_7 I838_G8_5n VDD VSS AOI21_X1
XI838_I104_XP I838_P8_7 I838_P6_5 I838_P8_5n VDD VSS NAND2_X1
XI838_I105_XG I838_P9_8 I838_G7_6 I838_G9_8 I838_G9_6n VDD VSS AOI21_X1
XI838_I105_XP I838_P9_8 I838_P7_6 I838_P9_6n VDD VSS NAND2_X1
XI838_I106_XG I838_P10_9 I838_G8_7 I838_G10_9 I838_G10_7n VDD VSS AOI21_X1
XI838_I106_XP I838_P10_9 I838_P8_7 I838_P10_7n VDD VSS NAND2_X1
XI838_I107_XG I838_P11_10 I838_G9_8 I838_G11_10 I838_G11_8n VDD VSS AOI21_X1
XI838_I107_XP I838_P11_10 I838_P9_8 I838_P11_8n VDD VSS NAND2_X1
XI838_I108_XG I838_P12_11 I838_G10_9 I838_G12_11 I838_G12_9n VDD VSS AOI21_X1
XI838_I108_XP I838_P12_11 I838_P10_9 I838_P12_9n VDD VSS NAND2_X1
XI838_I109_XG I838_P13_12 I838_G11_10 I838_G13_12 I838_G13_10n VDD VSS AOI21_X1
XI838_I109_XP I838_P13_12 I838_P11_10 I838_P13_10n VDD VSS NAND2_X1
XI838_I110_XG I838_P14_13 I838_G12_11 I838_G14_13 I838_G14_11n VDD VSS AOI21_X1
XI838_I110_XP I838_P14_13 I838_P12_11 I838_P14_11n VDD VSS NAND2_X1
XI838_I111_XG I838_P15_14 I838_G13_12 I838_G15_14 I838_G15_12n VDD VSS AOI21_X1
XI838_I111_XP I838_P15_14 I838_P13_12 I838_P15_12n VDD VSS NAND2_X1
XI838_I112_XG I838_P16_15 I838_G14_13 I838_G16_15 I838_G16_13n VDD VSS AOI21_X1
XI838_I112_XP I838_P16_15 I838_P14_13 I838_P16_13n VDD VSS NAND2_X1
XI838_I113_XG I838_P17_16 I838_G15_14 I838_G17_16 I838_G17_14n VDD VSS AOI21_X1
XI838_I113_XP I838_P17_16 I838_P15_14 I838_P17_14n VDD VSS NAND2_X1
XI838_I114_XG I838_P18_17 I838_G16_15 I838_G18_17 I838_G18_15n VDD VSS AOI21_X1
XI838_I114_XP I838_P18_17 I838_P16_15 I838_P18_15n VDD VSS NAND2_X1
XI838_I115_XG I838_P19_18 I838_G17_16 I838_G19_18 I838_G19_16n VDD VSS AOI21_X1
XI838_I115_XP I838_P19_18 I838_P17_16 I838_P19_16n VDD VSS NAND2_X1
XI838_I116_XG I838_P20_19 I838_G18_17 I838_G20_19 I838_G20_17n VDD VSS AOI21_X1
XI838_I116_XP I838_P20_19 I838_P18_17 I838_P20_17n VDD VSS NAND2_X1
XI838_I117_XG I838_P21_20 I838_G19_18 I838_G21_20 I838_G21_18n VDD VSS AOI21_X1
XI838_I117_XP I838_P21_20 I838_P19_18 I838_P21_18n VDD VSS NAND2_X1
XI838_I118_XG I838_P22_21 I838_G20_19 I838_G22_21 I838_G22_19n VDD VSS AOI21_X1
XI838_I118_XP I838_P22_21 I838_P20_19 I838_P22_19n VDD VSS NAND2_X1
XI838_I119_XG I838_P23_22 I838_G21_20 I838_G23_22 I838_G23_20n VDD VSS AOI21_X1
XI838_I119_XP I838_P23_22 I838_P21_20 I838_P23_20n VDD VSS NAND2_X1
XI838_I120_XG I838_P24_23 I838_G22_21 I838_G24_23 I838_G24_21n VDD VSS AOI21_X1
XI838_I120_XP I838_P24_23 I838_P22_21 I838_P24_21n VDD VSS NAND2_X1
XI838_I121_XG I838_P25_24 I838_G23_22 I838_G25_24 I838_G25_22n VDD VSS AOI21_X1
XI838_I121_XP I838_P25_24 I838_P23_22 I838_P25_22n VDD VSS NAND2_X1
XI838_I122_XG I838_P26_25 I838_G24_23 I838_G26_25 I838_G26_23n VDD VSS AOI21_X1
XI838_I122_XP I838_P26_25 I838_P24_23 I838_P26_23n VDD VSS NAND2_X1
XI838_I123_XG I838_P27_26 I838_G25_24 I838_G27_26 I838_G27_24n VDD VSS AOI21_X1
XI838_I123_XP I838_P27_26 I838_P25_24 I838_P27_24n VDD VSS NAND2_X1
XI838_I124_XG I838_P28_27 I838_G26_25 I838_G28_27 I838_G28_25n VDD VSS AOI21_X1
XI838_I124_XP I838_P28_27 I838_P26_25 I838_P28_25n VDD VSS NAND2_X1
XI838_I125_XG I838_P29_28 I838_G27_26 I838_G29_28 I838_G29_26n VDD VSS AOI21_X1
XI838_I125_XP I838_P29_28 I838_P27_26 I838_P29_26n VDD VSS NAND2_X1
XI838_I126_XG I838_P30_29 I838_G28_27 I838_G30_29 I838_G30_27n VDD VSS AOI21_X1
XI838_I126_XP I838_P30_29 I838_P28_27 I838_P30_27n VDD VSS NAND2_X1
XI838_I127_XG I838_P31_30 I838_G29_28 I838_G31_30 I838_G31_28n VDD VSS AOI21_X1
XI838_I127_XP I838_P31_30 I838_P29_28 I838_P31_28n VDD VSS NAND2_X1
XI838_I128_XG I838_P4_1n I838_G0_0n I838_G4_1n I838_G4_0 VDD VSS OAI21_X1
XI838_I129 I838_G1_0 I838_G1_0n VDD VSS INV_X1
XI838_I130_XG I838_P5_2n I838_G1_0n I838_G5_2n I838_G5_0 VDD VSS OAI21_X1
XI838_I131_XG I838_P6_3n I838_G2_0n I838_G6_3n I838_G6_0 VDD VSS OAI21_X1
XI838_I132_XG I838_P7_4n I838_G3_0n I838_G7_4n I838_G7_0 VDD VSS OAI21_X1
XI838_I133_XG I838_P8_5n I838_G4_1n I838_G8_5n I838_G8_1 VDD VSS OAI21_X1
XI838_I133_XP I838_P8_5n I838_P4_1n I838_P8_1 VDD VSS NOR2_X1
XI838_I134_XG I838_P9_6n I838_G5_2n I838_G9_6n I838_G9_2 VDD VSS OAI21_X1
XI838_I134_XP I838_P9_6n I838_P5_2n I838_P9_2 VDD VSS NOR2_X1
XI838_I135_XG I838_P10_7n I838_G6_3n I838_G10_7n I838_G10_3 VDD VSS OAI21_X1
XI838_I135_XP I838_P10_7n I838_P6_3n I838_P10_3 VDD VSS NOR2_X1
XI838_I136_XG I838_P11_8n I838_G7_4n I838_G11_8n I838_G11_4 VDD VSS OAI21_X1
XI838_I136_XP I838_P11_8n I838_P7_4n I838_P11_4 VDD VSS NOR2_X1
XI838_I137_XG I838_P12_9n I838_G8_5n I838_G12_9n I838_G12_5 VDD VSS OAI21_X1
XI838_I137_XP I838_P12_9n I838_P8_5n I838_P12_5 VDD VSS NOR2_X1
XI838_I138_XG I838_P13_10n I838_G9_6n I838_G13_10n I838_G13_6 VDD VSS OAI21_X1
XI838_I138_XP I838_P13_10n I838_P9_6n I838_P13_6 VDD VSS NOR2_X1
XI838_I139_XG I838_P14_11n I838_G10_7n I838_G14_11n I838_G14_7 VDD VSS OAI21_X1
XI838_I139_XP I838_P14_11n I838_P10_7n I838_P14_7 VDD VSS NOR2_X1
XI838_I140_XG I838_P15_12n I838_G11_8n I838_G15_12n I838_G15_8 VDD VSS OAI21_X1
XI838_I140_XP I838_P15_12n I838_P11_8n I838_P15_8 VDD VSS NOR2_X1
XI838_I141_XG I838_P16_13n I838_G12_9n I838_G16_13n I838_G16_9 VDD VSS OAI21_X1
XI838_I141_XP I838_P16_13n I838_P12_9n I838_P16_9 VDD VSS NOR2_X1
XI838_I142_XG I838_P17_14n I838_G13_10n I838_G17_14n I838_G17_10 VDD VSS OAI21_X1
XI838_I142_XP I838_P17_14n I838_P13_10n I838_P17_10 VDD VSS NOR2_X1
XI838_I143_XG I838_P18_15n I838_G14_11n I838_G18_15n I838_G18_11 VDD VSS OAI21_X1
XI838_I143_XP I838_P18_15n I838_P14_11n I838_P18_11 VDD VSS NOR2_X1
XI838_I144_XG I838_P19_16n I838_G15_12n I838_G19_16n I838_G19_12 VDD VSS OAI21_X1
XI838_I144_XP I838_P19_16n I838_P15_12n I838_P19_12 VDD VSS NOR2_X1
XI838_I145_XG I838_P20_17n I838_G16_13n I838_G20_17n I838_G20_13 VDD VSS OAI21_X1
XI838_I145_XP I838_P20_17n I838_P16_13n I838_P20_13 VDD VSS NOR2_X1
XI838_I146_XG I838_P21_18n I838_G17_14n I838_G21_18n I838_G21_14 VDD VSS OAI21_X1
XI838_I146_XP I838_P21_18n I838_P17_14n I838_P21_14 VDD VSS NOR2_X1
XI838_I147_XG I838_P22_19n I838_G18_15n I838_G22_19n I838_G22_15 VDD VSS OAI21_X1
XI838_I147_XP I838_P22_19n I838_P18_15n I838_P22_15 VDD VSS NOR2_X1
XI838_I148_XG I838_P23_20n I838_G19_16n I838_G23_20n I838_G23_16 VDD VSS OAI21_X1
XI838_I148_XP I838_P23_20n I838_P19_16n I838_P23_16 VDD VSS NOR2_X1
XI838_I149_XG I838_P24_21n I838_G20_17n I838_G24_21n I838_G24_17 VDD VSS OAI21_X1
XI838_I149_XP I838_P24_21n I838_P20_17n I838_P24_17 VDD VSS NOR2_X1
XI838_I150_XG I838_P25_22n I838_G21_18n I838_G25_22n I838_G25_18 VDD VSS OAI21_X1
XI838_I150_XP I838_P25_22n I838_P21_18n I838_P25_18 VDD VSS NOR2_X1
XI838_I151_XG I838_P26_23n I838_G22_19n I838_G26_23n I838_G26_19 VDD VSS OAI21_X1
XI838_I151_XP I838_P26_23n I838_P22_19n I838_P26_19 VDD VSS NOR2_X1
XI838_I152_XG I838_P27_24n I838_G23_20n I838_G27_24n I838_G27_20 VDD VSS OAI21_X1
XI838_I152_XP I838_P27_24n I838_P23_20n I838_P27_20 VDD VSS NOR2_X1
XI838_I153_XG I838_P28_25n I838_G24_21n I838_G28_25n I838_G28_21 VDD VSS OAI21_X1
XI838_I153_XP I838_P28_25n I838_P24_21n I838_P28_21 VDD VSS NOR2_X1
XI838_I154_XG I838_P29_26n I838_G25_22n I838_G29_26n I838_G29_22 VDD VSS OAI21_X1
XI838_I154_XP I838_P29_26n I838_P25_22n I838_P29_22 VDD VSS NOR2_X1
XI838_I155_XG I838_P30_27n I838_G26_23n I838_G30_27n I838_G30_23 VDD VSS OAI21_X1
XI838_I155_XP I838_P30_27n I838_P26_23n I838_P30_23 VDD VSS NOR2_X1
XI838_I156_XG I838_P31_28n I838_G27_24n I838_G31_28n I838_G31_24 VDD VSS OAI21_X1
XI838_I156_XP I838_P31_28n I838_P27_24n I838_P31_24 VDD VSS NOR2_X1
XI838_I157_XG I838_P8_1 I838_G0_0 I838_G8_1 I838_G8_0n VDD VSS AOI21_X1
XI838_I158_XG I838_P9_2 I838_G1_0 I838_G9_2 I838_G9_0n VDD VSS AOI21_X1
XI838_I159 I838_G2_0n I838_G2_0np VDD VSS INV_X1
XI838_I160_XG I838_P10_3 I838_G2_0np I838_G10_3 I838_G10_0n VDD VSS AOI21_X1
XI838_I161 I838_G3_0n I838_G3_0np VDD VSS INV_X1
XI838_I162_XG I838_P11_4 I838_G3_0np I838_G11_4 I838_G11_0n VDD VSS AOI21_X1
XI838_I163_XG I838_P12_5 I838_G4_0 I838_G12_5 I838_G12_0n VDD VSS AOI21_X1
XI838_I164_XG I838_P13_6 I838_G5_0 I838_G13_6 I838_G13_0n VDD VSS AOI21_X1
XI838_I165_XG I838_P14_7 I838_G6_0 I838_G14_7 I838_G14_0n VDD VSS AOI21_X1
XI838_I166_XG I838_P15_8 I838_G7_0 I838_G15_8 I838_G15_0n VDD VSS AOI21_X1
XI838_I167_XG I838_P16_9 I838_G8_1 I838_G16_9 I838_G16_1n VDD VSS AOI21_X1
XI838_I167_XP I838_P16_9 I838_P8_1 I838_P16_1n VDD VSS NAND2_X1
XI838_I168_XG I838_P17_10 I838_G9_2 I838_G17_10 I838_G17_2n VDD VSS AOI21_X1
XI838_I168_XP I838_P17_10 I838_P9_2 I838_P17_2n VDD VSS NAND2_X1
XI838_I169_XG I838_P18_11 I838_G10_3 I838_G18_11 I838_G18_3n VDD VSS AOI21_X1
XI838_I169_XP I838_P18_11 I838_P10_3 I838_P18_3n VDD VSS NAND2_X1
XI838_I170_XG I838_P19_12 I838_G11_4 I838_G19_12 I838_G19_4n VDD VSS AOI21_X1
XI838_I170_XP I838_P19_12 I838_P11_4 I838_P19_4n VDD VSS NAND2_X1
XI838_I171_XG I838_P20_13 I838_G12_5 I838_G20_13 I838_G20_5n VDD VSS AOI21_X1
XI838_I171_XP I838_P20_13 I838_P12_5 I838_P20_5n VDD VSS NAND2_X1
XI838_I172_XG I838_P21_14 I838_G13_6 I838_G21_14 I838_G21_6n VDD VSS AOI21_X1
XI838_I172_XP I838_P21_14 I838_P13_6 I838_P21_6n VDD VSS NAND2_X1
XI838_I173_XG I838_P22_15 I838_G14_7 I838_G22_15 I838_G22_7n VDD VSS AOI21_X1
XI838_I173_XP I838_P22_15 I838_P14_7 I838_P22_7n VDD VSS NAND2_X1
XI838_I174_XG I838_P23_16 I838_G15_8 I838_G23_16 I838_G23_8n VDD VSS AOI21_X1
XI838_I174_XP I838_P23_16 I838_P15_8 I838_P23_8n VDD VSS NAND2_X1
XI838_I175_XG I838_P24_17 I838_G16_9 I838_G24_17 I838_G24_9n VDD VSS AOI21_X1
XI838_I175_XP I838_P24_17 I838_P16_9 I838_P24_9n VDD VSS NAND2_X1
XI838_I176_XG I838_P25_18 I838_G17_10 I838_G25_18 I838_G25_10n VDD VSS AOI21_X1
XI838_I176_XP I838_P25_18 I838_P17_10 I838_P25_10n VDD VSS NAND2_X1
XI838_I177_XG I838_P26_19 I838_G18_11 I838_G26_19 I838_G26_11n VDD VSS AOI21_X1
XI838_I177_XP I838_P26_19 I838_P18_11 I838_P26_11n VDD VSS NAND2_X1
XI838_I178_XG I838_P27_20 I838_G19_12 I838_G27_20 I838_G27_12n VDD VSS AOI21_X1
XI838_I178_XP I838_P27_20 I838_P19_12 I838_P27_12n VDD VSS NAND2_X1
XI838_I179_XG I838_P28_21 I838_G20_13 I838_G28_21 I838_G28_13n VDD VSS AOI21_X1
XI838_I179_XP I838_P28_21 I838_P20_13 I838_P28_13n VDD VSS NAND2_X1
XI838_I180_XG I838_P29_22 I838_G21_14 I838_G29_22 I838_G29_14n VDD VSS AOI21_X1
XI838_I180_XP I838_P29_22 I838_P21_14 I838_P29_14n VDD VSS NAND2_X1
XI838_I181_XG I838_P30_23 I838_G22_15 I838_G30_23 I838_G30_15n VDD VSS AOI21_X1
XI838_I181_XP I838_P30_23 I838_P22_15 I838_P30_15n VDD VSS NAND2_X1
XI838_I182_XG I838_P31_24 I838_G23_16 I838_G31_24 I838_G31_16n VDD VSS AOI21_X1
XI838_I182_XP I838_P31_24 I838_P23_16 I838_P31_16n VDD VSS NAND2_X1
XI838_I183_XG I838_P16_1n I838_G0_0n I838_G16_1n I838_G16_0 VDD VSS OAI21_X1
XI838_I184_XG I838_P17_2n I838_G1_0n I838_G17_2n I838_G17_0 VDD VSS OAI21_X1
XI838_I185_XG I838_P18_3n I838_G2_0n I838_G18_3n I838_G18_0 VDD VSS OAI21_X1
XI838_I186_XG I838_P19_4n I838_G3_0n I838_G19_4n I838_G19_0 VDD VSS OAI21_X1
XI838_I187 I838_G4_0 I838_G4_0n VDD VSS INV_X1
XI838_I188_XG I838_P20_5n I838_G4_0n I838_G20_5n I838_G20_0 VDD VSS OAI21_X1
XI838_I189 I838_G5_0 I838_G5_0n VDD VSS INV_X1
XI838_I190_XG I838_P21_6n I838_G5_0n I838_G21_6n I838_G21_0 VDD VSS OAI21_X1
XI838_I191 I838_G6_0 I838_G6_0n VDD VSS INV_X1
XI838_I192_XG I838_P22_7n I838_G6_0n I838_G22_7n I838_G22_0 VDD VSS OAI21_X1
XI838_I193 I838_G7_0 I838_G7_0n VDD VSS INV_X1
XI838_I194_XG I838_P23_8n I838_G7_0n I838_G23_8n I838_G23_0 VDD VSS OAI21_X1
XI838_I195_XG I838_P24_9n I838_G8_0n I838_G24_9n I838_G24_0 VDD VSS OAI21_X1
XI838_I196_XG I838_P25_10n I838_G9_0n I838_G25_10n I838_G25_0 VDD VSS OAI21_X1
XI838_I197_XG I838_P26_11n I838_G10_0n I838_G26_11n I838_G26_0 VDD VSS OAI21_X1
XI838_I198_XG I838_P27_12n I838_G11_0n I838_G27_12n I838_G27_0 VDD VSS OAI21_X1
XI838_I199_XG I838_P28_13n I838_G12_0n I838_G28_13n I838_G28_0 VDD VSS OAI21_X1
XI838_I200_XG I838_P29_14n I838_G13_0n I838_G29_14n I838_G29_0 VDD VSS OAI21_X1
XI838_I201_XG I838_P30_15n I838_G14_0n I838_G30_15n c6_m VDD VSS OAI21_X1
XI838_I202_XG I838_P31_16n I838_G15_0n I838_G31_16n c6_o VDD VSS OAI21_X1
XI838_I203 I838_pn0 qu26_b3_5 p6_0 VDD VSS XNOR2_X1
XI838_I204 I838_pn1 I838_G0_0 p6_1 VDD VSS XNOR2_X1
XI838_I205 I838_pn2 I838_G1_0 p6_2 VDD VSS XNOR2_X1
XI838_I206 I838_pn3 I838_G2_0n p6_3 VDD VSS XOR2_X1
XI838_I207 I838_pn4 I838_G3_0n p6_4 VDD VSS XOR2_X1
XI838_I208 I838_pn5 I838_G4_0 p6_5 VDD VSS XNOR2_X1
XI838_I209 I838_pn6 I838_G5_0 p6_6 VDD VSS XNOR2_X1
XI838_I210 I838_pn7 I838_G6_0 p6_7 VDD VSS XNOR2_X1
XI838_I211 I838_pn8 I838_G7_0 p6_8 VDD VSS XNOR2_X1
XI838_I212 I838_pn9 I838_G8_0n p6_9 VDD VSS XOR2_X1
XI838_I213 I838_pn10 I838_G9_0n p6_10 VDD VSS XOR2_X1
XI838_I214 I838_pn11 I838_G10_0n p6_11 VDD VSS XOR2_X1
XI838_I215 I838_pn12 I838_G11_0n p6_12 VDD VSS XOR2_X1
XI838_I216 I838_pn13 I838_G12_0n p6_13 VDD VSS XOR2_X1
XI838_I217 I838_pn14 I838_G13_0n p6_14 VDD VSS XOR2_X1
XI838_I218 I838_pn15 I838_G14_0n p6_15 VDD VSS XOR2_X1
XI838_I219 I838_pn16 I838_G15_0n p6_16 VDD VSS XOR2_X1
XI838_I220 I838_pn17 I838_G16_0 p6_17 VDD VSS XNOR2_X1
XI838_I221 I838_pn18 I838_G17_0 p6_18 VDD VSS XNOR2_X1
XI838_I222 I838_pn19 I838_G18_0 p6_19 VDD VSS XNOR2_X1
XI838_I223 I838_pn20 I838_G19_0 p6_20 VDD VSS XNOR2_X1
XI838_I224 I838_pn21 I838_G20_0 p6_21 VDD VSS XNOR2_X1
XI838_I225 I838_pn22 I838_G21_0 p6_22 VDD VSS XNOR2_X1
XI838_I226 I838_pn23 I838_G22_0 p6_23 VDD VSS XNOR2_X1
XI838_I227 I838_pn24 I838_G23_0 p6_24 VDD VSS XNOR2_X1
XI838_I228 I838_pn25 I838_G24_0 p6_25 VDD VSS XNOR2_X1
XI838_I229 I838_pn26 I838_G25_0 p6_26 VDD VSS XNOR2_X1
XI838_I230 I838_pn27 I838_G26_0 p6_27 VDD VSS XNOR2_X1
XI838_I231 I838_pn28 I838_G27_0 p6_28 VDD VSS XNOR2_X1
XI838_I232 I838_pn29 I838_G28_0 p6_29 VDD VSS XNOR2_X1
XI838_I233 I838_pn30 I838_G29_0 p6_30 VDD VSS XNOR2_X1
XI838_I234 I838_pn31 c6_m p6_31 VDD VSS XNOR2_X1
XI839 p5_31 qu26_b3_5 h6 VDD VSS XOR2_X1
XI840 h6 c6_o p6_32 VDD VSS XOR2_X1
XI841 p6_32 qu25 VDD VSS INV_X4
XI842 qu25 qu25_b0 VDD VSS INV_X1
XI843 qu25_b0 qu25_b1_0 VDD VSS INV_X4
XI844 qu25_b1_0 qu25_b2_0 VDD VSS INV_X4
XI845 qu25_b1_0 qu25_b2_1 VDD VSS INV_X4
XI846 qu25_b2_0 qu25_b3_0 VDD VSS INV_X4
XI847 qu25_b2_0 qu25_b3_1 VDD VSS INV_X4
XI848 qu25_b2_0 qu25_b3_2 VDD VSS INV_X4
XI849 qu25_b2_1 qu25_b3_3 VDD VSS INV_X4
XI850 qu25_b2_1 qu25_b3_4 VDD VSS INV_X4
XI851 qu25_b2_1 qu25_b3_5 VDD VSS INV_X4
XI852 B_0_b3_1 qu25_b3_0 b7_0 VDD VSS XOR2_X1
XI853 dd1_b3_1 qu25_b3_0 b7_1 VDD VSS XOR2_X1
XI854 dd2_b3_1 qu25_b3_0 b7_2 VDD VSS XOR2_X1
XI855 dd3_b3_1 qu25_b3_0 b7_3 VDD VSS XOR2_X1
XI856 dd4_b3_1 qu25_b3_0 b7_4 VDD VSS XOR2_X1
XI857 dd5_b3_1 qu25_b3_0 b7_5 VDD VSS XOR2_X1
XI858 dd6_b3_1 qu25_b3_1 b7_6 VDD VSS XOR2_X1
XI859 dd7_b3_1 qu25_b3_1 b7_7 VDD VSS XOR2_X1
XI860 dd8_b3_1 qu25_b3_1 b7_8 VDD VSS XOR2_X1
XI861 dd9_b3_1 qu25_b3_1 b7_9 VDD VSS XOR2_X1
XI862 dd10_b3_1 qu25_b3_1 b7_10 VDD VSS XOR2_X1
XI863 dd11_b3_1 qu25_b3_1 b7_11 VDD VSS XOR2_X1
XI864 dd12_b3_1 qu25_b3_2 b7_12 VDD VSS XOR2_X1
XI865 dd13_b3_1 qu25_b3_2 b7_13 VDD VSS XOR2_X1
XI866 dd14_b3_1 qu25_b3_2 b7_14 VDD VSS XOR2_X1
XI867 dd15_b3_1 qu25_b3_2 b7_15 VDD VSS XOR2_X1
XI868 dd16_b3_1 qu25_b3_2 b7_16 VDD VSS XOR2_X1
XI869 dd17_b3_1 qu25_b3_2 b7_17 VDD VSS XOR2_X1
XI870 dd18_b3_1 qu25_b3_3 b7_18 VDD VSS XOR2_X1
XI871 dd19_b3_1 qu25_b3_3 b7_19 VDD VSS XOR2_X1
XI872 dd20_b3_1 qu25_b3_3 b7_20 VDD VSS XOR2_X1
XI873 dd21_b3_1 qu25_b3_3 b7_21 VDD VSS XOR2_X1
XI874 dd22_b3_1 qu25_b3_3 b7_22 VDD VSS XOR2_X1
XI875 dd23_b3_1 qu25_b3_3 b7_23 VDD VSS XOR2_X1
XI876 dd24_b3_1 qu25_b3_4 b7_24 VDD VSS XOR2_X1
XI877 dd25_b3_1 qu25_b3_4 b7_25 VDD VSS XOR2_X1
XI878 dd26_b3_1 qu25_b3_4 b7_26 VDD VSS XOR2_X1
XI879 dd27_b3_1 qu25_b3_4 b7_27 VDD VSS XOR2_X1
XI880 dd28_b3_1 qu25_b3_4 b7_28 VDD VSS XOR2_X1
XI881 dd29_b3_1 qu25_b3_4 b7_29 VDD VSS XOR2_X1
XI882 dd30_b3_1 qu25_b3_5 b7_30 VDD VSS XOR2_X1
XI883 dd31_b3_1 qu25_b3_5 b7_31 VDD VSS XOR2_X1
XI884_I0 aa24 b7_0 I884_gn0 VDD VSS NAND2_X1
XI884_I1 p6_0 b7_1 I884_gn1 VDD VSS NAND2_X1
XI884_I2 p6_1 b7_2 I884_gn2 VDD VSS NAND2_X1
XI884_I3 p6_2 b7_3 I884_gn3 VDD VSS NAND2_X1
XI884_I4 p6_3 b7_4 I884_gn4 VDD VSS NAND2_X1
XI884_I5 p6_4 b7_5 I884_gn5 VDD VSS NAND2_X1
XI884_I6 p6_5 b7_6 I884_gn6 VDD VSS NAND2_X1
XI884_I7 p6_6 b7_7 I884_gn7 VDD VSS NAND2_X1
XI884_I8 p6_7 b7_8 I884_gn8 VDD VSS NAND2_X1
XI884_I9 p6_8 b7_9 I884_gn9 VDD VSS NAND2_X1
XI884_I10 p6_9 b7_10 I884_gn10 VDD VSS NAND2_X1
XI884_I11 p6_10 b7_11 I884_gn11 VDD VSS NAND2_X1
XI884_I12 p6_11 b7_12 I884_gn12 VDD VSS NAND2_X1
XI884_I13 p6_12 b7_13 I884_gn13 VDD VSS NAND2_X1
XI884_I14 p6_13 b7_14 I884_gn14 VDD VSS NAND2_X1
XI884_I15 p6_14 b7_15 I884_gn15 VDD VSS NAND2_X1
XI884_I16 p6_15 b7_16 I884_gn16 VDD VSS NAND2_X1
XI884_I17 p6_16 b7_17 I884_gn17 VDD VSS NAND2_X1
XI884_I18 p6_17 b7_18 I884_gn18 VDD VSS NAND2_X1
XI884_I19 p6_18 b7_19 I884_gn19 VDD VSS NAND2_X1
XI884_I20 p6_19 b7_20 I884_gn20 VDD VSS NAND2_X1
XI884_I21 p6_20 b7_21 I884_gn21 VDD VSS NAND2_X1
XI884_I22 p6_21 b7_22 I884_gn22 VDD VSS NAND2_X1
XI884_I23 p6_22 b7_23 I884_gn23 VDD VSS NAND2_X1
XI884_I24 p6_23 b7_24 I884_gn24 VDD VSS NAND2_X1
XI884_I25 p6_24 b7_25 I884_gn25 VDD VSS NAND2_X1
XI884_I26 p6_25 b7_26 I884_gn26 VDD VSS NAND2_X1
XI884_I27 p6_26 b7_27 I884_gn27 VDD VSS NAND2_X1
XI884_I28 p6_27 b7_28 I884_gn28 VDD VSS NAND2_X1
XI884_I29 p6_28 b7_29 I884_gn29 VDD VSS NAND2_X1
XI884_I30 p6_29 b7_30 I884_gn30 VDD VSS NAND2_X1
XI884_I31 p6_30 b7_31 I884_gn31 VDD VSS NAND2_X1
XI884_I32 aa24 b7_0 I884_pn0 VDD VSS XNOR2_X1
XI884_I33 p6_0 b7_1 I884_pn1 VDD VSS XNOR2_X1
XI884_I34 p6_1 b7_2 I884_pn2 VDD VSS XNOR2_X1
XI884_I35 p6_2 b7_3 I884_pn3 VDD VSS XNOR2_X1
XI884_I36 p6_3 b7_4 I884_pn4 VDD VSS XNOR2_X1
XI884_I37 p6_4 b7_5 I884_pn5 VDD VSS XNOR2_X1
XI884_I38 p6_5 b7_6 I884_pn6 VDD VSS XNOR2_X1
XI884_I39 p6_6 b7_7 I884_pn7 VDD VSS XNOR2_X1
XI884_I40 p6_7 b7_8 I884_pn8 VDD VSS XNOR2_X1
XI884_I41 p6_8 b7_9 I884_pn9 VDD VSS XNOR2_X1
XI884_I42 p6_9 b7_10 I884_pn10 VDD VSS XNOR2_X1
XI884_I43 p6_10 b7_11 I884_pn11 VDD VSS XNOR2_X1
XI884_I44 p6_11 b7_12 I884_pn12 VDD VSS XNOR2_X1
XI884_I45 p6_12 b7_13 I884_pn13 VDD VSS XNOR2_X1
XI884_I46 p6_13 b7_14 I884_pn14 VDD VSS XNOR2_X1
XI884_I47 p6_14 b7_15 I884_pn15 VDD VSS XNOR2_X1
XI884_I48 p6_15 b7_16 I884_pn16 VDD VSS XNOR2_X1
XI884_I49 p6_16 b7_17 I884_pn17 VDD VSS XNOR2_X1
XI884_I50 p6_17 b7_18 I884_pn18 VDD VSS XNOR2_X1
XI884_I51 p6_18 b7_19 I884_pn19 VDD VSS XNOR2_X1
XI884_I52 p6_19 b7_20 I884_pn20 VDD VSS XNOR2_X1
XI884_I53 p6_20 b7_21 I884_pn21 VDD VSS XNOR2_X1
XI884_I54 p6_21 b7_22 I884_pn22 VDD VSS XNOR2_X1
XI884_I55 p6_22 b7_23 I884_pn23 VDD VSS XNOR2_X1
XI884_I56 p6_23 b7_24 I884_pn24 VDD VSS XNOR2_X1
XI884_I57 p6_24 b7_25 I884_pn25 VDD VSS XNOR2_X1
XI884_I58 p6_25 b7_26 I884_pn26 VDD VSS XNOR2_X1
XI884_I59 p6_26 b7_27 I884_pn27 VDD VSS XNOR2_X1
XI884_I60 p6_27 b7_28 I884_pn28 VDD VSS XNOR2_X1
XI884_I61 p6_28 b7_29 I884_pn29 VDD VSS XNOR2_X1
XI884_I62 p6_29 b7_30 I884_pn30 VDD VSS XNOR2_X1
XI884_I63 p6_30 b7_31 I884_pn31 VDD VSS XNOR2_X1
XI884_I64 qu25_b3_5 I884_cinn VDD VSS INV_X1
XI884_I65_XG I884_pn0 I884_cinn I884_gn0 I884_G0_0 VDD VSS OAI21_X1
XI884_I66 I884_G0_0 I884_G0_0n VDD VSS INV_X1
XI884_I67_XG I884_pn1 I884_G0_0n I884_gn1 I884_G1_0 VDD VSS OAI21_X1
XI884_I68_XG I884_pn2 I884_gn1 I884_gn2 I884_G2_1 VDD VSS OAI21_X1
XI884_I68_XP I884_pn2 I884_pn1 I884_P2_1 VDD VSS NOR2_X1
XI884_I69_XG I884_pn3 I884_gn2 I884_gn3 I884_G3_2 VDD VSS OAI21_X1
XI884_I69_XP I884_pn3 I884_pn2 I884_P3_2 VDD VSS NOR2_X1
XI884_I70_XG I884_pn4 I884_gn3 I884_gn4 I884_G4_3 VDD VSS OAI21_X1
XI884_I70_XP I884_pn4 I884_pn3 I884_P4_3 VDD VSS NOR2_X1
XI884_I71_XG I884_pn5 I884_gn4 I884_gn5 I884_G5_4 VDD VSS OAI21_X1
XI884_I71_XP I884_pn5 I884_pn4 I884_P5_4 VDD VSS NOR2_X1
XI884_I72_XG I884_pn6 I884_gn5 I884_gn6 I884_G6_5 VDD VSS OAI21_X1
XI884_I72_XP I884_pn6 I884_pn5 I884_P6_5 VDD VSS NOR2_X1
XI884_I73_XG I884_pn7 I884_gn6 I884_gn7 I884_G7_6 VDD VSS OAI21_X1
XI884_I73_XP I884_pn7 I884_pn6 I884_P7_6 VDD VSS NOR2_X1
XI884_I74_XG I884_pn8 I884_gn7 I884_gn8 I884_G8_7 VDD VSS OAI21_X1
XI884_I74_XP I884_pn8 I884_pn7 I884_P8_7 VDD VSS NOR2_X1
XI884_I75_XG I884_pn9 I884_gn8 I884_gn9 I884_G9_8 VDD VSS OAI21_X1
XI884_I75_XP I884_pn9 I884_pn8 I884_P9_8 VDD VSS NOR2_X1
XI884_I76_XG I884_pn10 I884_gn9 I884_gn10 I884_G10_9 VDD VSS OAI21_X1
XI884_I76_XP I884_pn10 I884_pn9 I884_P10_9 VDD VSS NOR2_X1
XI884_I77_XG I884_pn11 I884_gn10 I884_gn11 I884_G11_10 VDD VSS OAI21_X1
XI884_I77_XP I884_pn11 I884_pn10 I884_P11_10 VDD VSS NOR2_X1
XI884_I78_XG I884_pn12 I884_gn11 I884_gn12 I884_G12_11 VDD VSS OAI21_X1
XI884_I78_XP I884_pn12 I884_pn11 I884_P12_11 VDD VSS NOR2_X1
XI884_I79_XG I884_pn13 I884_gn12 I884_gn13 I884_G13_12 VDD VSS OAI21_X1
XI884_I79_XP I884_pn13 I884_pn12 I884_P13_12 VDD VSS NOR2_X1
XI884_I80_XG I884_pn14 I884_gn13 I884_gn14 I884_G14_13 VDD VSS OAI21_X1
XI884_I80_XP I884_pn14 I884_pn13 I884_P14_13 VDD VSS NOR2_X1
XI884_I81_XG I884_pn15 I884_gn14 I884_gn15 I884_G15_14 VDD VSS OAI21_X1
XI884_I81_XP I884_pn15 I884_pn14 I884_P15_14 VDD VSS NOR2_X1
XI884_I82_XG I884_pn16 I884_gn15 I884_gn16 I884_G16_15 VDD VSS OAI21_X1
XI884_I82_XP I884_pn16 I884_pn15 I884_P16_15 VDD VSS NOR2_X1
XI884_I83_XG I884_pn17 I884_gn16 I884_gn17 I884_G17_16 VDD VSS OAI21_X1
XI884_I83_XP I884_pn17 I884_pn16 I884_P17_16 VDD VSS NOR2_X1
XI884_I84_XG I884_pn18 I884_gn17 I884_gn18 I884_G18_17 VDD VSS OAI21_X1
XI884_I84_XP I884_pn18 I884_pn17 I884_P18_17 VDD VSS NOR2_X1
XI884_I85_XG I884_pn19 I884_gn18 I884_gn19 I884_G19_18 VDD VSS OAI21_X1
XI884_I85_XP I884_pn19 I884_pn18 I884_P19_18 VDD VSS NOR2_X1
XI884_I86_XG I884_pn20 I884_gn19 I884_gn20 I884_G20_19 VDD VSS OAI21_X1
XI884_I86_XP I884_pn20 I884_pn19 I884_P20_19 VDD VSS NOR2_X1
XI884_I87_XG I884_pn21 I884_gn20 I884_gn21 I884_G21_20 VDD VSS OAI21_X1
XI884_I87_XP I884_pn21 I884_pn20 I884_P21_20 VDD VSS NOR2_X1
XI884_I88_XG I884_pn22 I884_gn21 I884_gn22 I884_G22_21 VDD VSS OAI21_X1
XI884_I88_XP I884_pn22 I884_pn21 I884_P22_21 VDD VSS NOR2_X1
XI884_I89_XG I884_pn23 I884_gn22 I884_gn23 I884_G23_22 VDD VSS OAI21_X1
XI884_I89_XP I884_pn23 I884_pn22 I884_P23_22 VDD VSS NOR2_X1
XI884_I90_XG I884_pn24 I884_gn23 I884_gn24 I884_G24_23 VDD VSS OAI21_X1
XI884_I90_XP I884_pn24 I884_pn23 I884_P24_23 VDD VSS NOR2_X1
XI884_I91_XG I884_pn25 I884_gn24 I884_gn25 I884_G25_24 VDD VSS OAI21_X1
XI884_I91_XP I884_pn25 I884_pn24 I884_P25_24 VDD VSS NOR2_X1
XI884_I92_XG I884_pn26 I884_gn25 I884_gn26 I884_G26_25 VDD VSS OAI21_X1
XI884_I92_XP I884_pn26 I884_pn25 I884_P26_25 VDD VSS NOR2_X1
XI884_I93_XG I884_pn27 I884_gn26 I884_gn27 I884_G27_26 VDD VSS OAI21_X1
XI884_I93_XP I884_pn27 I884_pn26 I884_P27_26 VDD VSS NOR2_X1
XI884_I94_XG I884_pn28 I884_gn27 I884_gn28 I884_G28_27 VDD VSS OAI21_X1
XI884_I94_XP I884_pn28 I884_pn27 I884_P28_27 VDD VSS NOR2_X1
XI884_I95_XG I884_pn29 I884_gn28 I884_gn29 I884_G29_28 VDD VSS OAI21_X1
XI884_I95_XP I884_pn29 I884_pn28 I884_P29_28 VDD VSS NOR2_X1
XI884_I96_XG I884_pn30 I884_gn29 I884_gn30 I884_G30_29 VDD VSS OAI21_X1
XI884_I96_XP I884_pn30 I884_pn29 I884_P30_29 VDD VSS NOR2_X1
XI884_I97_XG I884_pn31 I884_gn30 I884_gn31 I884_G31_30 VDD VSS OAI21_X1
XI884_I97_XP I884_pn31 I884_pn30 I884_P31_30 VDD VSS NOR2_X1
XI884_I98_XG I884_P2_1 I884_G0_0 I884_G2_1 I884_G2_0n VDD VSS AOI21_X1
XI884_I99_XG I884_P3_2 I884_G1_0 I884_G3_2 I884_G3_0n VDD VSS AOI21_X1
XI884_I100_XG I884_P4_3 I884_G2_1 I884_G4_3 I884_G4_1n VDD VSS AOI21_X1
XI884_I100_XP I884_P4_3 I884_P2_1 I884_P4_1n VDD VSS NAND2_X1
XI884_I101_XG I884_P5_4 I884_G3_2 I884_G5_4 I884_G5_2n VDD VSS AOI21_X1
XI884_I101_XP I884_P5_4 I884_P3_2 I884_P5_2n VDD VSS NAND2_X1
XI884_I102_XG I884_P6_5 I884_G4_3 I884_G6_5 I884_G6_3n VDD VSS AOI21_X1
XI884_I102_XP I884_P6_5 I884_P4_3 I884_P6_3n VDD VSS NAND2_X1
XI884_I103_XG I884_P7_6 I884_G5_4 I884_G7_6 I884_G7_4n VDD VSS AOI21_X1
XI884_I103_XP I884_P7_6 I884_P5_4 I884_P7_4n VDD VSS NAND2_X1
XI884_I104_XG I884_P8_7 I884_G6_5 I884_G8_7 I884_G8_5n VDD VSS AOI21_X1
XI884_I104_XP I884_P8_7 I884_P6_5 I884_P8_5n VDD VSS NAND2_X1
XI884_I105_XG I884_P9_8 I884_G7_6 I884_G9_8 I884_G9_6n VDD VSS AOI21_X1
XI884_I105_XP I884_P9_8 I884_P7_6 I884_P9_6n VDD VSS NAND2_X1
XI884_I106_XG I884_P10_9 I884_G8_7 I884_G10_9 I884_G10_7n VDD VSS AOI21_X1
XI884_I106_XP I884_P10_9 I884_P8_7 I884_P10_7n VDD VSS NAND2_X1
XI884_I107_XG I884_P11_10 I884_G9_8 I884_G11_10 I884_G11_8n VDD VSS AOI21_X1
XI884_I107_XP I884_P11_10 I884_P9_8 I884_P11_8n VDD VSS NAND2_X1
XI884_I108_XG I884_P12_11 I884_G10_9 I884_G12_11 I884_G12_9n VDD VSS AOI21_X1
XI884_I108_XP I884_P12_11 I884_P10_9 I884_P12_9n VDD VSS NAND2_X1
XI884_I109_XG I884_P13_12 I884_G11_10 I884_G13_12 I884_G13_10n VDD VSS AOI21_X1
XI884_I109_XP I884_P13_12 I884_P11_10 I884_P13_10n VDD VSS NAND2_X1
XI884_I110_XG I884_P14_13 I884_G12_11 I884_G14_13 I884_G14_11n VDD VSS AOI21_X1
XI884_I110_XP I884_P14_13 I884_P12_11 I884_P14_11n VDD VSS NAND2_X1
XI884_I111_XG I884_P15_14 I884_G13_12 I884_G15_14 I884_G15_12n VDD VSS AOI21_X1
XI884_I111_XP I884_P15_14 I884_P13_12 I884_P15_12n VDD VSS NAND2_X1
XI884_I112_XG I884_P16_15 I884_G14_13 I884_G16_15 I884_G16_13n VDD VSS AOI21_X1
XI884_I112_XP I884_P16_15 I884_P14_13 I884_P16_13n VDD VSS NAND2_X1
XI884_I113_XG I884_P17_16 I884_G15_14 I884_G17_16 I884_G17_14n VDD VSS AOI21_X1
XI884_I113_XP I884_P17_16 I884_P15_14 I884_P17_14n VDD VSS NAND2_X1
XI884_I114_XG I884_P18_17 I884_G16_15 I884_G18_17 I884_G18_15n VDD VSS AOI21_X1
XI884_I114_XP I884_P18_17 I884_P16_15 I884_P18_15n VDD VSS NAND2_X1
XI884_I115_XG I884_P19_18 I884_G17_16 I884_G19_18 I884_G19_16n VDD VSS AOI21_X1
XI884_I115_XP I884_P19_18 I884_P17_16 I884_P19_16n VDD VSS NAND2_X1
XI884_I116_XG I884_P20_19 I884_G18_17 I884_G20_19 I884_G20_17n VDD VSS AOI21_X1
XI884_I116_XP I884_P20_19 I884_P18_17 I884_P20_17n VDD VSS NAND2_X1
XI884_I117_XG I884_P21_20 I884_G19_18 I884_G21_20 I884_G21_18n VDD VSS AOI21_X1
XI884_I117_XP I884_P21_20 I884_P19_18 I884_P21_18n VDD VSS NAND2_X1
XI884_I118_XG I884_P22_21 I884_G20_19 I884_G22_21 I884_G22_19n VDD VSS AOI21_X1
XI884_I118_XP I884_P22_21 I884_P20_19 I884_P22_19n VDD VSS NAND2_X1
XI884_I119_XG I884_P23_22 I884_G21_20 I884_G23_22 I884_G23_20n VDD VSS AOI21_X1
XI884_I119_XP I884_P23_22 I884_P21_20 I884_P23_20n VDD VSS NAND2_X1
XI884_I120_XG I884_P24_23 I884_G22_21 I884_G24_23 I884_G24_21n VDD VSS AOI21_X1
XI884_I120_XP I884_P24_23 I884_P22_21 I884_P24_21n VDD VSS NAND2_X1
XI884_I121_XG I884_P25_24 I884_G23_22 I884_G25_24 I884_G25_22n VDD VSS AOI21_X1
XI884_I121_XP I884_P25_24 I884_P23_22 I884_P25_22n VDD VSS NAND2_X1
XI884_I122_XG I884_P26_25 I884_G24_23 I884_G26_25 I884_G26_23n VDD VSS AOI21_X1
XI884_I122_XP I884_P26_25 I884_P24_23 I884_P26_23n VDD VSS NAND2_X1
XI884_I123_XG I884_P27_26 I884_G25_24 I884_G27_26 I884_G27_24n VDD VSS AOI21_X1
XI884_I123_XP I884_P27_26 I884_P25_24 I884_P27_24n VDD VSS NAND2_X1
XI884_I124_XG I884_P28_27 I884_G26_25 I884_G28_27 I884_G28_25n VDD VSS AOI21_X1
XI884_I124_XP I884_P28_27 I884_P26_25 I884_P28_25n VDD VSS NAND2_X1
XI884_I125_XG I884_P29_28 I884_G27_26 I884_G29_28 I884_G29_26n VDD VSS AOI21_X1
XI884_I125_XP I884_P29_28 I884_P27_26 I884_P29_26n VDD VSS NAND2_X1
XI884_I126_XG I884_P30_29 I884_G28_27 I884_G30_29 I884_G30_27n VDD VSS AOI21_X1
XI884_I126_XP I884_P30_29 I884_P28_27 I884_P30_27n VDD VSS NAND2_X1
XI884_I127_XG I884_P31_30 I884_G29_28 I884_G31_30 I884_G31_28n VDD VSS AOI21_X1
XI884_I127_XP I884_P31_30 I884_P29_28 I884_P31_28n VDD VSS NAND2_X1
XI884_I128_XG I884_P4_1n I884_G0_0n I884_G4_1n I884_G4_0 VDD VSS OAI21_X1
XI884_I129 I884_G1_0 I884_G1_0n VDD VSS INV_X1
XI884_I130_XG I884_P5_2n I884_G1_0n I884_G5_2n I884_G5_0 VDD VSS OAI21_X1
XI884_I131_XG I884_P6_3n I884_G2_0n I884_G6_3n I884_G6_0 VDD VSS OAI21_X1
XI884_I132_XG I884_P7_4n I884_G3_0n I884_G7_4n I884_G7_0 VDD VSS OAI21_X1
XI884_I133_XG I884_P8_5n I884_G4_1n I884_G8_5n I884_G8_1 VDD VSS OAI21_X1
XI884_I133_XP I884_P8_5n I884_P4_1n I884_P8_1 VDD VSS NOR2_X1
XI884_I134_XG I884_P9_6n I884_G5_2n I884_G9_6n I884_G9_2 VDD VSS OAI21_X1
XI884_I134_XP I884_P9_6n I884_P5_2n I884_P9_2 VDD VSS NOR2_X1
XI884_I135_XG I884_P10_7n I884_G6_3n I884_G10_7n I884_G10_3 VDD VSS OAI21_X1
XI884_I135_XP I884_P10_7n I884_P6_3n I884_P10_3 VDD VSS NOR2_X1
XI884_I136_XG I884_P11_8n I884_G7_4n I884_G11_8n I884_G11_4 VDD VSS OAI21_X1
XI884_I136_XP I884_P11_8n I884_P7_4n I884_P11_4 VDD VSS NOR2_X1
XI884_I137_XG I884_P12_9n I884_G8_5n I884_G12_9n I884_G12_5 VDD VSS OAI21_X1
XI884_I137_XP I884_P12_9n I884_P8_5n I884_P12_5 VDD VSS NOR2_X1
XI884_I138_XG I884_P13_10n I884_G9_6n I884_G13_10n I884_G13_6 VDD VSS OAI21_X1
XI884_I138_XP I884_P13_10n I884_P9_6n I884_P13_6 VDD VSS NOR2_X1
XI884_I139_XG I884_P14_11n I884_G10_7n I884_G14_11n I884_G14_7 VDD VSS OAI21_X1
XI884_I139_XP I884_P14_11n I884_P10_7n I884_P14_7 VDD VSS NOR2_X1
XI884_I140_XG I884_P15_12n I884_G11_8n I884_G15_12n I884_G15_8 VDD VSS OAI21_X1
XI884_I140_XP I884_P15_12n I884_P11_8n I884_P15_8 VDD VSS NOR2_X1
XI884_I141_XG I884_P16_13n I884_G12_9n I884_G16_13n I884_G16_9 VDD VSS OAI21_X1
XI884_I141_XP I884_P16_13n I884_P12_9n I884_P16_9 VDD VSS NOR2_X1
XI884_I142_XG I884_P17_14n I884_G13_10n I884_G17_14n I884_G17_10 VDD VSS OAI21_X1
XI884_I142_XP I884_P17_14n I884_P13_10n I884_P17_10 VDD VSS NOR2_X1
XI884_I143_XG I884_P18_15n I884_G14_11n I884_G18_15n I884_G18_11 VDD VSS OAI21_X1
XI884_I143_XP I884_P18_15n I884_P14_11n I884_P18_11 VDD VSS NOR2_X1
XI884_I144_XG I884_P19_16n I884_G15_12n I884_G19_16n I884_G19_12 VDD VSS OAI21_X1
XI884_I144_XP I884_P19_16n I884_P15_12n I884_P19_12 VDD VSS NOR2_X1
XI884_I145_XG I884_P20_17n I884_G16_13n I884_G20_17n I884_G20_13 VDD VSS OAI21_X1
XI884_I145_XP I884_P20_17n I884_P16_13n I884_P20_13 VDD VSS NOR2_X1
XI884_I146_XG I884_P21_18n I884_G17_14n I884_G21_18n I884_G21_14 VDD VSS OAI21_X1
XI884_I146_XP I884_P21_18n I884_P17_14n I884_P21_14 VDD VSS NOR2_X1
XI884_I147_XG I884_P22_19n I884_G18_15n I884_G22_19n I884_G22_15 VDD VSS OAI21_X1
XI884_I147_XP I884_P22_19n I884_P18_15n I884_P22_15 VDD VSS NOR2_X1
XI884_I148_XG I884_P23_20n I884_G19_16n I884_G23_20n I884_G23_16 VDD VSS OAI21_X1
XI884_I148_XP I884_P23_20n I884_P19_16n I884_P23_16 VDD VSS NOR2_X1
XI884_I149_XG I884_P24_21n I884_G20_17n I884_G24_21n I884_G24_17 VDD VSS OAI21_X1
XI884_I149_XP I884_P24_21n I884_P20_17n I884_P24_17 VDD VSS NOR2_X1
XI884_I150_XG I884_P25_22n I884_G21_18n I884_G25_22n I884_G25_18 VDD VSS OAI21_X1
XI884_I150_XP I884_P25_22n I884_P21_18n I884_P25_18 VDD VSS NOR2_X1
XI884_I151_XG I884_P26_23n I884_G22_19n I884_G26_23n I884_G26_19 VDD VSS OAI21_X1
XI884_I151_XP I884_P26_23n I884_P22_19n I884_P26_19 VDD VSS NOR2_X1
XI884_I152_XG I884_P27_24n I884_G23_20n I884_G27_24n I884_G27_20 VDD VSS OAI21_X1
XI884_I152_XP I884_P27_24n I884_P23_20n I884_P27_20 VDD VSS NOR2_X1
XI884_I153_XG I884_P28_25n I884_G24_21n I884_G28_25n I884_G28_21 VDD VSS OAI21_X1
XI884_I153_XP I884_P28_25n I884_P24_21n I884_P28_21 VDD VSS NOR2_X1
XI884_I154_XG I884_P29_26n I884_G25_22n I884_G29_26n I884_G29_22 VDD VSS OAI21_X1
XI884_I154_XP I884_P29_26n I884_P25_22n I884_P29_22 VDD VSS NOR2_X1
XI884_I155_XG I884_P30_27n I884_G26_23n I884_G30_27n I884_G30_23 VDD VSS OAI21_X1
XI884_I155_XP I884_P30_27n I884_P26_23n I884_P30_23 VDD VSS NOR2_X1
XI884_I156_XG I884_P31_28n I884_G27_24n I884_G31_28n I884_G31_24 VDD VSS OAI21_X1
XI884_I156_XP I884_P31_28n I884_P27_24n I884_P31_24 VDD VSS NOR2_X1
XI884_I157_XG I884_P8_1 I884_G0_0 I884_G8_1 I884_G8_0n VDD VSS AOI21_X1
XI884_I158_XG I884_P9_2 I884_G1_0 I884_G9_2 I884_G9_0n VDD VSS AOI21_X1
XI884_I159 I884_G2_0n I884_G2_0np VDD VSS INV_X1
XI884_I160_XG I884_P10_3 I884_G2_0np I884_G10_3 I884_G10_0n VDD VSS AOI21_X1
XI884_I161 I884_G3_0n I884_G3_0np VDD VSS INV_X1
XI884_I162_XG I884_P11_4 I884_G3_0np I884_G11_4 I884_G11_0n VDD VSS AOI21_X1
XI884_I163_XG I884_P12_5 I884_G4_0 I884_G12_5 I884_G12_0n VDD VSS AOI21_X1
XI884_I164_XG I884_P13_6 I884_G5_0 I884_G13_6 I884_G13_0n VDD VSS AOI21_X1
XI884_I165_XG I884_P14_7 I884_G6_0 I884_G14_7 I884_G14_0n VDD VSS AOI21_X1
XI884_I166_XG I884_P15_8 I884_G7_0 I884_G15_8 I884_G15_0n VDD VSS AOI21_X1
XI884_I167_XG I884_P16_9 I884_G8_1 I884_G16_9 I884_G16_1n VDD VSS AOI21_X1
XI884_I167_XP I884_P16_9 I884_P8_1 I884_P16_1n VDD VSS NAND2_X1
XI884_I168_XG I884_P17_10 I884_G9_2 I884_G17_10 I884_G17_2n VDD VSS AOI21_X1
XI884_I168_XP I884_P17_10 I884_P9_2 I884_P17_2n VDD VSS NAND2_X1
XI884_I169_XG I884_P18_11 I884_G10_3 I884_G18_11 I884_G18_3n VDD VSS AOI21_X1
XI884_I169_XP I884_P18_11 I884_P10_3 I884_P18_3n VDD VSS NAND2_X1
XI884_I170_XG I884_P19_12 I884_G11_4 I884_G19_12 I884_G19_4n VDD VSS AOI21_X1
XI884_I170_XP I884_P19_12 I884_P11_4 I884_P19_4n VDD VSS NAND2_X1
XI884_I171_XG I884_P20_13 I884_G12_5 I884_G20_13 I884_G20_5n VDD VSS AOI21_X1
XI884_I171_XP I884_P20_13 I884_P12_5 I884_P20_5n VDD VSS NAND2_X1
XI884_I172_XG I884_P21_14 I884_G13_6 I884_G21_14 I884_G21_6n VDD VSS AOI21_X1
XI884_I172_XP I884_P21_14 I884_P13_6 I884_P21_6n VDD VSS NAND2_X1
XI884_I173_XG I884_P22_15 I884_G14_7 I884_G22_15 I884_G22_7n VDD VSS AOI21_X1
XI884_I173_XP I884_P22_15 I884_P14_7 I884_P22_7n VDD VSS NAND2_X1
XI884_I174_XG I884_P23_16 I884_G15_8 I884_G23_16 I884_G23_8n VDD VSS AOI21_X1
XI884_I174_XP I884_P23_16 I884_P15_8 I884_P23_8n VDD VSS NAND2_X1
XI884_I175_XG I884_P24_17 I884_G16_9 I884_G24_17 I884_G24_9n VDD VSS AOI21_X1
XI884_I175_XP I884_P24_17 I884_P16_9 I884_P24_9n VDD VSS NAND2_X1
XI884_I176_XG I884_P25_18 I884_G17_10 I884_G25_18 I884_G25_10n VDD VSS AOI21_X1
XI884_I176_XP I884_P25_18 I884_P17_10 I884_P25_10n VDD VSS NAND2_X1
XI884_I177_XG I884_P26_19 I884_G18_11 I884_G26_19 I884_G26_11n VDD VSS AOI21_X1
XI884_I177_XP I884_P26_19 I884_P18_11 I884_P26_11n VDD VSS NAND2_X1
XI884_I178_XG I884_P27_20 I884_G19_12 I884_G27_20 I884_G27_12n VDD VSS AOI21_X1
XI884_I178_XP I884_P27_20 I884_P19_12 I884_P27_12n VDD VSS NAND2_X1
XI884_I179_XG I884_P28_21 I884_G20_13 I884_G28_21 I884_G28_13n VDD VSS AOI21_X1
XI884_I179_XP I884_P28_21 I884_P20_13 I884_P28_13n VDD VSS NAND2_X1
XI884_I180_XG I884_P29_22 I884_G21_14 I884_G29_22 I884_G29_14n VDD VSS AOI21_X1
XI884_I180_XP I884_P29_22 I884_P21_14 I884_P29_14n VDD VSS NAND2_X1
XI884_I181_XG I884_P30_23 I884_G22_15 I884_G30_23 I884_G30_15n VDD VSS AOI21_X1
XI884_I181_XP I884_P30_23 I884_P22_15 I884_P30_15n VDD VSS NAND2_X1
XI884_I182_XG I884_P31_24 I884_G23_16 I884_G31_24 I884_G31_16n VDD VSS AOI21_X1
XI884_I182_XP I884_P31_24 I884_P23_16 I884_P31_16n VDD VSS NAND2_X1
XI884_I183_XG I884_P16_1n I884_G0_0n I884_G16_1n I884_G16_0 VDD VSS OAI21_X1
XI884_I184_XG I884_P17_2n I884_G1_0n I884_G17_2n I884_G17_0 VDD VSS OAI21_X1
XI884_I185_XG I884_P18_3n I884_G2_0n I884_G18_3n I884_G18_0 VDD VSS OAI21_X1
XI884_I186_XG I884_P19_4n I884_G3_0n I884_G19_4n I884_G19_0 VDD VSS OAI21_X1
XI884_I187 I884_G4_0 I884_G4_0n VDD VSS INV_X1
XI884_I188_XG I884_P20_5n I884_G4_0n I884_G20_5n I884_G20_0 VDD VSS OAI21_X1
XI884_I189 I884_G5_0 I884_G5_0n VDD VSS INV_X1
XI884_I190_XG I884_P21_6n I884_G5_0n I884_G21_6n I884_G21_0 VDD VSS OAI21_X1
XI884_I191 I884_G6_0 I884_G6_0n VDD VSS INV_X1
XI884_I192_XG I884_P22_7n I884_G6_0n I884_G22_7n I884_G22_0 VDD VSS OAI21_X1
XI884_I193 I884_G7_0 I884_G7_0n VDD VSS INV_X1
XI884_I194_XG I884_P23_8n I884_G7_0n I884_G23_8n I884_G23_0 VDD VSS OAI21_X1
XI884_I195_XG I884_P24_9n I884_G8_0n I884_G24_9n I884_G24_0 VDD VSS OAI21_X1
XI884_I196_XG I884_P25_10n I884_G9_0n I884_G25_10n I884_G25_0 VDD VSS OAI21_X1
XI884_I197_XG I884_P26_11n I884_G10_0n I884_G26_11n I884_G26_0 VDD VSS OAI21_X1
XI884_I198_XG I884_P27_12n I884_G11_0n I884_G27_12n I884_G27_0 VDD VSS OAI21_X1
XI884_I199_XG I884_P28_13n I884_G12_0n I884_G28_13n I884_G28_0 VDD VSS OAI21_X1
XI884_I200_XG I884_P29_14n I884_G13_0n I884_G29_14n I884_G29_0 VDD VSS OAI21_X1
XI884_I201_XG I884_P30_15n I884_G14_0n I884_G30_15n c7_m VDD VSS OAI21_X1
XI884_I202_XG I884_P31_16n I884_G15_0n I884_G31_16n c7_o VDD VSS OAI21_X1
XI884_I203 I884_pn0 qu25_b3_5 p7_0 VDD VSS XNOR2_X1
XI884_I204 I884_pn1 I884_G0_0 p7_1 VDD VSS XNOR2_X1
XI884_I205 I884_pn2 I884_G1_0 p7_2 VDD VSS XNOR2_X1
XI884_I206 I884_pn3 I884_G2_0n p7_3 VDD VSS XOR2_X1
XI884_I207 I884_pn4 I884_G3_0n p7_4 VDD VSS XOR2_X1
XI884_I208 I884_pn5 I884_G4_0 p7_5 VDD VSS XNOR2_X1
XI884_I209 I884_pn6 I884_G5_0 p7_6 VDD VSS XNOR2_X1
XI884_I210 I884_pn7 I884_G6_0 p7_7 VDD VSS XNOR2_X1
XI884_I211 I884_pn8 I884_G7_0 p7_8 VDD VSS XNOR2_X1
XI884_I212 I884_pn9 I884_G8_0n p7_9 VDD VSS XOR2_X1
XI884_I213 I884_pn10 I884_G9_0n p7_10 VDD VSS XOR2_X1
XI884_I214 I884_pn11 I884_G10_0n p7_11 VDD VSS XOR2_X1
XI884_I215 I884_pn12 I884_G11_0n p7_12 VDD VSS XOR2_X1
XI884_I216 I884_pn13 I884_G12_0n p7_13 VDD VSS XOR2_X1
XI884_I217 I884_pn14 I884_G13_0n p7_14 VDD VSS XOR2_X1
XI884_I218 I884_pn15 I884_G14_0n p7_15 VDD VSS XOR2_X1
XI884_I219 I884_pn16 I884_G15_0n p7_16 VDD VSS XOR2_X1
XI884_I220 I884_pn17 I884_G16_0 p7_17 VDD VSS XNOR2_X1
XI884_I221 I884_pn18 I884_G17_0 p7_18 VDD VSS XNOR2_X1
XI884_I222 I884_pn19 I884_G18_0 p7_19 VDD VSS XNOR2_X1
XI884_I223 I884_pn20 I884_G19_0 p7_20 VDD VSS XNOR2_X1
XI884_I224 I884_pn21 I884_G20_0 p7_21 VDD VSS XNOR2_X1
XI884_I225 I884_pn22 I884_G21_0 p7_22 VDD VSS XNOR2_X1
XI884_I226 I884_pn23 I884_G22_0 p7_23 VDD VSS XNOR2_X1
XI884_I227 I884_pn24 I884_G23_0 p7_24 VDD VSS XNOR2_X1
XI884_I228 I884_pn25 I884_G24_0 p7_25 VDD VSS XNOR2_X1
XI884_I229 I884_pn26 I884_G25_0 p7_26 VDD VSS XNOR2_X1
XI884_I230 I884_pn27 I884_G26_0 p7_27 VDD VSS XNOR2_X1
XI884_I231 I884_pn28 I884_G27_0 p7_28 VDD VSS XNOR2_X1
XI884_I232 I884_pn29 I884_G28_0 p7_29 VDD VSS XNOR2_X1
XI884_I233 I884_pn30 I884_G29_0 p7_30 VDD VSS XNOR2_X1
XI884_I234 I884_pn31 c7_m p7_31 VDD VSS XNOR2_X1
XI885 p6_31 qu25_b3_5 h7 VDD VSS XOR2_X1
XI886 h7 c7_o p7_32 VDD VSS XOR2_X1
XI887 p7_32 qu24 VDD VSS INV_X4
XI888 qu24 qu24_b0 VDD VSS INV_X1
XI889 qu24_b0 qu24_b1_0 VDD VSS INV_X4
XI890 qu24_b1_0 qu24_b2_0 VDD VSS INV_X4
XI891 qu24_b1_0 qu24_b2_1 VDD VSS INV_X4
XI892 qu24_b2_0 qu24_b3_0 VDD VSS INV_X4
XI893 qu24_b2_0 qu24_b3_1 VDD VSS INV_X4
XI894 qu24_b2_0 qu24_b3_2 VDD VSS INV_X4
XI895 qu24_b2_1 qu24_b3_3 VDD VSS INV_X4
XI896 qu24_b2_1 qu24_b3_4 VDD VSS INV_X4
XI897 qu24_b2_1 qu24_b3_5 VDD VSS INV_X4
XI898 B_0_b3_1 qu24_b3_0 b8_0 VDD VSS XOR2_X1
XI899 dd1_b3_1 qu24_b3_0 b8_1 VDD VSS XOR2_X1
XI900 dd2_b3_1 qu24_b3_0 b8_2 VDD VSS XOR2_X1
XI901 dd3_b3_1 qu24_b3_0 b8_3 VDD VSS XOR2_X1
XI902 dd4_b3_1 qu24_b3_0 b8_4 VDD VSS XOR2_X1
XI903 dd5_b3_1 qu24_b3_0 b8_5 VDD VSS XOR2_X1
XI904 dd6_b3_1 qu24_b3_1 b8_6 VDD VSS XOR2_X1
XI905 dd7_b3_1 qu24_b3_1 b8_7 VDD VSS XOR2_X1
XI906 dd8_b3_1 qu24_b3_1 b8_8 VDD VSS XOR2_X1
XI907 dd9_b3_1 qu24_b3_1 b8_9 VDD VSS XOR2_X1
XI908 dd10_b3_1 qu24_b3_1 b8_10 VDD VSS XOR2_X1
XI909 dd11_b3_1 qu24_b3_1 b8_11 VDD VSS XOR2_X1
XI910 dd12_b3_1 qu24_b3_2 b8_12 VDD VSS XOR2_X1
XI911 dd13_b3_1 qu24_b3_2 b8_13 VDD VSS XOR2_X1
XI912 dd14_b3_1 qu24_b3_2 b8_14 VDD VSS XOR2_X1
XI913 dd15_b3_1 qu24_b3_2 b8_15 VDD VSS XOR2_X1
XI914 dd16_b3_1 qu24_b3_2 b8_16 VDD VSS XOR2_X1
XI915 dd17_b3_1 qu24_b3_2 b8_17 VDD VSS XOR2_X1
XI916 dd18_b3_1 qu24_b3_3 b8_18 VDD VSS XOR2_X1
XI917 dd19_b3_1 qu24_b3_3 b8_19 VDD VSS XOR2_X1
XI918 dd20_b3_1 qu24_b3_3 b8_20 VDD VSS XOR2_X1
XI919 dd21_b3_1 qu24_b3_3 b8_21 VDD VSS XOR2_X1
XI920 dd22_b3_1 qu24_b3_3 b8_22 VDD VSS XOR2_X1
XI921 dd23_b3_1 qu24_b3_3 b8_23 VDD VSS XOR2_X1
XI922 dd24_b3_1 qu24_b3_4 b8_24 VDD VSS XOR2_X1
XI923 dd25_b3_1 qu24_b3_4 b8_25 VDD VSS XOR2_X1
XI924 dd26_b3_1 qu24_b3_4 b8_26 VDD VSS XOR2_X1
XI925 dd27_b3_1 qu24_b3_4 b8_27 VDD VSS XOR2_X1
XI926 dd28_b3_1 qu24_b3_4 b8_28 VDD VSS XOR2_X1
XI927 dd29_b3_1 qu24_b3_4 b8_29 VDD VSS XOR2_X1
XI928 dd30_b3_1 qu24_b3_5 b8_30 VDD VSS XOR2_X1
XI929 dd31_b3_1 qu24_b3_5 b8_31 VDD VSS XOR2_X1
XI930_I0 aa23 b8_0 I930_gn0 VDD VSS NAND2_X1
XI930_I1 p7_0 b8_1 I930_gn1 VDD VSS NAND2_X1
XI930_I2 p7_1 b8_2 I930_gn2 VDD VSS NAND2_X1
XI930_I3 p7_2 b8_3 I930_gn3 VDD VSS NAND2_X1
XI930_I4 p7_3 b8_4 I930_gn4 VDD VSS NAND2_X1
XI930_I5 p7_4 b8_5 I930_gn5 VDD VSS NAND2_X1
XI930_I6 p7_5 b8_6 I930_gn6 VDD VSS NAND2_X1
XI930_I7 p7_6 b8_7 I930_gn7 VDD VSS NAND2_X1
XI930_I8 p7_7 b8_8 I930_gn8 VDD VSS NAND2_X1
XI930_I9 p7_8 b8_9 I930_gn9 VDD VSS NAND2_X1
XI930_I10 p7_9 b8_10 I930_gn10 VDD VSS NAND2_X1
XI930_I11 p7_10 b8_11 I930_gn11 VDD VSS NAND2_X1
XI930_I12 p7_11 b8_12 I930_gn12 VDD VSS NAND2_X1
XI930_I13 p7_12 b8_13 I930_gn13 VDD VSS NAND2_X1
XI930_I14 p7_13 b8_14 I930_gn14 VDD VSS NAND2_X1
XI930_I15 p7_14 b8_15 I930_gn15 VDD VSS NAND2_X1
XI930_I16 p7_15 b8_16 I930_gn16 VDD VSS NAND2_X1
XI930_I17 p7_16 b8_17 I930_gn17 VDD VSS NAND2_X1
XI930_I18 p7_17 b8_18 I930_gn18 VDD VSS NAND2_X1
XI930_I19 p7_18 b8_19 I930_gn19 VDD VSS NAND2_X1
XI930_I20 p7_19 b8_20 I930_gn20 VDD VSS NAND2_X1
XI930_I21 p7_20 b8_21 I930_gn21 VDD VSS NAND2_X1
XI930_I22 p7_21 b8_22 I930_gn22 VDD VSS NAND2_X1
XI930_I23 p7_22 b8_23 I930_gn23 VDD VSS NAND2_X1
XI930_I24 p7_23 b8_24 I930_gn24 VDD VSS NAND2_X1
XI930_I25 p7_24 b8_25 I930_gn25 VDD VSS NAND2_X1
XI930_I26 p7_25 b8_26 I930_gn26 VDD VSS NAND2_X1
XI930_I27 p7_26 b8_27 I930_gn27 VDD VSS NAND2_X1
XI930_I28 p7_27 b8_28 I930_gn28 VDD VSS NAND2_X1
XI930_I29 p7_28 b8_29 I930_gn29 VDD VSS NAND2_X1
XI930_I30 p7_29 b8_30 I930_gn30 VDD VSS NAND2_X1
XI930_I31 p7_30 b8_31 I930_gn31 VDD VSS NAND2_X1
XI930_I32 aa23 b8_0 I930_pn0 VDD VSS XNOR2_X1
XI930_I33 p7_0 b8_1 I930_pn1 VDD VSS XNOR2_X1
XI930_I34 p7_1 b8_2 I930_pn2 VDD VSS XNOR2_X1
XI930_I35 p7_2 b8_3 I930_pn3 VDD VSS XNOR2_X1
XI930_I36 p7_3 b8_4 I930_pn4 VDD VSS XNOR2_X1
XI930_I37 p7_4 b8_5 I930_pn5 VDD VSS XNOR2_X1
XI930_I38 p7_5 b8_6 I930_pn6 VDD VSS XNOR2_X1
XI930_I39 p7_6 b8_7 I930_pn7 VDD VSS XNOR2_X1
XI930_I40 p7_7 b8_8 I930_pn8 VDD VSS XNOR2_X1
XI930_I41 p7_8 b8_9 I930_pn9 VDD VSS XNOR2_X1
XI930_I42 p7_9 b8_10 I930_pn10 VDD VSS XNOR2_X1
XI930_I43 p7_10 b8_11 I930_pn11 VDD VSS XNOR2_X1
XI930_I44 p7_11 b8_12 I930_pn12 VDD VSS XNOR2_X1
XI930_I45 p7_12 b8_13 I930_pn13 VDD VSS XNOR2_X1
XI930_I46 p7_13 b8_14 I930_pn14 VDD VSS XNOR2_X1
XI930_I47 p7_14 b8_15 I930_pn15 VDD VSS XNOR2_X1
XI930_I48 p7_15 b8_16 I930_pn16 VDD VSS XNOR2_X1
XI930_I49 p7_16 b8_17 I930_pn17 VDD VSS XNOR2_X1
XI930_I50 p7_17 b8_18 I930_pn18 VDD VSS XNOR2_X1
XI930_I51 p7_18 b8_19 I930_pn19 VDD VSS XNOR2_X1
XI930_I52 p7_19 b8_20 I930_pn20 VDD VSS XNOR2_X1
XI930_I53 p7_20 b8_21 I930_pn21 VDD VSS XNOR2_X1
XI930_I54 p7_21 b8_22 I930_pn22 VDD VSS XNOR2_X1
XI930_I55 p7_22 b8_23 I930_pn23 VDD VSS XNOR2_X1
XI930_I56 p7_23 b8_24 I930_pn24 VDD VSS XNOR2_X1
XI930_I57 p7_24 b8_25 I930_pn25 VDD VSS XNOR2_X1
XI930_I58 p7_25 b8_26 I930_pn26 VDD VSS XNOR2_X1
XI930_I59 p7_26 b8_27 I930_pn27 VDD VSS XNOR2_X1
XI930_I60 p7_27 b8_28 I930_pn28 VDD VSS XNOR2_X1
XI930_I61 p7_28 b8_29 I930_pn29 VDD VSS XNOR2_X1
XI930_I62 p7_29 b8_30 I930_pn30 VDD VSS XNOR2_X1
XI930_I63 p7_30 b8_31 I930_pn31 VDD VSS XNOR2_X1
XI930_I64 qu24_b3_5 I930_cinn VDD VSS INV_X1
XI930_I65_XG I930_pn0 I930_cinn I930_gn0 I930_G0_0 VDD VSS OAI21_X1
XI930_I66 I930_G0_0 I930_G0_0n VDD VSS INV_X1
XI930_I67_XG I930_pn1 I930_G0_0n I930_gn1 I930_G1_0 VDD VSS OAI21_X1
XI930_I68_XG I930_pn2 I930_gn1 I930_gn2 I930_G2_1 VDD VSS OAI21_X1
XI930_I68_XP I930_pn2 I930_pn1 I930_P2_1 VDD VSS NOR2_X1
XI930_I69_XG I930_pn3 I930_gn2 I930_gn3 I930_G3_2 VDD VSS OAI21_X1
XI930_I69_XP I930_pn3 I930_pn2 I930_P3_2 VDD VSS NOR2_X1
XI930_I70_XG I930_pn4 I930_gn3 I930_gn4 I930_G4_3 VDD VSS OAI21_X1
XI930_I70_XP I930_pn4 I930_pn3 I930_P4_3 VDD VSS NOR2_X1
XI930_I71_XG I930_pn5 I930_gn4 I930_gn5 I930_G5_4 VDD VSS OAI21_X1
XI930_I71_XP I930_pn5 I930_pn4 I930_P5_4 VDD VSS NOR2_X1
XI930_I72_XG I930_pn6 I930_gn5 I930_gn6 I930_G6_5 VDD VSS OAI21_X1
XI930_I72_XP I930_pn6 I930_pn5 I930_P6_5 VDD VSS NOR2_X1
XI930_I73_XG I930_pn7 I930_gn6 I930_gn7 I930_G7_6 VDD VSS OAI21_X1
XI930_I73_XP I930_pn7 I930_pn6 I930_P7_6 VDD VSS NOR2_X1
XI930_I74_XG I930_pn8 I930_gn7 I930_gn8 I930_G8_7 VDD VSS OAI21_X1
XI930_I74_XP I930_pn8 I930_pn7 I930_P8_7 VDD VSS NOR2_X1
XI930_I75_XG I930_pn9 I930_gn8 I930_gn9 I930_G9_8 VDD VSS OAI21_X1
XI930_I75_XP I930_pn9 I930_pn8 I930_P9_8 VDD VSS NOR2_X1
XI930_I76_XG I930_pn10 I930_gn9 I930_gn10 I930_G10_9 VDD VSS OAI21_X1
XI930_I76_XP I930_pn10 I930_pn9 I930_P10_9 VDD VSS NOR2_X1
XI930_I77_XG I930_pn11 I930_gn10 I930_gn11 I930_G11_10 VDD VSS OAI21_X1
XI930_I77_XP I930_pn11 I930_pn10 I930_P11_10 VDD VSS NOR2_X1
XI930_I78_XG I930_pn12 I930_gn11 I930_gn12 I930_G12_11 VDD VSS OAI21_X1
XI930_I78_XP I930_pn12 I930_pn11 I930_P12_11 VDD VSS NOR2_X1
XI930_I79_XG I930_pn13 I930_gn12 I930_gn13 I930_G13_12 VDD VSS OAI21_X1
XI930_I79_XP I930_pn13 I930_pn12 I930_P13_12 VDD VSS NOR2_X1
XI930_I80_XG I930_pn14 I930_gn13 I930_gn14 I930_G14_13 VDD VSS OAI21_X1
XI930_I80_XP I930_pn14 I930_pn13 I930_P14_13 VDD VSS NOR2_X1
XI930_I81_XG I930_pn15 I930_gn14 I930_gn15 I930_G15_14 VDD VSS OAI21_X1
XI930_I81_XP I930_pn15 I930_pn14 I930_P15_14 VDD VSS NOR2_X1
XI930_I82_XG I930_pn16 I930_gn15 I930_gn16 I930_G16_15 VDD VSS OAI21_X1
XI930_I82_XP I930_pn16 I930_pn15 I930_P16_15 VDD VSS NOR2_X1
XI930_I83_XG I930_pn17 I930_gn16 I930_gn17 I930_G17_16 VDD VSS OAI21_X1
XI930_I83_XP I930_pn17 I930_pn16 I930_P17_16 VDD VSS NOR2_X1
XI930_I84_XG I930_pn18 I930_gn17 I930_gn18 I930_G18_17 VDD VSS OAI21_X1
XI930_I84_XP I930_pn18 I930_pn17 I930_P18_17 VDD VSS NOR2_X1
XI930_I85_XG I930_pn19 I930_gn18 I930_gn19 I930_G19_18 VDD VSS OAI21_X1
XI930_I85_XP I930_pn19 I930_pn18 I930_P19_18 VDD VSS NOR2_X1
XI930_I86_XG I930_pn20 I930_gn19 I930_gn20 I930_G20_19 VDD VSS OAI21_X1
XI930_I86_XP I930_pn20 I930_pn19 I930_P20_19 VDD VSS NOR2_X1
XI930_I87_XG I930_pn21 I930_gn20 I930_gn21 I930_G21_20 VDD VSS OAI21_X1
XI930_I87_XP I930_pn21 I930_pn20 I930_P21_20 VDD VSS NOR2_X1
XI930_I88_XG I930_pn22 I930_gn21 I930_gn22 I930_G22_21 VDD VSS OAI21_X1
XI930_I88_XP I930_pn22 I930_pn21 I930_P22_21 VDD VSS NOR2_X1
XI930_I89_XG I930_pn23 I930_gn22 I930_gn23 I930_G23_22 VDD VSS OAI21_X1
XI930_I89_XP I930_pn23 I930_pn22 I930_P23_22 VDD VSS NOR2_X1
XI930_I90_XG I930_pn24 I930_gn23 I930_gn24 I930_G24_23 VDD VSS OAI21_X1
XI930_I90_XP I930_pn24 I930_pn23 I930_P24_23 VDD VSS NOR2_X1
XI930_I91_XG I930_pn25 I930_gn24 I930_gn25 I930_G25_24 VDD VSS OAI21_X1
XI930_I91_XP I930_pn25 I930_pn24 I930_P25_24 VDD VSS NOR2_X1
XI930_I92_XG I930_pn26 I930_gn25 I930_gn26 I930_G26_25 VDD VSS OAI21_X1
XI930_I92_XP I930_pn26 I930_pn25 I930_P26_25 VDD VSS NOR2_X1
XI930_I93_XG I930_pn27 I930_gn26 I930_gn27 I930_G27_26 VDD VSS OAI21_X1
XI930_I93_XP I930_pn27 I930_pn26 I930_P27_26 VDD VSS NOR2_X1
XI930_I94_XG I930_pn28 I930_gn27 I930_gn28 I930_G28_27 VDD VSS OAI21_X1
XI930_I94_XP I930_pn28 I930_pn27 I930_P28_27 VDD VSS NOR2_X1
XI930_I95_XG I930_pn29 I930_gn28 I930_gn29 I930_G29_28 VDD VSS OAI21_X1
XI930_I95_XP I930_pn29 I930_pn28 I930_P29_28 VDD VSS NOR2_X1
XI930_I96_XG I930_pn30 I930_gn29 I930_gn30 I930_G30_29 VDD VSS OAI21_X1
XI930_I96_XP I930_pn30 I930_pn29 I930_P30_29 VDD VSS NOR2_X1
XI930_I97_XG I930_pn31 I930_gn30 I930_gn31 I930_G31_30 VDD VSS OAI21_X1
XI930_I97_XP I930_pn31 I930_pn30 I930_P31_30 VDD VSS NOR2_X1
XI930_I98_XG I930_P2_1 I930_G0_0 I930_G2_1 I930_G2_0n VDD VSS AOI21_X1
XI930_I99_XG I930_P3_2 I930_G1_0 I930_G3_2 I930_G3_0n VDD VSS AOI21_X1
XI930_I100_XG I930_P4_3 I930_G2_1 I930_G4_3 I930_G4_1n VDD VSS AOI21_X1
XI930_I100_XP I930_P4_3 I930_P2_1 I930_P4_1n VDD VSS NAND2_X1
XI930_I101_XG I930_P5_4 I930_G3_2 I930_G5_4 I930_G5_2n VDD VSS AOI21_X1
XI930_I101_XP I930_P5_4 I930_P3_2 I930_P5_2n VDD VSS NAND2_X1
XI930_I102_XG I930_P6_5 I930_G4_3 I930_G6_5 I930_G6_3n VDD VSS AOI21_X1
XI930_I102_XP I930_P6_5 I930_P4_3 I930_P6_3n VDD VSS NAND2_X1
XI930_I103_XG I930_P7_6 I930_G5_4 I930_G7_6 I930_G7_4n VDD VSS AOI21_X1
XI930_I103_XP I930_P7_6 I930_P5_4 I930_P7_4n VDD VSS NAND2_X1
XI930_I104_XG I930_P8_7 I930_G6_5 I930_G8_7 I930_G8_5n VDD VSS AOI21_X1
XI930_I104_XP I930_P8_7 I930_P6_5 I930_P8_5n VDD VSS NAND2_X1
XI930_I105_XG I930_P9_8 I930_G7_6 I930_G9_8 I930_G9_6n VDD VSS AOI21_X1
XI930_I105_XP I930_P9_8 I930_P7_6 I930_P9_6n VDD VSS NAND2_X1
XI930_I106_XG I930_P10_9 I930_G8_7 I930_G10_9 I930_G10_7n VDD VSS AOI21_X1
XI930_I106_XP I930_P10_9 I930_P8_7 I930_P10_7n VDD VSS NAND2_X1
XI930_I107_XG I930_P11_10 I930_G9_8 I930_G11_10 I930_G11_8n VDD VSS AOI21_X1
XI930_I107_XP I930_P11_10 I930_P9_8 I930_P11_8n VDD VSS NAND2_X1
XI930_I108_XG I930_P12_11 I930_G10_9 I930_G12_11 I930_G12_9n VDD VSS AOI21_X1
XI930_I108_XP I930_P12_11 I930_P10_9 I930_P12_9n VDD VSS NAND2_X1
XI930_I109_XG I930_P13_12 I930_G11_10 I930_G13_12 I930_G13_10n VDD VSS AOI21_X1
XI930_I109_XP I930_P13_12 I930_P11_10 I930_P13_10n VDD VSS NAND2_X1
XI930_I110_XG I930_P14_13 I930_G12_11 I930_G14_13 I930_G14_11n VDD VSS AOI21_X1
XI930_I110_XP I930_P14_13 I930_P12_11 I930_P14_11n VDD VSS NAND2_X1
XI930_I111_XG I930_P15_14 I930_G13_12 I930_G15_14 I930_G15_12n VDD VSS AOI21_X1
XI930_I111_XP I930_P15_14 I930_P13_12 I930_P15_12n VDD VSS NAND2_X1
XI930_I112_XG I930_P16_15 I930_G14_13 I930_G16_15 I930_G16_13n VDD VSS AOI21_X1
XI930_I112_XP I930_P16_15 I930_P14_13 I930_P16_13n VDD VSS NAND2_X1
XI930_I113_XG I930_P17_16 I930_G15_14 I930_G17_16 I930_G17_14n VDD VSS AOI21_X1
XI930_I113_XP I930_P17_16 I930_P15_14 I930_P17_14n VDD VSS NAND2_X1
XI930_I114_XG I930_P18_17 I930_G16_15 I930_G18_17 I930_G18_15n VDD VSS AOI21_X1
XI930_I114_XP I930_P18_17 I930_P16_15 I930_P18_15n VDD VSS NAND2_X1
XI930_I115_XG I930_P19_18 I930_G17_16 I930_G19_18 I930_G19_16n VDD VSS AOI21_X1
XI930_I115_XP I930_P19_18 I930_P17_16 I930_P19_16n VDD VSS NAND2_X1
XI930_I116_XG I930_P20_19 I930_G18_17 I930_G20_19 I930_G20_17n VDD VSS AOI21_X1
XI930_I116_XP I930_P20_19 I930_P18_17 I930_P20_17n VDD VSS NAND2_X1
XI930_I117_XG I930_P21_20 I930_G19_18 I930_G21_20 I930_G21_18n VDD VSS AOI21_X1
XI930_I117_XP I930_P21_20 I930_P19_18 I930_P21_18n VDD VSS NAND2_X1
XI930_I118_XG I930_P22_21 I930_G20_19 I930_G22_21 I930_G22_19n VDD VSS AOI21_X1
XI930_I118_XP I930_P22_21 I930_P20_19 I930_P22_19n VDD VSS NAND2_X1
XI930_I119_XG I930_P23_22 I930_G21_20 I930_G23_22 I930_G23_20n VDD VSS AOI21_X1
XI930_I119_XP I930_P23_22 I930_P21_20 I930_P23_20n VDD VSS NAND2_X1
XI930_I120_XG I930_P24_23 I930_G22_21 I930_G24_23 I930_G24_21n VDD VSS AOI21_X1
XI930_I120_XP I930_P24_23 I930_P22_21 I930_P24_21n VDD VSS NAND2_X1
XI930_I121_XG I930_P25_24 I930_G23_22 I930_G25_24 I930_G25_22n VDD VSS AOI21_X1
XI930_I121_XP I930_P25_24 I930_P23_22 I930_P25_22n VDD VSS NAND2_X1
XI930_I122_XG I930_P26_25 I930_G24_23 I930_G26_25 I930_G26_23n VDD VSS AOI21_X1
XI930_I122_XP I930_P26_25 I930_P24_23 I930_P26_23n VDD VSS NAND2_X1
XI930_I123_XG I930_P27_26 I930_G25_24 I930_G27_26 I930_G27_24n VDD VSS AOI21_X1
XI930_I123_XP I930_P27_26 I930_P25_24 I930_P27_24n VDD VSS NAND2_X1
XI930_I124_XG I930_P28_27 I930_G26_25 I930_G28_27 I930_G28_25n VDD VSS AOI21_X1
XI930_I124_XP I930_P28_27 I930_P26_25 I930_P28_25n VDD VSS NAND2_X1
XI930_I125_XG I930_P29_28 I930_G27_26 I930_G29_28 I930_G29_26n VDD VSS AOI21_X1
XI930_I125_XP I930_P29_28 I930_P27_26 I930_P29_26n VDD VSS NAND2_X1
XI930_I126_XG I930_P30_29 I930_G28_27 I930_G30_29 I930_G30_27n VDD VSS AOI21_X1
XI930_I126_XP I930_P30_29 I930_P28_27 I930_P30_27n VDD VSS NAND2_X1
XI930_I127_XG I930_P31_30 I930_G29_28 I930_G31_30 I930_G31_28n VDD VSS AOI21_X1
XI930_I127_XP I930_P31_30 I930_P29_28 I930_P31_28n VDD VSS NAND2_X1
XI930_I128_XG I930_P4_1n I930_G0_0n I930_G4_1n I930_G4_0 VDD VSS OAI21_X1
XI930_I129 I930_G1_0 I930_G1_0n VDD VSS INV_X1
XI930_I130_XG I930_P5_2n I930_G1_0n I930_G5_2n I930_G5_0 VDD VSS OAI21_X1
XI930_I131_XG I930_P6_3n I930_G2_0n I930_G6_3n I930_G6_0 VDD VSS OAI21_X1
XI930_I132_XG I930_P7_4n I930_G3_0n I930_G7_4n I930_G7_0 VDD VSS OAI21_X1
XI930_I133_XG I930_P8_5n I930_G4_1n I930_G8_5n I930_G8_1 VDD VSS OAI21_X1
XI930_I133_XP I930_P8_5n I930_P4_1n I930_P8_1 VDD VSS NOR2_X1
XI930_I134_XG I930_P9_6n I930_G5_2n I930_G9_6n I930_G9_2 VDD VSS OAI21_X1
XI930_I134_XP I930_P9_6n I930_P5_2n I930_P9_2 VDD VSS NOR2_X1
XI930_I135_XG I930_P10_7n I930_G6_3n I930_G10_7n I930_G10_3 VDD VSS OAI21_X1
XI930_I135_XP I930_P10_7n I930_P6_3n I930_P10_3 VDD VSS NOR2_X1
XI930_I136_XG I930_P11_8n I930_G7_4n I930_G11_8n I930_G11_4 VDD VSS OAI21_X1
XI930_I136_XP I930_P11_8n I930_P7_4n I930_P11_4 VDD VSS NOR2_X1
XI930_I137_XG I930_P12_9n I930_G8_5n I930_G12_9n I930_G12_5 VDD VSS OAI21_X1
XI930_I137_XP I930_P12_9n I930_P8_5n I930_P12_5 VDD VSS NOR2_X1
XI930_I138_XG I930_P13_10n I930_G9_6n I930_G13_10n I930_G13_6 VDD VSS OAI21_X1
XI930_I138_XP I930_P13_10n I930_P9_6n I930_P13_6 VDD VSS NOR2_X1
XI930_I139_XG I930_P14_11n I930_G10_7n I930_G14_11n I930_G14_7 VDD VSS OAI21_X1
XI930_I139_XP I930_P14_11n I930_P10_7n I930_P14_7 VDD VSS NOR2_X1
XI930_I140_XG I930_P15_12n I930_G11_8n I930_G15_12n I930_G15_8 VDD VSS OAI21_X1
XI930_I140_XP I930_P15_12n I930_P11_8n I930_P15_8 VDD VSS NOR2_X1
XI930_I141_XG I930_P16_13n I930_G12_9n I930_G16_13n I930_G16_9 VDD VSS OAI21_X1
XI930_I141_XP I930_P16_13n I930_P12_9n I930_P16_9 VDD VSS NOR2_X1
XI930_I142_XG I930_P17_14n I930_G13_10n I930_G17_14n I930_G17_10 VDD VSS OAI21_X1
XI930_I142_XP I930_P17_14n I930_P13_10n I930_P17_10 VDD VSS NOR2_X1
XI930_I143_XG I930_P18_15n I930_G14_11n I930_G18_15n I930_G18_11 VDD VSS OAI21_X1
XI930_I143_XP I930_P18_15n I930_P14_11n I930_P18_11 VDD VSS NOR2_X1
XI930_I144_XG I930_P19_16n I930_G15_12n I930_G19_16n I930_G19_12 VDD VSS OAI21_X1
XI930_I144_XP I930_P19_16n I930_P15_12n I930_P19_12 VDD VSS NOR2_X1
XI930_I145_XG I930_P20_17n I930_G16_13n I930_G20_17n I930_G20_13 VDD VSS OAI21_X1
XI930_I145_XP I930_P20_17n I930_P16_13n I930_P20_13 VDD VSS NOR2_X1
XI930_I146_XG I930_P21_18n I930_G17_14n I930_G21_18n I930_G21_14 VDD VSS OAI21_X1
XI930_I146_XP I930_P21_18n I930_P17_14n I930_P21_14 VDD VSS NOR2_X1
XI930_I147_XG I930_P22_19n I930_G18_15n I930_G22_19n I930_G22_15 VDD VSS OAI21_X1
XI930_I147_XP I930_P22_19n I930_P18_15n I930_P22_15 VDD VSS NOR2_X1
XI930_I148_XG I930_P23_20n I930_G19_16n I930_G23_20n I930_G23_16 VDD VSS OAI21_X1
XI930_I148_XP I930_P23_20n I930_P19_16n I930_P23_16 VDD VSS NOR2_X1
XI930_I149_XG I930_P24_21n I930_G20_17n I930_G24_21n I930_G24_17 VDD VSS OAI21_X1
XI930_I149_XP I930_P24_21n I930_P20_17n I930_P24_17 VDD VSS NOR2_X1
XI930_I150_XG I930_P25_22n I930_G21_18n I930_G25_22n I930_G25_18 VDD VSS OAI21_X1
XI930_I150_XP I930_P25_22n I930_P21_18n I930_P25_18 VDD VSS NOR2_X1
XI930_I151_XG I930_P26_23n I930_G22_19n I930_G26_23n I930_G26_19 VDD VSS OAI21_X1
XI930_I151_XP I930_P26_23n I930_P22_19n I930_P26_19 VDD VSS NOR2_X1
XI930_I152_XG I930_P27_24n I930_G23_20n I930_G27_24n I930_G27_20 VDD VSS OAI21_X1
XI930_I152_XP I930_P27_24n I930_P23_20n I930_P27_20 VDD VSS NOR2_X1
XI930_I153_XG I930_P28_25n I930_G24_21n I930_G28_25n I930_G28_21 VDD VSS OAI21_X1
XI930_I153_XP I930_P28_25n I930_P24_21n I930_P28_21 VDD VSS NOR2_X1
XI930_I154_XG I930_P29_26n I930_G25_22n I930_G29_26n I930_G29_22 VDD VSS OAI21_X1
XI930_I154_XP I930_P29_26n I930_P25_22n I930_P29_22 VDD VSS NOR2_X1
XI930_I155_XG I930_P30_27n I930_G26_23n I930_G30_27n I930_G30_23 VDD VSS OAI21_X1
XI930_I155_XP I930_P30_27n I930_P26_23n I930_P30_23 VDD VSS NOR2_X1
XI930_I156_XG I930_P31_28n I930_G27_24n I930_G31_28n I930_G31_24 VDD VSS OAI21_X1
XI930_I156_XP I930_P31_28n I930_P27_24n I930_P31_24 VDD VSS NOR2_X1
XI930_I157_XG I930_P8_1 I930_G0_0 I930_G8_1 I930_G8_0n VDD VSS AOI21_X1
XI930_I158_XG I930_P9_2 I930_G1_0 I930_G9_2 I930_G9_0n VDD VSS AOI21_X1
XI930_I159 I930_G2_0n I930_G2_0np VDD VSS INV_X1
XI930_I160_XG I930_P10_3 I930_G2_0np I930_G10_3 I930_G10_0n VDD VSS AOI21_X1
XI930_I161 I930_G3_0n I930_G3_0np VDD VSS INV_X1
XI930_I162_XG I930_P11_4 I930_G3_0np I930_G11_4 I930_G11_0n VDD VSS AOI21_X1
XI930_I163_XG I930_P12_5 I930_G4_0 I930_G12_5 I930_G12_0n VDD VSS AOI21_X1
XI930_I164_XG I930_P13_6 I930_G5_0 I930_G13_6 I930_G13_0n VDD VSS AOI21_X1
XI930_I165_XG I930_P14_7 I930_G6_0 I930_G14_7 I930_G14_0n VDD VSS AOI21_X1
XI930_I166_XG I930_P15_8 I930_G7_0 I930_G15_8 I930_G15_0n VDD VSS AOI21_X1
XI930_I167_XG I930_P16_9 I930_G8_1 I930_G16_9 I930_G16_1n VDD VSS AOI21_X1
XI930_I167_XP I930_P16_9 I930_P8_1 I930_P16_1n VDD VSS NAND2_X1
XI930_I168_XG I930_P17_10 I930_G9_2 I930_G17_10 I930_G17_2n VDD VSS AOI21_X1
XI930_I168_XP I930_P17_10 I930_P9_2 I930_P17_2n VDD VSS NAND2_X1
XI930_I169_XG I930_P18_11 I930_G10_3 I930_G18_11 I930_G18_3n VDD VSS AOI21_X1
XI930_I169_XP I930_P18_11 I930_P10_3 I930_P18_3n VDD VSS NAND2_X1
XI930_I170_XG I930_P19_12 I930_G11_4 I930_G19_12 I930_G19_4n VDD VSS AOI21_X1
XI930_I170_XP I930_P19_12 I930_P11_4 I930_P19_4n VDD VSS NAND2_X1
XI930_I171_XG I930_P20_13 I930_G12_5 I930_G20_13 I930_G20_5n VDD VSS AOI21_X1
XI930_I171_XP I930_P20_13 I930_P12_5 I930_P20_5n VDD VSS NAND2_X1
XI930_I172_XG I930_P21_14 I930_G13_6 I930_G21_14 I930_G21_6n VDD VSS AOI21_X1
XI930_I172_XP I930_P21_14 I930_P13_6 I930_P21_6n VDD VSS NAND2_X1
XI930_I173_XG I930_P22_15 I930_G14_7 I930_G22_15 I930_G22_7n VDD VSS AOI21_X1
XI930_I173_XP I930_P22_15 I930_P14_7 I930_P22_7n VDD VSS NAND2_X1
XI930_I174_XG I930_P23_16 I930_G15_8 I930_G23_16 I930_G23_8n VDD VSS AOI21_X1
XI930_I174_XP I930_P23_16 I930_P15_8 I930_P23_8n VDD VSS NAND2_X1
XI930_I175_XG I930_P24_17 I930_G16_9 I930_G24_17 I930_G24_9n VDD VSS AOI21_X1
XI930_I175_XP I930_P24_17 I930_P16_9 I930_P24_9n VDD VSS NAND2_X1
XI930_I176_XG I930_P25_18 I930_G17_10 I930_G25_18 I930_G25_10n VDD VSS AOI21_X1
XI930_I176_XP I930_P25_18 I930_P17_10 I930_P25_10n VDD VSS NAND2_X1
XI930_I177_XG I930_P26_19 I930_G18_11 I930_G26_19 I930_G26_11n VDD VSS AOI21_X1
XI930_I177_XP I930_P26_19 I930_P18_11 I930_P26_11n VDD VSS NAND2_X1
XI930_I178_XG I930_P27_20 I930_G19_12 I930_G27_20 I930_G27_12n VDD VSS AOI21_X1
XI930_I178_XP I930_P27_20 I930_P19_12 I930_P27_12n VDD VSS NAND2_X1
XI930_I179_XG I930_P28_21 I930_G20_13 I930_G28_21 I930_G28_13n VDD VSS AOI21_X1
XI930_I179_XP I930_P28_21 I930_P20_13 I930_P28_13n VDD VSS NAND2_X1
XI930_I180_XG I930_P29_22 I930_G21_14 I930_G29_22 I930_G29_14n VDD VSS AOI21_X1
XI930_I180_XP I930_P29_22 I930_P21_14 I930_P29_14n VDD VSS NAND2_X1
XI930_I181_XG I930_P30_23 I930_G22_15 I930_G30_23 I930_G30_15n VDD VSS AOI21_X1
XI930_I181_XP I930_P30_23 I930_P22_15 I930_P30_15n VDD VSS NAND2_X1
XI930_I182_XG I930_P31_24 I930_G23_16 I930_G31_24 I930_G31_16n VDD VSS AOI21_X1
XI930_I182_XP I930_P31_24 I930_P23_16 I930_P31_16n VDD VSS NAND2_X1
XI930_I183_XG I930_P16_1n I930_G0_0n I930_G16_1n I930_G16_0 VDD VSS OAI21_X1
XI930_I184_XG I930_P17_2n I930_G1_0n I930_G17_2n I930_G17_0 VDD VSS OAI21_X1
XI930_I185_XG I930_P18_3n I930_G2_0n I930_G18_3n I930_G18_0 VDD VSS OAI21_X1
XI930_I186_XG I930_P19_4n I930_G3_0n I930_G19_4n I930_G19_0 VDD VSS OAI21_X1
XI930_I187 I930_G4_0 I930_G4_0n VDD VSS INV_X1
XI930_I188_XG I930_P20_5n I930_G4_0n I930_G20_5n I930_G20_0 VDD VSS OAI21_X1
XI930_I189 I930_G5_0 I930_G5_0n VDD VSS INV_X1
XI930_I190_XG I930_P21_6n I930_G5_0n I930_G21_6n I930_G21_0 VDD VSS OAI21_X1
XI930_I191 I930_G6_0 I930_G6_0n VDD VSS INV_X1
XI930_I192_XG I930_P22_7n I930_G6_0n I930_G22_7n I930_G22_0 VDD VSS OAI21_X1
XI930_I193 I930_G7_0 I930_G7_0n VDD VSS INV_X1
XI930_I194_XG I930_P23_8n I930_G7_0n I930_G23_8n I930_G23_0 VDD VSS OAI21_X1
XI930_I195_XG I930_P24_9n I930_G8_0n I930_G24_9n I930_G24_0 VDD VSS OAI21_X1
XI930_I196_XG I930_P25_10n I930_G9_0n I930_G25_10n I930_G25_0 VDD VSS OAI21_X1
XI930_I197_XG I930_P26_11n I930_G10_0n I930_G26_11n I930_G26_0 VDD VSS OAI21_X1
XI930_I198_XG I930_P27_12n I930_G11_0n I930_G27_12n I930_G27_0 VDD VSS OAI21_X1
XI930_I199_XG I930_P28_13n I930_G12_0n I930_G28_13n I930_G28_0 VDD VSS OAI21_X1
XI930_I200_XG I930_P29_14n I930_G13_0n I930_G29_14n I930_G29_0 VDD VSS OAI21_X1
XI930_I201_XG I930_P30_15n I930_G14_0n I930_G30_15n c8_m VDD VSS OAI21_X1
XI930_I202_XG I930_P31_16n I930_G15_0n I930_G31_16n c8_o VDD VSS OAI21_X1
XI930_I203 I930_pn0 qu24_b3_5 p8_0 VDD VSS XNOR2_X1
XI930_I204 I930_pn1 I930_G0_0 p8_1 VDD VSS XNOR2_X1
XI930_I205 I930_pn2 I930_G1_0 p8_2 VDD VSS XNOR2_X1
XI930_I206 I930_pn3 I930_G2_0n p8_3 VDD VSS XOR2_X1
XI930_I207 I930_pn4 I930_G3_0n p8_4 VDD VSS XOR2_X1
XI930_I208 I930_pn5 I930_G4_0 p8_5 VDD VSS XNOR2_X1
XI930_I209 I930_pn6 I930_G5_0 p8_6 VDD VSS XNOR2_X1
XI930_I210 I930_pn7 I930_G6_0 p8_7 VDD VSS XNOR2_X1
XI930_I211 I930_pn8 I930_G7_0 p8_8 VDD VSS XNOR2_X1
XI930_I212 I930_pn9 I930_G8_0n p8_9 VDD VSS XOR2_X1
XI930_I213 I930_pn10 I930_G9_0n p8_10 VDD VSS XOR2_X1
XI930_I214 I930_pn11 I930_G10_0n p8_11 VDD VSS XOR2_X1
XI930_I215 I930_pn12 I930_G11_0n p8_12 VDD VSS XOR2_X1
XI930_I216 I930_pn13 I930_G12_0n p8_13 VDD VSS XOR2_X1
XI930_I217 I930_pn14 I930_G13_0n p8_14 VDD VSS XOR2_X1
XI930_I218 I930_pn15 I930_G14_0n p8_15 VDD VSS XOR2_X1
XI930_I219 I930_pn16 I930_G15_0n p8_16 VDD VSS XOR2_X1
XI930_I220 I930_pn17 I930_G16_0 p8_17 VDD VSS XNOR2_X1
XI930_I221 I930_pn18 I930_G17_0 p8_18 VDD VSS XNOR2_X1
XI930_I222 I930_pn19 I930_G18_0 p8_19 VDD VSS XNOR2_X1
XI930_I223 I930_pn20 I930_G19_0 p8_20 VDD VSS XNOR2_X1
XI930_I224 I930_pn21 I930_G20_0 p8_21 VDD VSS XNOR2_X1
XI930_I225 I930_pn22 I930_G21_0 p8_22 VDD VSS XNOR2_X1
XI930_I226 I930_pn23 I930_G22_0 p8_23 VDD VSS XNOR2_X1
XI930_I227 I930_pn24 I930_G23_0 p8_24 VDD VSS XNOR2_X1
XI930_I228 I930_pn25 I930_G24_0 p8_25 VDD VSS XNOR2_X1
XI930_I229 I930_pn26 I930_G25_0 p8_26 VDD VSS XNOR2_X1
XI930_I230 I930_pn27 I930_G26_0 p8_27 VDD VSS XNOR2_X1
XI930_I231 I930_pn28 I930_G27_0 p8_28 VDD VSS XNOR2_X1
XI930_I232 I930_pn29 I930_G28_0 p8_29 VDD VSS XNOR2_X1
XI930_I233 I930_pn30 I930_G29_0 p8_30 VDD VSS XNOR2_X1
XI930_I234 I930_pn31 c8_m p8_31 VDD VSS XNOR2_X1
XI931 p7_31 qu24_b3_5 h8 VDD VSS XOR2_X1
XI932 h8 c8_o p8_32 VDD VSS XOR2_X1
XI933 p8_32 qu23 VDD VSS INV_X4
XI934 qu23 qu23_b0 VDD VSS INV_X1
XI935 qu23_b0 qu23_b1_0 VDD VSS INV_X4
XI936 qu23_b1_0 qu23_b2_0 VDD VSS INV_X4
XI937 qu23_b1_0 qu23_b2_1 VDD VSS INV_X4
XI938 qu23_b2_0 qu23_b3_0 VDD VSS INV_X4
XI939 qu23_b2_0 qu23_b3_1 VDD VSS INV_X4
XI940 qu23_b2_0 qu23_b3_2 VDD VSS INV_X4
XI941 qu23_b2_1 qu23_b3_3 VDD VSS INV_X4
XI942 qu23_b2_1 qu23_b3_4 VDD VSS INV_X4
XI943 qu23_b2_1 qu23_b3_5 VDD VSS INV_X4
XI944 B_0_b3_1 qu23_b3_0 b9_0 VDD VSS XOR2_X1
XI945 dd1_b3_1 qu23_b3_0 b9_1 VDD VSS XOR2_X1
XI946 dd2_b3_1 qu23_b3_0 b9_2 VDD VSS XOR2_X1
XI947 dd3_b3_1 qu23_b3_0 b9_3 VDD VSS XOR2_X1
XI948 dd4_b3_1 qu23_b3_0 b9_4 VDD VSS XOR2_X1
XI949 dd5_b3_1 qu23_b3_0 b9_5 VDD VSS XOR2_X1
XI950 dd6_b3_1 qu23_b3_1 b9_6 VDD VSS XOR2_X1
XI951 dd7_b3_1 qu23_b3_1 b9_7 VDD VSS XOR2_X1
XI952 dd8_b3_1 qu23_b3_1 b9_8 VDD VSS XOR2_X1
XI953 dd9_b3_1 qu23_b3_1 b9_9 VDD VSS XOR2_X1
XI954 dd10_b3_1 qu23_b3_1 b9_10 VDD VSS XOR2_X1
XI955 dd11_b3_1 qu23_b3_1 b9_11 VDD VSS XOR2_X1
XI956 dd12_b3_1 qu23_b3_2 b9_12 VDD VSS XOR2_X1
XI957 dd13_b3_1 qu23_b3_2 b9_13 VDD VSS XOR2_X1
XI958 dd14_b3_1 qu23_b3_2 b9_14 VDD VSS XOR2_X1
XI959 dd15_b3_1 qu23_b3_2 b9_15 VDD VSS XOR2_X1
XI960 dd16_b3_1 qu23_b3_2 b9_16 VDD VSS XOR2_X1
XI961 dd17_b3_1 qu23_b3_2 b9_17 VDD VSS XOR2_X1
XI962 dd18_b3_1 qu23_b3_3 b9_18 VDD VSS XOR2_X1
XI963 dd19_b3_1 qu23_b3_3 b9_19 VDD VSS XOR2_X1
XI964 dd20_b3_1 qu23_b3_3 b9_20 VDD VSS XOR2_X1
XI965 dd21_b3_1 qu23_b3_3 b9_21 VDD VSS XOR2_X1
XI966 dd22_b3_1 qu23_b3_3 b9_22 VDD VSS XOR2_X1
XI967 dd23_b3_1 qu23_b3_3 b9_23 VDD VSS XOR2_X1
XI968 dd24_b3_1 qu23_b3_4 b9_24 VDD VSS XOR2_X1
XI969 dd25_b3_1 qu23_b3_4 b9_25 VDD VSS XOR2_X1
XI970 dd26_b3_1 qu23_b3_4 b9_26 VDD VSS XOR2_X1
XI971 dd27_b3_1 qu23_b3_4 b9_27 VDD VSS XOR2_X1
XI972 dd28_b3_1 qu23_b3_4 b9_28 VDD VSS XOR2_X1
XI973 dd29_b3_1 qu23_b3_4 b9_29 VDD VSS XOR2_X1
XI974 dd30_b3_1 qu23_b3_5 b9_30 VDD VSS XOR2_X1
XI975 dd31_b3_1 qu23_b3_5 b9_31 VDD VSS XOR2_X1
XI976_I0 aa22 b9_0 I976_gn0 VDD VSS NAND2_X1
XI976_I1 p8_0 b9_1 I976_gn1 VDD VSS NAND2_X1
XI976_I2 p8_1 b9_2 I976_gn2 VDD VSS NAND2_X1
XI976_I3 p8_2 b9_3 I976_gn3 VDD VSS NAND2_X1
XI976_I4 p8_3 b9_4 I976_gn4 VDD VSS NAND2_X1
XI976_I5 p8_4 b9_5 I976_gn5 VDD VSS NAND2_X1
XI976_I6 p8_5 b9_6 I976_gn6 VDD VSS NAND2_X1
XI976_I7 p8_6 b9_7 I976_gn7 VDD VSS NAND2_X1
XI976_I8 p8_7 b9_8 I976_gn8 VDD VSS NAND2_X1
XI976_I9 p8_8 b9_9 I976_gn9 VDD VSS NAND2_X1
XI976_I10 p8_9 b9_10 I976_gn10 VDD VSS NAND2_X1
XI976_I11 p8_10 b9_11 I976_gn11 VDD VSS NAND2_X1
XI976_I12 p8_11 b9_12 I976_gn12 VDD VSS NAND2_X1
XI976_I13 p8_12 b9_13 I976_gn13 VDD VSS NAND2_X1
XI976_I14 p8_13 b9_14 I976_gn14 VDD VSS NAND2_X1
XI976_I15 p8_14 b9_15 I976_gn15 VDD VSS NAND2_X1
XI976_I16 p8_15 b9_16 I976_gn16 VDD VSS NAND2_X1
XI976_I17 p8_16 b9_17 I976_gn17 VDD VSS NAND2_X1
XI976_I18 p8_17 b9_18 I976_gn18 VDD VSS NAND2_X1
XI976_I19 p8_18 b9_19 I976_gn19 VDD VSS NAND2_X1
XI976_I20 p8_19 b9_20 I976_gn20 VDD VSS NAND2_X1
XI976_I21 p8_20 b9_21 I976_gn21 VDD VSS NAND2_X1
XI976_I22 p8_21 b9_22 I976_gn22 VDD VSS NAND2_X1
XI976_I23 p8_22 b9_23 I976_gn23 VDD VSS NAND2_X1
XI976_I24 p8_23 b9_24 I976_gn24 VDD VSS NAND2_X1
XI976_I25 p8_24 b9_25 I976_gn25 VDD VSS NAND2_X1
XI976_I26 p8_25 b9_26 I976_gn26 VDD VSS NAND2_X1
XI976_I27 p8_26 b9_27 I976_gn27 VDD VSS NAND2_X1
XI976_I28 p8_27 b9_28 I976_gn28 VDD VSS NAND2_X1
XI976_I29 p8_28 b9_29 I976_gn29 VDD VSS NAND2_X1
XI976_I30 p8_29 b9_30 I976_gn30 VDD VSS NAND2_X1
XI976_I31 p8_30 b9_31 I976_gn31 VDD VSS NAND2_X1
XI976_I32 aa22 b9_0 I976_pn0 VDD VSS XNOR2_X1
XI976_I33 p8_0 b9_1 I976_pn1 VDD VSS XNOR2_X1
XI976_I34 p8_1 b9_2 I976_pn2 VDD VSS XNOR2_X1
XI976_I35 p8_2 b9_3 I976_pn3 VDD VSS XNOR2_X1
XI976_I36 p8_3 b9_4 I976_pn4 VDD VSS XNOR2_X1
XI976_I37 p8_4 b9_5 I976_pn5 VDD VSS XNOR2_X1
XI976_I38 p8_5 b9_6 I976_pn6 VDD VSS XNOR2_X1
XI976_I39 p8_6 b9_7 I976_pn7 VDD VSS XNOR2_X1
XI976_I40 p8_7 b9_8 I976_pn8 VDD VSS XNOR2_X1
XI976_I41 p8_8 b9_9 I976_pn9 VDD VSS XNOR2_X1
XI976_I42 p8_9 b9_10 I976_pn10 VDD VSS XNOR2_X1
XI976_I43 p8_10 b9_11 I976_pn11 VDD VSS XNOR2_X1
XI976_I44 p8_11 b9_12 I976_pn12 VDD VSS XNOR2_X1
XI976_I45 p8_12 b9_13 I976_pn13 VDD VSS XNOR2_X1
XI976_I46 p8_13 b9_14 I976_pn14 VDD VSS XNOR2_X1
XI976_I47 p8_14 b9_15 I976_pn15 VDD VSS XNOR2_X1
XI976_I48 p8_15 b9_16 I976_pn16 VDD VSS XNOR2_X1
XI976_I49 p8_16 b9_17 I976_pn17 VDD VSS XNOR2_X1
XI976_I50 p8_17 b9_18 I976_pn18 VDD VSS XNOR2_X1
XI976_I51 p8_18 b9_19 I976_pn19 VDD VSS XNOR2_X1
XI976_I52 p8_19 b9_20 I976_pn20 VDD VSS XNOR2_X1
XI976_I53 p8_20 b9_21 I976_pn21 VDD VSS XNOR2_X1
XI976_I54 p8_21 b9_22 I976_pn22 VDD VSS XNOR2_X1
XI976_I55 p8_22 b9_23 I976_pn23 VDD VSS XNOR2_X1
XI976_I56 p8_23 b9_24 I976_pn24 VDD VSS XNOR2_X1
XI976_I57 p8_24 b9_25 I976_pn25 VDD VSS XNOR2_X1
XI976_I58 p8_25 b9_26 I976_pn26 VDD VSS XNOR2_X1
XI976_I59 p8_26 b9_27 I976_pn27 VDD VSS XNOR2_X1
XI976_I60 p8_27 b9_28 I976_pn28 VDD VSS XNOR2_X1
XI976_I61 p8_28 b9_29 I976_pn29 VDD VSS XNOR2_X1
XI976_I62 p8_29 b9_30 I976_pn30 VDD VSS XNOR2_X1
XI976_I63 p8_30 b9_31 I976_pn31 VDD VSS XNOR2_X1
XI976_I64 qu23_b3_5 I976_cinn VDD VSS INV_X1
XI976_I65_XG I976_pn0 I976_cinn I976_gn0 I976_G0_0 VDD VSS OAI21_X1
XI976_I66 I976_G0_0 I976_G0_0n VDD VSS INV_X1
XI976_I67_XG I976_pn1 I976_G0_0n I976_gn1 I976_G1_0 VDD VSS OAI21_X1
XI976_I68_XG I976_pn2 I976_gn1 I976_gn2 I976_G2_1 VDD VSS OAI21_X1
XI976_I68_XP I976_pn2 I976_pn1 I976_P2_1 VDD VSS NOR2_X1
XI976_I69_XG I976_pn3 I976_gn2 I976_gn3 I976_G3_2 VDD VSS OAI21_X1
XI976_I69_XP I976_pn3 I976_pn2 I976_P3_2 VDD VSS NOR2_X1
XI976_I70_XG I976_pn4 I976_gn3 I976_gn4 I976_G4_3 VDD VSS OAI21_X1
XI976_I70_XP I976_pn4 I976_pn3 I976_P4_3 VDD VSS NOR2_X1
XI976_I71_XG I976_pn5 I976_gn4 I976_gn5 I976_G5_4 VDD VSS OAI21_X1
XI976_I71_XP I976_pn5 I976_pn4 I976_P5_4 VDD VSS NOR2_X1
XI976_I72_XG I976_pn6 I976_gn5 I976_gn6 I976_G6_5 VDD VSS OAI21_X1
XI976_I72_XP I976_pn6 I976_pn5 I976_P6_5 VDD VSS NOR2_X1
XI976_I73_XG I976_pn7 I976_gn6 I976_gn7 I976_G7_6 VDD VSS OAI21_X1
XI976_I73_XP I976_pn7 I976_pn6 I976_P7_6 VDD VSS NOR2_X1
XI976_I74_XG I976_pn8 I976_gn7 I976_gn8 I976_G8_7 VDD VSS OAI21_X1
XI976_I74_XP I976_pn8 I976_pn7 I976_P8_7 VDD VSS NOR2_X1
XI976_I75_XG I976_pn9 I976_gn8 I976_gn9 I976_G9_8 VDD VSS OAI21_X1
XI976_I75_XP I976_pn9 I976_pn8 I976_P9_8 VDD VSS NOR2_X1
XI976_I76_XG I976_pn10 I976_gn9 I976_gn10 I976_G10_9 VDD VSS OAI21_X1
XI976_I76_XP I976_pn10 I976_pn9 I976_P10_9 VDD VSS NOR2_X1
XI976_I77_XG I976_pn11 I976_gn10 I976_gn11 I976_G11_10 VDD VSS OAI21_X1
XI976_I77_XP I976_pn11 I976_pn10 I976_P11_10 VDD VSS NOR2_X1
XI976_I78_XG I976_pn12 I976_gn11 I976_gn12 I976_G12_11 VDD VSS OAI21_X1
XI976_I78_XP I976_pn12 I976_pn11 I976_P12_11 VDD VSS NOR2_X1
XI976_I79_XG I976_pn13 I976_gn12 I976_gn13 I976_G13_12 VDD VSS OAI21_X1
XI976_I79_XP I976_pn13 I976_pn12 I976_P13_12 VDD VSS NOR2_X1
XI976_I80_XG I976_pn14 I976_gn13 I976_gn14 I976_G14_13 VDD VSS OAI21_X1
XI976_I80_XP I976_pn14 I976_pn13 I976_P14_13 VDD VSS NOR2_X1
XI976_I81_XG I976_pn15 I976_gn14 I976_gn15 I976_G15_14 VDD VSS OAI21_X1
XI976_I81_XP I976_pn15 I976_pn14 I976_P15_14 VDD VSS NOR2_X1
XI976_I82_XG I976_pn16 I976_gn15 I976_gn16 I976_G16_15 VDD VSS OAI21_X1
XI976_I82_XP I976_pn16 I976_pn15 I976_P16_15 VDD VSS NOR2_X1
XI976_I83_XG I976_pn17 I976_gn16 I976_gn17 I976_G17_16 VDD VSS OAI21_X1
XI976_I83_XP I976_pn17 I976_pn16 I976_P17_16 VDD VSS NOR2_X1
XI976_I84_XG I976_pn18 I976_gn17 I976_gn18 I976_G18_17 VDD VSS OAI21_X1
XI976_I84_XP I976_pn18 I976_pn17 I976_P18_17 VDD VSS NOR2_X1
XI976_I85_XG I976_pn19 I976_gn18 I976_gn19 I976_G19_18 VDD VSS OAI21_X1
XI976_I85_XP I976_pn19 I976_pn18 I976_P19_18 VDD VSS NOR2_X1
XI976_I86_XG I976_pn20 I976_gn19 I976_gn20 I976_G20_19 VDD VSS OAI21_X1
XI976_I86_XP I976_pn20 I976_pn19 I976_P20_19 VDD VSS NOR2_X1
XI976_I87_XG I976_pn21 I976_gn20 I976_gn21 I976_G21_20 VDD VSS OAI21_X1
XI976_I87_XP I976_pn21 I976_pn20 I976_P21_20 VDD VSS NOR2_X1
XI976_I88_XG I976_pn22 I976_gn21 I976_gn22 I976_G22_21 VDD VSS OAI21_X1
XI976_I88_XP I976_pn22 I976_pn21 I976_P22_21 VDD VSS NOR2_X1
XI976_I89_XG I976_pn23 I976_gn22 I976_gn23 I976_G23_22 VDD VSS OAI21_X1
XI976_I89_XP I976_pn23 I976_pn22 I976_P23_22 VDD VSS NOR2_X1
XI976_I90_XG I976_pn24 I976_gn23 I976_gn24 I976_G24_23 VDD VSS OAI21_X1
XI976_I90_XP I976_pn24 I976_pn23 I976_P24_23 VDD VSS NOR2_X1
XI976_I91_XG I976_pn25 I976_gn24 I976_gn25 I976_G25_24 VDD VSS OAI21_X1
XI976_I91_XP I976_pn25 I976_pn24 I976_P25_24 VDD VSS NOR2_X1
XI976_I92_XG I976_pn26 I976_gn25 I976_gn26 I976_G26_25 VDD VSS OAI21_X1
XI976_I92_XP I976_pn26 I976_pn25 I976_P26_25 VDD VSS NOR2_X1
XI976_I93_XG I976_pn27 I976_gn26 I976_gn27 I976_G27_26 VDD VSS OAI21_X1
XI976_I93_XP I976_pn27 I976_pn26 I976_P27_26 VDD VSS NOR2_X1
XI976_I94_XG I976_pn28 I976_gn27 I976_gn28 I976_G28_27 VDD VSS OAI21_X1
XI976_I94_XP I976_pn28 I976_pn27 I976_P28_27 VDD VSS NOR2_X1
XI976_I95_XG I976_pn29 I976_gn28 I976_gn29 I976_G29_28 VDD VSS OAI21_X1
XI976_I95_XP I976_pn29 I976_pn28 I976_P29_28 VDD VSS NOR2_X1
XI976_I96_XG I976_pn30 I976_gn29 I976_gn30 I976_G30_29 VDD VSS OAI21_X1
XI976_I96_XP I976_pn30 I976_pn29 I976_P30_29 VDD VSS NOR2_X1
XI976_I97_XG I976_pn31 I976_gn30 I976_gn31 I976_G31_30 VDD VSS OAI21_X1
XI976_I97_XP I976_pn31 I976_pn30 I976_P31_30 VDD VSS NOR2_X1
XI976_I98_XG I976_P2_1 I976_G0_0 I976_G2_1 I976_G2_0n VDD VSS AOI21_X1
XI976_I99_XG I976_P3_2 I976_G1_0 I976_G3_2 I976_G3_0n VDD VSS AOI21_X1
XI976_I100_XG I976_P4_3 I976_G2_1 I976_G4_3 I976_G4_1n VDD VSS AOI21_X1
XI976_I100_XP I976_P4_3 I976_P2_1 I976_P4_1n VDD VSS NAND2_X1
XI976_I101_XG I976_P5_4 I976_G3_2 I976_G5_4 I976_G5_2n VDD VSS AOI21_X1
XI976_I101_XP I976_P5_4 I976_P3_2 I976_P5_2n VDD VSS NAND2_X1
XI976_I102_XG I976_P6_5 I976_G4_3 I976_G6_5 I976_G6_3n VDD VSS AOI21_X1
XI976_I102_XP I976_P6_5 I976_P4_3 I976_P6_3n VDD VSS NAND2_X1
XI976_I103_XG I976_P7_6 I976_G5_4 I976_G7_6 I976_G7_4n VDD VSS AOI21_X1
XI976_I103_XP I976_P7_6 I976_P5_4 I976_P7_4n VDD VSS NAND2_X1
XI976_I104_XG I976_P8_7 I976_G6_5 I976_G8_7 I976_G8_5n VDD VSS AOI21_X1
XI976_I104_XP I976_P8_7 I976_P6_5 I976_P8_5n VDD VSS NAND2_X1
XI976_I105_XG I976_P9_8 I976_G7_6 I976_G9_8 I976_G9_6n VDD VSS AOI21_X1
XI976_I105_XP I976_P9_8 I976_P7_6 I976_P9_6n VDD VSS NAND2_X1
XI976_I106_XG I976_P10_9 I976_G8_7 I976_G10_9 I976_G10_7n VDD VSS AOI21_X1
XI976_I106_XP I976_P10_9 I976_P8_7 I976_P10_7n VDD VSS NAND2_X1
XI976_I107_XG I976_P11_10 I976_G9_8 I976_G11_10 I976_G11_8n VDD VSS AOI21_X1
XI976_I107_XP I976_P11_10 I976_P9_8 I976_P11_8n VDD VSS NAND2_X1
XI976_I108_XG I976_P12_11 I976_G10_9 I976_G12_11 I976_G12_9n VDD VSS AOI21_X1
XI976_I108_XP I976_P12_11 I976_P10_9 I976_P12_9n VDD VSS NAND2_X1
XI976_I109_XG I976_P13_12 I976_G11_10 I976_G13_12 I976_G13_10n VDD VSS AOI21_X1
XI976_I109_XP I976_P13_12 I976_P11_10 I976_P13_10n VDD VSS NAND2_X1
XI976_I110_XG I976_P14_13 I976_G12_11 I976_G14_13 I976_G14_11n VDD VSS AOI21_X1
XI976_I110_XP I976_P14_13 I976_P12_11 I976_P14_11n VDD VSS NAND2_X1
XI976_I111_XG I976_P15_14 I976_G13_12 I976_G15_14 I976_G15_12n VDD VSS AOI21_X1
XI976_I111_XP I976_P15_14 I976_P13_12 I976_P15_12n VDD VSS NAND2_X1
XI976_I112_XG I976_P16_15 I976_G14_13 I976_G16_15 I976_G16_13n VDD VSS AOI21_X1
XI976_I112_XP I976_P16_15 I976_P14_13 I976_P16_13n VDD VSS NAND2_X1
XI976_I113_XG I976_P17_16 I976_G15_14 I976_G17_16 I976_G17_14n VDD VSS AOI21_X1
XI976_I113_XP I976_P17_16 I976_P15_14 I976_P17_14n VDD VSS NAND2_X1
XI976_I114_XG I976_P18_17 I976_G16_15 I976_G18_17 I976_G18_15n VDD VSS AOI21_X1
XI976_I114_XP I976_P18_17 I976_P16_15 I976_P18_15n VDD VSS NAND2_X1
XI976_I115_XG I976_P19_18 I976_G17_16 I976_G19_18 I976_G19_16n VDD VSS AOI21_X1
XI976_I115_XP I976_P19_18 I976_P17_16 I976_P19_16n VDD VSS NAND2_X1
XI976_I116_XG I976_P20_19 I976_G18_17 I976_G20_19 I976_G20_17n VDD VSS AOI21_X1
XI976_I116_XP I976_P20_19 I976_P18_17 I976_P20_17n VDD VSS NAND2_X1
XI976_I117_XG I976_P21_20 I976_G19_18 I976_G21_20 I976_G21_18n VDD VSS AOI21_X1
XI976_I117_XP I976_P21_20 I976_P19_18 I976_P21_18n VDD VSS NAND2_X1
XI976_I118_XG I976_P22_21 I976_G20_19 I976_G22_21 I976_G22_19n VDD VSS AOI21_X1
XI976_I118_XP I976_P22_21 I976_P20_19 I976_P22_19n VDD VSS NAND2_X1
XI976_I119_XG I976_P23_22 I976_G21_20 I976_G23_22 I976_G23_20n VDD VSS AOI21_X1
XI976_I119_XP I976_P23_22 I976_P21_20 I976_P23_20n VDD VSS NAND2_X1
XI976_I120_XG I976_P24_23 I976_G22_21 I976_G24_23 I976_G24_21n VDD VSS AOI21_X1
XI976_I120_XP I976_P24_23 I976_P22_21 I976_P24_21n VDD VSS NAND2_X1
XI976_I121_XG I976_P25_24 I976_G23_22 I976_G25_24 I976_G25_22n VDD VSS AOI21_X1
XI976_I121_XP I976_P25_24 I976_P23_22 I976_P25_22n VDD VSS NAND2_X1
XI976_I122_XG I976_P26_25 I976_G24_23 I976_G26_25 I976_G26_23n VDD VSS AOI21_X1
XI976_I122_XP I976_P26_25 I976_P24_23 I976_P26_23n VDD VSS NAND2_X1
XI976_I123_XG I976_P27_26 I976_G25_24 I976_G27_26 I976_G27_24n VDD VSS AOI21_X1
XI976_I123_XP I976_P27_26 I976_P25_24 I976_P27_24n VDD VSS NAND2_X1
XI976_I124_XG I976_P28_27 I976_G26_25 I976_G28_27 I976_G28_25n VDD VSS AOI21_X1
XI976_I124_XP I976_P28_27 I976_P26_25 I976_P28_25n VDD VSS NAND2_X1
XI976_I125_XG I976_P29_28 I976_G27_26 I976_G29_28 I976_G29_26n VDD VSS AOI21_X1
XI976_I125_XP I976_P29_28 I976_P27_26 I976_P29_26n VDD VSS NAND2_X1
XI976_I126_XG I976_P30_29 I976_G28_27 I976_G30_29 I976_G30_27n VDD VSS AOI21_X1
XI976_I126_XP I976_P30_29 I976_P28_27 I976_P30_27n VDD VSS NAND2_X1
XI976_I127_XG I976_P31_30 I976_G29_28 I976_G31_30 I976_G31_28n VDD VSS AOI21_X1
XI976_I127_XP I976_P31_30 I976_P29_28 I976_P31_28n VDD VSS NAND2_X1
XI976_I128_XG I976_P4_1n I976_G0_0n I976_G4_1n I976_G4_0 VDD VSS OAI21_X1
XI976_I129 I976_G1_0 I976_G1_0n VDD VSS INV_X1
XI976_I130_XG I976_P5_2n I976_G1_0n I976_G5_2n I976_G5_0 VDD VSS OAI21_X1
XI976_I131_XG I976_P6_3n I976_G2_0n I976_G6_3n I976_G6_0 VDD VSS OAI21_X1
XI976_I132_XG I976_P7_4n I976_G3_0n I976_G7_4n I976_G7_0 VDD VSS OAI21_X1
XI976_I133_XG I976_P8_5n I976_G4_1n I976_G8_5n I976_G8_1 VDD VSS OAI21_X1
XI976_I133_XP I976_P8_5n I976_P4_1n I976_P8_1 VDD VSS NOR2_X1
XI976_I134_XG I976_P9_6n I976_G5_2n I976_G9_6n I976_G9_2 VDD VSS OAI21_X1
XI976_I134_XP I976_P9_6n I976_P5_2n I976_P9_2 VDD VSS NOR2_X1
XI976_I135_XG I976_P10_7n I976_G6_3n I976_G10_7n I976_G10_3 VDD VSS OAI21_X1
XI976_I135_XP I976_P10_7n I976_P6_3n I976_P10_3 VDD VSS NOR2_X1
XI976_I136_XG I976_P11_8n I976_G7_4n I976_G11_8n I976_G11_4 VDD VSS OAI21_X1
XI976_I136_XP I976_P11_8n I976_P7_4n I976_P11_4 VDD VSS NOR2_X1
XI976_I137_XG I976_P12_9n I976_G8_5n I976_G12_9n I976_G12_5 VDD VSS OAI21_X1
XI976_I137_XP I976_P12_9n I976_P8_5n I976_P12_5 VDD VSS NOR2_X1
XI976_I138_XG I976_P13_10n I976_G9_6n I976_G13_10n I976_G13_6 VDD VSS OAI21_X1
XI976_I138_XP I976_P13_10n I976_P9_6n I976_P13_6 VDD VSS NOR2_X1
XI976_I139_XG I976_P14_11n I976_G10_7n I976_G14_11n I976_G14_7 VDD VSS OAI21_X1
XI976_I139_XP I976_P14_11n I976_P10_7n I976_P14_7 VDD VSS NOR2_X1
XI976_I140_XG I976_P15_12n I976_G11_8n I976_G15_12n I976_G15_8 VDD VSS OAI21_X1
XI976_I140_XP I976_P15_12n I976_P11_8n I976_P15_8 VDD VSS NOR2_X1
XI976_I141_XG I976_P16_13n I976_G12_9n I976_G16_13n I976_G16_9 VDD VSS OAI21_X1
XI976_I141_XP I976_P16_13n I976_P12_9n I976_P16_9 VDD VSS NOR2_X1
XI976_I142_XG I976_P17_14n I976_G13_10n I976_G17_14n I976_G17_10 VDD VSS OAI21_X1
XI976_I142_XP I976_P17_14n I976_P13_10n I976_P17_10 VDD VSS NOR2_X1
XI976_I143_XG I976_P18_15n I976_G14_11n I976_G18_15n I976_G18_11 VDD VSS OAI21_X1
XI976_I143_XP I976_P18_15n I976_P14_11n I976_P18_11 VDD VSS NOR2_X1
XI976_I144_XG I976_P19_16n I976_G15_12n I976_G19_16n I976_G19_12 VDD VSS OAI21_X1
XI976_I144_XP I976_P19_16n I976_P15_12n I976_P19_12 VDD VSS NOR2_X1
XI976_I145_XG I976_P20_17n I976_G16_13n I976_G20_17n I976_G20_13 VDD VSS OAI21_X1
XI976_I145_XP I976_P20_17n I976_P16_13n I976_P20_13 VDD VSS NOR2_X1
XI976_I146_XG I976_P21_18n I976_G17_14n I976_G21_18n I976_G21_14 VDD VSS OAI21_X1
XI976_I146_XP I976_P21_18n I976_P17_14n I976_P21_14 VDD VSS NOR2_X1
XI976_I147_XG I976_P22_19n I976_G18_15n I976_G22_19n I976_G22_15 VDD VSS OAI21_X1
XI976_I147_XP I976_P22_19n I976_P18_15n I976_P22_15 VDD VSS NOR2_X1
XI976_I148_XG I976_P23_20n I976_G19_16n I976_G23_20n I976_G23_16 VDD VSS OAI21_X1
XI976_I148_XP I976_P23_20n I976_P19_16n I976_P23_16 VDD VSS NOR2_X1
XI976_I149_XG I976_P24_21n I976_G20_17n I976_G24_21n I976_G24_17 VDD VSS OAI21_X1
XI976_I149_XP I976_P24_21n I976_P20_17n I976_P24_17 VDD VSS NOR2_X1
XI976_I150_XG I976_P25_22n I976_G21_18n I976_G25_22n I976_G25_18 VDD VSS OAI21_X1
XI976_I150_XP I976_P25_22n I976_P21_18n I976_P25_18 VDD VSS NOR2_X1
XI976_I151_XG I976_P26_23n I976_G22_19n I976_G26_23n I976_G26_19 VDD VSS OAI21_X1
XI976_I151_XP I976_P26_23n I976_P22_19n I976_P26_19 VDD VSS NOR2_X1
XI976_I152_XG I976_P27_24n I976_G23_20n I976_G27_24n I976_G27_20 VDD VSS OAI21_X1
XI976_I152_XP I976_P27_24n I976_P23_20n I976_P27_20 VDD VSS NOR2_X1
XI976_I153_XG I976_P28_25n I976_G24_21n I976_G28_25n I976_G28_21 VDD VSS OAI21_X1
XI976_I153_XP I976_P28_25n I976_P24_21n I976_P28_21 VDD VSS NOR2_X1
XI976_I154_XG I976_P29_26n I976_G25_22n I976_G29_26n I976_G29_22 VDD VSS OAI21_X1
XI976_I154_XP I976_P29_26n I976_P25_22n I976_P29_22 VDD VSS NOR2_X1
XI976_I155_XG I976_P30_27n I976_G26_23n I976_G30_27n I976_G30_23 VDD VSS OAI21_X1
XI976_I155_XP I976_P30_27n I976_P26_23n I976_P30_23 VDD VSS NOR2_X1
XI976_I156_XG I976_P31_28n I976_G27_24n I976_G31_28n I976_G31_24 VDD VSS OAI21_X1
XI976_I156_XP I976_P31_28n I976_P27_24n I976_P31_24 VDD VSS NOR2_X1
XI976_I157_XG I976_P8_1 I976_G0_0 I976_G8_1 I976_G8_0n VDD VSS AOI21_X1
XI976_I158_XG I976_P9_2 I976_G1_0 I976_G9_2 I976_G9_0n VDD VSS AOI21_X1
XI976_I159 I976_G2_0n I976_G2_0np VDD VSS INV_X1
XI976_I160_XG I976_P10_3 I976_G2_0np I976_G10_3 I976_G10_0n VDD VSS AOI21_X1
XI976_I161 I976_G3_0n I976_G3_0np VDD VSS INV_X1
XI976_I162_XG I976_P11_4 I976_G3_0np I976_G11_4 I976_G11_0n VDD VSS AOI21_X1
XI976_I163_XG I976_P12_5 I976_G4_0 I976_G12_5 I976_G12_0n VDD VSS AOI21_X1
XI976_I164_XG I976_P13_6 I976_G5_0 I976_G13_6 I976_G13_0n VDD VSS AOI21_X1
XI976_I165_XG I976_P14_7 I976_G6_0 I976_G14_7 I976_G14_0n VDD VSS AOI21_X1
XI976_I166_XG I976_P15_8 I976_G7_0 I976_G15_8 I976_G15_0n VDD VSS AOI21_X1
XI976_I167_XG I976_P16_9 I976_G8_1 I976_G16_9 I976_G16_1n VDD VSS AOI21_X1
XI976_I167_XP I976_P16_9 I976_P8_1 I976_P16_1n VDD VSS NAND2_X1
XI976_I168_XG I976_P17_10 I976_G9_2 I976_G17_10 I976_G17_2n VDD VSS AOI21_X1
XI976_I168_XP I976_P17_10 I976_P9_2 I976_P17_2n VDD VSS NAND2_X1
XI976_I169_XG I976_P18_11 I976_G10_3 I976_G18_11 I976_G18_3n VDD VSS AOI21_X1
XI976_I169_XP I976_P18_11 I976_P10_3 I976_P18_3n VDD VSS NAND2_X1
XI976_I170_XG I976_P19_12 I976_G11_4 I976_G19_12 I976_G19_4n VDD VSS AOI21_X1
XI976_I170_XP I976_P19_12 I976_P11_4 I976_P19_4n VDD VSS NAND2_X1
XI976_I171_XG I976_P20_13 I976_G12_5 I976_G20_13 I976_G20_5n VDD VSS AOI21_X1
XI976_I171_XP I976_P20_13 I976_P12_5 I976_P20_5n VDD VSS NAND2_X1
XI976_I172_XG I976_P21_14 I976_G13_6 I976_G21_14 I976_G21_6n VDD VSS AOI21_X1
XI976_I172_XP I976_P21_14 I976_P13_6 I976_P21_6n VDD VSS NAND2_X1
XI976_I173_XG I976_P22_15 I976_G14_7 I976_G22_15 I976_G22_7n VDD VSS AOI21_X1
XI976_I173_XP I976_P22_15 I976_P14_7 I976_P22_7n VDD VSS NAND2_X1
XI976_I174_XG I976_P23_16 I976_G15_8 I976_G23_16 I976_G23_8n VDD VSS AOI21_X1
XI976_I174_XP I976_P23_16 I976_P15_8 I976_P23_8n VDD VSS NAND2_X1
XI976_I175_XG I976_P24_17 I976_G16_9 I976_G24_17 I976_G24_9n VDD VSS AOI21_X1
XI976_I175_XP I976_P24_17 I976_P16_9 I976_P24_9n VDD VSS NAND2_X1
XI976_I176_XG I976_P25_18 I976_G17_10 I976_G25_18 I976_G25_10n VDD VSS AOI21_X1
XI976_I176_XP I976_P25_18 I976_P17_10 I976_P25_10n VDD VSS NAND2_X1
XI976_I177_XG I976_P26_19 I976_G18_11 I976_G26_19 I976_G26_11n VDD VSS AOI21_X1
XI976_I177_XP I976_P26_19 I976_P18_11 I976_P26_11n VDD VSS NAND2_X1
XI976_I178_XG I976_P27_20 I976_G19_12 I976_G27_20 I976_G27_12n VDD VSS AOI21_X1
XI976_I178_XP I976_P27_20 I976_P19_12 I976_P27_12n VDD VSS NAND2_X1
XI976_I179_XG I976_P28_21 I976_G20_13 I976_G28_21 I976_G28_13n VDD VSS AOI21_X1
XI976_I179_XP I976_P28_21 I976_P20_13 I976_P28_13n VDD VSS NAND2_X1
XI976_I180_XG I976_P29_22 I976_G21_14 I976_G29_22 I976_G29_14n VDD VSS AOI21_X1
XI976_I180_XP I976_P29_22 I976_P21_14 I976_P29_14n VDD VSS NAND2_X1
XI976_I181_XG I976_P30_23 I976_G22_15 I976_G30_23 I976_G30_15n VDD VSS AOI21_X1
XI976_I181_XP I976_P30_23 I976_P22_15 I976_P30_15n VDD VSS NAND2_X1
XI976_I182_XG I976_P31_24 I976_G23_16 I976_G31_24 I976_G31_16n VDD VSS AOI21_X1
XI976_I182_XP I976_P31_24 I976_P23_16 I976_P31_16n VDD VSS NAND2_X1
XI976_I183_XG I976_P16_1n I976_G0_0n I976_G16_1n I976_G16_0 VDD VSS OAI21_X1
XI976_I184_XG I976_P17_2n I976_G1_0n I976_G17_2n I976_G17_0 VDD VSS OAI21_X1
XI976_I185_XG I976_P18_3n I976_G2_0n I976_G18_3n I976_G18_0 VDD VSS OAI21_X1
XI976_I186_XG I976_P19_4n I976_G3_0n I976_G19_4n I976_G19_0 VDD VSS OAI21_X1
XI976_I187 I976_G4_0 I976_G4_0n VDD VSS INV_X1
XI976_I188_XG I976_P20_5n I976_G4_0n I976_G20_5n I976_G20_0 VDD VSS OAI21_X1
XI976_I189 I976_G5_0 I976_G5_0n VDD VSS INV_X1
XI976_I190_XG I976_P21_6n I976_G5_0n I976_G21_6n I976_G21_0 VDD VSS OAI21_X1
XI976_I191 I976_G6_0 I976_G6_0n VDD VSS INV_X1
XI976_I192_XG I976_P22_7n I976_G6_0n I976_G22_7n I976_G22_0 VDD VSS OAI21_X1
XI976_I193 I976_G7_0 I976_G7_0n VDD VSS INV_X1
XI976_I194_XG I976_P23_8n I976_G7_0n I976_G23_8n I976_G23_0 VDD VSS OAI21_X1
XI976_I195_XG I976_P24_9n I976_G8_0n I976_G24_9n I976_G24_0 VDD VSS OAI21_X1
XI976_I196_XG I976_P25_10n I976_G9_0n I976_G25_10n I976_G25_0 VDD VSS OAI21_X1
XI976_I197_XG I976_P26_11n I976_G10_0n I976_G26_11n I976_G26_0 VDD VSS OAI21_X1
XI976_I198_XG I976_P27_12n I976_G11_0n I976_G27_12n I976_G27_0 VDD VSS OAI21_X1
XI976_I199_XG I976_P28_13n I976_G12_0n I976_G28_13n I976_G28_0 VDD VSS OAI21_X1
XI976_I200_XG I976_P29_14n I976_G13_0n I976_G29_14n I976_G29_0 VDD VSS OAI21_X1
XI976_I201_XG I976_P30_15n I976_G14_0n I976_G30_15n c9_m VDD VSS OAI21_X1
XI976_I202_XG I976_P31_16n I976_G15_0n I976_G31_16n c9_o VDD VSS OAI21_X1
XI976_I203 I976_pn0 qu23_b3_5 p9_0 VDD VSS XNOR2_X1
XI976_I204 I976_pn1 I976_G0_0 p9_1 VDD VSS XNOR2_X1
XI976_I205 I976_pn2 I976_G1_0 p9_2 VDD VSS XNOR2_X1
XI976_I206 I976_pn3 I976_G2_0n p9_3 VDD VSS XOR2_X1
XI976_I207 I976_pn4 I976_G3_0n p9_4 VDD VSS XOR2_X1
XI976_I208 I976_pn5 I976_G4_0 p9_5 VDD VSS XNOR2_X1
XI976_I209 I976_pn6 I976_G5_0 p9_6 VDD VSS XNOR2_X1
XI976_I210 I976_pn7 I976_G6_0 p9_7 VDD VSS XNOR2_X1
XI976_I211 I976_pn8 I976_G7_0 p9_8 VDD VSS XNOR2_X1
XI976_I212 I976_pn9 I976_G8_0n p9_9 VDD VSS XOR2_X1
XI976_I213 I976_pn10 I976_G9_0n p9_10 VDD VSS XOR2_X1
XI976_I214 I976_pn11 I976_G10_0n p9_11 VDD VSS XOR2_X1
XI976_I215 I976_pn12 I976_G11_0n p9_12 VDD VSS XOR2_X1
XI976_I216 I976_pn13 I976_G12_0n p9_13 VDD VSS XOR2_X1
XI976_I217 I976_pn14 I976_G13_0n p9_14 VDD VSS XOR2_X1
XI976_I218 I976_pn15 I976_G14_0n p9_15 VDD VSS XOR2_X1
XI976_I219 I976_pn16 I976_G15_0n p9_16 VDD VSS XOR2_X1
XI976_I220 I976_pn17 I976_G16_0 p9_17 VDD VSS XNOR2_X1
XI976_I221 I976_pn18 I976_G17_0 p9_18 VDD VSS XNOR2_X1
XI976_I222 I976_pn19 I976_G18_0 p9_19 VDD VSS XNOR2_X1
XI976_I223 I976_pn20 I976_G19_0 p9_20 VDD VSS XNOR2_X1
XI976_I224 I976_pn21 I976_G20_0 p9_21 VDD VSS XNOR2_X1
XI976_I225 I976_pn22 I976_G21_0 p9_22 VDD VSS XNOR2_X1
XI976_I226 I976_pn23 I976_G22_0 p9_23 VDD VSS XNOR2_X1
XI976_I227 I976_pn24 I976_G23_0 p9_24 VDD VSS XNOR2_X1
XI976_I228 I976_pn25 I976_G24_0 p9_25 VDD VSS XNOR2_X1
XI976_I229 I976_pn26 I976_G25_0 p9_26 VDD VSS XNOR2_X1
XI976_I230 I976_pn27 I976_G26_0 p9_27 VDD VSS XNOR2_X1
XI976_I231 I976_pn28 I976_G27_0 p9_28 VDD VSS XNOR2_X1
XI976_I232 I976_pn29 I976_G28_0 p9_29 VDD VSS XNOR2_X1
XI976_I233 I976_pn30 I976_G29_0 p9_30 VDD VSS XNOR2_X1
XI976_I234 I976_pn31 c9_m p9_31 VDD VSS XNOR2_X1
XI977 p8_31 qu23_b3_5 h9 VDD VSS XOR2_X1
XI978 h9 c9_o p9_32 VDD VSS XOR2_X1
XI979 p9_32 qu22 VDD VSS INV_X4
XI980 qu22 qu22_b0 VDD VSS INV_X1
XI981 qu22_b0 qu22_b1_0 VDD VSS INV_X4
XI982 qu22_b1_0 qu22_b2_0 VDD VSS INV_X4
XI983 qu22_b1_0 qu22_b2_1 VDD VSS INV_X4
XI984 qu22_b2_0 qu22_b3_0 VDD VSS INV_X4
XI985 qu22_b2_0 qu22_b3_1 VDD VSS INV_X4
XI986 qu22_b2_0 qu22_b3_2 VDD VSS INV_X4
XI987 qu22_b2_1 qu22_b3_3 VDD VSS INV_X4
XI988 qu22_b2_1 qu22_b3_4 VDD VSS INV_X4
XI989 qu22_b2_1 qu22_b3_5 VDD VSS INV_X4
XI990 B_0_b3_1 qu22_b3_0 b10_0 VDD VSS XOR2_X1
XI991 dd1_b3_1 qu22_b3_0 b10_1 VDD VSS XOR2_X1
XI992 dd2_b3_1 qu22_b3_0 b10_2 VDD VSS XOR2_X1
XI993 dd3_b3_1 qu22_b3_0 b10_3 VDD VSS XOR2_X1
XI994 dd4_b3_1 qu22_b3_0 b10_4 VDD VSS XOR2_X1
XI995 dd5_b3_1 qu22_b3_0 b10_5 VDD VSS XOR2_X1
XI996 dd6_b3_1 qu22_b3_1 b10_6 VDD VSS XOR2_X1
XI997 dd7_b3_1 qu22_b3_1 b10_7 VDD VSS XOR2_X1
XI998 dd8_b3_1 qu22_b3_1 b10_8 VDD VSS XOR2_X1
XI999 dd9_b3_1 qu22_b3_1 b10_9 VDD VSS XOR2_X1
XI1000 dd10_b3_1 qu22_b3_1 b10_10 VDD VSS XOR2_X1
XI1001 dd11_b3_1 qu22_b3_1 b10_11 VDD VSS XOR2_X1
XI1002 dd12_b3_1 qu22_b3_2 b10_12 VDD VSS XOR2_X1
XI1003 dd13_b3_1 qu22_b3_2 b10_13 VDD VSS XOR2_X1
XI1004 dd14_b3_1 qu22_b3_2 b10_14 VDD VSS XOR2_X1
XI1005 dd15_b3_1 qu22_b3_2 b10_15 VDD VSS XOR2_X1
XI1006 dd16_b3_1 qu22_b3_2 b10_16 VDD VSS XOR2_X1
XI1007 dd17_b3_1 qu22_b3_2 b10_17 VDD VSS XOR2_X1
XI1008 dd18_b3_1 qu22_b3_3 b10_18 VDD VSS XOR2_X1
XI1009 dd19_b3_1 qu22_b3_3 b10_19 VDD VSS XOR2_X1
XI1010 dd20_b3_1 qu22_b3_3 b10_20 VDD VSS XOR2_X1
XI1011 dd21_b3_1 qu22_b3_3 b10_21 VDD VSS XOR2_X1
XI1012 dd22_b3_1 qu22_b3_3 b10_22 VDD VSS XOR2_X1
XI1013 dd23_b3_1 qu22_b3_3 b10_23 VDD VSS XOR2_X1
XI1014 dd24_b3_1 qu22_b3_4 b10_24 VDD VSS XOR2_X1
XI1015 dd25_b3_1 qu22_b3_4 b10_25 VDD VSS XOR2_X1
XI1016 dd26_b3_1 qu22_b3_4 b10_26 VDD VSS XOR2_X1
XI1017 dd27_b3_1 qu22_b3_4 b10_27 VDD VSS XOR2_X1
XI1018 dd28_b3_1 qu22_b3_4 b10_28 VDD VSS XOR2_X1
XI1019 dd29_b3_1 qu22_b3_4 b10_29 VDD VSS XOR2_X1
XI1020 dd30_b3_1 qu22_b3_5 b10_30 VDD VSS XOR2_X1
XI1021 dd31_b3_1 qu22_b3_5 b10_31 VDD VSS XOR2_X1
XI1022_I0 aa21 b10_0 I1022_gn0 VDD VSS NAND2_X1
XI1022_I1 p9_0 b10_1 I1022_gn1 VDD VSS NAND2_X1
XI1022_I2 p9_1 b10_2 I1022_gn2 VDD VSS NAND2_X1
XI1022_I3 p9_2 b10_3 I1022_gn3 VDD VSS NAND2_X1
XI1022_I4 p9_3 b10_4 I1022_gn4 VDD VSS NAND2_X1
XI1022_I5 p9_4 b10_5 I1022_gn5 VDD VSS NAND2_X1
XI1022_I6 p9_5 b10_6 I1022_gn6 VDD VSS NAND2_X1
XI1022_I7 p9_6 b10_7 I1022_gn7 VDD VSS NAND2_X1
XI1022_I8 p9_7 b10_8 I1022_gn8 VDD VSS NAND2_X1
XI1022_I9 p9_8 b10_9 I1022_gn9 VDD VSS NAND2_X1
XI1022_I10 p9_9 b10_10 I1022_gn10 VDD VSS NAND2_X1
XI1022_I11 p9_10 b10_11 I1022_gn11 VDD VSS NAND2_X1
XI1022_I12 p9_11 b10_12 I1022_gn12 VDD VSS NAND2_X1
XI1022_I13 p9_12 b10_13 I1022_gn13 VDD VSS NAND2_X1
XI1022_I14 p9_13 b10_14 I1022_gn14 VDD VSS NAND2_X1
XI1022_I15 p9_14 b10_15 I1022_gn15 VDD VSS NAND2_X1
XI1022_I16 p9_15 b10_16 I1022_gn16 VDD VSS NAND2_X1
XI1022_I17 p9_16 b10_17 I1022_gn17 VDD VSS NAND2_X1
XI1022_I18 p9_17 b10_18 I1022_gn18 VDD VSS NAND2_X1
XI1022_I19 p9_18 b10_19 I1022_gn19 VDD VSS NAND2_X1
XI1022_I20 p9_19 b10_20 I1022_gn20 VDD VSS NAND2_X1
XI1022_I21 p9_20 b10_21 I1022_gn21 VDD VSS NAND2_X1
XI1022_I22 p9_21 b10_22 I1022_gn22 VDD VSS NAND2_X1
XI1022_I23 p9_22 b10_23 I1022_gn23 VDD VSS NAND2_X1
XI1022_I24 p9_23 b10_24 I1022_gn24 VDD VSS NAND2_X1
XI1022_I25 p9_24 b10_25 I1022_gn25 VDD VSS NAND2_X1
XI1022_I26 p9_25 b10_26 I1022_gn26 VDD VSS NAND2_X1
XI1022_I27 p9_26 b10_27 I1022_gn27 VDD VSS NAND2_X1
XI1022_I28 p9_27 b10_28 I1022_gn28 VDD VSS NAND2_X1
XI1022_I29 p9_28 b10_29 I1022_gn29 VDD VSS NAND2_X1
XI1022_I30 p9_29 b10_30 I1022_gn30 VDD VSS NAND2_X1
XI1022_I31 p9_30 b10_31 I1022_gn31 VDD VSS NAND2_X1
XI1022_I32 aa21 b10_0 I1022_pn0 VDD VSS XNOR2_X1
XI1022_I33 p9_0 b10_1 I1022_pn1 VDD VSS XNOR2_X1
XI1022_I34 p9_1 b10_2 I1022_pn2 VDD VSS XNOR2_X1
XI1022_I35 p9_2 b10_3 I1022_pn3 VDD VSS XNOR2_X1
XI1022_I36 p9_3 b10_4 I1022_pn4 VDD VSS XNOR2_X1
XI1022_I37 p9_4 b10_5 I1022_pn5 VDD VSS XNOR2_X1
XI1022_I38 p9_5 b10_6 I1022_pn6 VDD VSS XNOR2_X1
XI1022_I39 p9_6 b10_7 I1022_pn7 VDD VSS XNOR2_X1
XI1022_I40 p9_7 b10_8 I1022_pn8 VDD VSS XNOR2_X1
XI1022_I41 p9_8 b10_9 I1022_pn9 VDD VSS XNOR2_X1
XI1022_I42 p9_9 b10_10 I1022_pn10 VDD VSS XNOR2_X1
XI1022_I43 p9_10 b10_11 I1022_pn11 VDD VSS XNOR2_X1
XI1022_I44 p9_11 b10_12 I1022_pn12 VDD VSS XNOR2_X1
XI1022_I45 p9_12 b10_13 I1022_pn13 VDD VSS XNOR2_X1
XI1022_I46 p9_13 b10_14 I1022_pn14 VDD VSS XNOR2_X1
XI1022_I47 p9_14 b10_15 I1022_pn15 VDD VSS XNOR2_X1
XI1022_I48 p9_15 b10_16 I1022_pn16 VDD VSS XNOR2_X1
XI1022_I49 p9_16 b10_17 I1022_pn17 VDD VSS XNOR2_X1
XI1022_I50 p9_17 b10_18 I1022_pn18 VDD VSS XNOR2_X1
XI1022_I51 p9_18 b10_19 I1022_pn19 VDD VSS XNOR2_X1
XI1022_I52 p9_19 b10_20 I1022_pn20 VDD VSS XNOR2_X1
XI1022_I53 p9_20 b10_21 I1022_pn21 VDD VSS XNOR2_X1
XI1022_I54 p9_21 b10_22 I1022_pn22 VDD VSS XNOR2_X1
XI1022_I55 p9_22 b10_23 I1022_pn23 VDD VSS XNOR2_X1
XI1022_I56 p9_23 b10_24 I1022_pn24 VDD VSS XNOR2_X1
XI1022_I57 p9_24 b10_25 I1022_pn25 VDD VSS XNOR2_X1
XI1022_I58 p9_25 b10_26 I1022_pn26 VDD VSS XNOR2_X1
XI1022_I59 p9_26 b10_27 I1022_pn27 VDD VSS XNOR2_X1
XI1022_I60 p9_27 b10_28 I1022_pn28 VDD VSS XNOR2_X1
XI1022_I61 p9_28 b10_29 I1022_pn29 VDD VSS XNOR2_X1
XI1022_I62 p9_29 b10_30 I1022_pn30 VDD VSS XNOR2_X1
XI1022_I63 p9_30 b10_31 I1022_pn31 VDD VSS XNOR2_X1
XI1022_I64 qu22_b3_5 I1022_cinn VDD VSS INV_X1
XI1022_I65_XG I1022_pn0 I1022_cinn I1022_gn0 I1022_G0_0 VDD VSS OAI21_X1
XI1022_I66 I1022_G0_0 I1022_G0_0n VDD VSS INV_X1
XI1022_I67_XG I1022_pn1 I1022_G0_0n I1022_gn1 I1022_G1_0 VDD VSS OAI21_X1
XI1022_I68_XG I1022_pn2 I1022_gn1 I1022_gn2 I1022_G2_1 VDD VSS OAI21_X1
XI1022_I68_XP I1022_pn2 I1022_pn1 I1022_P2_1 VDD VSS NOR2_X1
XI1022_I69_XG I1022_pn3 I1022_gn2 I1022_gn3 I1022_G3_2 VDD VSS OAI21_X1
XI1022_I69_XP I1022_pn3 I1022_pn2 I1022_P3_2 VDD VSS NOR2_X1
XI1022_I70_XG I1022_pn4 I1022_gn3 I1022_gn4 I1022_G4_3 VDD VSS OAI21_X1
XI1022_I70_XP I1022_pn4 I1022_pn3 I1022_P4_3 VDD VSS NOR2_X1
XI1022_I71_XG I1022_pn5 I1022_gn4 I1022_gn5 I1022_G5_4 VDD VSS OAI21_X1
XI1022_I71_XP I1022_pn5 I1022_pn4 I1022_P5_4 VDD VSS NOR2_X1
XI1022_I72_XG I1022_pn6 I1022_gn5 I1022_gn6 I1022_G6_5 VDD VSS OAI21_X1
XI1022_I72_XP I1022_pn6 I1022_pn5 I1022_P6_5 VDD VSS NOR2_X1
XI1022_I73_XG I1022_pn7 I1022_gn6 I1022_gn7 I1022_G7_6 VDD VSS OAI21_X1
XI1022_I73_XP I1022_pn7 I1022_pn6 I1022_P7_6 VDD VSS NOR2_X1
XI1022_I74_XG I1022_pn8 I1022_gn7 I1022_gn8 I1022_G8_7 VDD VSS OAI21_X1
XI1022_I74_XP I1022_pn8 I1022_pn7 I1022_P8_7 VDD VSS NOR2_X1
XI1022_I75_XG I1022_pn9 I1022_gn8 I1022_gn9 I1022_G9_8 VDD VSS OAI21_X1
XI1022_I75_XP I1022_pn9 I1022_pn8 I1022_P9_8 VDD VSS NOR2_X1
XI1022_I76_XG I1022_pn10 I1022_gn9 I1022_gn10 I1022_G10_9 VDD VSS OAI21_X1
XI1022_I76_XP I1022_pn10 I1022_pn9 I1022_P10_9 VDD VSS NOR2_X1
XI1022_I77_XG I1022_pn11 I1022_gn10 I1022_gn11 I1022_G11_10 VDD VSS OAI21_X1
XI1022_I77_XP I1022_pn11 I1022_pn10 I1022_P11_10 VDD VSS NOR2_X1
XI1022_I78_XG I1022_pn12 I1022_gn11 I1022_gn12 I1022_G12_11 VDD VSS OAI21_X1
XI1022_I78_XP I1022_pn12 I1022_pn11 I1022_P12_11 VDD VSS NOR2_X1
XI1022_I79_XG I1022_pn13 I1022_gn12 I1022_gn13 I1022_G13_12 VDD VSS OAI21_X1
XI1022_I79_XP I1022_pn13 I1022_pn12 I1022_P13_12 VDD VSS NOR2_X1
XI1022_I80_XG I1022_pn14 I1022_gn13 I1022_gn14 I1022_G14_13 VDD VSS OAI21_X1
XI1022_I80_XP I1022_pn14 I1022_pn13 I1022_P14_13 VDD VSS NOR2_X1
XI1022_I81_XG I1022_pn15 I1022_gn14 I1022_gn15 I1022_G15_14 VDD VSS OAI21_X1
XI1022_I81_XP I1022_pn15 I1022_pn14 I1022_P15_14 VDD VSS NOR2_X1
XI1022_I82_XG I1022_pn16 I1022_gn15 I1022_gn16 I1022_G16_15 VDD VSS OAI21_X1
XI1022_I82_XP I1022_pn16 I1022_pn15 I1022_P16_15 VDD VSS NOR2_X1
XI1022_I83_XG I1022_pn17 I1022_gn16 I1022_gn17 I1022_G17_16 VDD VSS OAI21_X1
XI1022_I83_XP I1022_pn17 I1022_pn16 I1022_P17_16 VDD VSS NOR2_X1
XI1022_I84_XG I1022_pn18 I1022_gn17 I1022_gn18 I1022_G18_17 VDD VSS OAI21_X1
XI1022_I84_XP I1022_pn18 I1022_pn17 I1022_P18_17 VDD VSS NOR2_X1
XI1022_I85_XG I1022_pn19 I1022_gn18 I1022_gn19 I1022_G19_18 VDD VSS OAI21_X1
XI1022_I85_XP I1022_pn19 I1022_pn18 I1022_P19_18 VDD VSS NOR2_X1
XI1022_I86_XG I1022_pn20 I1022_gn19 I1022_gn20 I1022_G20_19 VDD VSS OAI21_X1
XI1022_I86_XP I1022_pn20 I1022_pn19 I1022_P20_19 VDD VSS NOR2_X1
XI1022_I87_XG I1022_pn21 I1022_gn20 I1022_gn21 I1022_G21_20 VDD VSS OAI21_X1
XI1022_I87_XP I1022_pn21 I1022_pn20 I1022_P21_20 VDD VSS NOR2_X1
XI1022_I88_XG I1022_pn22 I1022_gn21 I1022_gn22 I1022_G22_21 VDD VSS OAI21_X1
XI1022_I88_XP I1022_pn22 I1022_pn21 I1022_P22_21 VDD VSS NOR2_X1
XI1022_I89_XG I1022_pn23 I1022_gn22 I1022_gn23 I1022_G23_22 VDD VSS OAI21_X1
XI1022_I89_XP I1022_pn23 I1022_pn22 I1022_P23_22 VDD VSS NOR2_X1
XI1022_I90_XG I1022_pn24 I1022_gn23 I1022_gn24 I1022_G24_23 VDD VSS OAI21_X1
XI1022_I90_XP I1022_pn24 I1022_pn23 I1022_P24_23 VDD VSS NOR2_X1
XI1022_I91_XG I1022_pn25 I1022_gn24 I1022_gn25 I1022_G25_24 VDD VSS OAI21_X1
XI1022_I91_XP I1022_pn25 I1022_pn24 I1022_P25_24 VDD VSS NOR2_X1
XI1022_I92_XG I1022_pn26 I1022_gn25 I1022_gn26 I1022_G26_25 VDD VSS OAI21_X1
XI1022_I92_XP I1022_pn26 I1022_pn25 I1022_P26_25 VDD VSS NOR2_X1
XI1022_I93_XG I1022_pn27 I1022_gn26 I1022_gn27 I1022_G27_26 VDD VSS OAI21_X1
XI1022_I93_XP I1022_pn27 I1022_pn26 I1022_P27_26 VDD VSS NOR2_X1
XI1022_I94_XG I1022_pn28 I1022_gn27 I1022_gn28 I1022_G28_27 VDD VSS OAI21_X1
XI1022_I94_XP I1022_pn28 I1022_pn27 I1022_P28_27 VDD VSS NOR2_X1
XI1022_I95_XG I1022_pn29 I1022_gn28 I1022_gn29 I1022_G29_28 VDD VSS OAI21_X1
XI1022_I95_XP I1022_pn29 I1022_pn28 I1022_P29_28 VDD VSS NOR2_X1
XI1022_I96_XG I1022_pn30 I1022_gn29 I1022_gn30 I1022_G30_29 VDD VSS OAI21_X1
XI1022_I96_XP I1022_pn30 I1022_pn29 I1022_P30_29 VDD VSS NOR2_X1
XI1022_I97_XG I1022_pn31 I1022_gn30 I1022_gn31 I1022_G31_30 VDD VSS OAI21_X1
XI1022_I97_XP I1022_pn31 I1022_pn30 I1022_P31_30 VDD VSS NOR2_X1
XI1022_I98_XG I1022_P2_1 I1022_G0_0 I1022_G2_1 I1022_G2_0n VDD VSS AOI21_X1
XI1022_I99_XG I1022_P3_2 I1022_G1_0 I1022_G3_2 I1022_G3_0n VDD VSS AOI21_X1
XI1022_I100_XG I1022_P4_3 I1022_G2_1 I1022_G4_3 I1022_G4_1n VDD VSS AOI21_X1
XI1022_I100_XP I1022_P4_3 I1022_P2_1 I1022_P4_1n VDD VSS NAND2_X1
XI1022_I101_XG I1022_P5_4 I1022_G3_2 I1022_G5_4 I1022_G5_2n VDD VSS AOI21_X1
XI1022_I101_XP I1022_P5_4 I1022_P3_2 I1022_P5_2n VDD VSS NAND2_X1
XI1022_I102_XG I1022_P6_5 I1022_G4_3 I1022_G6_5 I1022_G6_3n VDD VSS AOI21_X1
XI1022_I102_XP I1022_P6_5 I1022_P4_3 I1022_P6_3n VDD VSS NAND2_X1
XI1022_I103_XG I1022_P7_6 I1022_G5_4 I1022_G7_6 I1022_G7_4n VDD VSS AOI21_X1
XI1022_I103_XP I1022_P7_6 I1022_P5_4 I1022_P7_4n VDD VSS NAND2_X1
XI1022_I104_XG I1022_P8_7 I1022_G6_5 I1022_G8_7 I1022_G8_5n VDD VSS AOI21_X1
XI1022_I104_XP I1022_P8_7 I1022_P6_5 I1022_P8_5n VDD VSS NAND2_X1
XI1022_I105_XG I1022_P9_8 I1022_G7_6 I1022_G9_8 I1022_G9_6n VDD VSS AOI21_X1
XI1022_I105_XP I1022_P9_8 I1022_P7_6 I1022_P9_6n VDD VSS NAND2_X1
XI1022_I106_XG I1022_P10_9 I1022_G8_7 I1022_G10_9 I1022_G10_7n VDD VSS AOI21_X1
XI1022_I106_XP I1022_P10_9 I1022_P8_7 I1022_P10_7n VDD VSS NAND2_X1
XI1022_I107_XG I1022_P11_10 I1022_G9_8 I1022_G11_10 I1022_G11_8n VDD VSS AOI21_X1
XI1022_I107_XP I1022_P11_10 I1022_P9_8 I1022_P11_8n VDD VSS NAND2_X1
XI1022_I108_XG I1022_P12_11 I1022_G10_9 I1022_G12_11 I1022_G12_9n VDD VSS AOI21_X1
XI1022_I108_XP I1022_P12_11 I1022_P10_9 I1022_P12_9n VDD VSS NAND2_X1
XI1022_I109_XG I1022_P13_12 I1022_G11_10 I1022_G13_12 I1022_G13_10n VDD VSS AOI21_X1
XI1022_I109_XP I1022_P13_12 I1022_P11_10 I1022_P13_10n VDD VSS NAND2_X1
XI1022_I110_XG I1022_P14_13 I1022_G12_11 I1022_G14_13 I1022_G14_11n VDD VSS AOI21_X1
XI1022_I110_XP I1022_P14_13 I1022_P12_11 I1022_P14_11n VDD VSS NAND2_X1
XI1022_I111_XG I1022_P15_14 I1022_G13_12 I1022_G15_14 I1022_G15_12n VDD VSS AOI21_X1
XI1022_I111_XP I1022_P15_14 I1022_P13_12 I1022_P15_12n VDD VSS NAND2_X1
XI1022_I112_XG I1022_P16_15 I1022_G14_13 I1022_G16_15 I1022_G16_13n VDD VSS AOI21_X1
XI1022_I112_XP I1022_P16_15 I1022_P14_13 I1022_P16_13n VDD VSS NAND2_X1
XI1022_I113_XG I1022_P17_16 I1022_G15_14 I1022_G17_16 I1022_G17_14n VDD VSS AOI21_X1
XI1022_I113_XP I1022_P17_16 I1022_P15_14 I1022_P17_14n VDD VSS NAND2_X1
XI1022_I114_XG I1022_P18_17 I1022_G16_15 I1022_G18_17 I1022_G18_15n VDD VSS AOI21_X1
XI1022_I114_XP I1022_P18_17 I1022_P16_15 I1022_P18_15n VDD VSS NAND2_X1
XI1022_I115_XG I1022_P19_18 I1022_G17_16 I1022_G19_18 I1022_G19_16n VDD VSS AOI21_X1
XI1022_I115_XP I1022_P19_18 I1022_P17_16 I1022_P19_16n VDD VSS NAND2_X1
XI1022_I116_XG I1022_P20_19 I1022_G18_17 I1022_G20_19 I1022_G20_17n VDD VSS AOI21_X1
XI1022_I116_XP I1022_P20_19 I1022_P18_17 I1022_P20_17n VDD VSS NAND2_X1
XI1022_I117_XG I1022_P21_20 I1022_G19_18 I1022_G21_20 I1022_G21_18n VDD VSS AOI21_X1
XI1022_I117_XP I1022_P21_20 I1022_P19_18 I1022_P21_18n VDD VSS NAND2_X1
XI1022_I118_XG I1022_P22_21 I1022_G20_19 I1022_G22_21 I1022_G22_19n VDD VSS AOI21_X1
XI1022_I118_XP I1022_P22_21 I1022_P20_19 I1022_P22_19n VDD VSS NAND2_X1
XI1022_I119_XG I1022_P23_22 I1022_G21_20 I1022_G23_22 I1022_G23_20n VDD VSS AOI21_X1
XI1022_I119_XP I1022_P23_22 I1022_P21_20 I1022_P23_20n VDD VSS NAND2_X1
XI1022_I120_XG I1022_P24_23 I1022_G22_21 I1022_G24_23 I1022_G24_21n VDD VSS AOI21_X1
XI1022_I120_XP I1022_P24_23 I1022_P22_21 I1022_P24_21n VDD VSS NAND2_X1
XI1022_I121_XG I1022_P25_24 I1022_G23_22 I1022_G25_24 I1022_G25_22n VDD VSS AOI21_X1
XI1022_I121_XP I1022_P25_24 I1022_P23_22 I1022_P25_22n VDD VSS NAND2_X1
XI1022_I122_XG I1022_P26_25 I1022_G24_23 I1022_G26_25 I1022_G26_23n VDD VSS AOI21_X1
XI1022_I122_XP I1022_P26_25 I1022_P24_23 I1022_P26_23n VDD VSS NAND2_X1
XI1022_I123_XG I1022_P27_26 I1022_G25_24 I1022_G27_26 I1022_G27_24n VDD VSS AOI21_X1
XI1022_I123_XP I1022_P27_26 I1022_P25_24 I1022_P27_24n VDD VSS NAND2_X1
XI1022_I124_XG I1022_P28_27 I1022_G26_25 I1022_G28_27 I1022_G28_25n VDD VSS AOI21_X1
XI1022_I124_XP I1022_P28_27 I1022_P26_25 I1022_P28_25n VDD VSS NAND2_X1
XI1022_I125_XG I1022_P29_28 I1022_G27_26 I1022_G29_28 I1022_G29_26n VDD VSS AOI21_X1
XI1022_I125_XP I1022_P29_28 I1022_P27_26 I1022_P29_26n VDD VSS NAND2_X1
XI1022_I126_XG I1022_P30_29 I1022_G28_27 I1022_G30_29 I1022_G30_27n VDD VSS AOI21_X1
XI1022_I126_XP I1022_P30_29 I1022_P28_27 I1022_P30_27n VDD VSS NAND2_X1
XI1022_I127_XG I1022_P31_30 I1022_G29_28 I1022_G31_30 I1022_G31_28n VDD VSS AOI21_X1
XI1022_I127_XP I1022_P31_30 I1022_P29_28 I1022_P31_28n VDD VSS NAND2_X1
XI1022_I128_XG I1022_P4_1n I1022_G0_0n I1022_G4_1n I1022_G4_0 VDD VSS OAI21_X1
XI1022_I129 I1022_G1_0 I1022_G1_0n VDD VSS INV_X1
XI1022_I130_XG I1022_P5_2n I1022_G1_0n I1022_G5_2n I1022_G5_0 VDD VSS OAI21_X1
XI1022_I131_XG I1022_P6_3n I1022_G2_0n I1022_G6_3n I1022_G6_0 VDD VSS OAI21_X1
XI1022_I132_XG I1022_P7_4n I1022_G3_0n I1022_G7_4n I1022_G7_0 VDD VSS OAI21_X1
XI1022_I133_XG I1022_P8_5n I1022_G4_1n I1022_G8_5n I1022_G8_1 VDD VSS OAI21_X1
XI1022_I133_XP I1022_P8_5n I1022_P4_1n I1022_P8_1 VDD VSS NOR2_X1
XI1022_I134_XG I1022_P9_6n I1022_G5_2n I1022_G9_6n I1022_G9_2 VDD VSS OAI21_X1
XI1022_I134_XP I1022_P9_6n I1022_P5_2n I1022_P9_2 VDD VSS NOR2_X1
XI1022_I135_XG I1022_P10_7n I1022_G6_3n I1022_G10_7n I1022_G10_3 VDD VSS OAI21_X1
XI1022_I135_XP I1022_P10_7n I1022_P6_3n I1022_P10_3 VDD VSS NOR2_X1
XI1022_I136_XG I1022_P11_8n I1022_G7_4n I1022_G11_8n I1022_G11_4 VDD VSS OAI21_X1
XI1022_I136_XP I1022_P11_8n I1022_P7_4n I1022_P11_4 VDD VSS NOR2_X1
XI1022_I137_XG I1022_P12_9n I1022_G8_5n I1022_G12_9n I1022_G12_5 VDD VSS OAI21_X1
XI1022_I137_XP I1022_P12_9n I1022_P8_5n I1022_P12_5 VDD VSS NOR2_X1
XI1022_I138_XG I1022_P13_10n I1022_G9_6n I1022_G13_10n I1022_G13_6 VDD VSS OAI21_X1
XI1022_I138_XP I1022_P13_10n I1022_P9_6n I1022_P13_6 VDD VSS NOR2_X1
XI1022_I139_XG I1022_P14_11n I1022_G10_7n I1022_G14_11n I1022_G14_7 VDD VSS OAI21_X1
XI1022_I139_XP I1022_P14_11n I1022_P10_7n I1022_P14_7 VDD VSS NOR2_X1
XI1022_I140_XG I1022_P15_12n I1022_G11_8n I1022_G15_12n I1022_G15_8 VDD VSS OAI21_X1
XI1022_I140_XP I1022_P15_12n I1022_P11_8n I1022_P15_8 VDD VSS NOR2_X1
XI1022_I141_XG I1022_P16_13n I1022_G12_9n I1022_G16_13n I1022_G16_9 VDD VSS OAI21_X1
XI1022_I141_XP I1022_P16_13n I1022_P12_9n I1022_P16_9 VDD VSS NOR2_X1
XI1022_I142_XG I1022_P17_14n I1022_G13_10n I1022_G17_14n I1022_G17_10 VDD VSS OAI21_X1
XI1022_I142_XP I1022_P17_14n I1022_P13_10n I1022_P17_10 VDD VSS NOR2_X1
XI1022_I143_XG I1022_P18_15n I1022_G14_11n I1022_G18_15n I1022_G18_11 VDD VSS OAI21_X1
XI1022_I143_XP I1022_P18_15n I1022_P14_11n I1022_P18_11 VDD VSS NOR2_X1
XI1022_I144_XG I1022_P19_16n I1022_G15_12n I1022_G19_16n I1022_G19_12 VDD VSS OAI21_X1
XI1022_I144_XP I1022_P19_16n I1022_P15_12n I1022_P19_12 VDD VSS NOR2_X1
XI1022_I145_XG I1022_P20_17n I1022_G16_13n I1022_G20_17n I1022_G20_13 VDD VSS OAI21_X1
XI1022_I145_XP I1022_P20_17n I1022_P16_13n I1022_P20_13 VDD VSS NOR2_X1
XI1022_I146_XG I1022_P21_18n I1022_G17_14n I1022_G21_18n I1022_G21_14 VDD VSS OAI21_X1
XI1022_I146_XP I1022_P21_18n I1022_P17_14n I1022_P21_14 VDD VSS NOR2_X1
XI1022_I147_XG I1022_P22_19n I1022_G18_15n I1022_G22_19n I1022_G22_15 VDD VSS OAI21_X1
XI1022_I147_XP I1022_P22_19n I1022_P18_15n I1022_P22_15 VDD VSS NOR2_X1
XI1022_I148_XG I1022_P23_20n I1022_G19_16n I1022_G23_20n I1022_G23_16 VDD VSS OAI21_X1
XI1022_I148_XP I1022_P23_20n I1022_P19_16n I1022_P23_16 VDD VSS NOR2_X1
XI1022_I149_XG I1022_P24_21n I1022_G20_17n I1022_G24_21n I1022_G24_17 VDD VSS OAI21_X1
XI1022_I149_XP I1022_P24_21n I1022_P20_17n I1022_P24_17 VDD VSS NOR2_X1
XI1022_I150_XG I1022_P25_22n I1022_G21_18n I1022_G25_22n I1022_G25_18 VDD VSS OAI21_X1
XI1022_I150_XP I1022_P25_22n I1022_P21_18n I1022_P25_18 VDD VSS NOR2_X1
XI1022_I151_XG I1022_P26_23n I1022_G22_19n I1022_G26_23n I1022_G26_19 VDD VSS OAI21_X1
XI1022_I151_XP I1022_P26_23n I1022_P22_19n I1022_P26_19 VDD VSS NOR2_X1
XI1022_I152_XG I1022_P27_24n I1022_G23_20n I1022_G27_24n I1022_G27_20 VDD VSS OAI21_X1
XI1022_I152_XP I1022_P27_24n I1022_P23_20n I1022_P27_20 VDD VSS NOR2_X1
XI1022_I153_XG I1022_P28_25n I1022_G24_21n I1022_G28_25n I1022_G28_21 VDD VSS OAI21_X1
XI1022_I153_XP I1022_P28_25n I1022_P24_21n I1022_P28_21 VDD VSS NOR2_X1
XI1022_I154_XG I1022_P29_26n I1022_G25_22n I1022_G29_26n I1022_G29_22 VDD VSS OAI21_X1
XI1022_I154_XP I1022_P29_26n I1022_P25_22n I1022_P29_22 VDD VSS NOR2_X1
XI1022_I155_XG I1022_P30_27n I1022_G26_23n I1022_G30_27n I1022_G30_23 VDD VSS OAI21_X1
XI1022_I155_XP I1022_P30_27n I1022_P26_23n I1022_P30_23 VDD VSS NOR2_X1
XI1022_I156_XG I1022_P31_28n I1022_G27_24n I1022_G31_28n I1022_G31_24 VDD VSS OAI21_X1
XI1022_I156_XP I1022_P31_28n I1022_P27_24n I1022_P31_24 VDD VSS NOR2_X1
XI1022_I157_XG I1022_P8_1 I1022_G0_0 I1022_G8_1 I1022_G8_0n VDD VSS AOI21_X1
XI1022_I158_XG I1022_P9_2 I1022_G1_0 I1022_G9_2 I1022_G9_0n VDD VSS AOI21_X1
XI1022_I159 I1022_G2_0n I1022_G2_0np VDD VSS INV_X1
XI1022_I160_XG I1022_P10_3 I1022_G2_0np I1022_G10_3 I1022_G10_0n VDD VSS AOI21_X1
XI1022_I161 I1022_G3_0n I1022_G3_0np VDD VSS INV_X1
XI1022_I162_XG I1022_P11_4 I1022_G3_0np I1022_G11_4 I1022_G11_0n VDD VSS AOI21_X1
XI1022_I163_XG I1022_P12_5 I1022_G4_0 I1022_G12_5 I1022_G12_0n VDD VSS AOI21_X1
XI1022_I164_XG I1022_P13_6 I1022_G5_0 I1022_G13_6 I1022_G13_0n VDD VSS AOI21_X1
XI1022_I165_XG I1022_P14_7 I1022_G6_0 I1022_G14_7 I1022_G14_0n VDD VSS AOI21_X1
XI1022_I166_XG I1022_P15_8 I1022_G7_0 I1022_G15_8 I1022_G15_0n VDD VSS AOI21_X1
XI1022_I167_XG I1022_P16_9 I1022_G8_1 I1022_G16_9 I1022_G16_1n VDD VSS AOI21_X1
XI1022_I167_XP I1022_P16_9 I1022_P8_1 I1022_P16_1n VDD VSS NAND2_X1
XI1022_I168_XG I1022_P17_10 I1022_G9_2 I1022_G17_10 I1022_G17_2n VDD VSS AOI21_X1
XI1022_I168_XP I1022_P17_10 I1022_P9_2 I1022_P17_2n VDD VSS NAND2_X1
XI1022_I169_XG I1022_P18_11 I1022_G10_3 I1022_G18_11 I1022_G18_3n VDD VSS AOI21_X1
XI1022_I169_XP I1022_P18_11 I1022_P10_3 I1022_P18_3n VDD VSS NAND2_X1
XI1022_I170_XG I1022_P19_12 I1022_G11_4 I1022_G19_12 I1022_G19_4n VDD VSS AOI21_X1
XI1022_I170_XP I1022_P19_12 I1022_P11_4 I1022_P19_4n VDD VSS NAND2_X1
XI1022_I171_XG I1022_P20_13 I1022_G12_5 I1022_G20_13 I1022_G20_5n VDD VSS AOI21_X1
XI1022_I171_XP I1022_P20_13 I1022_P12_5 I1022_P20_5n VDD VSS NAND2_X1
XI1022_I172_XG I1022_P21_14 I1022_G13_6 I1022_G21_14 I1022_G21_6n VDD VSS AOI21_X1
XI1022_I172_XP I1022_P21_14 I1022_P13_6 I1022_P21_6n VDD VSS NAND2_X1
XI1022_I173_XG I1022_P22_15 I1022_G14_7 I1022_G22_15 I1022_G22_7n VDD VSS AOI21_X1
XI1022_I173_XP I1022_P22_15 I1022_P14_7 I1022_P22_7n VDD VSS NAND2_X1
XI1022_I174_XG I1022_P23_16 I1022_G15_8 I1022_G23_16 I1022_G23_8n VDD VSS AOI21_X1
XI1022_I174_XP I1022_P23_16 I1022_P15_8 I1022_P23_8n VDD VSS NAND2_X1
XI1022_I175_XG I1022_P24_17 I1022_G16_9 I1022_G24_17 I1022_G24_9n VDD VSS AOI21_X1
XI1022_I175_XP I1022_P24_17 I1022_P16_9 I1022_P24_9n VDD VSS NAND2_X1
XI1022_I176_XG I1022_P25_18 I1022_G17_10 I1022_G25_18 I1022_G25_10n VDD VSS AOI21_X1
XI1022_I176_XP I1022_P25_18 I1022_P17_10 I1022_P25_10n VDD VSS NAND2_X1
XI1022_I177_XG I1022_P26_19 I1022_G18_11 I1022_G26_19 I1022_G26_11n VDD VSS AOI21_X1
XI1022_I177_XP I1022_P26_19 I1022_P18_11 I1022_P26_11n VDD VSS NAND2_X1
XI1022_I178_XG I1022_P27_20 I1022_G19_12 I1022_G27_20 I1022_G27_12n VDD VSS AOI21_X1
XI1022_I178_XP I1022_P27_20 I1022_P19_12 I1022_P27_12n VDD VSS NAND2_X1
XI1022_I179_XG I1022_P28_21 I1022_G20_13 I1022_G28_21 I1022_G28_13n VDD VSS AOI21_X1
XI1022_I179_XP I1022_P28_21 I1022_P20_13 I1022_P28_13n VDD VSS NAND2_X1
XI1022_I180_XG I1022_P29_22 I1022_G21_14 I1022_G29_22 I1022_G29_14n VDD VSS AOI21_X1
XI1022_I180_XP I1022_P29_22 I1022_P21_14 I1022_P29_14n VDD VSS NAND2_X1
XI1022_I181_XG I1022_P30_23 I1022_G22_15 I1022_G30_23 I1022_G30_15n VDD VSS AOI21_X1
XI1022_I181_XP I1022_P30_23 I1022_P22_15 I1022_P30_15n VDD VSS NAND2_X1
XI1022_I182_XG I1022_P31_24 I1022_G23_16 I1022_G31_24 I1022_G31_16n VDD VSS AOI21_X1
XI1022_I182_XP I1022_P31_24 I1022_P23_16 I1022_P31_16n VDD VSS NAND2_X1
XI1022_I183_XG I1022_P16_1n I1022_G0_0n I1022_G16_1n I1022_G16_0 VDD VSS OAI21_X1
XI1022_I184_XG I1022_P17_2n I1022_G1_0n I1022_G17_2n I1022_G17_0 VDD VSS OAI21_X1
XI1022_I185_XG I1022_P18_3n I1022_G2_0n I1022_G18_3n I1022_G18_0 VDD VSS OAI21_X1
XI1022_I186_XG I1022_P19_4n I1022_G3_0n I1022_G19_4n I1022_G19_0 VDD VSS OAI21_X1
XI1022_I187 I1022_G4_0 I1022_G4_0n VDD VSS INV_X1
XI1022_I188_XG I1022_P20_5n I1022_G4_0n I1022_G20_5n I1022_G20_0 VDD VSS OAI21_X1
XI1022_I189 I1022_G5_0 I1022_G5_0n VDD VSS INV_X1
XI1022_I190_XG I1022_P21_6n I1022_G5_0n I1022_G21_6n I1022_G21_0 VDD VSS OAI21_X1
XI1022_I191 I1022_G6_0 I1022_G6_0n VDD VSS INV_X1
XI1022_I192_XG I1022_P22_7n I1022_G6_0n I1022_G22_7n I1022_G22_0 VDD VSS OAI21_X1
XI1022_I193 I1022_G7_0 I1022_G7_0n VDD VSS INV_X1
XI1022_I194_XG I1022_P23_8n I1022_G7_0n I1022_G23_8n I1022_G23_0 VDD VSS OAI21_X1
XI1022_I195_XG I1022_P24_9n I1022_G8_0n I1022_G24_9n I1022_G24_0 VDD VSS OAI21_X1
XI1022_I196_XG I1022_P25_10n I1022_G9_0n I1022_G25_10n I1022_G25_0 VDD VSS OAI21_X1
XI1022_I197_XG I1022_P26_11n I1022_G10_0n I1022_G26_11n I1022_G26_0 VDD VSS OAI21_X1
XI1022_I198_XG I1022_P27_12n I1022_G11_0n I1022_G27_12n I1022_G27_0 VDD VSS OAI21_X1
XI1022_I199_XG I1022_P28_13n I1022_G12_0n I1022_G28_13n I1022_G28_0 VDD VSS OAI21_X1
XI1022_I200_XG I1022_P29_14n I1022_G13_0n I1022_G29_14n I1022_G29_0 VDD VSS OAI21_X1
XI1022_I201_XG I1022_P30_15n I1022_G14_0n I1022_G30_15n c10_m VDD VSS OAI21_X1
XI1022_I202_XG I1022_P31_16n I1022_G15_0n I1022_G31_16n c10_o VDD VSS OAI21_X1
XI1022_I203 I1022_pn0 qu22_b3_5 p10_0 VDD VSS XNOR2_X1
XI1022_I204 I1022_pn1 I1022_G0_0 p10_1 VDD VSS XNOR2_X1
XI1022_I205 I1022_pn2 I1022_G1_0 p10_2 VDD VSS XNOR2_X1
XI1022_I206 I1022_pn3 I1022_G2_0n p10_3 VDD VSS XOR2_X1
XI1022_I207 I1022_pn4 I1022_G3_0n p10_4 VDD VSS XOR2_X1
XI1022_I208 I1022_pn5 I1022_G4_0 p10_5 VDD VSS XNOR2_X1
XI1022_I209 I1022_pn6 I1022_G5_0 p10_6 VDD VSS XNOR2_X1
XI1022_I210 I1022_pn7 I1022_G6_0 p10_7 VDD VSS XNOR2_X1
XI1022_I211 I1022_pn8 I1022_G7_0 p10_8 VDD VSS XNOR2_X1
XI1022_I212 I1022_pn9 I1022_G8_0n p10_9 VDD VSS XOR2_X1
XI1022_I213 I1022_pn10 I1022_G9_0n p10_10 VDD VSS XOR2_X1
XI1022_I214 I1022_pn11 I1022_G10_0n p10_11 VDD VSS XOR2_X1
XI1022_I215 I1022_pn12 I1022_G11_0n p10_12 VDD VSS XOR2_X1
XI1022_I216 I1022_pn13 I1022_G12_0n p10_13 VDD VSS XOR2_X1
XI1022_I217 I1022_pn14 I1022_G13_0n p10_14 VDD VSS XOR2_X1
XI1022_I218 I1022_pn15 I1022_G14_0n p10_15 VDD VSS XOR2_X1
XI1022_I219 I1022_pn16 I1022_G15_0n p10_16 VDD VSS XOR2_X1
XI1022_I220 I1022_pn17 I1022_G16_0 p10_17 VDD VSS XNOR2_X1
XI1022_I221 I1022_pn18 I1022_G17_0 p10_18 VDD VSS XNOR2_X1
XI1022_I222 I1022_pn19 I1022_G18_0 p10_19 VDD VSS XNOR2_X1
XI1022_I223 I1022_pn20 I1022_G19_0 p10_20 VDD VSS XNOR2_X1
XI1022_I224 I1022_pn21 I1022_G20_0 p10_21 VDD VSS XNOR2_X1
XI1022_I225 I1022_pn22 I1022_G21_0 p10_22 VDD VSS XNOR2_X1
XI1022_I226 I1022_pn23 I1022_G22_0 p10_23 VDD VSS XNOR2_X1
XI1022_I227 I1022_pn24 I1022_G23_0 p10_24 VDD VSS XNOR2_X1
XI1022_I228 I1022_pn25 I1022_G24_0 p10_25 VDD VSS XNOR2_X1
XI1022_I229 I1022_pn26 I1022_G25_0 p10_26 VDD VSS XNOR2_X1
XI1022_I230 I1022_pn27 I1022_G26_0 p10_27 VDD VSS XNOR2_X1
XI1022_I231 I1022_pn28 I1022_G27_0 p10_28 VDD VSS XNOR2_X1
XI1022_I232 I1022_pn29 I1022_G28_0 p10_29 VDD VSS XNOR2_X1
XI1022_I233 I1022_pn30 I1022_G29_0 p10_30 VDD VSS XNOR2_X1
XI1022_I234 I1022_pn31 c10_m p10_31 VDD VSS XNOR2_X1
XI1023 p9_31 qu22_b3_5 h10 VDD VSS XOR2_X1
XI1024 h10 c10_o p10_32 VDD VSS XOR2_X1
XI1025 p10_32 qu21 VDD VSS INV_X4
XI1026 qu21 qu21_b0 VDD VSS INV_X1
XI1027 qu21_b0 qu21_b1_0 VDD VSS INV_X4
XI1028 qu21_b1_0 qu21_b2_0 VDD VSS INV_X4
XI1029 qu21_b1_0 qu21_b2_1 VDD VSS INV_X4
XI1030 qu21_b2_0 qu21_b3_0 VDD VSS INV_X4
XI1031 qu21_b2_0 qu21_b3_1 VDD VSS INV_X4
XI1032 qu21_b2_0 qu21_b3_2 VDD VSS INV_X4
XI1033 qu21_b2_1 qu21_b3_3 VDD VSS INV_X4
XI1034 qu21_b2_1 qu21_b3_4 VDD VSS INV_X4
XI1035 qu21_b2_1 qu21_b3_5 VDD VSS INV_X4
XI1036 B_0_b3_2 qu21_b3_0 b11_0 VDD VSS XOR2_X1
XI1037 dd1_b3_2 qu21_b3_0 b11_1 VDD VSS XOR2_X1
XI1038 dd2_b3_2 qu21_b3_0 b11_2 VDD VSS XOR2_X1
XI1039 dd3_b3_2 qu21_b3_0 b11_3 VDD VSS XOR2_X1
XI1040 dd4_b3_2 qu21_b3_0 b11_4 VDD VSS XOR2_X1
XI1041 dd5_b3_2 qu21_b3_0 b11_5 VDD VSS XOR2_X1
XI1042 dd6_b3_2 qu21_b3_1 b11_6 VDD VSS XOR2_X1
XI1043 dd7_b3_2 qu21_b3_1 b11_7 VDD VSS XOR2_X1
XI1044 dd8_b3_2 qu21_b3_1 b11_8 VDD VSS XOR2_X1
XI1045 dd9_b3_2 qu21_b3_1 b11_9 VDD VSS XOR2_X1
XI1046 dd10_b3_2 qu21_b3_1 b11_10 VDD VSS XOR2_X1
XI1047 dd11_b3_2 qu21_b3_1 b11_11 VDD VSS XOR2_X1
XI1048 dd12_b3_2 qu21_b3_2 b11_12 VDD VSS XOR2_X1
XI1049 dd13_b3_2 qu21_b3_2 b11_13 VDD VSS XOR2_X1
XI1050 dd14_b3_2 qu21_b3_2 b11_14 VDD VSS XOR2_X1
XI1051 dd15_b3_2 qu21_b3_2 b11_15 VDD VSS XOR2_X1
XI1052 dd16_b3_2 qu21_b3_2 b11_16 VDD VSS XOR2_X1
XI1053 dd17_b3_2 qu21_b3_2 b11_17 VDD VSS XOR2_X1
XI1054 dd18_b3_2 qu21_b3_3 b11_18 VDD VSS XOR2_X1
XI1055 dd19_b3_2 qu21_b3_3 b11_19 VDD VSS XOR2_X1
XI1056 dd20_b3_2 qu21_b3_3 b11_20 VDD VSS XOR2_X1
XI1057 dd21_b3_2 qu21_b3_3 b11_21 VDD VSS XOR2_X1
XI1058 dd22_b3_2 qu21_b3_3 b11_22 VDD VSS XOR2_X1
XI1059 dd23_b3_2 qu21_b3_3 b11_23 VDD VSS XOR2_X1
XI1060 dd24_b3_2 qu21_b3_4 b11_24 VDD VSS XOR2_X1
XI1061 dd25_b3_2 qu21_b3_4 b11_25 VDD VSS XOR2_X1
XI1062 dd26_b3_2 qu21_b3_4 b11_26 VDD VSS XOR2_X1
XI1063 dd27_b3_2 qu21_b3_4 b11_27 VDD VSS XOR2_X1
XI1064 dd28_b3_2 qu21_b3_4 b11_28 VDD VSS XOR2_X1
XI1065 dd29_b3_2 qu21_b3_4 b11_29 VDD VSS XOR2_X1
XI1066 dd30_b3_2 qu21_b3_5 b11_30 VDD VSS XOR2_X1
XI1067 dd31_b3_2 qu21_b3_5 b11_31 VDD VSS XOR2_X1
XI1068_I0 aa20 b11_0 I1068_gn0 VDD VSS NAND2_X1
XI1068_I1 p10_0 b11_1 I1068_gn1 VDD VSS NAND2_X1
XI1068_I2 p10_1 b11_2 I1068_gn2 VDD VSS NAND2_X1
XI1068_I3 p10_2 b11_3 I1068_gn3 VDD VSS NAND2_X1
XI1068_I4 p10_3 b11_4 I1068_gn4 VDD VSS NAND2_X1
XI1068_I5 p10_4 b11_5 I1068_gn5 VDD VSS NAND2_X1
XI1068_I6 p10_5 b11_6 I1068_gn6 VDD VSS NAND2_X1
XI1068_I7 p10_6 b11_7 I1068_gn7 VDD VSS NAND2_X1
XI1068_I8 p10_7 b11_8 I1068_gn8 VDD VSS NAND2_X1
XI1068_I9 p10_8 b11_9 I1068_gn9 VDD VSS NAND2_X1
XI1068_I10 p10_9 b11_10 I1068_gn10 VDD VSS NAND2_X1
XI1068_I11 p10_10 b11_11 I1068_gn11 VDD VSS NAND2_X1
XI1068_I12 p10_11 b11_12 I1068_gn12 VDD VSS NAND2_X1
XI1068_I13 p10_12 b11_13 I1068_gn13 VDD VSS NAND2_X1
XI1068_I14 p10_13 b11_14 I1068_gn14 VDD VSS NAND2_X1
XI1068_I15 p10_14 b11_15 I1068_gn15 VDD VSS NAND2_X1
XI1068_I16 p10_15 b11_16 I1068_gn16 VDD VSS NAND2_X1
XI1068_I17 p10_16 b11_17 I1068_gn17 VDD VSS NAND2_X1
XI1068_I18 p10_17 b11_18 I1068_gn18 VDD VSS NAND2_X1
XI1068_I19 p10_18 b11_19 I1068_gn19 VDD VSS NAND2_X1
XI1068_I20 p10_19 b11_20 I1068_gn20 VDD VSS NAND2_X1
XI1068_I21 p10_20 b11_21 I1068_gn21 VDD VSS NAND2_X1
XI1068_I22 p10_21 b11_22 I1068_gn22 VDD VSS NAND2_X1
XI1068_I23 p10_22 b11_23 I1068_gn23 VDD VSS NAND2_X1
XI1068_I24 p10_23 b11_24 I1068_gn24 VDD VSS NAND2_X1
XI1068_I25 p10_24 b11_25 I1068_gn25 VDD VSS NAND2_X1
XI1068_I26 p10_25 b11_26 I1068_gn26 VDD VSS NAND2_X1
XI1068_I27 p10_26 b11_27 I1068_gn27 VDD VSS NAND2_X1
XI1068_I28 p10_27 b11_28 I1068_gn28 VDD VSS NAND2_X1
XI1068_I29 p10_28 b11_29 I1068_gn29 VDD VSS NAND2_X1
XI1068_I30 p10_29 b11_30 I1068_gn30 VDD VSS NAND2_X1
XI1068_I31 p10_30 b11_31 I1068_gn31 VDD VSS NAND2_X1
XI1068_I32 aa20 b11_0 I1068_pn0 VDD VSS XNOR2_X1
XI1068_I33 p10_0 b11_1 I1068_pn1 VDD VSS XNOR2_X1
XI1068_I34 p10_1 b11_2 I1068_pn2 VDD VSS XNOR2_X1
XI1068_I35 p10_2 b11_3 I1068_pn3 VDD VSS XNOR2_X1
XI1068_I36 p10_3 b11_4 I1068_pn4 VDD VSS XNOR2_X1
XI1068_I37 p10_4 b11_5 I1068_pn5 VDD VSS XNOR2_X1
XI1068_I38 p10_5 b11_6 I1068_pn6 VDD VSS XNOR2_X1
XI1068_I39 p10_6 b11_7 I1068_pn7 VDD VSS XNOR2_X1
XI1068_I40 p10_7 b11_8 I1068_pn8 VDD VSS XNOR2_X1
XI1068_I41 p10_8 b11_9 I1068_pn9 VDD VSS XNOR2_X1
XI1068_I42 p10_9 b11_10 I1068_pn10 VDD VSS XNOR2_X1
XI1068_I43 p10_10 b11_11 I1068_pn11 VDD VSS XNOR2_X1
XI1068_I44 p10_11 b11_12 I1068_pn12 VDD VSS XNOR2_X1
XI1068_I45 p10_12 b11_13 I1068_pn13 VDD VSS XNOR2_X1
XI1068_I46 p10_13 b11_14 I1068_pn14 VDD VSS XNOR2_X1
XI1068_I47 p10_14 b11_15 I1068_pn15 VDD VSS XNOR2_X1
XI1068_I48 p10_15 b11_16 I1068_pn16 VDD VSS XNOR2_X1
XI1068_I49 p10_16 b11_17 I1068_pn17 VDD VSS XNOR2_X1
XI1068_I50 p10_17 b11_18 I1068_pn18 VDD VSS XNOR2_X1
XI1068_I51 p10_18 b11_19 I1068_pn19 VDD VSS XNOR2_X1
XI1068_I52 p10_19 b11_20 I1068_pn20 VDD VSS XNOR2_X1
XI1068_I53 p10_20 b11_21 I1068_pn21 VDD VSS XNOR2_X1
XI1068_I54 p10_21 b11_22 I1068_pn22 VDD VSS XNOR2_X1
XI1068_I55 p10_22 b11_23 I1068_pn23 VDD VSS XNOR2_X1
XI1068_I56 p10_23 b11_24 I1068_pn24 VDD VSS XNOR2_X1
XI1068_I57 p10_24 b11_25 I1068_pn25 VDD VSS XNOR2_X1
XI1068_I58 p10_25 b11_26 I1068_pn26 VDD VSS XNOR2_X1
XI1068_I59 p10_26 b11_27 I1068_pn27 VDD VSS XNOR2_X1
XI1068_I60 p10_27 b11_28 I1068_pn28 VDD VSS XNOR2_X1
XI1068_I61 p10_28 b11_29 I1068_pn29 VDD VSS XNOR2_X1
XI1068_I62 p10_29 b11_30 I1068_pn30 VDD VSS XNOR2_X1
XI1068_I63 p10_30 b11_31 I1068_pn31 VDD VSS XNOR2_X1
XI1068_I64 qu21_b3_5 I1068_cinn VDD VSS INV_X1
XI1068_I65_XG I1068_pn0 I1068_cinn I1068_gn0 I1068_G0_0 VDD VSS OAI21_X1
XI1068_I66 I1068_G0_0 I1068_G0_0n VDD VSS INV_X1
XI1068_I67_XG I1068_pn1 I1068_G0_0n I1068_gn1 I1068_G1_0 VDD VSS OAI21_X1
XI1068_I68_XG I1068_pn2 I1068_gn1 I1068_gn2 I1068_G2_1 VDD VSS OAI21_X1
XI1068_I68_XP I1068_pn2 I1068_pn1 I1068_P2_1 VDD VSS NOR2_X1
XI1068_I69_XG I1068_pn3 I1068_gn2 I1068_gn3 I1068_G3_2 VDD VSS OAI21_X1
XI1068_I69_XP I1068_pn3 I1068_pn2 I1068_P3_2 VDD VSS NOR2_X1
XI1068_I70_XG I1068_pn4 I1068_gn3 I1068_gn4 I1068_G4_3 VDD VSS OAI21_X1
XI1068_I70_XP I1068_pn4 I1068_pn3 I1068_P4_3 VDD VSS NOR2_X1
XI1068_I71_XG I1068_pn5 I1068_gn4 I1068_gn5 I1068_G5_4 VDD VSS OAI21_X1
XI1068_I71_XP I1068_pn5 I1068_pn4 I1068_P5_4 VDD VSS NOR2_X1
XI1068_I72_XG I1068_pn6 I1068_gn5 I1068_gn6 I1068_G6_5 VDD VSS OAI21_X1
XI1068_I72_XP I1068_pn6 I1068_pn5 I1068_P6_5 VDD VSS NOR2_X1
XI1068_I73_XG I1068_pn7 I1068_gn6 I1068_gn7 I1068_G7_6 VDD VSS OAI21_X1
XI1068_I73_XP I1068_pn7 I1068_pn6 I1068_P7_6 VDD VSS NOR2_X1
XI1068_I74_XG I1068_pn8 I1068_gn7 I1068_gn8 I1068_G8_7 VDD VSS OAI21_X1
XI1068_I74_XP I1068_pn8 I1068_pn7 I1068_P8_7 VDD VSS NOR2_X1
XI1068_I75_XG I1068_pn9 I1068_gn8 I1068_gn9 I1068_G9_8 VDD VSS OAI21_X1
XI1068_I75_XP I1068_pn9 I1068_pn8 I1068_P9_8 VDD VSS NOR2_X1
XI1068_I76_XG I1068_pn10 I1068_gn9 I1068_gn10 I1068_G10_9 VDD VSS OAI21_X1
XI1068_I76_XP I1068_pn10 I1068_pn9 I1068_P10_9 VDD VSS NOR2_X1
XI1068_I77_XG I1068_pn11 I1068_gn10 I1068_gn11 I1068_G11_10 VDD VSS OAI21_X1
XI1068_I77_XP I1068_pn11 I1068_pn10 I1068_P11_10 VDD VSS NOR2_X1
XI1068_I78_XG I1068_pn12 I1068_gn11 I1068_gn12 I1068_G12_11 VDD VSS OAI21_X1
XI1068_I78_XP I1068_pn12 I1068_pn11 I1068_P12_11 VDD VSS NOR2_X1
XI1068_I79_XG I1068_pn13 I1068_gn12 I1068_gn13 I1068_G13_12 VDD VSS OAI21_X1
XI1068_I79_XP I1068_pn13 I1068_pn12 I1068_P13_12 VDD VSS NOR2_X1
XI1068_I80_XG I1068_pn14 I1068_gn13 I1068_gn14 I1068_G14_13 VDD VSS OAI21_X1
XI1068_I80_XP I1068_pn14 I1068_pn13 I1068_P14_13 VDD VSS NOR2_X1
XI1068_I81_XG I1068_pn15 I1068_gn14 I1068_gn15 I1068_G15_14 VDD VSS OAI21_X1
XI1068_I81_XP I1068_pn15 I1068_pn14 I1068_P15_14 VDD VSS NOR2_X1
XI1068_I82_XG I1068_pn16 I1068_gn15 I1068_gn16 I1068_G16_15 VDD VSS OAI21_X1
XI1068_I82_XP I1068_pn16 I1068_pn15 I1068_P16_15 VDD VSS NOR2_X1
XI1068_I83_XG I1068_pn17 I1068_gn16 I1068_gn17 I1068_G17_16 VDD VSS OAI21_X1
XI1068_I83_XP I1068_pn17 I1068_pn16 I1068_P17_16 VDD VSS NOR2_X1
XI1068_I84_XG I1068_pn18 I1068_gn17 I1068_gn18 I1068_G18_17 VDD VSS OAI21_X1
XI1068_I84_XP I1068_pn18 I1068_pn17 I1068_P18_17 VDD VSS NOR2_X1
XI1068_I85_XG I1068_pn19 I1068_gn18 I1068_gn19 I1068_G19_18 VDD VSS OAI21_X1
XI1068_I85_XP I1068_pn19 I1068_pn18 I1068_P19_18 VDD VSS NOR2_X1
XI1068_I86_XG I1068_pn20 I1068_gn19 I1068_gn20 I1068_G20_19 VDD VSS OAI21_X1
XI1068_I86_XP I1068_pn20 I1068_pn19 I1068_P20_19 VDD VSS NOR2_X1
XI1068_I87_XG I1068_pn21 I1068_gn20 I1068_gn21 I1068_G21_20 VDD VSS OAI21_X1
XI1068_I87_XP I1068_pn21 I1068_pn20 I1068_P21_20 VDD VSS NOR2_X1
XI1068_I88_XG I1068_pn22 I1068_gn21 I1068_gn22 I1068_G22_21 VDD VSS OAI21_X1
XI1068_I88_XP I1068_pn22 I1068_pn21 I1068_P22_21 VDD VSS NOR2_X1
XI1068_I89_XG I1068_pn23 I1068_gn22 I1068_gn23 I1068_G23_22 VDD VSS OAI21_X1
XI1068_I89_XP I1068_pn23 I1068_pn22 I1068_P23_22 VDD VSS NOR2_X1
XI1068_I90_XG I1068_pn24 I1068_gn23 I1068_gn24 I1068_G24_23 VDD VSS OAI21_X1
XI1068_I90_XP I1068_pn24 I1068_pn23 I1068_P24_23 VDD VSS NOR2_X1
XI1068_I91_XG I1068_pn25 I1068_gn24 I1068_gn25 I1068_G25_24 VDD VSS OAI21_X1
XI1068_I91_XP I1068_pn25 I1068_pn24 I1068_P25_24 VDD VSS NOR2_X1
XI1068_I92_XG I1068_pn26 I1068_gn25 I1068_gn26 I1068_G26_25 VDD VSS OAI21_X1
XI1068_I92_XP I1068_pn26 I1068_pn25 I1068_P26_25 VDD VSS NOR2_X1
XI1068_I93_XG I1068_pn27 I1068_gn26 I1068_gn27 I1068_G27_26 VDD VSS OAI21_X1
XI1068_I93_XP I1068_pn27 I1068_pn26 I1068_P27_26 VDD VSS NOR2_X1
XI1068_I94_XG I1068_pn28 I1068_gn27 I1068_gn28 I1068_G28_27 VDD VSS OAI21_X1
XI1068_I94_XP I1068_pn28 I1068_pn27 I1068_P28_27 VDD VSS NOR2_X1
XI1068_I95_XG I1068_pn29 I1068_gn28 I1068_gn29 I1068_G29_28 VDD VSS OAI21_X1
XI1068_I95_XP I1068_pn29 I1068_pn28 I1068_P29_28 VDD VSS NOR2_X1
XI1068_I96_XG I1068_pn30 I1068_gn29 I1068_gn30 I1068_G30_29 VDD VSS OAI21_X1
XI1068_I96_XP I1068_pn30 I1068_pn29 I1068_P30_29 VDD VSS NOR2_X1
XI1068_I97_XG I1068_pn31 I1068_gn30 I1068_gn31 I1068_G31_30 VDD VSS OAI21_X1
XI1068_I97_XP I1068_pn31 I1068_pn30 I1068_P31_30 VDD VSS NOR2_X1
XI1068_I98_XG I1068_P2_1 I1068_G0_0 I1068_G2_1 I1068_G2_0n VDD VSS AOI21_X1
XI1068_I99_XG I1068_P3_2 I1068_G1_0 I1068_G3_2 I1068_G3_0n VDD VSS AOI21_X1
XI1068_I100_XG I1068_P4_3 I1068_G2_1 I1068_G4_3 I1068_G4_1n VDD VSS AOI21_X1
XI1068_I100_XP I1068_P4_3 I1068_P2_1 I1068_P4_1n VDD VSS NAND2_X1
XI1068_I101_XG I1068_P5_4 I1068_G3_2 I1068_G5_4 I1068_G5_2n VDD VSS AOI21_X1
XI1068_I101_XP I1068_P5_4 I1068_P3_2 I1068_P5_2n VDD VSS NAND2_X1
XI1068_I102_XG I1068_P6_5 I1068_G4_3 I1068_G6_5 I1068_G6_3n VDD VSS AOI21_X1
XI1068_I102_XP I1068_P6_5 I1068_P4_3 I1068_P6_3n VDD VSS NAND2_X1
XI1068_I103_XG I1068_P7_6 I1068_G5_4 I1068_G7_6 I1068_G7_4n VDD VSS AOI21_X1
XI1068_I103_XP I1068_P7_6 I1068_P5_4 I1068_P7_4n VDD VSS NAND2_X1
XI1068_I104_XG I1068_P8_7 I1068_G6_5 I1068_G8_7 I1068_G8_5n VDD VSS AOI21_X1
XI1068_I104_XP I1068_P8_7 I1068_P6_5 I1068_P8_5n VDD VSS NAND2_X1
XI1068_I105_XG I1068_P9_8 I1068_G7_6 I1068_G9_8 I1068_G9_6n VDD VSS AOI21_X1
XI1068_I105_XP I1068_P9_8 I1068_P7_6 I1068_P9_6n VDD VSS NAND2_X1
XI1068_I106_XG I1068_P10_9 I1068_G8_7 I1068_G10_9 I1068_G10_7n VDD VSS AOI21_X1
XI1068_I106_XP I1068_P10_9 I1068_P8_7 I1068_P10_7n VDD VSS NAND2_X1
XI1068_I107_XG I1068_P11_10 I1068_G9_8 I1068_G11_10 I1068_G11_8n VDD VSS AOI21_X1
XI1068_I107_XP I1068_P11_10 I1068_P9_8 I1068_P11_8n VDD VSS NAND2_X1
XI1068_I108_XG I1068_P12_11 I1068_G10_9 I1068_G12_11 I1068_G12_9n VDD VSS AOI21_X1
XI1068_I108_XP I1068_P12_11 I1068_P10_9 I1068_P12_9n VDD VSS NAND2_X1
XI1068_I109_XG I1068_P13_12 I1068_G11_10 I1068_G13_12 I1068_G13_10n VDD VSS AOI21_X1
XI1068_I109_XP I1068_P13_12 I1068_P11_10 I1068_P13_10n VDD VSS NAND2_X1
XI1068_I110_XG I1068_P14_13 I1068_G12_11 I1068_G14_13 I1068_G14_11n VDD VSS AOI21_X1
XI1068_I110_XP I1068_P14_13 I1068_P12_11 I1068_P14_11n VDD VSS NAND2_X1
XI1068_I111_XG I1068_P15_14 I1068_G13_12 I1068_G15_14 I1068_G15_12n VDD VSS AOI21_X1
XI1068_I111_XP I1068_P15_14 I1068_P13_12 I1068_P15_12n VDD VSS NAND2_X1
XI1068_I112_XG I1068_P16_15 I1068_G14_13 I1068_G16_15 I1068_G16_13n VDD VSS AOI21_X1
XI1068_I112_XP I1068_P16_15 I1068_P14_13 I1068_P16_13n VDD VSS NAND2_X1
XI1068_I113_XG I1068_P17_16 I1068_G15_14 I1068_G17_16 I1068_G17_14n VDD VSS AOI21_X1
XI1068_I113_XP I1068_P17_16 I1068_P15_14 I1068_P17_14n VDD VSS NAND2_X1
XI1068_I114_XG I1068_P18_17 I1068_G16_15 I1068_G18_17 I1068_G18_15n VDD VSS AOI21_X1
XI1068_I114_XP I1068_P18_17 I1068_P16_15 I1068_P18_15n VDD VSS NAND2_X1
XI1068_I115_XG I1068_P19_18 I1068_G17_16 I1068_G19_18 I1068_G19_16n VDD VSS AOI21_X1
XI1068_I115_XP I1068_P19_18 I1068_P17_16 I1068_P19_16n VDD VSS NAND2_X1
XI1068_I116_XG I1068_P20_19 I1068_G18_17 I1068_G20_19 I1068_G20_17n VDD VSS AOI21_X1
XI1068_I116_XP I1068_P20_19 I1068_P18_17 I1068_P20_17n VDD VSS NAND2_X1
XI1068_I117_XG I1068_P21_20 I1068_G19_18 I1068_G21_20 I1068_G21_18n VDD VSS AOI21_X1
XI1068_I117_XP I1068_P21_20 I1068_P19_18 I1068_P21_18n VDD VSS NAND2_X1
XI1068_I118_XG I1068_P22_21 I1068_G20_19 I1068_G22_21 I1068_G22_19n VDD VSS AOI21_X1
XI1068_I118_XP I1068_P22_21 I1068_P20_19 I1068_P22_19n VDD VSS NAND2_X1
XI1068_I119_XG I1068_P23_22 I1068_G21_20 I1068_G23_22 I1068_G23_20n VDD VSS AOI21_X1
XI1068_I119_XP I1068_P23_22 I1068_P21_20 I1068_P23_20n VDD VSS NAND2_X1
XI1068_I120_XG I1068_P24_23 I1068_G22_21 I1068_G24_23 I1068_G24_21n VDD VSS AOI21_X1
XI1068_I120_XP I1068_P24_23 I1068_P22_21 I1068_P24_21n VDD VSS NAND2_X1
XI1068_I121_XG I1068_P25_24 I1068_G23_22 I1068_G25_24 I1068_G25_22n VDD VSS AOI21_X1
XI1068_I121_XP I1068_P25_24 I1068_P23_22 I1068_P25_22n VDD VSS NAND2_X1
XI1068_I122_XG I1068_P26_25 I1068_G24_23 I1068_G26_25 I1068_G26_23n VDD VSS AOI21_X1
XI1068_I122_XP I1068_P26_25 I1068_P24_23 I1068_P26_23n VDD VSS NAND2_X1
XI1068_I123_XG I1068_P27_26 I1068_G25_24 I1068_G27_26 I1068_G27_24n VDD VSS AOI21_X1
XI1068_I123_XP I1068_P27_26 I1068_P25_24 I1068_P27_24n VDD VSS NAND2_X1
XI1068_I124_XG I1068_P28_27 I1068_G26_25 I1068_G28_27 I1068_G28_25n VDD VSS AOI21_X1
XI1068_I124_XP I1068_P28_27 I1068_P26_25 I1068_P28_25n VDD VSS NAND2_X1
XI1068_I125_XG I1068_P29_28 I1068_G27_26 I1068_G29_28 I1068_G29_26n VDD VSS AOI21_X1
XI1068_I125_XP I1068_P29_28 I1068_P27_26 I1068_P29_26n VDD VSS NAND2_X1
XI1068_I126_XG I1068_P30_29 I1068_G28_27 I1068_G30_29 I1068_G30_27n VDD VSS AOI21_X1
XI1068_I126_XP I1068_P30_29 I1068_P28_27 I1068_P30_27n VDD VSS NAND2_X1
XI1068_I127_XG I1068_P31_30 I1068_G29_28 I1068_G31_30 I1068_G31_28n VDD VSS AOI21_X1
XI1068_I127_XP I1068_P31_30 I1068_P29_28 I1068_P31_28n VDD VSS NAND2_X1
XI1068_I128_XG I1068_P4_1n I1068_G0_0n I1068_G4_1n I1068_G4_0 VDD VSS OAI21_X1
XI1068_I129 I1068_G1_0 I1068_G1_0n VDD VSS INV_X1
XI1068_I130_XG I1068_P5_2n I1068_G1_0n I1068_G5_2n I1068_G5_0 VDD VSS OAI21_X1
XI1068_I131_XG I1068_P6_3n I1068_G2_0n I1068_G6_3n I1068_G6_0 VDD VSS OAI21_X1
XI1068_I132_XG I1068_P7_4n I1068_G3_0n I1068_G7_4n I1068_G7_0 VDD VSS OAI21_X1
XI1068_I133_XG I1068_P8_5n I1068_G4_1n I1068_G8_5n I1068_G8_1 VDD VSS OAI21_X1
XI1068_I133_XP I1068_P8_5n I1068_P4_1n I1068_P8_1 VDD VSS NOR2_X1
XI1068_I134_XG I1068_P9_6n I1068_G5_2n I1068_G9_6n I1068_G9_2 VDD VSS OAI21_X1
XI1068_I134_XP I1068_P9_6n I1068_P5_2n I1068_P9_2 VDD VSS NOR2_X1
XI1068_I135_XG I1068_P10_7n I1068_G6_3n I1068_G10_7n I1068_G10_3 VDD VSS OAI21_X1
XI1068_I135_XP I1068_P10_7n I1068_P6_3n I1068_P10_3 VDD VSS NOR2_X1
XI1068_I136_XG I1068_P11_8n I1068_G7_4n I1068_G11_8n I1068_G11_4 VDD VSS OAI21_X1
XI1068_I136_XP I1068_P11_8n I1068_P7_4n I1068_P11_4 VDD VSS NOR2_X1
XI1068_I137_XG I1068_P12_9n I1068_G8_5n I1068_G12_9n I1068_G12_5 VDD VSS OAI21_X1
XI1068_I137_XP I1068_P12_9n I1068_P8_5n I1068_P12_5 VDD VSS NOR2_X1
XI1068_I138_XG I1068_P13_10n I1068_G9_6n I1068_G13_10n I1068_G13_6 VDD VSS OAI21_X1
XI1068_I138_XP I1068_P13_10n I1068_P9_6n I1068_P13_6 VDD VSS NOR2_X1
XI1068_I139_XG I1068_P14_11n I1068_G10_7n I1068_G14_11n I1068_G14_7 VDD VSS OAI21_X1
XI1068_I139_XP I1068_P14_11n I1068_P10_7n I1068_P14_7 VDD VSS NOR2_X1
XI1068_I140_XG I1068_P15_12n I1068_G11_8n I1068_G15_12n I1068_G15_8 VDD VSS OAI21_X1
XI1068_I140_XP I1068_P15_12n I1068_P11_8n I1068_P15_8 VDD VSS NOR2_X1
XI1068_I141_XG I1068_P16_13n I1068_G12_9n I1068_G16_13n I1068_G16_9 VDD VSS OAI21_X1
XI1068_I141_XP I1068_P16_13n I1068_P12_9n I1068_P16_9 VDD VSS NOR2_X1
XI1068_I142_XG I1068_P17_14n I1068_G13_10n I1068_G17_14n I1068_G17_10 VDD VSS OAI21_X1
XI1068_I142_XP I1068_P17_14n I1068_P13_10n I1068_P17_10 VDD VSS NOR2_X1
XI1068_I143_XG I1068_P18_15n I1068_G14_11n I1068_G18_15n I1068_G18_11 VDD VSS OAI21_X1
XI1068_I143_XP I1068_P18_15n I1068_P14_11n I1068_P18_11 VDD VSS NOR2_X1
XI1068_I144_XG I1068_P19_16n I1068_G15_12n I1068_G19_16n I1068_G19_12 VDD VSS OAI21_X1
XI1068_I144_XP I1068_P19_16n I1068_P15_12n I1068_P19_12 VDD VSS NOR2_X1
XI1068_I145_XG I1068_P20_17n I1068_G16_13n I1068_G20_17n I1068_G20_13 VDD VSS OAI21_X1
XI1068_I145_XP I1068_P20_17n I1068_P16_13n I1068_P20_13 VDD VSS NOR2_X1
XI1068_I146_XG I1068_P21_18n I1068_G17_14n I1068_G21_18n I1068_G21_14 VDD VSS OAI21_X1
XI1068_I146_XP I1068_P21_18n I1068_P17_14n I1068_P21_14 VDD VSS NOR2_X1
XI1068_I147_XG I1068_P22_19n I1068_G18_15n I1068_G22_19n I1068_G22_15 VDD VSS OAI21_X1
XI1068_I147_XP I1068_P22_19n I1068_P18_15n I1068_P22_15 VDD VSS NOR2_X1
XI1068_I148_XG I1068_P23_20n I1068_G19_16n I1068_G23_20n I1068_G23_16 VDD VSS OAI21_X1
XI1068_I148_XP I1068_P23_20n I1068_P19_16n I1068_P23_16 VDD VSS NOR2_X1
XI1068_I149_XG I1068_P24_21n I1068_G20_17n I1068_G24_21n I1068_G24_17 VDD VSS OAI21_X1
XI1068_I149_XP I1068_P24_21n I1068_P20_17n I1068_P24_17 VDD VSS NOR2_X1
XI1068_I150_XG I1068_P25_22n I1068_G21_18n I1068_G25_22n I1068_G25_18 VDD VSS OAI21_X1
XI1068_I150_XP I1068_P25_22n I1068_P21_18n I1068_P25_18 VDD VSS NOR2_X1
XI1068_I151_XG I1068_P26_23n I1068_G22_19n I1068_G26_23n I1068_G26_19 VDD VSS OAI21_X1
XI1068_I151_XP I1068_P26_23n I1068_P22_19n I1068_P26_19 VDD VSS NOR2_X1
XI1068_I152_XG I1068_P27_24n I1068_G23_20n I1068_G27_24n I1068_G27_20 VDD VSS OAI21_X1
XI1068_I152_XP I1068_P27_24n I1068_P23_20n I1068_P27_20 VDD VSS NOR2_X1
XI1068_I153_XG I1068_P28_25n I1068_G24_21n I1068_G28_25n I1068_G28_21 VDD VSS OAI21_X1
XI1068_I153_XP I1068_P28_25n I1068_P24_21n I1068_P28_21 VDD VSS NOR2_X1
XI1068_I154_XG I1068_P29_26n I1068_G25_22n I1068_G29_26n I1068_G29_22 VDD VSS OAI21_X1
XI1068_I154_XP I1068_P29_26n I1068_P25_22n I1068_P29_22 VDD VSS NOR2_X1
XI1068_I155_XG I1068_P30_27n I1068_G26_23n I1068_G30_27n I1068_G30_23 VDD VSS OAI21_X1
XI1068_I155_XP I1068_P30_27n I1068_P26_23n I1068_P30_23 VDD VSS NOR2_X1
XI1068_I156_XG I1068_P31_28n I1068_G27_24n I1068_G31_28n I1068_G31_24 VDD VSS OAI21_X1
XI1068_I156_XP I1068_P31_28n I1068_P27_24n I1068_P31_24 VDD VSS NOR2_X1
XI1068_I157_XG I1068_P8_1 I1068_G0_0 I1068_G8_1 I1068_G8_0n VDD VSS AOI21_X1
XI1068_I158_XG I1068_P9_2 I1068_G1_0 I1068_G9_2 I1068_G9_0n VDD VSS AOI21_X1
XI1068_I159 I1068_G2_0n I1068_G2_0np VDD VSS INV_X1
XI1068_I160_XG I1068_P10_3 I1068_G2_0np I1068_G10_3 I1068_G10_0n VDD VSS AOI21_X1
XI1068_I161 I1068_G3_0n I1068_G3_0np VDD VSS INV_X1
XI1068_I162_XG I1068_P11_4 I1068_G3_0np I1068_G11_4 I1068_G11_0n VDD VSS AOI21_X1
XI1068_I163_XG I1068_P12_5 I1068_G4_0 I1068_G12_5 I1068_G12_0n VDD VSS AOI21_X1
XI1068_I164_XG I1068_P13_6 I1068_G5_0 I1068_G13_6 I1068_G13_0n VDD VSS AOI21_X1
XI1068_I165_XG I1068_P14_7 I1068_G6_0 I1068_G14_7 I1068_G14_0n VDD VSS AOI21_X1
XI1068_I166_XG I1068_P15_8 I1068_G7_0 I1068_G15_8 I1068_G15_0n VDD VSS AOI21_X1
XI1068_I167_XG I1068_P16_9 I1068_G8_1 I1068_G16_9 I1068_G16_1n VDD VSS AOI21_X1
XI1068_I167_XP I1068_P16_9 I1068_P8_1 I1068_P16_1n VDD VSS NAND2_X1
XI1068_I168_XG I1068_P17_10 I1068_G9_2 I1068_G17_10 I1068_G17_2n VDD VSS AOI21_X1
XI1068_I168_XP I1068_P17_10 I1068_P9_2 I1068_P17_2n VDD VSS NAND2_X1
XI1068_I169_XG I1068_P18_11 I1068_G10_3 I1068_G18_11 I1068_G18_3n VDD VSS AOI21_X1
XI1068_I169_XP I1068_P18_11 I1068_P10_3 I1068_P18_3n VDD VSS NAND2_X1
XI1068_I170_XG I1068_P19_12 I1068_G11_4 I1068_G19_12 I1068_G19_4n VDD VSS AOI21_X1
XI1068_I170_XP I1068_P19_12 I1068_P11_4 I1068_P19_4n VDD VSS NAND2_X1
XI1068_I171_XG I1068_P20_13 I1068_G12_5 I1068_G20_13 I1068_G20_5n VDD VSS AOI21_X1
XI1068_I171_XP I1068_P20_13 I1068_P12_5 I1068_P20_5n VDD VSS NAND2_X1
XI1068_I172_XG I1068_P21_14 I1068_G13_6 I1068_G21_14 I1068_G21_6n VDD VSS AOI21_X1
XI1068_I172_XP I1068_P21_14 I1068_P13_6 I1068_P21_6n VDD VSS NAND2_X1
XI1068_I173_XG I1068_P22_15 I1068_G14_7 I1068_G22_15 I1068_G22_7n VDD VSS AOI21_X1
XI1068_I173_XP I1068_P22_15 I1068_P14_7 I1068_P22_7n VDD VSS NAND2_X1
XI1068_I174_XG I1068_P23_16 I1068_G15_8 I1068_G23_16 I1068_G23_8n VDD VSS AOI21_X1
XI1068_I174_XP I1068_P23_16 I1068_P15_8 I1068_P23_8n VDD VSS NAND2_X1
XI1068_I175_XG I1068_P24_17 I1068_G16_9 I1068_G24_17 I1068_G24_9n VDD VSS AOI21_X1
XI1068_I175_XP I1068_P24_17 I1068_P16_9 I1068_P24_9n VDD VSS NAND2_X1
XI1068_I176_XG I1068_P25_18 I1068_G17_10 I1068_G25_18 I1068_G25_10n VDD VSS AOI21_X1
XI1068_I176_XP I1068_P25_18 I1068_P17_10 I1068_P25_10n VDD VSS NAND2_X1
XI1068_I177_XG I1068_P26_19 I1068_G18_11 I1068_G26_19 I1068_G26_11n VDD VSS AOI21_X1
XI1068_I177_XP I1068_P26_19 I1068_P18_11 I1068_P26_11n VDD VSS NAND2_X1
XI1068_I178_XG I1068_P27_20 I1068_G19_12 I1068_G27_20 I1068_G27_12n VDD VSS AOI21_X1
XI1068_I178_XP I1068_P27_20 I1068_P19_12 I1068_P27_12n VDD VSS NAND2_X1
XI1068_I179_XG I1068_P28_21 I1068_G20_13 I1068_G28_21 I1068_G28_13n VDD VSS AOI21_X1
XI1068_I179_XP I1068_P28_21 I1068_P20_13 I1068_P28_13n VDD VSS NAND2_X1
XI1068_I180_XG I1068_P29_22 I1068_G21_14 I1068_G29_22 I1068_G29_14n VDD VSS AOI21_X1
XI1068_I180_XP I1068_P29_22 I1068_P21_14 I1068_P29_14n VDD VSS NAND2_X1
XI1068_I181_XG I1068_P30_23 I1068_G22_15 I1068_G30_23 I1068_G30_15n VDD VSS AOI21_X1
XI1068_I181_XP I1068_P30_23 I1068_P22_15 I1068_P30_15n VDD VSS NAND2_X1
XI1068_I182_XG I1068_P31_24 I1068_G23_16 I1068_G31_24 I1068_G31_16n VDD VSS AOI21_X1
XI1068_I182_XP I1068_P31_24 I1068_P23_16 I1068_P31_16n VDD VSS NAND2_X1
XI1068_I183_XG I1068_P16_1n I1068_G0_0n I1068_G16_1n I1068_G16_0 VDD VSS OAI21_X1
XI1068_I184_XG I1068_P17_2n I1068_G1_0n I1068_G17_2n I1068_G17_0 VDD VSS OAI21_X1
XI1068_I185_XG I1068_P18_3n I1068_G2_0n I1068_G18_3n I1068_G18_0 VDD VSS OAI21_X1
XI1068_I186_XG I1068_P19_4n I1068_G3_0n I1068_G19_4n I1068_G19_0 VDD VSS OAI21_X1
XI1068_I187 I1068_G4_0 I1068_G4_0n VDD VSS INV_X1
XI1068_I188_XG I1068_P20_5n I1068_G4_0n I1068_G20_5n I1068_G20_0 VDD VSS OAI21_X1
XI1068_I189 I1068_G5_0 I1068_G5_0n VDD VSS INV_X1
XI1068_I190_XG I1068_P21_6n I1068_G5_0n I1068_G21_6n I1068_G21_0 VDD VSS OAI21_X1
XI1068_I191 I1068_G6_0 I1068_G6_0n VDD VSS INV_X1
XI1068_I192_XG I1068_P22_7n I1068_G6_0n I1068_G22_7n I1068_G22_0 VDD VSS OAI21_X1
XI1068_I193 I1068_G7_0 I1068_G7_0n VDD VSS INV_X1
XI1068_I194_XG I1068_P23_8n I1068_G7_0n I1068_G23_8n I1068_G23_0 VDD VSS OAI21_X1
XI1068_I195_XG I1068_P24_9n I1068_G8_0n I1068_G24_9n I1068_G24_0 VDD VSS OAI21_X1
XI1068_I196_XG I1068_P25_10n I1068_G9_0n I1068_G25_10n I1068_G25_0 VDD VSS OAI21_X1
XI1068_I197_XG I1068_P26_11n I1068_G10_0n I1068_G26_11n I1068_G26_0 VDD VSS OAI21_X1
XI1068_I198_XG I1068_P27_12n I1068_G11_0n I1068_G27_12n I1068_G27_0 VDD VSS OAI21_X1
XI1068_I199_XG I1068_P28_13n I1068_G12_0n I1068_G28_13n I1068_G28_0 VDD VSS OAI21_X1
XI1068_I200_XG I1068_P29_14n I1068_G13_0n I1068_G29_14n I1068_G29_0 VDD VSS OAI21_X1
XI1068_I201_XG I1068_P30_15n I1068_G14_0n I1068_G30_15n c11_m VDD VSS OAI21_X1
XI1068_I202_XG I1068_P31_16n I1068_G15_0n I1068_G31_16n c11_o VDD VSS OAI21_X1
XI1068_I203 I1068_pn0 qu21_b3_5 p11_0 VDD VSS XNOR2_X1
XI1068_I204 I1068_pn1 I1068_G0_0 p11_1 VDD VSS XNOR2_X1
XI1068_I205 I1068_pn2 I1068_G1_0 p11_2 VDD VSS XNOR2_X1
XI1068_I206 I1068_pn3 I1068_G2_0n p11_3 VDD VSS XOR2_X1
XI1068_I207 I1068_pn4 I1068_G3_0n p11_4 VDD VSS XOR2_X1
XI1068_I208 I1068_pn5 I1068_G4_0 p11_5 VDD VSS XNOR2_X1
XI1068_I209 I1068_pn6 I1068_G5_0 p11_6 VDD VSS XNOR2_X1
XI1068_I210 I1068_pn7 I1068_G6_0 p11_7 VDD VSS XNOR2_X1
XI1068_I211 I1068_pn8 I1068_G7_0 p11_8 VDD VSS XNOR2_X1
XI1068_I212 I1068_pn9 I1068_G8_0n p11_9 VDD VSS XOR2_X1
XI1068_I213 I1068_pn10 I1068_G9_0n p11_10 VDD VSS XOR2_X1
XI1068_I214 I1068_pn11 I1068_G10_0n p11_11 VDD VSS XOR2_X1
XI1068_I215 I1068_pn12 I1068_G11_0n p11_12 VDD VSS XOR2_X1
XI1068_I216 I1068_pn13 I1068_G12_0n p11_13 VDD VSS XOR2_X1
XI1068_I217 I1068_pn14 I1068_G13_0n p11_14 VDD VSS XOR2_X1
XI1068_I218 I1068_pn15 I1068_G14_0n p11_15 VDD VSS XOR2_X1
XI1068_I219 I1068_pn16 I1068_G15_0n p11_16 VDD VSS XOR2_X1
XI1068_I220 I1068_pn17 I1068_G16_0 p11_17 VDD VSS XNOR2_X1
XI1068_I221 I1068_pn18 I1068_G17_0 p11_18 VDD VSS XNOR2_X1
XI1068_I222 I1068_pn19 I1068_G18_0 p11_19 VDD VSS XNOR2_X1
XI1068_I223 I1068_pn20 I1068_G19_0 p11_20 VDD VSS XNOR2_X1
XI1068_I224 I1068_pn21 I1068_G20_0 p11_21 VDD VSS XNOR2_X1
XI1068_I225 I1068_pn22 I1068_G21_0 p11_22 VDD VSS XNOR2_X1
XI1068_I226 I1068_pn23 I1068_G22_0 p11_23 VDD VSS XNOR2_X1
XI1068_I227 I1068_pn24 I1068_G23_0 p11_24 VDD VSS XNOR2_X1
XI1068_I228 I1068_pn25 I1068_G24_0 p11_25 VDD VSS XNOR2_X1
XI1068_I229 I1068_pn26 I1068_G25_0 p11_26 VDD VSS XNOR2_X1
XI1068_I230 I1068_pn27 I1068_G26_0 p11_27 VDD VSS XNOR2_X1
XI1068_I231 I1068_pn28 I1068_G27_0 p11_28 VDD VSS XNOR2_X1
XI1068_I232 I1068_pn29 I1068_G28_0 p11_29 VDD VSS XNOR2_X1
XI1068_I233 I1068_pn30 I1068_G29_0 p11_30 VDD VSS XNOR2_X1
XI1068_I234 I1068_pn31 c11_m p11_31 VDD VSS XNOR2_X1
XI1069 p10_31 qu21_b3_5 h11 VDD VSS XOR2_X1
XI1070 h11 c11_o p11_32 VDD VSS XOR2_X1
XI1071 p11_32 qu20 VDD VSS INV_X4
XI1072 qu20 qu20_b0 VDD VSS INV_X1
XI1073 qu20_b0 qu20_b1_0 VDD VSS INV_X4
XI1074 qu20_b1_0 qu20_b2_0 VDD VSS INV_X4
XI1075 qu20_b1_0 qu20_b2_1 VDD VSS INV_X4
XI1076 qu20_b2_0 qu20_b3_0 VDD VSS INV_X4
XI1077 qu20_b2_0 qu20_b3_1 VDD VSS INV_X4
XI1078 qu20_b2_0 qu20_b3_2 VDD VSS INV_X4
XI1079 qu20_b2_1 qu20_b3_3 VDD VSS INV_X4
XI1080 qu20_b2_1 qu20_b3_4 VDD VSS INV_X4
XI1081 qu20_b2_1 qu20_b3_5 VDD VSS INV_X4
XI1082 B_0_b3_2 qu20_b3_0 b12_0 VDD VSS XOR2_X1
XI1083 dd1_b3_2 qu20_b3_0 b12_1 VDD VSS XOR2_X1
XI1084 dd2_b3_2 qu20_b3_0 b12_2 VDD VSS XOR2_X1
XI1085 dd3_b3_2 qu20_b3_0 b12_3 VDD VSS XOR2_X1
XI1086 dd4_b3_2 qu20_b3_0 b12_4 VDD VSS XOR2_X1
XI1087 dd5_b3_2 qu20_b3_0 b12_5 VDD VSS XOR2_X1
XI1088 dd6_b3_2 qu20_b3_1 b12_6 VDD VSS XOR2_X1
XI1089 dd7_b3_2 qu20_b3_1 b12_7 VDD VSS XOR2_X1
XI1090 dd8_b3_2 qu20_b3_1 b12_8 VDD VSS XOR2_X1
XI1091 dd9_b3_2 qu20_b3_1 b12_9 VDD VSS XOR2_X1
XI1092 dd10_b3_2 qu20_b3_1 b12_10 VDD VSS XOR2_X1
XI1093 dd11_b3_2 qu20_b3_1 b12_11 VDD VSS XOR2_X1
XI1094 dd12_b3_2 qu20_b3_2 b12_12 VDD VSS XOR2_X1
XI1095 dd13_b3_2 qu20_b3_2 b12_13 VDD VSS XOR2_X1
XI1096 dd14_b3_2 qu20_b3_2 b12_14 VDD VSS XOR2_X1
XI1097 dd15_b3_2 qu20_b3_2 b12_15 VDD VSS XOR2_X1
XI1098 dd16_b3_2 qu20_b3_2 b12_16 VDD VSS XOR2_X1
XI1099 dd17_b3_2 qu20_b3_2 b12_17 VDD VSS XOR2_X1
XI1100 dd18_b3_2 qu20_b3_3 b12_18 VDD VSS XOR2_X1
XI1101 dd19_b3_2 qu20_b3_3 b12_19 VDD VSS XOR2_X1
XI1102 dd20_b3_2 qu20_b3_3 b12_20 VDD VSS XOR2_X1
XI1103 dd21_b3_2 qu20_b3_3 b12_21 VDD VSS XOR2_X1
XI1104 dd22_b3_2 qu20_b3_3 b12_22 VDD VSS XOR2_X1
XI1105 dd23_b3_2 qu20_b3_3 b12_23 VDD VSS XOR2_X1
XI1106 dd24_b3_2 qu20_b3_4 b12_24 VDD VSS XOR2_X1
XI1107 dd25_b3_2 qu20_b3_4 b12_25 VDD VSS XOR2_X1
XI1108 dd26_b3_2 qu20_b3_4 b12_26 VDD VSS XOR2_X1
XI1109 dd27_b3_2 qu20_b3_4 b12_27 VDD VSS XOR2_X1
XI1110 dd28_b3_2 qu20_b3_4 b12_28 VDD VSS XOR2_X1
XI1111 dd29_b3_2 qu20_b3_4 b12_29 VDD VSS XOR2_X1
XI1112 dd30_b3_2 qu20_b3_5 b12_30 VDD VSS XOR2_X1
XI1113 dd31_b3_2 qu20_b3_5 b12_31 VDD VSS XOR2_X1
XI1114_I0 aa19 b12_0 I1114_gn0 VDD VSS NAND2_X1
XI1114_I1 p11_0 b12_1 I1114_gn1 VDD VSS NAND2_X1
XI1114_I2 p11_1 b12_2 I1114_gn2 VDD VSS NAND2_X1
XI1114_I3 p11_2 b12_3 I1114_gn3 VDD VSS NAND2_X1
XI1114_I4 p11_3 b12_4 I1114_gn4 VDD VSS NAND2_X1
XI1114_I5 p11_4 b12_5 I1114_gn5 VDD VSS NAND2_X1
XI1114_I6 p11_5 b12_6 I1114_gn6 VDD VSS NAND2_X1
XI1114_I7 p11_6 b12_7 I1114_gn7 VDD VSS NAND2_X1
XI1114_I8 p11_7 b12_8 I1114_gn8 VDD VSS NAND2_X1
XI1114_I9 p11_8 b12_9 I1114_gn9 VDD VSS NAND2_X1
XI1114_I10 p11_9 b12_10 I1114_gn10 VDD VSS NAND2_X1
XI1114_I11 p11_10 b12_11 I1114_gn11 VDD VSS NAND2_X1
XI1114_I12 p11_11 b12_12 I1114_gn12 VDD VSS NAND2_X1
XI1114_I13 p11_12 b12_13 I1114_gn13 VDD VSS NAND2_X1
XI1114_I14 p11_13 b12_14 I1114_gn14 VDD VSS NAND2_X1
XI1114_I15 p11_14 b12_15 I1114_gn15 VDD VSS NAND2_X1
XI1114_I16 p11_15 b12_16 I1114_gn16 VDD VSS NAND2_X1
XI1114_I17 p11_16 b12_17 I1114_gn17 VDD VSS NAND2_X1
XI1114_I18 p11_17 b12_18 I1114_gn18 VDD VSS NAND2_X1
XI1114_I19 p11_18 b12_19 I1114_gn19 VDD VSS NAND2_X1
XI1114_I20 p11_19 b12_20 I1114_gn20 VDD VSS NAND2_X1
XI1114_I21 p11_20 b12_21 I1114_gn21 VDD VSS NAND2_X1
XI1114_I22 p11_21 b12_22 I1114_gn22 VDD VSS NAND2_X1
XI1114_I23 p11_22 b12_23 I1114_gn23 VDD VSS NAND2_X1
XI1114_I24 p11_23 b12_24 I1114_gn24 VDD VSS NAND2_X1
XI1114_I25 p11_24 b12_25 I1114_gn25 VDD VSS NAND2_X1
XI1114_I26 p11_25 b12_26 I1114_gn26 VDD VSS NAND2_X1
XI1114_I27 p11_26 b12_27 I1114_gn27 VDD VSS NAND2_X1
XI1114_I28 p11_27 b12_28 I1114_gn28 VDD VSS NAND2_X1
XI1114_I29 p11_28 b12_29 I1114_gn29 VDD VSS NAND2_X1
XI1114_I30 p11_29 b12_30 I1114_gn30 VDD VSS NAND2_X1
XI1114_I31 p11_30 b12_31 I1114_gn31 VDD VSS NAND2_X1
XI1114_I32 aa19 b12_0 I1114_pn0 VDD VSS XNOR2_X1
XI1114_I33 p11_0 b12_1 I1114_pn1 VDD VSS XNOR2_X1
XI1114_I34 p11_1 b12_2 I1114_pn2 VDD VSS XNOR2_X1
XI1114_I35 p11_2 b12_3 I1114_pn3 VDD VSS XNOR2_X1
XI1114_I36 p11_3 b12_4 I1114_pn4 VDD VSS XNOR2_X1
XI1114_I37 p11_4 b12_5 I1114_pn5 VDD VSS XNOR2_X1
XI1114_I38 p11_5 b12_6 I1114_pn6 VDD VSS XNOR2_X1
XI1114_I39 p11_6 b12_7 I1114_pn7 VDD VSS XNOR2_X1
XI1114_I40 p11_7 b12_8 I1114_pn8 VDD VSS XNOR2_X1
XI1114_I41 p11_8 b12_9 I1114_pn9 VDD VSS XNOR2_X1
XI1114_I42 p11_9 b12_10 I1114_pn10 VDD VSS XNOR2_X1
XI1114_I43 p11_10 b12_11 I1114_pn11 VDD VSS XNOR2_X1
XI1114_I44 p11_11 b12_12 I1114_pn12 VDD VSS XNOR2_X1
XI1114_I45 p11_12 b12_13 I1114_pn13 VDD VSS XNOR2_X1
XI1114_I46 p11_13 b12_14 I1114_pn14 VDD VSS XNOR2_X1
XI1114_I47 p11_14 b12_15 I1114_pn15 VDD VSS XNOR2_X1
XI1114_I48 p11_15 b12_16 I1114_pn16 VDD VSS XNOR2_X1
XI1114_I49 p11_16 b12_17 I1114_pn17 VDD VSS XNOR2_X1
XI1114_I50 p11_17 b12_18 I1114_pn18 VDD VSS XNOR2_X1
XI1114_I51 p11_18 b12_19 I1114_pn19 VDD VSS XNOR2_X1
XI1114_I52 p11_19 b12_20 I1114_pn20 VDD VSS XNOR2_X1
XI1114_I53 p11_20 b12_21 I1114_pn21 VDD VSS XNOR2_X1
XI1114_I54 p11_21 b12_22 I1114_pn22 VDD VSS XNOR2_X1
XI1114_I55 p11_22 b12_23 I1114_pn23 VDD VSS XNOR2_X1
XI1114_I56 p11_23 b12_24 I1114_pn24 VDD VSS XNOR2_X1
XI1114_I57 p11_24 b12_25 I1114_pn25 VDD VSS XNOR2_X1
XI1114_I58 p11_25 b12_26 I1114_pn26 VDD VSS XNOR2_X1
XI1114_I59 p11_26 b12_27 I1114_pn27 VDD VSS XNOR2_X1
XI1114_I60 p11_27 b12_28 I1114_pn28 VDD VSS XNOR2_X1
XI1114_I61 p11_28 b12_29 I1114_pn29 VDD VSS XNOR2_X1
XI1114_I62 p11_29 b12_30 I1114_pn30 VDD VSS XNOR2_X1
XI1114_I63 p11_30 b12_31 I1114_pn31 VDD VSS XNOR2_X1
XI1114_I64 qu20_b3_5 I1114_cinn VDD VSS INV_X1
XI1114_I65_XG I1114_pn0 I1114_cinn I1114_gn0 I1114_G0_0 VDD VSS OAI21_X1
XI1114_I66 I1114_G0_0 I1114_G0_0n VDD VSS INV_X1
XI1114_I67_XG I1114_pn1 I1114_G0_0n I1114_gn1 I1114_G1_0 VDD VSS OAI21_X1
XI1114_I68_XG I1114_pn2 I1114_gn1 I1114_gn2 I1114_G2_1 VDD VSS OAI21_X1
XI1114_I68_XP I1114_pn2 I1114_pn1 I1114_P2_1 VDD VSS NOR2_X1
XI1114_I69_XG I1114_pn3 I1114_gn2 I1114_gn3 I1114_G3_2 VDD VSS OAI21_X1
XI1114_I69_XP I1114_pn3 I1114_pn2 I1114_P3_2 VDD VSS NOR2_X1
XI1114_I70_XG I1114_pn4 I1114_gn3 I1114_gn4 I1114_G4_3 VDD VSS OAI21_X1
XI1114_I70_XP I1114_pn4 I1114_pn3 I1114_P4_3 VDD VSS NOR2_X1
XI1114_I71_XG I1114_pn5 I1114_gn4 I1114_gn5 I1114_G5_4 VDD VSS OAI21_X1
XI1114_I71_XP I1114_pn5 I1114_pn4 I1114_P5_4 VDD VSS NOR2_X1
XI1114_I72_XG I1114_pn6 I1114_gn5 I1114_gn6 I1114_G6_5 VDD VSS OAI21_X1
XI1114_I72_XP I1114_pn6 I1114_pn5 I1114_P6_5 VDD VSS NOR2_X1
XI1114_I73_XG I1114_pn7 I1114_gn6 I1114_gn7 I1114_G7_6 VDD VSS OAI21_X1
XI1114_I73_XP I1114_pn7 I1114_pn6 I1114_P7_6 VDD VSS NOR2_X1
XI1114_I74_XG I1114_pn8 I1114_gn7 I1114_gn8 I1114_G8_7 VDD VSS OAI21_X1
XI1114_I74_XP I1114_pn8 I1114_pn7 I1114_P8_7 VDD VSS NOR2_X1
XI1114_I75_XG I1114_pn9 I1114_gn8 I1114_gn9 I1114_G9_8 VDD VSS OAI21_X1
XI1114_I75_XP I1114_pn9 I1114_pn8 I1114_P9_8 VDD VSS NOR2_X1
XI1114_I76_XG I1114_pn10 I1114_gn9 I1114_gn10 I1114_G10_9 VDD VSS OAI21_X1
XI1114_I76_XP I1114_pn10 I1114_pn9 I1114_P10_9 VDD VSS NOR2_X1
XI1114_I77_XG I1114_pn11 I1114_gn10 I1114_gn11 I1114_G11_10 VDD VSS OAI21_X1
XI1114_I77_XP I1114_pn11 I1114_pn10 I1114_P11_10 VDD VSS NOR2_X1
XI1114_I78_XG I1114_pn12 I1114_gn11 I1114_gn12 I1114_G12_11 VDD VSS OAI21_X1
XI1114_I78_XP I1114_pn12 I1114_pn11 I1114_P12_11 VDD VSS NOR2_X1
XI1114_I79_XG I1114_pn13 I1114_gn12 I1114_gn13 I1114_G13_12 VDD VSS OAI21_X1
XI1114_I79_XP I1114_pn13 I1114_pn12 I1114_P13_12 VDD VSS NOR2_X1
XI1114_I80_XG I1114_pn14 I1114_gn13 I1114_gn14 I1114_G14_13 VDD VSS OAI21_X1
XI1114_I80_XP I1114_pn14 I1114_pn13 I1114_P14_13 VDD VSS NOR2_X1
XI1114_I81_XG I1114_pn15 I1114_gn14 I1114_gn15 I1114_G15_14 VDD VSS OAI21_X1
XI1114_I81_XP I1114_pn15 I1114_pn14 I1114_P15_14 VDD VSS NOR2_X1
XI1114_I82_XG I1114_pn16 I1114_gn15 I1114_gn16 I1114_G16_15 VDD VSS OAI21_X1
XI1114_I82_XP I1114_pn16 I1114_pn15 I1114_P16_15 VDD VSS NOR2_X1
XI1114_I83_XG I1114_pn17 I1114_gn16 I1114_gn17 I1114_G17_16 VDD VSS OAI21_X1
XI1114_I83_XP I1114_pn17 I1114_pn16 I1114_P17_16 VDD VSS NOR2_X1
XI1114_I84_XG I1114_pn18 I1114_gn17 I1114_gn18 I1114_G18_17 VDD VSS OAI21_X1
XI1114_I84_XP I1114_pn18 I1114_pn17 I1114_P18_17 VDD VSS NOR2_X1
XI1114_I85_XG I1114_pn19 I1114_gn18 I1114_gn19 I1114_G19_18 VDD VSS OAI21_X1
XI1114_I85_XP I1114_pn19 I1114_pn18 I1114_P19_18 VDD VSS NOR2_X1
XI1114_I86_XG I1114_pn20 I1114_gn19 I1114_gn20 I1114_G20_19 VDD VSS OAI21_X1
XI1114_I86_XP I1114_pn20 I1114_pn19 I1114_P20_19 VDD VSS NOR2_X1
XI1114_I87_XG I1114_pn21 I1114_gn20 I1114_gn21 I1114_G21_20 VDD VSS OAI21_X1
XI1114_I87_XP I1114_pn21 I1114_pn20 I1114_P21_20 VDD VSS NOR2_X1
XI1114_I88_XG I1114_pn22 I1114_gn21 I1114_gn22 I1114_G22_21 VDD VSS OAI21_X1
XI1114_I88_XP I1114_pn22 I1114_pn21 I1114_P22_21 VDD VSS NOR2_X1
XI1114_I89_XG I1114_pn23 I1114_gn22 I1114_gn23 I1114_G23_22 VDD VSS OAI21_X1
XI1114_I89_XP I1114_pn23 I1114_pn22 I1114_P23_22 VDD VSS NOR2_X1
XI1114_I90_XG I1114_pn24 I1114_gn23 I1114_gn24 I1114_G24_23 VDD VSS OAI21_X1
XI1114_I90_XP I1114_pn24 I1114_pn23 I1114_P24_23 VDD VSS NOR2_X1
XI1114_I91_XG I1114_pn25 I1114_gn24 I1114_gn25 I1114_G25_24 VDD VSS OAI21_X1
XI1114_I91_XP I1114_pn25 I1114_pn24 I1114_P25_24 VDD VSS NOR2_X1
XI1114_I92_XG I1114_pn26 I1114_gn25 I1114_gn26 I1114_G26_25 VDD VSS OAI21_X1
XI1114_I92_XP I1114_pn26 I1114_pn25 I1114_P26_25 VDD VSS NOR2_X1
XI1114_I93_XG I1114_pn27 I1114_gn26 I1114_gn27 I1114_G27_26 VDD VSS OAI21_X1
XI1114_I93_XP I1114_pn27 I1114_pn26 I1114_P27_26 VDD VSS NOR2_X1
XI1114_I94_XG I1114_pn28 I1114_gn27 I1114_gn28 I1114_G28_27 VDD VSS OAI21_X1
XI1114_I94_XP I1114_pn28 I1114_pn27 I1114_P28_27 VDD VSS NOR2_X1
XI1114_I95_XG I1114_pn29 I1114_gn28 I1114_gn29 I1114_G29_28 VDD VSS OAI21_X1
XI1114_I95_XP I1114_pn29 I1114_pn28 I1114_P29_28 VDD VSS NOR2_X1
XI1114_I96_XG I1114_pn30 I1114_gn29 I1114_gn30 I1114_G30_29 VDD VSS OAI21_X1
XI1114_I96_XP I1114_pn30 I1114_pn29 I1114_P30_29 VDD VSS NOR2_X1
XI1114_I97_XG I1114_pn31 I1114_gn30 I1114_gn31 I1114_G31_30 VDD VSS OAI21_X1
XI1114_I97_XP I1114_pn31 I1114_pn30 I1114_P31_30 VDD VSS NOR2_X1
XI1114_I98_XG I1114_P2_1 I1114_G0_0 I1114_G2_1 I1114_G2_0n VDD VSS AOI21_X1
XI1114_I99_XG I1114_P3_2 I1114_G1_0 I1114_G3_2 I1114_G3_0n VDD VSS AOI21_X1
XI1114_I100_XG I1114_P4_3 I1114_G2_1 I1114_G4_3 I1114_G4_1n VDD VSS AOI21_X1
XI1114_I100_XP I1114_P4_3 I1114_P2_1 I1114_P4_1n VDD VSS NAND2_X1
XI1114_I101_XG I1114_P5_4 I1114_G3_2 I1114_G5_4 I1114_G5_2n VDD VSS AOI21_X1
XI1114_I101_XP I1114_P5_4 I1114_P3_2 I1114_P5_2n VDD VSS NAND2_X1
XI1114_I102_XG I1114_P6_5 I1114_G4_3 I1114_G6_5 I1114_G6_3n VDD VSS AOI21_X1
XI1114_I102_XP I1114_P6_5 I1114_P4_3 I1114_P6_3n VDD VSS NAND2_X1
XI1114_I103_XG I1114_P7_6 I1114_G5_4 I1114_G7_6 I1114_G7_4n VDD VSS AOI21_X1
XI1114_I103_XP I1114_P7_6 I1114_P5_4 I1114_P7_4n VDD VSS NAND2_X1
XI1114_I104_XG I1114_P8_7 I1114_G6_5 I1114_G8_7 I1114_G8_5n VDD VSS AOI21_X1
XI1114_I104_XP I1114_P8_7 I1114_P6_5 I1114_P8_5n VDD VSS NAND2_X1
XI1114_I105_XG I1114_P9_8 I1114_G7_6 I1114_G9_8 I1114_G9_6n VDD VSS AOI21_X1
XI1114_I105_XP I1114_P9_8 I1114_P7_6 I1114_P9_6n VDD VSS NAND2_X1
XI1114_I106_XG I1114_P10_9 I1114_G8_7 I1114_G10_9 I1114_G10_7n VDD VSS AOI21_X1
XI1114_I106_XP I1114_P10_9 I1114_P8_7 I1114_P10_7n VDD VSS NAND2_X1
XI1114_I107_XG I1114_P11_10 I1114_G9_8 I1114_G11_10 I1114_G11_8n VDD VSS AOI21_X1
XI1114_I107_XP I1114_P11_10 I1114_P9_8 I1114_P11_8n VDD VSS NAND2_X1
XI1114_I108_XG I1114_P12_11 I1114_G10_9 I1114_G12_11 I1114_G12_9n VDD VSS AOI21_X1
XI1114_I108_XP I1114_P12_11 I1114_P10_9 I1114_P12_9n VDD VSS NAND2_X1
XI1114_I109_XG I1114_P13_12 I1114_G11_10 I1114_G13_12 I1114_G13_10n VDD VSS AOI21_X1
XI1114_I109_XP I1114_P13_12 I1114_P11_10 I1114_P13_10n VDD VSS NAND2_X1
XI1114_I110_XG I1114_P14_13 I1114_G12_11 I1114_G14_13 I1114_G14_11n VDD VSS AOI21_X1
XI1114_I110_XP I1114_P14_13 I1114_P12_11 I1114_P14_11n VDD VSS NAND2_X1
XI1114_I111_XG I1114_P15_14 I1114_G13_12 I1114_G15_14 I1114_G15_12n VDD VSS AOI21_X1
XI1114_I111_XP I1114_P15_14 I1114_P13_12 I1114_P15_12n VDD VSS NAND2_X1
XI1114_I112_XG I1114_P16_15 I1114_G14_13 I1114_G16_15 I1114_G16_13n VDD VSS AOI21_X1
XI1114_I112_XP I1114_P16_15 I1114_P14_13 I1114_P16_13n VDD VSS NAND2_X1
XI1114_I113_XG I1114_P17_16 I1114_G15_14 I1114_G17_16 I1114_G17_14n VDD VSS AOI21_X1
XI1114_I113_XP I1114_P17_16 I1114_P15_14 I1114_P17_14n VDD VSS NAND2_X1
XI1114_I114_XG I1114_P18_17 I1114_G16_15 I1114_G18_17 I1114_G18_15n VDD VSS AOI21_X1
XI1114_I114_XP I1114_P18_17 I1114_P16_15 I1114_P18_15n VDD VSS NAND2_X1
XI1114_I115_XG I1114_P19_18 I1114_G17_16 I1114_G19_18 I1114_G19_16n VDD VSS AOI21_X1
XI1114_I115_XP I1114_P19_18 I1114_P17_16 I1114_P19_16n VDD VSS NAND2_X1
XI1114_I116_XG I1114_P20_19 I1114_G18_17 I1114_G20_19 I1114_G20_17n VDD VSS AOI21_X1
XI1114_I116_XP I1114_P20_19 I1114_P18_17 I1114_P20_17n VDD VSS NAND2_X1
XI1114_I117_XG I1114_P21_20 I1114_G19_18 I1114_G21_20 I1114_G21_18n VDD VSS AOI21_X1
XI1114_I117_XP I1114_P21_20 I1114_P19_18 I1114_P21_18n VDD VSS NAND2_X1
XI1114_I118_XG I1114_P22_21 I1114_G20_19 I1114_G22_21 I1114_G22_19n VDD VSS AOI21_X1
XI1114_I118_XP I1114_P22_21 I1114_P20_19 I1114_P22_19n VDD VSS NAND2_X1
XI1114_I119_XG I1114_P23_22 I1114_G21_20 I1114_G23_22 I1114_G23_20n VDD VSS AOI21_X1
XI1114_I119_XP I1114_P23_22 I1114_P21_20 I1114_P23_20n VDD VSS NAND2_X1
XI1114_I120_XG I1114_P24_23 I1114_G22_21 I1114_G24_23 I1114_G24_21n VDD VSS AOI21_X1
XI1114_I120_XP I1114_P24_23 I1114_P22_21 I1114_P24_21n VDD VSS NAND2_X1
XI1114_I121_XG I1114_P25_24 I1114_G23_22 I1114_G25_24 I1114_G25_22n VDD VSS AOI21_X1
XI1114_I121_XP I1114_P25_24 I1114_P23_22 I1114_P25_22n VDD VSS NAND2_X1
XI1114_I122_XG I1114_P26_25 I1114_G24_23 I1114_G26_25 I1114_G26_23n VDD VSS AOI21_X1
XI1114_I122_XP I1114_P26_25 I1114_P24_23 I1114_P26_23n VDD VSS NAND2_X1
XI1114_I123_XG I1114_P27_26 I1114_G25_24 I1114_G27_26 I1114_G27_24n VDD VSS AOI21_X1
XI1114_I123_XP I1114_P27_26 I1114_P25_24 I1114_P27_24n VDD VSS NAND2_X1
XI1114_I124_XG I1114_P28_27 I1114_G26_25 I1114_G28_27 I1114_G28_25n VDD VSS AOI21_X1
XI1114_I124_XP I1114_P28_27 I1114_P26_25 I1114_P28_25n VDD VSS NAND2_X1
XI1114_I125_XG I1114_P29_28 I1114_G27_26 I1114_G29_28 I1114_G29_26n VDD VSS AOI21_X1
XI1114_I125_XP I1114_P29_28 I1114_P27_26 I1114_P29_26n VDD VSS NAND2_X1
XI1114_I126_XG I1114_P30_29 I1114_G28_27 I1114_G30_29 I1114_G30_27n VDD VSS AOI21_X1
XI1114_I126_XP I1114_P30_29 I1114_P28_27 I1114_P30_27n VDD VSS NAND2_X1
XI1114_I127_XG I1114_P31_30 I1114_G29_28 I1114_G31_30 I1114_G31_28n VDD VSS AOI21_X1
XI1114_I127_XP I1114_P31_30 I1114_P29_28 I1114_P31_28n VDD VSS NAND2_X1
XI1114_I128_XG I1114_P4_1n I1114_G0_0n I1114_G4_1n I1114_G4_0 VDD VSS OAI21_X1
XI1114_I129 I1114_G1_0 I1114_G1_0n VDD VSS INV_X1
XI1114_I130_XG I1114_P5_2n I1114_G1_0n I1114_G5_2n I1114_G5_0 VDD VSS OAI21_X1
XI1114_I131_XG I1114_P6_3n I1114_G2_0n I1114_G6_3n I1114_G6_0 VDD VSS OAI21_X1
XI1114_I132_XG I1114_P7_4n I1114_G3_0n I1114_G7_4n I1114_G7_0 VDD VSS OAI21_X1
XI1114_I133_XG I1114_P8_5n I1114_G4_1n I1114_G8_5n I1114_G8_1 VDD VSS OAI21_X1
XI1114_I133_XP I1114_P8_5n I1114_P4_1n I1114_P8_1 VDD VSS NOR2_X1
XI1114_I134_XG I1114_P9_6n I1114_G5_2n I1114_G9_6n I1114_G9_2 VDD VSS OAI21_X1
XI1114_I134_XP I1114_P9_6n I1114_P5_2n I1114_P9_2 VDD VSS NOR2_X1
XI1114_I135_XG I1114_P10_7n I1114_G6_3n I1114_G10_7n I1114_G10_3 VDD VSS OAI21_X1
XI1114_I135_XP I1114_P10_7n I1114_P6_3n I1114_P10_3 VDD VSS NOR2_X1
XI1114_I136_XG I1114_P11_8n I1114_G7_4n I1114_G11_8n I1114_G11_4 VDD VSS OAI21_X1
XI1114_I136_XP I1114_P11_8n I1114_P7_4n I1114_P11_4 VDD VSS NOR2_X1
XI1114_I137_XG I1114_P12_9n I1114_G8_5n I1114_G12_9n I1114_G12_5 VDD VSS OAI21_X1
XI1114_I137_XP I1114_P12_9n I1114_P8_5n I1114_P12_5 VDD VSS NOR2_X1
XI1114_I138_XG I1114_P13_10n I1114_G9_6n I1114_G13_10n I1114_G13_6 VDD VSS OAI21_X1
XI1114_I138_XP I1114_P13_10n I1114_P9_6n I1114_P13_6 VDD VSS NOR2_X1
XI1114_I139_XG I1114_P14_11n I1114_G10_7n I1114_G14_11n I1114_G14_7 VDD VSS OAI21_X1
XI1114_I139_XP I1114_P14_11n I1114_P10_7n I1114_P14_7 VDD VSS NOR2_X1
XI1114_I140_XG I1114_P15_12n I1114_G11_8n I1114_G15_12n I1114_G15_8 VDD VSS OAI21_X1
XI1114_I140_XP I1114_P15_12n I1114_P11_8n I1114_P15_8 VDD VSS NOR2_X1
XI1114_I141_XG I1114_P16_13n I1114_G12_9n I1114_G16_13n I1114_G16_9 VDD VSS OAI21_X1
XI1114_I141_XP I1114_P16_13n I1114_P12_9n I1114_P16_9 VDD VSS NOR2_X1
XI1114_I142_XG I1114_P17_14n I1114_G13_10n I1114_G17_14n I1114_G17_10 VDD VSS OAI21_X1
XI1114_I142_XP I1114_P17_14n I1114_P13_10n I1114_P17_10 VDD VSS NOR2_X1
XI1114_I143_XG I1114_P18_15n I1114_G14_11n I1114_G18_15n I1114_G18_11 VDD VSS OAI21_X1
XI1114_I143_XP I1114_P18_15n I1114_P14_11n I1114_P18_11 VDD VSS NOR2_X1
XI1114_I144_XG I1114_P19_16n I1114_G15_12n I1114_G19_16n I1114_G19_12 VDD VSS OAI21_X1
XI1114_I144_XP I1114_P19_16n I1114_P15_12n I1114_P19_12 VDD VSS NOR2_X1
XI1114_I145_XG I1114_P20_17n I1114_G16_13n I1114_G20_17n I1114_G20_13 VDD VSS OAI21_X1
XI1114_I145_XP I1114_P20_17n I1114_P16_13n I1114_P20_13 VDD VSS NOR2_X1
XI1114_I146_XG I1114_P21_18n I1114_G17_14n I1114_G21_18n I1114_G21_14 VDD VSS OAI21_X1
XI1114_I146_XP I1114_P21_18n I1114_P17_14n I1114_P21_14 VDD VSS NOR2_X1
XI1114_I147_XG I1114_P22_19n I1114_G18_15n I1114_G22_19n I1114_G22_15 VDD VSS OAI21_X1
XI1114_I147_XP I1114_P22_19n I1114_P18_15n I1114_P22_15 VDD VSS NOR2_X1
XI1114_I148_XG I1114_P23_20n I1114_G19_16n I1114_G23_20n I1114_G23_16 VDD VSS OAI21_X1
XI1114_I148_XP I1114_P23_20n I1114_P19_16n I1114_P23_16 VDD VSS NOR2_X1
XI1114_I149_XG I1114_P24_21n I1114_G20_17n I1114_G24_21n I1114_G24_17 VDD VSS OAI21_X1
XI1114_I149_XP I1114_P24_21n I1114_P20_17n I1114_P24_17 VDD VSS NOR2_X1
XI1114_I150_XG I1114_P25_22n I1114_G21_18n I1114_G25_22n I1114_G25_18 VDD VSS OAI21_X1
XI1114_I150_XP I1114_P25_22n I1114_P21_18n I1114_P25_18 VDD VSS NOR2_X1
XI1114_I151_XG I1114_P26_23n I1114_G22_19n I1114_G26_23n I1114_G26_19 VDD VSS OAI21_X1
XI1114_I151_XP I1114_P26_23n I1114_P22_19n I1114_P26_19 VDD VSS NOR2_X1
XI1114_I152_XG I1114_P27_24n I1114_G23_20n I1114_G27_24n I1114_G27_20 VDD VSS OAI21_X1
XI1114_I152_XP I1114_P27_24n I1114_P23_20n I1114_P27_20 VDD VSS NOR2_X1
XI1114_I153_XG I1114_P28_25n I1114_G24_21n I1114_G28_25n I1114_G28_21 VDD VSS OAI21_X1
XI1114_I153_XP I1114_P28_25n I1114_P24_21n I1114_P28_21 VDD VSS NOR2_X1
XI1114_I154_XG I1114_P29_26n I1114_G25_22n I1114_G29_26n I1114_G29_22 VDD VSS OAI21_X1
XI1114_I154_XP I1114_P29_26n I1114_P25_22n I1114_P29_22 VDD VSS NOR2_X1
XI1114_I155_XG I1114_P30_27n I1114_G26_23n I1114_G30_27n I1114_G30_23 VDD VSS OAI21_X1
XI1114_I155_XP I1114_P30_27n I1114_P26_23n I1114_P30_23 VDD VSS NOR2_X1
XI1114_I156_XG I1114_P31_28n I1114_G27_24n I1114_G31_28n I1114_G31_24 VDD VSS OAI21_X1
XI1114_I156_XP I1114_P31_28n I1114_P27_24n I1114_P31_24 VDD VSS NOR2_X1
XI1114_I157_XG I1114_P8_1 I1114_G0_0 I1114_G8_1 I1114_G8_0n VDD VSS AOI21_X1
XI1114_I158_XG I1114_P9_2 I1114_G1_0 I1114_G9_2 I1114_G9_0n VDD VSS AOI21_X1
XI1114_I159 I1114_G2_0n I1114_G2_0np VDD VSS INV_X1
XI1114_I160_XG I1114_P10_3 I1114_G2_0np I1114_G10_3 I1114_G10_0n VDD VSS AOI21_X1
XI1114_I161 I1114_G3_0n I1114_G3_0np VDD VSS INV_X1
XI1114_I162_XG I1114_P11_4 I1114_G3_0np I1114_G11_4 I1114_G11_0n VDD VSS AOI21_X1
XI1114_I163_XG I1114_P12_5 I1114_G4_0 I1114_G12_5 I1114_G12_0n VDD VSS AOI21_X1
XI1114_I164_XG I1114_P13_6 I1114_G5_0 I1114_G13_6 I1114_G13_0n VDD VSS AOI21_X1
XI1114_I165_XG I1114_P14_7 I1114_G6_0 I1114_G14_7 I1114_G14_0n VDD VSS AOI21_X1
XI1114_I166_XG I1114_P15_8 I1114_G7_0 I1114_G15_8 I1114_G15_0n VDD VSS AOI21_X1
XI1114_I167_XG I1114_P16_9 I1114_G8_1 I1114_G16_9 I1114_G16_1n VDD VSS AOI21_X1
XI1114_I167_XP I1114_P16_9 I1114_P8_1 I1114_P16_1n VDD VSS NAND2_X1
XI1114_I168_XG I1114_P17_10 I1114_G9_2 I1114_G17_10 I1114_G17_2n VDD VSS AOI21_X1
XI1114_I168_XP I1114_P17_10 I1114_P9_2 I1114_P17_2n VDD VSS NAND2_X1
XI1114_I169_XG I1114_P18_11 I1114_G10_3 I1114_G18_11 I1114_G18_3n VDD VSS AOI21_X1
XI1114_I169_XP I1114_P18_11 I1114_P10_3 I1114_P18_3n VDD VSS NAND2_X1
XI1114_I170_XG I1114_P19_12 I1114_G11_4 I1114_G19_12 I1114_G19_4n VDD VSS AOI21_X1
XI1114_I170_XP I1114_P19_12 I1114_P11_4 I1114_P19_4n VDD VSS NAND2_X1
XI1114_I171_XG I1114_P20_13 I1114_G12_5 I1114_G20_13 I1114_G20_5n VDD VSS AOI21_X1
XI1114_I171_XP I1114_P20_13 I1114_P12_5 I1114_P20_5n VDD VSS NAND2_X1
XI1114_I172_XG I1114_P21_14 I1114_G13_6 I1114_G21_14 I1114_G21_6n VDD VSS AOI21_X1
XI1114_I172_XP I1114_P21_14 I1114_P13_6 I1114_P21_6n VDD VSS NAND2_X1
XI1114_I173_XG I1114_P22_15 I1114_G14_7 I1114_G22_15 I1114_G22_7n VDD VSS AOI21_X1
XI1114_I173_XP I1114_P22_15 I1114_P14_7 I1114_P22_7n VDD VSS NAND2_X1
XI1114_I174_XG I1114_P23_16 I1114_G15_8 I1114_G23_16 I1114_G23_8n VDD VSS AOI21_X1
XI1114_I174_XP I1114_P23_16 I1114_P15_8 I1114_P23_8n VDD VSS NAND2_X1
XI1114_I175_XG I1114_P24_17 I1114_G16_9 I1114_G24_17 I1114_G24_9n VDD VSS AOI21_X1
XI1114_I175_XP I1114_P24_17 I1114_P16_9 I1114_P24_9n VDD VSS NAND2_X1
XI1114_I176_XG I1114_P25_18 I1114_G17_10 I1114_G25_18 I1114_G25_10n VDD VSS AOI21_X1
XI1114_I176_XP I1114_P25_18 I1114_P17_10 I1114_P25_10n VDD VSS NAND2_X1
XI1114_I177_XG I1114_P26_19 I1114_G18_11 I1114_G26_19 I1114_G26_11n VDD VSS AOI21_X1
XI1114_I177_XP I1114_P26_19 I1114_P18_11 I1114_P26_11n VDD VSS NAND2_X1
XI1114_I178_XG I1114_P27_20 I1114_G19_12 I1114_G27_20 I1114_G27_12n VDD VSS AOI21_X1
XI1114_I178_XP I1114_P27_20 I1114_P19_12 I1114_P27_12n VDD VSS NAND2_X1
XI1114_I179_XG I1114_P28_21 I1114_G20_13 I1114_G28_21 I1114_G28_13n VDD VSS AOI21_X1
XI1114_I179_XP I1114_P28_21 I1114_P20_13 I1114_P28_13n VDD VSS NAND2_X1
XI1114_I180_XG I1114_P29_22 I1114_G21_14 I1114_G29_22 I1114_G29_14n VDD VSS AOI21_X1
XI1114_I180_XP I1114_P29_22 I1114_P21_14 I1114_P29_14n VDD VSS NAND2_X1
XI1114_I181_XG I1114_P30_23 I1114_G22_15 I1114_G30_23 I1114_G30_15n VDD VSS AOI21_X1
XI1114_I181_XP I1114_P30_23 I1114_P22_15 I1114_P30_15n VDD VSS NAND2_X1
XI1114_I182_XG I1114_P31_24 I1114_G23_16 I1114_G31_24 I1114_G31_16n VDD VSS AOI21_X1
XI1114_I182_XP I1114_P31_24 I1114_P23_16 I1114_P31_16n VDD VSS NAND2_X1
XI1114_I183_XG I1114_P16_1n I1114_G0_0n I1114_G16_1n I1114_G16_0 VDD VSS OAI21_X1
XI1114_I184_XG I1114_P17_2n I1114_G1_0n I1114_G17_2n I1114_G17_0 VDD VSS OAI21_X1
XI1114_I185_XG I1114_P18_3n I1114_G2_0n I1114_G18_3n I1114_G18_0 VDD VSS OAI21_X1
XI1114_I186_XG I1114_P19_4n I1114_G3_0n I1114_G19_4n I1114_G19_0 VDD VSS OAI21_X1
XI1114_I187 I1114_G4_0 I1114_G4_0n VDD VSS INV_X1
XI1114_I188_XG I1114_P20_5n I1114_G4_0n I1114_G20_5n I1114_G20_0 VDD VSS OAI21_X1
XI1114_I189 I1114_G5_0 I1114_G5_0n VDD VSS INV_X1
XI1114_I190_XG I1114_P21_6n I1114_G5_0n I1114_G21_6n I1114_G21_0 VDD VSS OAI21_X1
XI1114_I191 I1114_G6_0 I1114_G6_0n VDD VSS INV_X1
XI1114_I192_XG I1114_P22_7n I1114_G6_0n I1114_G22_7n I1114_G22_0 VDD VSS OAI21_X1
XI1114_I193 I1114_G7_0 I1114_G7_0n VDD VSS INV_X1
XI1114_I194_XG I1114_P23_8n I1114_G7_0n I1114_G23_8n I1114_G23_0 VDD VSS OAI21_X1
XI1114_I195_XG I1114_P24_9n I1114_G8_0n I1114_G24_9n I1114_G24_0 VDD VSS OAI21_X1
XI1114_I196_XG I1114_P25_10n I1114_G9_0n I1114_G25_10n I1114_G25_0 VDD VSS OAI21_X1
XI1114_I197_XG I1114_P26_11n I1114_G10_0n I1114_G26_11n I1114_G26_0 VDD VSS OAI21_X1
XI1114_I198_XG I1114_P27_12n I1114_G11_0n I1114_G27_12n I1114_G27_0 VDD VSS OAI21_X1
XI1114_I199_XG I1114_P28_13n I1114_G12_0n I1114_G28_13n I1114_G28_0 VDD VSS OAI21_X1
XI1114_I200_XG I1114_P29_14n I1114_G13_0n I1114_G29_14n I1114_G29_0 VDD VSS OAI21_X1
XI1114_I201_XG I1114_P30_15n I1114_G14_0n I1114_G30_15n c12_m VDD VSS OAI21_X1
XI1114_I202_XG I1114_P31_16n I1114_G15_0n I1114_G31_16n c12_o VDD VSS OAI21_X1
XI1114_I203 I1114_pn0 qu20_b3_5 p12_0 VDD VSS XNOR2_X1
XI1114_I204 I1114_pn1 I1114_G0_0 p12_1 VDD VSS XNOR2_X1
XI1114_I205 I1114_pn2 I1114_G1_0 p12_2 VDD VSS XNOR2_X1
XI1114_I206 I1114_pn3 I1114_G2_0n p12_3 VDD VSS XOR2_X1
XI1114_I207 I1114_pn4 I1114_G3_0n p12_4 VDD VSS XOR2_X1
XI1114_I208 I1114_pn5 I1114_G4_0 p12_5 VDD VSS XNOR2_X1
XI1114_I209 I1114_pn6 I1114_G5_0 p12_6 VDD VSS XNOR2_X1
XI1114_I210 I1114_pn7 I1114_G6_0 p12_7 VDD VSS XNOR2_X1
XI1114_I211 I1114_pn8 I1114_G7_0 p12_8 VDD VSS XNOR2_X1
XI1114_I212 I1114_pn9 I1114_G8_0n p12_9 VDD VSS XOR2_X1
XI1114_I213 I1114_pn10 I1114_G9_0n p12_10 VDD VSS XOR2_X1
XI1114_I214 I1114_pn11 I1114_G10_0n p12_11 VDD VSS XOR2_X1
XI1114_I215 I1114_pn12 I1114_G11_0n p12_12 VDD VSS XOR2_X1
XI1114_I216 I1114_pn13 I1114_G12_0n p12_13 VDD VSS XOR2_X1
XI1114_I217 I1114_pn14 I1114_G13_0n p12_14 VDD VSS XOR2_X1
XI1114_I218 I1114_pn15 I1114_G14_0n p12_15 VDD VSS XOR2_X1
XI1114_I219 I1114_pn16 I1114_G15_0n p12_16 VDD VSS XOR2_X1
XI1114_I220 I1114_pn17 I1114_G16_0 p12_17 VDD VSS XNOR2_X1
XI1114_I221 I1114_pn18 I1114_G17_0 p12_18 VDD VSS XNOR2_X1
XI1114_I222 I1114_pn19 I1114_G18_0 p12_19 VDD VSS XNOR2_X1
XI1114_I223 I1114_pn20 I1114_G19_0 p12_20 VDD VSS XNOR2_X1
XI1114_I224 I1114_pn21 I1114_G20_0 p12_21 VDD VSS XNOR2_X1
XI1114_I225 I1114_pn22 I1114_G21_0 p12_22 VDD VSS XNOR2_X1
XI1114_I226 I1114_pn23 I1114_G22_0 p12_23 VDD VSS XNOR2_X1
XI1114_I227 I1114_pn24 I1114_G23_0 p12_24 VDD VSS XNOR2_X1
XI1114_I228 I1114_pn25 I1114_G24_0 p12_25 VDD VSS XNOR2_X1
XI1114_I229 I1114_pn26 I1114_G25_0 p12_26 VDD VSS XNOR2_X1
XI1114_I230 I1114_pn27 I1114_G26_0 p12_27 VDD VSS XNOR2_X1
XI1114_I231 I1114_pn28 I1114_G27_0 p12_28 VDD VSS XNOR2_X1
XI1114_I232 I1114_pn29 I1114_G28_0 p12_29 VDD VSS XNOR2_X1
XI1114_I233 I1114_pn30 I1114_G29_0 p12_30 VDD VSS XNOR2_X1
XI1114_I234 I1114_pn31 c12_m p12_31 VDD VSS XNOR2_X1
XI1115 p11_31 qu20_b3_5 h12 VDD VSS XOR2_X1
XI1116 h12 c12_o p12_32 VDD VSS XOR2_X1
XI1117 p12_32 qu19 VDD VSS INV_X4
XI1118 qu19 qu19_b0 VDD VSS INV_X1
XI1119 qu19_b0 qu19_b1_0 VDD VSS INV_X4
XI1120 qu19_b1_0 qu19_b2_0 VDD VSS INV_X4
XI1121 qu19_b1_0 qu19_b2_1 VDD VSS INV_X4
XI1122 qu19_b2_0 qu19_b3_0 VDD VSS INV_X4
XI1123 qu19_b2_0 qu19_b3_1 VDD VSS INV_X4
XI1124 qu19_b2_0 qu19_b3_2 VDD VSS INV_X4
XI1125 qu19_b2_1 qu19_b3_3 VDD VSS INV_X4
XI1126 qu19_b2_1 qu19_b3_4 VDD VSS INV_X4
XI1127 qu19_b2_1 qu19_b3_5 VDD VSS INV_X4
XI1128 B_0_b3_2 qu19_b3_0 b13_0 VDD VSS XOR2_X1
XI1129 dd1_b3_2 qu19_b3_0 b13_1 VDD VSS XOR2_X1
XI1130 dd2_b3_2 qu19_b3_0 b13_2 VDD VSS XOR2_X1
XI1131 dd3_b3_2 qu19_b3_0 b13_3 VDD VSS XOR2_X1
XI1132 dd4_b3_2 qu19_b3_0 b13_4 VDD VSS XOR2_X1
XI1133 dd5_b3_2 qu19_b3_0 b13_5 VDD VSS XOR2_X1
XI1134 dd6_b3_2 qu19_b3_1 b13_6 VDD VSS XOR2_X1
XI1135 dd7_b3_2 qu19_b3_1 b13_7 VDD VSS XOR2_X1
XI1136 dd8_b3_2 qu19_b3_1 b13_8 VDD VSS XOR2_X1
XI1137 dd9_b3_2 qu19_b3_1 b13_9 VDD VSS XOR2_X1
XI1138 dd10_b3_2 qu19_b3_1 b13_10 VDD VSS XOR2_X1
XI1139 dd11_b3_2 qu19_b3_1 b13_11 VDD VSS XOR2_X1
XI1140 dd12_b3_2 qu19_b3_2 b13_12 VDD VSS XOR2_X1
XI1141 dd13_b3_2 qu19_b3_2 b13_13 VDD VSS XOR2_X1
XI1142 dd14_b3_2 qu19_b3_2 b13_14 VDD VSS XOR2_X1
XI1143 dd15_b3_2 qu19_b3_2 b13_15 VDD VSS XOR2_X1
XI1144 dd16_b3_2 qu19_b3_2 b13_16 VDD VSS XOR2_X1
XI1145 dd17_b3_2 qu19_b3_2 b13_17 VDD VSS XOR2_X1
XI1146 dd18_b3_2 qu19_b3_3 b13_18 VDD VSS XOR2_X1
XI1147 dd19_b3_2 qu19_b3_3 b13_19 VDD VSS XOR2_X1
XI1148 dd20_b3_2 qu19_b3_3 b13_20 VDD VSS XOR2_X1
XI1149 dd21_b3_2 qu19_b3_3 b13_21 VDD VSS XOR2_X1
XI1150 dd22_b3_2 qu19_b3_3 b13_22 VDD VSS XOR2_X1
XI1151 dd23_b3_2 qu19_b3_3 b13_23 VDD VSS XOR2_X1
XI1152 dd24_b3_2 qu19_b3_4 b13_24 VDD VSS XOR2_X1
XI1153 dd25_b3_2 qu19_b3_4 b13_25 VDD VSS XOR2_X1
XI1154 dd26_b3_2 qu19_b3_4 b13_26 VDD VSS XOR2_X1
XI1155 dd27_b3_2 qu19_b3_4 b13_27 VDD VSS XOR2_X1
XI1156 dd28_b3_2 qu19_b3_4 b13_28 VDD VSS XOR2_X1
XI1157 dd29_b3_2 qu19_b3_4 b13_29 VDD VSS XOR2_X1
XI1158 dd30_b3_2 qu19_b3_5 b13_30 VDD VSS XOR2_X1
XI1159 dd31_b3_2 qu19_b3_5 b13_31 VDD VSS XOR2_X1
XI1160_I0 aa18 b13_0 I1160_gn0 VDD VSS NAND2_X1
XI1160_I1 p12_0 b13_1 I1160_gn1 VDD VSS NAND2_X1
XI1160_I2 p12_1 b13_2 I1160_gn2 VDD VSS NAND2_X1
XI1160_I3 p12_2 b13_3 I1160_gn3 VDD VSS NAND2_X1
XI1160_I4 p12_3 b13_4 I1160_gn4 VDD VSS NAND2_X1
XI1160_I5 p12_4 b13_5 I1160_gn5 VDD VSS NAND2_X1
XI1160_I6 p12_5 b13_6 I1160_gn6 VDD VSS NAND2_X1
XI1160_I7 p12_6 b13_7 I1160_gn7 VDD VSS NAND2_X1
XI1160_I8 p12_7 b13_8 I1160_gn8 VDD VSS NAND2_X1
XI1160_I9 p12_8 b13_9 I1160_gn9 VDD VSS NAND2_X1
XI1160_I10 p12_9 b13_10 I1160_gn10 VDD VSS NAND2_X1
XI1160_I11 p12_10 b13_11 I1160_gn11 VDD VSS NAND2_X1
XI1160_I12 p12_11 b13_12 I1160_gn12 VDD VSS NAND2_X1
XI1160_I13 p12_12 b13_13 I1160_gn13 VDD VSS NAND2_X1
XI1160_I14 p12_13 b13_14 I1160_gn14 VDD VSS NAND2_X1
XI1160_I15 p12_14 b13_15 I1160_gn15 VDD VSS NAND2_X1
XI1160_I16 p12_15 b13_16 I1160_gn16 VDD VSS NAND2_X1
XI1160_I17 p12_16 b13_17 I1160_gn17 VDD VSS NAND2_X1
XI1160_I18 p12_17 b13_18 I1160_gn18 VDD VSS NAND2_X1
XI1160_I19 p12_18 b13_19 I1160_gn19 VDD VSS NAND2_X1
XI1160_I20 p12_19 b13_20 I1160_gn20 VDD VSS NAND2_X1
XI1160_I21 p12_20 b13_21 I1160_gn21 VDD VSS NAND2_X1
XI1160_I22 p12_21 b13_22 I1160_gn22 VDD VSS NAND2_X1
XI1160_I23 p12_22 b13_23 I1160_gn23 VDD VSS NAND2_X1
XI1160_I24 p12_23 b13_24 I1160_gn24 VDD VSS NAND2_X1
XI1160_I25 p12_24 b13_25 I1160_gn25 VDD VSS NAND2_X1
XI1160_I26 p12_25 b13_26 I1160_gn26 VDD VSS NAND2_X1
XI1160_I27 p12_26 b13_27 I1160_gn27 VDD VSS NAND2_X1
XI1160_I28 p12_27 b13_28 I1160_gn28 VDD VSS NAND2_X1
XI1160_I29 p12_28 b13_29 I1160_gn29 VDD VSS NAND2_X1
XI1160_I30 p12_29 b13_30 I1160_gn30 VDD VSS NAND2_X1
XI1160_I31 p12_30 b13_31 I1160_gn31 VDD VSS NAND2_X1
XI1160_I32 aa18 b13_0 I1160_pn0 VDD VSS XNOR2_X1
XI1160_I33 p12_0 b13_1 I1160_pn1 VDD VSS XNOR2_X1
XI1160_I34 p12_1 b13_2 I1160_pn2 VDD VSS XNOR2_X1
XI1160_I35 p12_2 b13_3 I1160_pn3 VDD VSS XNOR2_X1
XI1160_I36 p12_3 b13_4 I1160_pn4 VDD VSS XNOR2_X1
XI1160_I37 p12_4 b13_5 I1160_pn5 VDD VSS XNOR2_X1
XI1160_I38 p12_5 b13_6 I1160_pn6 VDD VSS XNOR2_X1
XI1160_I39 p12_6 b13_7 I1160_pn7 VDD VSS XNOR2_X1
XI1160_I40 p12_7 b13_8 I1160_pn8 VDD VSS XNOR2_X1
XI1160_I41 p12_8 b13_9 I1160_pn9 VDD VSS XNOR2_X1
XI1160_I42 p12_9 b13_10 I1160_pn10 VDD VSS XNOR2_X1
XI1160_I43 p12_10 b13_11 I1160_pn11 VDD VSS XNOR2_X1
XI1160_I44 p12_11 b13_12 I1160_pn12 VDD VSS XNOR2_X1
XI1160_I45 p12_12 b13_13 I1160_pn13 VDD VSS XNOR2_X1
XI1160_I46 p12_13 b13_14 I1160_pn14 VDD VSS XNOR2_X1
XI1160_I47 p12_14 b13_15 I1160_pn15 VDD VSS XNOR2_X1
XI1160_I48 p12_15 b13_16 I1160_pn16 VDD VSS XNOR2_X1
XI1160_I49 p12_16 b13_17 I1160_pn17 VDD VSS XNOR2_X1
XI1160_I50 p12_17 b13_18 I1160_pn18 VDD VSS XNOR2_X1
XI1160_I51 p12_18 b13_19 I1160_pn19 VDD VSS XNOR2_X1
XI1160_I52 p12_19 b13_20 I1160_pn20 VDD VSS XNOR2_X1
XI1160_I53 p12_20 b13_21 I1160_pn21 VDD VSS XNOR2_X1
XI1160_I54 p12_21 b13_22 I1160_pn22 VDD VSS XNOR2_X1
XI1160_I55 p12_22 b13_23 I1160_pn23 VDD VSS XNOR2_X1
XI1160_I56 p12_23 b13_24 I1160_pn24 VDD VSS XNOR2_X1
XI1160_I57 p12_24 b13_25 I1160_pn25 VDD VSS XNOR2_X1
XI1160_I58 p12_25 b13_26 I1160_pn26 VDD VSS XNOR2_X1
XI1160_I59 p12_26 b13_27 I1160_pn27 VDD VSS XNOR2_X1
XI1160_I60 p12_27 b13_28 I1160_pn28 VDD VSS XNOR2_X1
XI1160_I61 p12_28 b13_29 I1160_pn29 VDD VSS XNOR2_X1
XI1160_I62 p12_29 b13_30 I1160_pn30 VDD VSS XNOR2_X1
XI1160_I63 p12_30 b13_31 I1160_pn31 VDD VSS XNOR2_X1
XI1160_I64 qu19_b3_5 I1160_cinn VDD VSS INV_X1
XI1160_I65_XG I1160_pn0 I1160_cinn I1160_gn0 I1160_G0_0 VDD VSS OAI21_X1
XI1160_I66 I1160_G0_0 I1160_G0_0n VDD VSS INV_X1
XI1160_I67_XG I1160_pn1 I1160_G0_0n I1160_gn1 I1160_G1_0 VDD VSS OAI21_X1
XI1160_I68_XG I1160_pn2 I1160_gn1 I1160_gn2 I1160_G2_1 VDD VSS OAI21_X1
XI1160_I68_XP I1160_pn2 I1160_pn1 I1160_P2_1 VDD VSS NOR2_X1
XI1160_I69_XG I1160_pn3 I1160_gn2 I1160_gn3 I1160_G3_2 VDD VSS OAI21_X1
XI1160_I69_XP I1160_pn3 I1160_pn2 I1160_P3_2 VDD VSS NOR2_X1
XI1160_I70_XG I1160_pn4 I1160_gn3 I1160_gn4 I1160_G4_3 VDD VSS OAI21_X1
XI1160_I70_XP I1160_pn4 I1160_pn3 I1160_P4_3 VDD VSS NOR2_X1
XI1160_I71_XG I1160_pn5 I1160_gn4 I1160_gn5 I1160_G5_4 VDD VSS OAI21_X1
XI1160_I71_XP I1160_pn5 I1160_pn4 I1160_P5_4 VDD VSS NOR2_X1
XI1160_I72_XG I1160_pn6 I1160_gn5 I1160_gn6 I1160_G6_5 VDD VSS OAI21_X1
XI1160_I72_XP I1160_pn6 I1160_pn5 I1160_P6_5 VDD VSS NOR2_X1
XI1160_I73_XG I1160_pn7 I1160_gn6 I1160_gn7 I1160_G7_6 VDD VSS OAI21_X1
XI1160_I73_XP I1160_pn7 I1160_pn6 I1160_P7_6 VDD VSS NOR2_X1
XI1160_I74_XG I1160_pn8 I1160_gn7 I1160_gn8 I1160_G8_7 VDD VSS OAI21_X1
XI1160_I74_XP I1160_pn8 I1160_pn7 I1160_P8_7 VDD VSS NOR2_X1
XI1160_I75_XG I1160_pn9 I1160_gn8 I1160_gn9 I1160_G9_8 VDD VSS OAI21_X1
XI1160_I75_XP I1160_pn9 I1160_pn8 I1160_P9_8 VDD VSS NOR2_X1
XI1160_I76_XG I1160_pn10 I1160_gn9 I1160_gn10 I1160_G10_9 VDD VSS OAI21_X1
XI1160_I76_XP I1160_pn10 I1160_pn9 I1160_P10_9 VDD VSS NOR2_X1
XI1160_I77_XG I1160_pn11 I1160_gn10 I1160_gn11 I1160_G11_10 VDD VSS OAI21_X1
XI1160_I77_XP I1160_pn11 I1160_pn10 I1160_P11_10 VDD VSS NOR2_X1
XI1160_I78_XG I1160_pn12 I1160_gn11 I1160_gn12 I1160_G12_11 VDD VSS OAI21_X1
XI1160_I78_XP I1160_pn12 I1160_pn11 I1160_P12_11 VDD VSS NOR2_X1
XI1160_I79_XG I1160_pn13 I1160_gn12 I1160_gn13 I1160_G13_12 VDD VSS OAI21_X1
XI1160_I79_XP I1160_pn13 I1160_pn12 I1160_P13_12 VDD VSS NOR2_X1
XI1160_I80_XG I1160_pn14 I1160_gn13 I1160_gn14 I1160_G14_13 VDD VSS OAI21_X1
XI1160_I80_XP I1160_pn14 I1160_pn13 I1160_P14_13 VDD VSS NOR2_X1
XI1160_I81_XG I1160_pn15 I1160_gn14 I1160_gn15 I1160_G15_14 VDD VSS OAI21_X1
XI1160_I81_XP I1160_pn15 I1160_pn14 I1160_P15_14 VDD VSS NOR2_X1
XI1160_I82_XG I1160_pn16 I1160_gn15 I1160_gn16 I1160_G16_15 VDD VSS OAI21_X1
XI1160_I82_XP I1160_pn16 I1160_pn15 I1160_P16_15 VDD VSS NOR2_X1
XI1160_I83_XG I1160_pn17 I1160_gn16 I1160_gn17 I1160_G17_16 VDD VSS OAI21_X1
XI1160_I83_XP I1160_pn17 I1160_pn16 I1160_P17_16 VDD VSS NOR2_X1
XI1160_I84_XG I1160_pn18 I1160_gn17 I1160_gn18 I1160_G18_17 VDD VSS OAI21_X1
XI1160_I84_XP I1160_pn18 I1160_pn17 I1160_P18_17 VDD VSS NOR2_X1
XI1160_I85_XG I1160_pn19 I1160_gn18 I1160_gn19 I1160_G19_18 VDD VSS OAI21_X1
XI1160_I85_XP I1160_pn19 I1160_pn18 I1160_P19_18 VDD VSS NOR2_X1
XI1160_I86_XG I1160_pn20 I1160_gn19 I1160_gn20 I1160_G20_19 VDD VSS OAI21_X1
XI1160_I86_XP I1160_pn20 I1160_pn19 I1160_P20_19 VDD VSS NOR2_X1
XI1160_I87_XG I1160_pn21 I1160_gn20 I1160_gn21 I1160_G21_20 VDD VSS OAI21_X1
XI1160_I87_XP I1160_pn21 I1160_pn20 I1160_P21_20 VDD VSS NOR2_X1
XI1160_I88_XG I1160_pn22 I1160_gn21 I1160_gn22 I1160_G22_21 VDD VSS OAI21_X1
XI1160_I88_XP I1160_pn22 I1160_pn21 I1160_P22_21 VDD VSS NOR2_X1
XI1160_I89_XG I1160_pn23 I1160_gn22 I1160_gn23 I1160_G23_22 VDD VSS OAI21_X1
XI1160_I89_XP I1160_pn23 I1160_pn22 I1160_P23_22 VDD VSS NOR2_X1
XI1160_I90_XG I1160_pn24 I1160_gn23 I1160_gn24 I1160_G24_23 VDD VSS OAI21_X1
XI1160_I90_XP I1160_pn24 I1160_pn23 I1160_P24_23 VDD VSS NOR2_X1
XI1160_I91_XG I1160_pn25 I1160_gn24 I1160_gn25 I1160_G25_24 VDD VSS OAI21_X1
XI1160_I91_XP I1160_pn25 I1160_pn24 I1160_P25_24 VDD VSS NOR2_X1
XI1160_I92_XG I1160_pn26 I1160_gn25 I1160_gn26 I1160_G26_25 VDD VSS OAI21_X1
XI1160_I92_XP I1160_pn26 I1160_pn25 I1160_P26_25 VDD VSS NOR2_X1
XI1160_I93_XG I1160_pn27 I1160_gn26 I1160_gn27 I1160_G27_26 VDD VSS OAI21_X1
XI1160_I93_XP I1160_pn27 I1160_pn26 I1160_P27_26 VDD VSS NOR2_X1
XI1160_I94_XG I1160_pn28 I1160_gn27 I1160_gn28 I1160_G28_27 VDD VSS OAI21_X1
XI1160_I94_XP I1160_pn28 I1160_pn27 I1160_P28_27 VDD VSS NOR2_X1
XI1160_I95_XG I1160_pn29 I1160_gn28 I1160_gn29 I1160_G29_28 VDD VSS OAI21_X1
XI1160_I95_XP I1160_pn29 I1160_pn28 I1160_P29_28 VDD VSS NOR2_X1
XI1160_I96_XG I1160_pn30 I1160_gn29 I1160_gn30 I1160_G30_29 VDD VSS OAI21_X1
XI1160_I96_XP I1160_pn30 I1160_pn29 I1160_P30_29 VDD VSS NOR2_X1
XI1160_I97_XG I1160_pn31 I1160_gn30 I1160_gn31 I1160_G31_30 VDD VSS OAI21_X1
XI1160_I97_XP I1160_pn31 I1160_pn30 I1160_P31_30 VDD VSS NOR2_X1
XI1160_I98_XG I1160_P2_1 I1160_G0_0 I1160_G2_1 I1160_G2_0n VDD VSS AOI21_X1
XI1160_I99_XG I1160_P3_2 I1160_G1_0 I1160_G3_2 I1160_G3_0n VDD VSS AOI21_X1
XI1160_I100_XG I1160_P4_3 I1160_G2_1 I1160_G4_3 I1160_G4_1n VDD VSS AOI21_X1
XI1160_I100_XP I1160_P4_3 I1160_P2_1 I1160_P4_1n VDD VSS NAND2_X1
XI1160_I101_XG I1160_P5_4 I1160_G3_2 I1160_G5_4 I1160_G5_2n VDD VSS AOI21_X1
XI1160_I101_XP I1160_P5_4 I1160_P3_2 I1160_P5_2n VDD VSS NAND2_X1
XI1160_I102_XG I1160_P6_5 I1160_G4_3 I1160_G6_5 I1160_G6_3n VDD VSS AOI21_X1
XI1160_I102_XP I1160_P6_5 I1160_P4_3 I1160_P6_3n VDD VSS NAND2_X1
XI1160_I103_XG I1160_P7_6 I1160_G5_4 I1160_G7_6 I1160_G7_4n VDD VSS AOI21_X1
XI1160_I103_XP I1160_P7_6 I1160_P5_4 I1160_P7_4n VDD VSS NAND2_X1
XI1160_I104_XG I1160_P8_7 I1160_G6_5 I1160_G8_7 I1160_G8_5n VDD VSS AOI21_X1
XI1160_I104_XP I1160_P8_7 I1160_P6_5 I1160_P8_5n VDD VSS NAND2_X1
XI1160_I105_XG I1160_P9_8 I1160_G7_6 I1160_G9_8 I1160_G9_6n VDD VSS AOI21_X1
XI1160_I105_XP I1160_P9_8 I1160_P7_6 I1160_P9_6n VDD VSS NAND2_X1
XI1160_I106_XG I1160_P10_9 I1160_G8_7 I1160_G10_9 I1160_G10_7n VDD VSS AOI21_X1
XI1160_I106_XP I1160_P10_9 I1160_P8_7 I1160_P10_7n VDD VSS NAND2_X1
XI1160_I107_XG I1160_P11_10 I1160_G9_8 I1160_G11_10 I1160_G11_8n VDD VSS AOI21_X1
XI1160_I107_XP I1160_P11_10 I1160_P9_8 I1160_P11_8n VDD VSS NAND2_X1
XI1160_I108_XG I1160_P12_11 I1160_G10_9 I1160_G12_11 I1160_G12_9n VDD VSS AOI21_X1
XI1160_I108_XP I1160_P12_11 I1160_P10_9 I1160_P12_9n VDD VSS NAND2_X1
XI1160_I109_XG I1160_P13_12 I1160_G11_10 I1160_G13_12 I1160_G13_10n VDD VSS AOI21_X1
XI1160_I109_XP I1160_P13_12 I1160_P11_10 I1160_P13_10n VDD VSS NAND2_X1
XI1160_I110_XG I1160_P14_13 I1160_G12_11 I1160_G14_13 I1160_G14_11n VDD VSS AOI21_X1
XI1160_I110_XP I1160_P14_13 I1160_P12_11 I1160_P14_11n VDD VSS NAND2_X1
XI1160_I111_XG I1160_P15_14 I1160_G13_12 I1160_G15_14 I1160_G15_12n VDD VSS AOI21_X1
XI1160_I111_XP I1160_P15_14 I1160_P13_12 I1160_P15_12n VDD VSS NAND2_X1
XI1160_I112_XG I1160_P16_15 I1160_G14_13 I1160_G16_15 I1160_G16_13n VDD VSS AOI21_X1
XI1160_I112_XP I1160_P16_15 I1160_P14_13 I1160_P16_13n VDD VSS NAND2_X1
XI1160_I113_XG I1160_P17_16 I1160_G15_14 I1160_G17_16 I1160_G17_14n VDD VSS AOI21_X1
XI1160_I113_XP I1160_P17_16 I1160_P15_14 I1160_P17_14n VDD VSS NAND2_X1
XI1160_I114_XG I1160_P18_17 I1160_G16_15 I1160_G18_17 I1160_G18_15n VDD VSS AOI21_X1
XI1160_I114_XP I1160_P18_17 I1160_P16_15 I1160_P18_15n VDD VSS NAND2_X1
XI1160_I115_XG I1160_P19_18 I1160_G17_16 I1160_G19_18 I1160_G19_16n VDD VSS AOI21_X1
XI1160_I115_XP I1160_P19_18 I1160_P17_16 I1160_P19_16n VDD VSS NAND2_X1
XI1160_I116_XG I1160_P20_19 I1160_G18_17 I1160_G20_19 I1160_G20_17n VDD VSS AOI21_X1
XI1160_I116_XP I1160_P20_19 I1160_P18_17 I1160_P20_17n VDD VSS NAND2_X1
XI1160_I117_XG I1160_P21_20 I1160_G19_18 I1160_G21_20 I1160_G21_18n VDD VSS AOI21_X1
XI1160_I117_XP I1160_P21_20 I1160_P19_18 I1160_P21_18n VDD VSS NAND2_X1
XI1160_I118_XG I1160_P22_21 I1160_G20_19 I1160_G22_21 I1160_G22_19n VDD VSS AOI21_X1
XI1160_I118_XP I1160_P22_21 I1160_P20_19 I1160_P22_19n VDD VSS NAND2_X1
XI1160_I119_XG I1160_P23_22 I1160_G21_20 I1160_G23_22 I1160_G23_20n VDD VSS AOI21_X1
XI1160_I119_XP I1160_P23_22 I1160_P21_20 I1160_P23_20n VDD VSS NAND2_X1
XI1160_I120_XG I1160_P24_23 I1160_G22_21 I1160_G24_23 I1160_G24_21n VDD VSS AOI21_X1
XI1160_I120_XP I1160_P24_23 I1160_P22_21 I1160_P24_21n VDD VSS NAND2_X1
XI1160_I121_XG I1160_P25_24 I1160_G23_22 I1160_G25_24 I1160_G25_22n VDD VSS AOI21_X1
XI1160_I121_XP I1160_P25_24 I1160_P23_22 I1160_P25_22n VDD VSS NAND2_X1
XI1160_I122_XG I1160_P26_25 I1160_G24_23 I1160_G26_25 I1160_G26_23n VDD VSS AOI21_X1
XI1160_I122_XP I1160_P26_25 I1160_P24_23 I1160_P26_23n VDD VSS NAND2_X1
XI1160_I123_XG I1160_P27_26 I1160_G25_24 I1160_G27_26 I1160_G27_24n VDD VSS AOI21_X1
XI1160_I123_XP I1160_P27_26 I1160_P25_24 I1160_P27_24n VDD VSS NAND2_X1
XI1160_I124_XG I1160_P28_27 I1160_G26_25 I1160_G28_27 I1160_G28_25n VDD VSS AOI21_X1
XI1160_I124_XP I1160_P28_27 I1160_P26_25 I1160_P28_25n VDD VSS NAND2_X1
XI1160_I125_XG I1160_P29_28 I1160_G27_26 I1160_G29_28 I1160_G29_26n VDD VSS AOI21_X1
XI1160_I125_XP I1160_P29_28 I1160_P27_26 I1160_P29_26n VDD VSS NAND2_X1
XI1160_I126_XG I1160_P30_29 I1160_G28_27 I1160_G30_29 I1160_G30_27n VDD VSS AOI21_X1
XI1160_I126_XP I1160_P30_29 I1160_P28_27 I1160_P30_27n VDD VSS NAND2_X1
XI1160_I127_XG I1160_P31_30 I1160_G29_28 I1160_G31_30 I1160_G31_28n VDD VSS AOI21_X1
XI1160_I127_XP I1160_P31_30 I1160_P29_28 I1160_P31_28n VDD VSS NAND2_X1
XI1160_I128_XG I1160_P4_1n I1160_G0_0n I1160_G4_1n I1160_G4_0 VDD VSS OAI21_X1
XI1160_I129 I1160_G1_0 I1160_G1_0n VDD VSS INV_X1
XI1160_I130_XG I1160_P5_2n I1160_G1_0n I1160_G5_2n I1160_G5_0 VDD VSS OAI21_X1
XI1160_I131_XG I1160_P6_3n I1160_G2_0n I1160_G6_3n I1160_G6_0 VDD VSS OAI21_X1
XI1160_I132_XG I1160_P7_4n I1160_G3_0n I1160_G7_4n I1160_G7_0 VDD VSS OAI21_X1
XI1160_I133_XG I1160_P8_5n I1160_G4_1n I1160_G8_5n I1160_G8_1 VDD VSS OAI21_X1
XI1160_I133_XP I1160_P8_5n I1160_P4_1n I1160_P8_1 VDD VSS NOR2_X1
XI1160_I134_XG I1160_P9_6n I1160_G5_2n I1160_G9_6n I1160_G9_2 VDD VSS OAI21_X1
XI1160_I134_XP I1160_P9_6n I1160_P5_2n I1160_P9_2 VDD VSS NOR2_X1
XI1160_I135_XG I1160_P10_7n I1160_G6_3n I1160_G10_7n I1160_G10_3 VDD VSS OAI21_X1
XI1160_I135_XP I1160_P10_7n I1160_P6_3n I1160_P10_3 VDD VSS NOR2_X1
XI1160_I136_XG I1160_P11_8n I1160_G7_4n I1160_G11_8n I1160_G11_4 VDD VSS OAI21_X1
XI1160_I136_XP I1160_P11_8n I1160_P7_4n I1160_P11_4 VDD VSS NOR2_X1
XI1160_I137_XG I1160_P12_9n I1160_G8_5n I1160_G12_9n I1160_G12_5 VDD VSS OAI21_X1
XI1160_I137_XP I1160_P12_9n I1160_P8_5n I1160_P12_5 VDD VSS NOR2_X1
XI1160_I138_XG I1160_P13_10n I1160_G9_6n I1160_G13_10n I1160_G13_6 VDD VSS OAI21_X1
XI1160_I138_XP I1160_P13_10n I1160_P9_6n I1160_P13_6 VDD VSS NOR2_X1
XI1160_I139_XG I1160_P14_11n I1160_G10_7n I1160_G14_11n I1160_G14_7 VDD VSS OAI21_X1
XI1160_I139_XP I1160_P14_11n I1160_P10_7n I1160_P14_7 VDD VSS NOR2_X1
XI1160_I140_XG I1160_P15_12n I1160_G11_8n I1160_G15_12n I1160_G15_8 VDD VSS OAI21_X1
XI1160_I140_XP I1160_P15_12n I1160_P11_8n I1160_P15_8 VDD VSS NOR2_X1
XI1160_I141_XG I1160_P16_13n I1160_G12_9n I1160_G16_13n I1160_G16_9 VDD VSS OAI21_X1
XI1160_I141_XP I1160_P16_13n I1160_P12_9n I1160_P16_9 VDD VSS NOR2_X1
XI1160_I142_XG I1160_P17_14n I1160_G13_10n I1160_G17_14n I1160_G17_10 VDD VSS OAI21_X1
XI1160_I142_XP I1160_P17_14n I1160_P13_10n I1160_P17_10 VDD VSS NOR2_X1
XI1160_I143_XG I1160_P18_15n I1160_G14_11n I1160_G18_15n I1160_G18_11 VDD VSS OAI21_X1
XI1160_I143_XP I1160_P18_15n I1160_P14_11n I1160_P18_11 VDD VSS NOR2_X1
XI1160_I144_XG I1160_P19_16n I1160_G15_12n I1160_G19_16n I1160_G19_12 VDD VSS OAI21_X1
XI1160_I144_XP I1160_P19_16n I1160_P15_12n I1160_P19_12 VDD VSS NOR2_X1
XI1160_I145_XG I1160_P20_17n I1160_G16_13n I1160_G20_17n I1160_G20_13 VDD VSS OAI21_X1
XI1160_I145_XP I1160_P20_17n I1160_P16_13n I1160_P20_13 VDD VSS NOR2_X1
XI1160_I146_XG I1160_P21_18n I1160_G17_14n I1160_G21_18n I1160_G21_14 VDD VSS OAI21_X1
XI1160_I146_XP I1160_P21_18n I1160_P17_14n I1160_P21_14 VDD VSS NOR2_X1
XI1160_I147_XG I1160_P22_19n I1160_G18_15n I1160_G22_19n I1160_G22_15 VDD VSS OAI21_X1
XI1160_I147_XP I1160_P22_19n I1160_P18_15n I1160_P22_15 VDD VSS NOR2_X1
XI1160_I148_XG I1160_P23_20n I1160_G19_16n I1160_G23_20n I1160_G23_16 VDD VSS OAI21_X1
XI1160_I148_XP I1160_P23_20n I1160_P19_16n I1160_P23_16 VDD VSS NOR2_X1
XI1160_I149_XG I1160_P24_21n I1160_G20_17n I1160_G24_21n I1160_G24_17 VDD VSS OAI21_X1
XI1160_I149_XP I1160_P24_21n I1160_P20_17n I1160_P24_17 VDD VSS NOR2_X1
XI1160_I150_XG I1160_P25_22n I1160_G21_18n I1160_G25_22n I1160_G25_18 VDD VSS OAI21_X1
XI1160_I150_XP I1160_P25_22n I1160_P21_18n I1160_P25_18 VDD VSS NOR2_X1
XI1160_I151_XG I1160_P26_23n I1160_G22_19n I1160_G26_23n I1160_G26_19 VDD VSS OAI21_X1
XI1160_I151_XP I1160_P26_23n I1160_P22_19n I1160_P26_19 VDD VSS NOR2_X1
XI1160_I152_XG I1160_P27_24n I1160_G23_20n I1160_G27_24n I1160_G27_20 VDD VSS OAI21_X1
XI1160_I152_XP I1160_P27_24n I1160_P23_20n I1160_P27_20 VDD VSS NOR2_X1
XI1160_I153_XG I1160_P28_25n I1160_G24_21n I1160_G28_25n I1160_G28_21 VDD VSS OAI21_X1
XI1160_I153_XP I1160_P28_25n I1160_P24_21n I1160_P28_21 VDD VSS NOR2_X1
XI1160_I154_XG I1160_P29_26n I1160_G25_22n I1160_G29_26n I1160_G29_22 VDD VSS OAI21_X1
XI1160_I154_XP I1160_P29_26n I1160_P25_22n I1160_P29_22 VDD VSS NOR2_X1
XI1160_I155_XG I1160_P30_27n I1160_G26_23n I1160_G30_27n I1160_G30_23 VDD VSS OAI21_X1
XI1160_I155_XP I1160_P30_27n I1160_P26_23n I1160_P30_23 VDD VSS NOR2_X1
XI1160_I156_XG I1160_P31_28n I1160_G27_24n I1160_G31_28n I1160_G31_24 VDD VSS OAI21_X1
XI1160_I156_XP I1160_P31_28n I1160_P27_24n I1160_P31_24 VDD VSS NOR2_X1
XI1160_I157_XG I1160_P8_1 I1160_G0_0 I1160_G8_1 I1160_G8_0n VDD VSS AOI21_X1
XI1160_I158_XG I1160_P9_2 I1160_G1_0 I1160_G9_2 I1160_G9_0n VDD VSS AOI21_X1
XI1160_I159 I1160_G2_0n I1160_G2_0np VDD VSS INV_X1
XI1160_I160_XG I1160_P10_3 I1160_G2_0np I1160_G10_3 I1160_G10_0n VDD VSS AOI21_X1
XI1160_I161 I1160_G3_0n I1160_G3_0np VDD VSS INV_X1
XI1160_I162_XG I1160_P11_4 I1160_G3_0np I1160_G11_4 I1160_G11_0n VDD VSS AOI21_X1
XI1160_I163_XG I1160_P12_5 I1160_G4_0 I1160_G12_5 I1160_G12_0n VDD VSS AOI21_X1
XI1160_I164_XG I1160_P13_6 I1160_G5_0 I1160_G13_6 I1160_G13_0n VDD VSS AOI21_X1
XI1160_I165_XG I1160_P14_7 I1160_G6_0 I1160_G14_7 I1160_G14_0n VDD VSS AOI21_X1
XI1160_I166_XG I1160_P15_8 I1160_G7_0 I1160_G15_8 I1160_G15_0n VDD VSS AOI21_X1
XI1160_I167_XG I1160_P16_9 I1160_G8_1 I1160_G16_9 I1160_G16_1n VDD VSS AOI21_X1
XI1160_I167_XP I1160_P16_9 I1160_P8_1 I1160_P16_1n VDD VSS NAND2_X1
XI1160_I168_XG I1160_P17_10 I1160_G9_2 I1160_G17_10 I1160_G17_2n VDD VSS AOI21_X1
XI1160_I168_XP I1160_P17_10 I1160_P9_2 I1160_P17_2n VDD VSS NAND2_X1
XI1160_I169_XG I1160_P18_11 I1160_G10_3 I1160_G18_11 I1160_G18_3n VDD VSS AOI21_X1
XI1160_I169_XP I1160_P18_11 I1160_P10_3 I1160_P18_3n VDD VSS NAND2_X1
XI1160_I170_XG I1160_P19_12 I1160_G11_4 I1160_G19_12 I1160_G19_4n VDD VSS AOI21_X1
XI1160_I170_XP I1160_P19_12 I1160_P11_4 I1160_P19_4n VDD VSS NAND2_X1
XI1160_I171_XG I1160_P20_13 I1160_G12_5 I1160_G20_13 I1160_G20_5n VDD VSS AOI21_X1
XI1160_I171_XP I1160_P20_13 I1160_P12_5 I1160_P20_5n VDD VSS NAND2_X1
XI1160_I172_XG I1160_P21_14 I1160_G13_6 I1160_G21_14 I1160_G21_6n VDD VSS AOI21_X1
XI1160_I172_XP I1160_P21_14 I1160_P13_6 I1160_P21_6n VDD VSS NAND2_X1
XI1160_I173_XG I1160_P22_15 I1160_G14_7 I1160_G22_15 I1160_G22_7n VDD VSS AOI21_X1
XI1160_I173_XP I1160_P22_15 I1160_P14_7 I1160_P22_7n VDD VSS NAND2_X1
XI1160_I174_XG I1160_P23_16 I1160_G15_8 I1160_G23_16 I1160_G23_8n VDD VSS AOI21_X1
XI1160_I174_XP I1160_P23_16 I1160_P15_8 I1160_P23_8n VDD VSS NAND2_X1
XI1160_I175_XG I1160_P24_17 I1160_G16_9 I1160_G24_17 I1160_G24_9n VDD VSS AOI21_X1
XI1160_I175_XP I1160_P24_17 I1160_P16_9 I1160_P24_9n VDD VSS NAND2_X1
XI1160_I176_XG I1160_P25_18 I1160_G17_10 I1160_G25_18 I1160_G25_10n VDD VSS AOI21_X1
XI1160_I176_XP I1160_P25_18 I1160_P17_10 I1160_P25_10n VDD VSS NAND2_X1
XI1160_I177_XG I1160_P26_19 I1160_G18_11 I1160_G26_19 I1160_G26_11n VDD VSS AOI21_X1
XI1160_I177_XP I1160_P26_19 I1160_P18_11 I1160_P26_11n VDD VSS NAND2_X1
XI1160_I178_XG I1160_P27_20 I1160_G19_12 I1160_G27_20 I1160_G27_12n VDD VSS AOI21_X1
XI1160_I178_XP I1160_P27_20 I1160_P19_12 I1160_P27_12n VDD VSS NAND2_X1
XI1160_I179_XG I1160_P28_21 I1160_G20_13 I1160_G28_21 I1160_G28_13n VDD VSS AOI21_X1
XI1160_I179_XP I1160_P28_21 I1160_P20_13 I1160_P28_13n VDD VSS NAND2_X1
XI1160_I180_XG I1160_P29_22 I1160_G21_14 I1160_G29_22 I1160_G29_14n VDD VSS AOI21_X1
XI1160_I180_XP I1160_P29_22 I1160_P21_14 I1160_P29_14n VDD VSS NAND2_X1
XI1160_I181_XG I1160_P30_23 I1160_G22_15 I1160_G30_23 I1160_G30_15n VDD VSS AOI21_X1
XI1160_I181_XP I1160_P30_23 I1160_P22_15 I1160_P30_15n VDD VSS NAND2_X1
XI1160_I182_XG I1160_P31_24 I1160_G23_16 I1160_G31_24 I1160_G31_16n VDD VSS AOI21_X1
XI1160_I182_XP I1160_P31_24 I1160_P23_16 I1160_P31_16n VDD VSS NAND2_X1
XI1160_I183_XG I1160_P16_1n I1160_G0_0n I1160_G16_1n I1160_G16_0 VDD VSS OAI21_X1
XI1160_I184_XG I1160_P17_2n I1160_G1_0n I1160_G17_2n I1160_G17_0 VDD VSS OAI21_X1
XI1160_I185_XG I1160_P18_3n I1160_G2_0n I1160_G18_3n I1160_G18_0 VDD VSS OAI21_X1
XI1160_I186_XG I1160_P19_4n I1160_G3_0n I1160_G19_4n I1160_G19_0 VDD VSS OAI21_X1
XI1160_I187 I1160_G4_0 I1160_G4_0n VDD VSS INV_X1
XI1160_I188_XG I1160_P20_5n I1160_G4_0n I1160_G20_5n I1160_G20_0 VDD VSS OAI21_X1
XI1160_I189 I1160_G5_0 I1160_G5_0n VDD VSS INV_X1
XI1160_I190_XG I1160_P21_6n I1160_G5_0n I1160_G21_6n I1160_G21_0 VDD VSS OAI21_X1
XI1160_I191 I1160_G6_0 I1160_G6_0n VDD VSS INV_X1
XI1160_I192_XG I1160_P22_7n I1160_G6_0n I1160_G22_7n I1160_G22_0 VDD VSS OAI21_X1
XI1160_I193 I1160_G7_0 I1160_G7_0n VDD VSS INV_X1
XI1160_I194_XG I1160_P23_8n I1160_G7_0n I1160_G23_8n I1160_G23_0 VDD VSS OAI21_X1
XI1160_I195_XG I1160_P24_9n I1160_G8_0n I1160_G24_9n I1160_G24_0 VDD VSS OAI21_X1
XI1160_I196_XG I1160_P25_10n I1160_G9_0n I1160_G25_10n I1160_G25_0 VDD VSS OAI21_X1
XI1160_I197_XG I1160_P26_11n I1160_G10_0n I1160_G26_11n I1160_G26_0 VDD VSS OAI21_X1
XI1160_I198_XG I1160_P27_12n I1160_G11_0n I1160_G27_12n I1160_G27_0 VDD VSS OAI21_X1
XI1160_I199_XG I1160_P28_13n I1160_G12_0n I1160_G28_13n I1160_G28_0 VDD VSS OAI21_X1
XI1160_I200_XG I1160_P29_14n I1160_G13_0n I1160_G29_14n I1160_G29_0 VDD VSS OAI21_X1
XI1160_I201_XG I1160_P30_15n I1160_G14_0n I1160_G30_15n c13_m VDD VSS OAI21_X1
XI1160_I202_XG I1160_P31_16n I1160_G15_0n I1160_G31_16n c13_o VDD VSS OAI21_X1
XI1160_I203 I1160_pn0 qu19_b3_5 p13_0 VDD VSS XNOR2_X1
XI1160_I204 I1160_pn1 I1160_G0_0 p13_1 VDD VSS XNOR2_X1
XI1160_I205 I1160_pn2 I1160_G1_0 p13_2 VDD VSS XNOR2_X1
XI1160_I206 I1160_pn3 I1160_G2_0n p13_3 VDD VSS XOR2_X1
XI1160_I207 I1160_pn4 I1160_G3_0n p13_4 VDD VSS XOR2_X1
XI1160_I208 I1160_pn5 I1160_G4_0 p13_5 VDD VSS XNOR2_X1
XI1160_I209 I1160_pn6 I1160_G5_0 p13_6 VDD VSS XNOR2_X1
XI1160_I210 I1160_pn7 I1160_G6_0 p13_7 VDD VSS XNOR2_X1
XI1160_I211 I1160_pn8 I1160_G7_0 p13_8 VDD VSS XNOR2_X1
XI1160_I212 I1160_pn9 I1160_G8_0n p13_9 VDD VSS XOR2_X1
XI1160_I213 I1160_pn10 I1160_G9_0n p13_10 VDD VSS XOR2_X1
XI1160_I214 I1160_pn11 I1160_G10_0n p13_11 VDD VSS XOR2_X1
XI1160_I215 I1160_pn12 I1160_G11_0n p13_12 VDD VSS XOR2_X1
XI1160_I216 I1160_pn13 I1160_G12_0n p13_13 VDD VSS XOR2_X1
XI1160_I217 I1160_pn14 I1160_G13_0n p13_14 VDD VSS XOR2_X1
XI1160_I218 I1160_pn15 I1160_G14_0n p13_15 VDD VSS XOR2_X1
XI1160_I219 I1160_pn16 I1160_G15_0n p13_16 VDD VSS XOR2_X1
XI1160_I220 I1160_pn17 I1160_G16_0 p13_17 VDD VSS XNOR2_X1
XI1160_I221 I1160_pn18 I1160_G17_0 p13_18 VDD VSS XNOR2_X1
XI1160_I222 I1160_pn19 I1160_G18_0 p13_19 VDD VSS XNOR2_X1
XI1160_I223 I1160_pn20 I1160_G19_0 p13_20 VDD VSS XNOR2_X1
XI1160_I224 I1160_pn21 I1160_G20_0 p13_21 VDD VSS XNOR2_X1
XI1160_I225 I1160_pn22 I1160_G21_0 p13_22 VDD VSS XNOR2_X1
XI1160_I226 I1160_pn23 I1160_G22_0 p13_23 VDD VSS XNOR2_X1
XI1160_I227 I1160_pn24 I1160_G23_0 p13_24 VDD VSS XNOR2_X1
XI1160_I228 I1160_pn25 I1160_G24_0 p13_25 VDD VSS XNOR2_X1
XI1160_I229 I1160_pn26 I1160_G25_0 p13_26 VDD VSS XNOR2_X1
XI1160_I230 I1160_pn27 I1160_G26_0 p13_27 VDD VSS XNOR2_X1
XI1160_I231 I1160_pn28 I1160_G27_0 p13_28 VDD VSS XNOR2_X1
XI1160_I232 I1160_pn29 I1160_G28_0 p13_29 VDD VSS XNOR2_X1
XI1160_I233 I1160_pn30 I1160_G29_0 p13_30 VDD VSS XNOR2_X1
XI1160_I234 I1160_pn31 c13_m p13_31 VDD VSS XNOR2_X1
XI1161 p12_31 qu19_b3_5 h13 VDD VSS XOR2_X1
XI1162 h13 c13_o p13_32 VDD VSS XOR2_X1
XI1163 p13_32 qu18 VDD VSS INV_X4
XI1164 qu18 qu18_b0 VDD VSS INV_X1
XI1165 qu18_b0 qu18_b1_0 VDD VSS INV_X4
XI1166 qu18_b1_0 qu18_b2_0 VDD VSS INV_X4
XI1167 qu18_b1_0 qu18_b2_1 VDD VSS INV_X4
XI1168 qu18_b2_0 qu18_b3_0 VDD VSS INV_X4
XI1169 qu18_b2_0 qu18_b3_1 VDD VSS INV_X4
XI1170 qu18_b2_0 qu18_b3_2 VDD VSS INV_X4
XI1171 qu18_b2_1 qu18_b3_3 VDD VSS INV_X4
XI1172 qu18_b2_1 qu18_b3_4 VDD VSS INV_X4
XI1173 qu18_b2_1 qu18_b3_5 VDD VSS INV_X4
XI1174 B_0_b3_2 qu18_b3_0 b14_0 VDD VSS XOR2_X1
XI1175 dd1_b3_2 qu18_b3_0 b14_1 VDD VSS XOR2_X1
XI1176 dd2_b3_2 qu18_b3_0 b14_2 VDD VSS XOR2_X1
XI1177 dd3_b3_2 qu18_b3_0 b14_3 VDD VSS XOR2_X1
XI1178 dd4_b3_2 qu18_b3_0 b14_4 VDD VSS XOR2_X1
XI1179 dd5_b3_2 qu18_b3_0 b14_5 VDD VSS XOR2_X1
XI1180 dd6_b3_2 qu18_b3_1 b14_6 VDD VSS XOR2_X1
XI1181 dd7_b3_2 qu18_b3_1 b14_7 VDD VSS XOR2_X1
XI1182 dd8_b3_2 qu18_b3_1 b14_8 VDD VSS XOR2_X1
XI1183 dd9_b3_2 qu18_b3_1 b14_9 VDD VSS XOR2_X1
XI1184 dd10_b3_2 qu18_b3_1 b14_10 VDD VSS XOR2_X1
XI1185 dd11_b3_2 qu18_b3_1 b14_11 VDD VSS XOR2_X1
XI1186 dd12_b3_2 qu18_b3_2 b14_12 VDD VSS XOR2_X1
XI1187 dd13_b3_2 qu18_b3_2 b14_13 VDD VSS XOR2_X1
XI1188 dd14_b3_2 qu18_b3_2 b14_14 VDD VSS XOR2_X1
XI1189 dd15_b3_2 qu18_b3_2 b14_15 VDD VSS XOR2_X1
XI1190 dd16_b3_2 qu18_b3_2 b14_16 VDD VSS XOR2_X1
XI1191 dd17_b3_2 qu18_b3_2 b14_17 VDD VSS XOR2_X1
XI1192 dd18_b3_2 qu18_b3_3 b14_18 VDD VSS XOR2_X1
XI1193 dd19_b3_2 qu18_b3_3 b14_19 VDD VSS XOR2_X1
XI1194 dd20_b3_2 qu18_b3_3 b14_20 VDD VSS XOR2_X1
XI1195 dd21_b3_2 qu18_b3_3 b14_21 VDD VSS XOR2_X1
XI1196 dd22_b3_2 qu18_b3_3 b14_22 VDD VSS XOR2_X1
XI1197 dd23_b3_2 qu18_b3_3 b14_23 VDD VSS XOR2_X1
XI1198 dd24_b3_2 qu18_b3_4 b14_24 VDD VSS XOR2_X1
XI1199 dd25_b3_2 qu18_b3_4 b14_25 VDD VSS XOR2_X1
XI1200 dd26_b3_2 qu18_b3_4 b14_26 VDD VSS XOR2_X1
XI1201 dd27_b3_2 qu18_b3_4 b14_27 VDD VSS XOR2_X1
XI1202 dd28_b3_2 qu18_b3_4 b14_28 VDD VSS XOR2_X1
XI1203 dd29_b3_2 qu18_b3_4 b14_29 VDD VSS XOR2_X1
XI1204 dd30_b3_2 qu18_b3_5 b14_30 VDD VSS XOR2_X1
XI1205 dd31_b3_2 qu18_b3_5 b14_31 VDD VSS XOR2_X1
XI1206_I0 aa17 b14_0 I1206_gn0 VDD VSS NAND2_X1
XI1206_I1 p13_0 b14_1 I1206_gn1 VDD VSS NAND2_X1
XI1206_I2 p13_1 b14_2 I1206_gn2 VDD VSS NAND2_X1
XI1206_I3 p13_2 b14_3 I1206_gn3 VDD VSS NAND2_X1
XI1206_I4 p13_3 b14_4 I1206_gn4 VDD VSS NAND2_X1
XI1206_I5 p13_4 b14_5 I1206_gn5 VDD VSS NAND2_X1
XI1206_I6 p13_5 b14_6 I1206_gn6 VDD VSS NAND2_X1
XI1206_I7 p13_6 b14_7 I1206_gn7 VDD VSS NAND2_X1
XI1206_I8 p13_7 b14_8 I1206_gn8 VDD VSS NAND2_X1
XI1206_I9 p13_8 b14_9 I1206_gn9 VDD VSS NAND2_X1
XI1206_I10 p13_9 b14_10 I1206_gn10 VDD VSS NAND2_X1
XI1206_I11 p13_10 b14_11 I1206_gn11 VDD VSS NAND2_X1
XI1206_I12 p13_11 b14_12 I1206_gn12 VDD VSS NAND2_X1
XI1206_I13 p13_12 b14_13 I1206_gn13 VDD VSS NAND2_X1
XI1206_I14 p13_13 b14_14 I1206_gn14 VDD VSS NAND2_X1
XI1206_I15 p13_14 b14_15 I1206_gn15 VDD VSS NAND2_X1
XI1206_I16 p13_15 b14_16 I1206_gn16 VDD VSS NAND2_X1
XI1206_I17 p13_16 b14_17 I1206_gn17 VDD VSS NAND2_X1
XI1206_I18 p13_17 b14_18 I1206_gn18 VDD VSS NAND2_X1
XI1206_I19 p13_18 b14_19 I1206_gn19 VDD VSS NAND2_X1
XI1206_I20 p13_19 b14_20 I1206_gn20 VDD VSS NAND2_X1
XI1206_I21 p13_20 b14_21 I1206_gn21 VDD VSS NAND2_X1
XI1206_I22 p13_21 b14_22 I1206_gn22 VDD VSS NAND2_X1
XI1206_I23 p13_22 b14_23 I1206_gn23 VDD VSS NAND2_X1
XI1206_I24 p13_23 b14_24 I1206_gn24 VDD VSS NAND2_X1
XI1206_I25 p13_24 b14_25 I1206_gn25 VDD VSS NAND2_X1
XI1206_I26 p13_25 b14_26 I1206_gn26 VDD VSS NAND2_X1
XI1206_I27 p13_26 b14_27 I1206_gn27 VDD VSS NAND2_X1
XI1206_I28 p13_27 b14_28 I1206_gn28 VDD VSS NAND2_X1
XI1206_I29 p13_28 b14_29 I1206_gn29 VDD VSS NAND2_X1
XI1206_I30 p13_29 b14_30 I1206_gn30 VDD VSS NAND2_X1
XI1206_I31 p13_30 b14_31 I1206_gn31 VDD VSS NAND2_X1
XI1206_I32 aa17 b14_0 I1206_pn0 VDD VSS XNOR2_X1
XI1206_I33 p13_0 b14_1 I1206_pn1 VDD VSS XNOR2_X1
XI1206_I34 p13_1 b14_2 I1206_pn2 VDD VSS XNOR2_X1
XI1206_I35 p13_2 b14_3 I1206_pn3 VDD VSS XNOR2_X1
XI1206_I36 p13_3 b14_4 I1206_pn4 VDD VSS XNOR2_X1
XI1206_I37 p13_4 b14_5 I1206_pn5 VDD VSS XNOR2_X1
XI1206_I38 p13_5 b14_6 I1206_pn6 VDD VSS XNOR2_X1
XI1206_I39 p13_6 b14_7 I1206_pn7 VDD VSS XNOR2_X1
XI1206_I40 p13_7 b14_8 I1206_pn8 VDD VSS XNOR2_X1
XI1206_I41 p13_8 b14_9 I1206_pn9 VDD VSS XNOR2_X1
XI1206_I42 p13_9 b14_10 I1206_pn10 VDD VSS XNOR2_X1
XI1206_I43 p13_10 b14_11 I1206_pn11 VDD VSS XNOR2_X1
XI1206_I44 p13_11 b14_12 I1206_pn12 VDD VSS XNOR2_X1
XI1206_I45 p13_12 b14_13 I1206_pn13 VDD VSS XNOR2_X1
XI1206_I46 p13_13 b14_14 I1206_pn14 VDD VSS XNOR2_X1
XI1206_I47 p13_14 b14_15 I1206_pn15 VDD VSS XNOR2_X1
XI1206_I48 p13_15 b14_16 I1206_pn16 VDD VSS XNOR2_X1
XI1206_I49 p13_16 b14_17 I1206_pn17 VDD VSS XNOR2_X1
XI1206_I50 p13_17 b14_18 I1206_pn18 VDD VSS XNOR2_X1
XI1206_I51 p13_18 b14_19 I1206_pn19 VDD VSS XNOR2_X1
XI1206_I52 p13_19 b14_20 I1206_pn20 VDD VSS XNOR2_X1
XI1206_I53 p13_20 b14_21 I1206_pn21 VDD VSS XNOR2_X1
XI1206_I54 p13_21 b14_22 I1206_pn22 VDD VSS XNOR2_X1
XI1206_I55 p13_22 b14_23 I1206_pn23 VDD VSS XNOR2_X1
XI1206_I56 p13_23 b14_24 I1206_pn24 VDD VSS XNOR2_X1
XI1206_I57 p13_24 b14_25 I1206_pn25 VDD VSS XNOR2_X1
XI1206_I58 p13_25 b14_26 I1206_pn26 VDD VSS XNOR2_X1
XI1206_I59 p13_26 b14_27 I1206_pn27 VDD VSS XNOR2_X1
XI1206_I60 p13_27 b14_28 I1206_pn28 VDD VSS XNOR2_X1
XI1206_I61 p13_28 b14_29 I1206_pn29 VDD VSS XNOR2_X1
XI1206_I62 p13_29 b14_30 I1206_pn30 VDD VSS XNOR2_X1
XI1206_I63 p13_30 b14_31 I1206_pn31 VDD VSS XNOR2_X1
XI1206_I64 qu18_b3_5 I1206_cinn VDD VSS INV_X1
XI1206_I65_XG I1206_pn0 I1206_cinn I1206_gn0 I1206_G0_0 VDD VSS OAI21_X1
XI1206_I66 I1206_G0_0 I1206_G0_0n VDD VSS INV_X1
XI1206_I67_XG I1206_pn1 I1206_G0_0n I1206_gn1 I1206_G1_0 VDD VSS OAI21_X1
XI1206_I68_XG I1206_pn2 I1206_gn1 I1206_gn2 I1206_G2_1 VDD VSS OAI21_X1
XI1206_I68_XP I1206_pn2 I1206_pn1 I1206_P2_1 VDD VSS NOR2_X1
XI1206_I69_XG I1206_pn3 I1206_gn2 I1206_gn3 I1206_G3_2 VDD VSS OAI21_X1
XI1206_I69_XP I1206_pn3 I1206_pn2 I1206_P3_2 VDD VSS NOR2_X1
XI1206_I70_XG I1206_pn4 I1206_gn3 I1206_gn4 I1206_G4_3 VDD VSS OAI21_X1
XI1206_I70_XP I1206_pn4 I1206_pn3 I1206_P4_3 VDD VSS NOR2_X1
XI1206_I71_XG I1206_pn5 I1206_gn4 I1206_gn5 I1206_G5_4 VDD VSS OAI21_X1
XI1206_I71_XP I1206_pn5 I1206_pn4 I1206_P5_4 VDD VSS NOR2_X1
XI1206_I72_XG I1206_pn6 I1206_gn5 I1206_gn6 I1206_G6_5 VDD VSS OAI21_X1
XI1206_I72_XP I1206_pn6 I1206_pn5 I1206_P6_5 VDD VSS NOR2_X1
XI1206_I73_XG I1206_pn7 I1206_gn6 I1206_gn7 I1206_G7_6 VDD VSS OAI21_X1
XI1206_I73_XP I1206_pn7 I1206_pn6 I1206_P7_6 VDD VSS NOR2_X1
XI1206_I74_XG I1206_pn8 I1206_gn7 I1206_gn8 I1206_G8_7 VDD VSS OAI21_X1
XI1206_I74_XP I1206_pn8 I1206_pn7 I1206_P8_7 VDD VSS NOR2_X1
XI1206_I75_XG I1206_pn9 I1206_gn8 I1206_gn9 I1206_G9_8 VDD VSS OAI21_X1
XI1206_I75_XP I1206_pn9 I1206_pn8 I1206_P9_8 VDD VSS NOR2_X1
XI1206_I76_XG I1206_pn10 I1206_gn9 I1206_gn10 I1206_G10_9 VDD VSS OAI21_X1
XI1206_I76_XP I1206_pn10 I1206_pn9 I1206_P10_9 VDD VSS NOR2_X1
XI1206_I77_XG I1206_pn11 I1206_gn10 I1206_gn11 I1206_G11_10 VDD VSS OAI21_X1
XI1206_I77_XP I1206_pn11 I1206_pn10 I1206_P11_10 VDD VSS NOR2_X1
XI1206_I78_XG I1206_pn12 I1206_gn11 I1206_gn12 I1206_G12_11 VDD VSS OAI21_X1
XI1206_I78_XP I1206_pn12 I1206_pn11 I1206_P12_11 VDD VSS NOR2_X1
XI1206_I79_XG I1206_pn13 I1206_gn12 I1206_gn13 I1206_G13_12 VDD VSS OAI21_X1
XI1206_I79_XP I1206_pn13 I1206_pn12 I1206_P13_12 VDD VSS NOR2_X1
XI1206_I80_XG I1206_pn14 I1206_gn13 I1206_gn14 I1206_G14_13 VDD VSS OAI21_X1
XI1206_I80_XP I1206_pn14 I1206_pn13 I1206_P14_13 VDD VSS NOR2_X1
XI1206_I81_XG I1206_pn15 I1206_gn14 I1206_gn15 I1206_G15_14 VDD VSS OAI21_X1
XI1206_I81_XP I1206_pn15 I1206_pn14 I1206_P15_14 VDD VSS NOR2_X1
XI1206_I82_XG I1206_pn16 I1206_gn15 I1206_gn16 I1206_G16_15 VDD VSS OAI21_X1
XI1206_I82_XP I1206_pn16 I1206_pn15 I1206_P16_15 VDD VSS NOR2_X1
XI1206_I83_XG I1206_pn17 I1206_gn16 I1206_gn17 I1206_G17_16 VDD VSS OAI21_X1
XI1206_I83_XP I1206_pn17 I1206_pn16 I1206_P17_16 VDD VSS NOR2_X1
XI1206_I84_XG I1206_pn18 I1206_gn17 I1206_gn18 I1206_G18_17 VDD VSS OAI21_X1
XI1206_I84_XP I1206_pn18 I1206_pn17 I1206_P18_17 VDD VSS NOR2_X1
XI1206_I85_XG I1206_pn19 I1206_gn18 I1206_gn19 I1206_G19_18 VDD VSS OAI21_X1
XI1206_I85_XP I1206_pn19 I1206_pn18 I1206_P19_18 VDD VSS NOR2_X1
XI1206_I86_XG I1206_pn20 I1206_gn19 I1206_gn20 I1206_G20_19 VDD VSS OAI21_X1
XI1206_I86_XP I1206_pn20 I1206_pn19 I1206_P20_19 VDD VSS NOR2_X1
XI1206_I87_XG I1206_pn21 I1206_gn20 I1206_gn21 I1206_G21_20 VDD VSS OAI21_X1
XI1206_I87_XP I1206_pn21 I1206_pn20 I1206_P21_20 VDD VSS NOR2_X1
XI1206_I88_XG I1206_pn22 I1206_gn21 I1206_gn22 I1206_G22_21 VDD VSS OAI21_X1
XI1206_I88_XP I1206_pn22 I1206_pn21 I1206_P22_21 VDD VSS NOR2_X1
XI1206_I89_XG I1206_pn23 I1206_gn22 I1206_gn23 I1206_G23_22 VDD VSS OAI21_X1
XI1206_I89_XP I1206_pn23 I1206_pn22 I1206_P23_22 VDD VSS NOR2_X1
XI1206_I90_XG I1206_pn24 I1206_gn23 I1206_gn24 I1206_G24_23 VDD VSS OAI21_X1
XI1206_I90_XP I1206_pn24 I1206_pn23 I1206_P24_23 VDD VSS NOR2_X1
XI1206_I91_XG I1206_pn25 I1206_gn24 I1206_gn25 I1206_G25_24 VDD VSS OAI21_X1
XI1206_I91_XP I1206_pn25 I1206_pn24 I1206_P25_24 VDD VSS NOR2_X1
XI1206_I92_XG I1206_pn26 I1206_gn25 I1206_gn26 I1206_G26_25 VDD VSS OAI21_X1
XI1206_I92_XP I1206_pn26 I1206_pn25 I1206_P26_25 VDD VSS NOR2_X1
XI1206_I93_XG I1206_pn27 I1206_gn26 I1206_gn27 I1206_G27_26 VDD VSS OAI21_X1
XI1206_I93_XP I1206_pn27 I1206_pn26 I1206_P27_26 VDD VSS NOR2_X1
XI1206_I94_XG I1206_pn28 I1206_gn27 I1206_gn28 I1206_G28_27 VDD VSS OAI21_X1
XI1206_I94_XP I1206_pn28 I1206_pn27 I1206_P28_27 VDD VSS NOR2_X1
XI1206_I95_XG I1206_pn29 I1206_gn28 I1206_gn29 I1206_G29_28 VDD VSS OAI21_X1
XI1206_I95_XP I1206_pn29 I1206_pn28 I1206_P29_28 VDD VSS NOR2_X1
XI1206_I96_XG I1206_pn30 I1206_gn29 I1206_gn30 I1206_G30_29 VDD VSS OAI21_X1
XI1206_I96_XP I1206_pn30 I1206_pn29 I1206_P30_29 VDD VSS NOR2_X1
XI1206_I97_XG I1206_pn31 I1206_gn30 I1206_gn31 I1206_G31_30 VDD VSS OAI21_X1
XI1206_I97_XP I1206_pn31 I1206_pn30 I1206_P31_30 VDD VSS NOR2_X1
XI1206_I98_XG I1206_P2_1 I1206_G0_0 I1206_G2_1 I1206_G2_0n VDD VSS AOI21_X1
XI1206_I99_XG I1206_P3_2 I1206_G1_0 I1206_G3_2 I1206_G3_0n VDD VSS AOI21_X1
XI1206_I100_XG I1206_P4_3 I1206_G2_1 I1206_G4_3 I1206_G4_1n VDD VSS AOI21_X1
XI1206_I100_XP I1206_P4_3 I1206_P2_1 I1206_P4_1n VDD VSS NAND2_X1
XI1206_I101_XG I1206_P5_4 I1206_G3_2 I1206_G5_4 I1206_G5_2n VDD VSS AOI21_X1
XI1206_I101_XP I1206_P5_4 I1206_P3_2 I1206_P5_2n VDD VSS NAND2_X1
XI1206_I102_XG I1206_P6_5 I1206_G4_3 I1206_G6_5 I1206_G6_3n VDD VSS AOI21_X1
XI1206_I102_XP I1206_P6_5 I1206_P4_3 I1206_P6_3n VDD VSS NAND2_X1
XI1206_I103_XG I1206_P7_6 I1206_G5_4 I1206_G7_6 I1206_G7_4n VDD VSS AOI21_X1
XI1206_I103_XP I1206_P7_6 I1206_P5_4 I1206_P7_4n VDD VSS NAND2_X1
XI1206_I104_XG I1206_P8_7 I1206_G6_5 I1206_G8_7 I1206_G8_5n VDD VSS AOI21_X1
XI1206_I104_XP I1206_P8_7 I1206_P6_5 I1206_P8_5n VDD VSS NAND2_X1
XI1206_I105_XG I1206_P9_8 I1206_G7_6 I1206_G9_8 I1206_G9_6n VDD VSS AOI21_X1
XI1206_I105_XP I1206_P9_8 I1206_P7_6 I1206_P9_6n VDD VSS NAND2_X1
XI1206_I106_XG I1206_P10_9 I1206_G8_7 I1206_G10_9 I1206_G10_7n VDD VSS AOI21_X1
XI1206_I106_XP I1206_P10_9 I1206_P8_7 I1206_P10_7n VDD VSS NAND2_X1
XI1206_I107_XG I1206_P11_10 I1206_G9_8 I1206_G11_10 I1206_G11_8n VDD VSS AOI21_X1
XI1206_I107_XP I1206_P11_10 I1206_P9_8 I1206_P11_8n VDD VSS NAND2_X1
XI1206_I108_XG I1206_P12_11 I1206_G10_9 I1206_G12_11 I1206_G12_9n VDD VSS AOI21_X1
XI1206_I108_XP I1206_P12_11 I1206_P10_9 I1206_P12_9n VDD VSS NAND2_X1
XI1206_I109_XG I1206_P13_12 I1206_G11_10 I1206_G13_12 I1206_G13_10n VDD VSS AOI21_X1
XI1206_I109_XP I1206_P13_12 I1206_P11_10 I1206_P13_10n VDD VSS NAND2_X1
XI1206_I110_XG I1206_P14_13 I1206_G12_11 I1206_G14_13 I1206_G14_11n VDD VSS AOI21_X1
XI1206_I110_XP I1206_P14_13 I1206_P12_11 I1206_P14_11n VDD VSS NAND2_X1
XI1206_I111_XG I1206_P15_14 I1206_G13_12 I1206_G15_14 I1206_G15_12n VDD VSS AOI21_X1
XI1206_I111_XP I1206_P15_14 I1206_P13_12 I1206_P15_12n VDD VSS NAND2_X1
XI1206_I112_XG I1206_P16_15 I1206_G14_13 I1206_G16_15 I1206_G16_13n VDD VSS AOI21_X1
XI1206_I112_XP I1206_P16_15 I1206_P14_13 I1206_P16_13n VDD VSS NAND2_X1
XI1206_I113_XG I1206_P17_16 I1206_G15_14 I1206_G17_16 I1206_G17_14n VDD VSS AOI21_X1
XI1206_I113_XP I1206_P17_16 I1206_P15_14 I1206_P17_14n VDD VSS NAND2_X1
XI1206_I114_XG I1206_P18_17 I1206_G16_15 I1206_G18_17 I1206_G18_15n VDD VSS AOI21_X1
XI1206_I114_XP I1206_P18_17 I1206_P16_15 I1206_P18_15n VDD VSS NAND2_X1
XI1206_I115_XG I1206_P19_18 I1206_G17_16 I1206_G19_18 I1206_G19_16n VDD VSS AOI21_X1
XI1206_I115_XP I1206_P19_18 I1206_P17_16 I1206_P19_16n VDD VSS NAND2_X1
XI1206_I116_XG I1206_P20_19 I1206_G18_17 I1206_G20_19 I1206_G20_17n VDD VSS AOI21_X1
XI1206_I116_XP I1206_P20_19 I1206_P18_17 I1206_P20_17n VDD VSS NAND2_X1
XI1206_I117_XG I1206_P21_20 I1206_G19_18 I1206_G21_20 I1206_G21_18n VDD VSS AOI21_X1
XI1206_I117_XP I1206_P21_20 I1206_P19_18 I1206_P21_18n VDD VSS NAND2_X1
XI1206_I118_XG I1206_P22_21 I1206_G20_19 I1206_G22_21 I1206_G22_19n VDD VSS AOI21_X1
XI1206_I118_XP I1206_P22_21 I1206_P20_19 I1206_P22_19n VDD VSS NAND2_X1
XI1206_I119_XG I1206_P23_22 I1206_G21_20 I1206_G23_22 I1206_G23_20n VDD VSS AOI21_X1
XI1206_I119_XP I1206_P23_22 I1206_P21_20 I1206_P23_20n VDD VSS NAND2_X1
XI1206_I120_XG I1206_P24_23 I1206_G22_21 I1206_G24_23 I1206_G24_21n VDD VSS AOI21_X1
XI1206_I120_XP I1206_P24_23 I1206_P22_21 I1206_P24_21n VDD VSS NAND2_X1
XI1206_I121_XG I1206_P25_24 I1206_G23_22 I1206_G25_24 I1206_G25_22n VDD VSS AOI21_X1
XI1206_I121_XP I1206_P25_24 I1206_P23_22 I1206_P25_22n VDD VSS NAND2_X1
XI1206_I122_XG I1206_P26_25 I1206_G24_23 I1206_G26_25 I1206_G26_23n VDD VSS AOI21_X1
XI1206_I122_XP I1206_P26_25 I1206_P24_23 I1206_P26_23n VDD VSS NAND2_X1
XI1206_I123_XG I1206_P27_26 I1206_G25_24 I1206_G27_26 I1206_G27_24n VDD VSS AOI21_X1
XI1206_I123_XP I1206_P27_26 I1206_P25_24 I1206_P27_24n VDD VSS NAND2_X1
XI1206_I124_XG I1206_P28_27 I1206_G26_25 I1206_G28_27 I1206_G28_25n VDD VSS AOI21_X1
XI1206_I124_XP I1206_P28_27 I1206_P26_25 I1206_P28_25n VDD VSS NAND2_X1
XI1206_I125_XG I1206_P29_28 I1206_G27_26 I1206_G29_28 I1206_G29_26n VDD VSS AOI21_X1
XI1206_I125_XP I1206_P29_28 I1206_P27_26 I1206_P29_26n VDD VSS NAND2_X1
XI1206_I126_XG I1206_P30_29 I1206_G28_27 I1206_G30_29 I1206_G30_27n VDD VSS AOI21_X1
XI1206_I126_XP I1206_P30_29 I1206_P28_27 I1206_P30_27n VDD VSS NAND2_X1
XI1206_I127_XG I1206_P31_30 I1206_G29_28 I1206_G31_30 I1206_G31_28n VDD VSS AOI21_X1
XI1206_I127_XP I1206_P31_30 I1206_P29_28 I1206_P31_28n VDD VSS NAND2_X1
XI1206_I128_XG I1206_P4_1n I1206_G0_0n I1206_G4_1n I1206_G4_0 VDD VSS OAI21_X1
XI1206_I129 I1206_G1_0 I1206_G1_0n VDD VSS INV_X1
XI1206_I130_XG I1206_P5_2n I1206_G1_0n I1206_G5_2n I1206_G5_0 VDD VSS OAI21_X1
XI1206_I131_XG I1206_P6_3n I1206_G2_0n I1206_G6_3n I1206_G6_0 VDD VSS OAI21_X1
XI1206_I132_XG I1206_P7_4n I1206_G3_0n I1206_G7_4n I1206_G7_0 VDD VSS OAI21_X1
XI1206_I133_XG I1206_P8_5n I1206_G4_1n I1206_G8_5n I1206_G8_1 VDD VSS OAI21_X1
XI1206_I133_XP I1206_P8_5n I1206_P4_1n I1206_P8_1 VDD VSS NOR2_X1
XI1206_I134_XG I1206_P9_6n I1206_G5_2n I1206_G9_6n I1206_G9_2 VDD VSS OAI21_X1
XI1206_I134_XP I1206_P9_6n I1206_P5_2n I1206_P9_2 VDD VSS NOR2_X1
XI1206_I135_XG I1206_P10_7n I1206_G6_3n I1206_G10_7n I1206_G10_3 VDD VSS OAI21_X1
XI1206_I135_XP I1206_P10_7n I1206_P6_3n I1206_P10_3 VDD VSS NOR2_X1
XI1206_I136_XG I1206_P11_8n I1206_G7_4n I1206_G11_8n I1206_G11_4 VDD VSS OAI21_X1
XI1206_I136_XP I1206_P11_8n I1206_P7_4n I1206_P11_4 VDD VSS NOR2_X1
XI1206_I137_XG I1206_P12_9n I1206_G8_5n I1206_G12_9n I1206_G12_5 VDD VSS OAI21_X1
XI1206_I137_XP I1206_P12_9n I1206_P8_5n I1206_P12_5 VDD VSS NOR2_X1
XI1206_I138_XG I1206_P13_10n I1206_G9_6n I1206_G13_10n I1206_G13_6 VDD VSS OAI21_X1
XI1206_I138_XP I1206_P13_10n I1206_P9_6n I1206_P13_6 VDD VSS NOR2_X1
XI1206_I139_XG I1206_P14_11n I1206_G10_7n I1206_G14_11n I1206_G14_7 VDD VSS OAI21_X1
XI1206_I139_XP I1206_P14_11n I1206_P10_7n I1206_P14_7 VDD VSS NOR2_X1
XI1206_I140_XG I1206_P15_12n I1206_G11_8n I1206_G15_12n I1206_G15_8 VDD VSS OAI21_X1
XI1206_I140_XP I1206_P15_12n I1206_P11_8n I1206_P15_8 VDD VSS NOR2_X1
XI1206_I141_XG I1206_P16_13n I1206_G12_9n I1206_G16_13n I1206_G16_9 VDD VSS OAI21_X1
XI1206_I141_XP I1206_P16_13n I1206_P12_9n I1206_P16_9 VDD VSS NOR2_X1
XI1206_I142_XG I1206_P17_14n I1206_G13_10n I1206_G17_14n I1206_G17_10 VDD VSS OAI21_X1
XI1206_I142_XP I1206_P17_14n I1206_P13_10n I1206_P17_10 VDD VSS NOR2_X1
XI1206_I143_XG I1206_P18_15n I1206_G14_11n I1206_G18_15n I1206_G18_11 VDD VSS OAI21_X1
XI1206_I143_XP I1206_P18_15n I1206_P14_11n I1206_P18_11 VDD VSS NOR2_X1
XI1206_I144_XG I1206_P19_16n I1206_G15_12n I1206_G19_16n I1206_G19_12 VDD VSS OAI21_X1
XI1206_I144_XP I1206_P19_16n I1206_P15_12n I1206_P19_12 VDD VSS NOR2_X1
XI1206_I145_XG I1206_P20_17n I1206_G16_13n I1206_G20_17n I1206_G20_13 VDD VSS OAI21_X1
XI1206_I145_XP I1206_P20_17n I1206_P16_13n I1206_P20_13 VDD VSS NOR2_X1
XI1206_I146_XG I1206_P21_18n I1206_G17_14n I1206_G21_18n I1206_G21_14 VDD VSS OAI21_X1
XI1206_I146_XP I1206_P21_18n I1206_P17_14n I1206_P21_14 VDD VSS NOR2_X1
XI1206_I147_XG I1206_P22_19n I1206_G18_15n I1206_G22_19n I1206_G22_15 VDD VSS OAI21_X1
XI1206_I147_XP I1206_P22_19n I1206_P18_15n I1206_P22_15 VDD VSS NOR2_X1
XI1206_I148_XG I1206_P23_20n I1206_G19_16n I1206_G23_20n I1206_G23_16 VDD VSS OAI21_X1
XI1206_I148_XP I1206_P23_20n I1206_P19_16n I1206_P23_16 VDD VSS NOR2_X1
XI1206_I149_XG I1206_P24_21n I1206_G20_17n I1206_G24_21n I1206_G24_17 VDD VSS OAI21_X1
XI1206_I149_XP I1206_P24_21n I1206_P20_17n I1206_P24_17 VDD VSS NOR2_X1
XI1206_I150_XG I1206_P25_22n I1206_G21_18n I1206_G25_22n I1206_G25_18 VDD VSS OAI21_X1
XI1206_I150_XP I1206_P25_22n I1206_P21_18n I1206_P25_18 VDD VSS NOR2_X1
XI1206_I151_XG I1206_P26_23n I1206_G22_19n I1206_G26_23n I1206_G26_19 VDD VSS OAI21_X1
XI1206_I151_XP I1206_P26_23n I1206_P22_19n I1206_P26_19 VDD VSS NOR2_X1
XI1206_I152_XG I1206_P27_24n I1206_G23_20n I1206_G27_24n I1206_G27_20 VDD VSS OAI21_X1
XI1206_I152_XP I1206_P27_24n I1206_P23_20n I1206_P27_20 VDD VSS NOR2_X1
XI1206_I153_XG I1206_P28_25n I1206_G24_21n I1206_G28_25n I1206_G28_21 VDD VSS OAI21_X1
XI1206_I153_XP I1206_P28_25n I1206_P24_21n I1206_P28_21 VDD VSS NOR2_X1
XI1206_I154_XG I1206_P29_26n I1206_G25_22n I1206_G29_26n I1206_G29_22 VDD VSS OAI21_X1
XI1206_I154_XP I1206_P29_26n I1206_P25_22n I1206_P29_22 VDD VSS NOR2_X1
XI1206_I155_XG I1206_P30_27n I1206_G26_23n I1206_G30_27n I1206_G30_23 VDD VSS OAI21_X1
XI1206_I155_XP I1206_P30_27n I1206_P26_23n I1206_P30_23 VDD VSS NOR2_X1
XI1206_I156_XG I1206_P31_28n I1206_G27_24n I1206_G31_28n I1206_G31_24 VDD VSS OAI21_X1
XI1206_I156_XP I1206_P31_28n I1206_P27_24n I1206_P31_24 VDD VSS NOR2_X1
XI1206_I157_XG I1206_P8_1 I1206_G0_0 I1206_G8_1 I1206_G8_0n VDD VSS AOI21_X1
XI1206_I158_XG I1206_P9_2 I1206_G1_0 I1206_G9_2 I1206_G9_0n VDD VSS AOI21_X1
XI1206_I159 I1206_G2_0n I1206_G2_0np VDD VSS INV_X1
XI1206_I160_XG I1206_P10_3 I1206_G2_0np I1206_G10_3 I1206_G10_0n VDD VSS AOI21_X1
XI1206_I161 I1206_G3_0n I1206_G3_0np VDD VSS INV_X1
XI1206_I162_XG I1206_P11_4 I1206_G3_0np I1206_G11_4 I1206_G11_0n VDD VSS AOI21_X1
XI1206_I163_XG I1206_P12_5 I1206_G4_0 I1206_G12_5 I1206_G12_0n VDD VSS AOI21_X1
XI1206_I164_XG I1206_P13_6 I1206_G5_0 I1206_G13_6 I1206_G13_0n VDD VSS AOI21_X1
XI1206_I165_XG I1206_P14_7 I1206_G6_0 I1206_G14_7 I1206_G14_0n VDD VSS AOI21_X1
XI1206_I166_XG I1206_P15_8 I1206_G7_0 I1206_G15_8 I1206_G15_0n VDD VSS AOI21_X1
XI1206_I167_XG I1206_P16_9 I1206_G8_1 I1206_G16_9 I1206_G16_1n VDD VSS AOI21_X1
XI1206_I167_XP I1206_P16_9 I1206_P8_1 I1206_P16_1n VDD VSS NAND2_X1
XI1206_I168_XG I1206_P17_10 I1206_G9_2 I1206_G17_10 I1206_G17_2n VDD VSS AOI21_X1
XI1206_I168_XP I1206_P17_10 I1206_P9_2 I1206_P17_2n VDD VSS NAND2_X1
XI1206_I169_XG I1206_P18_11 I1206_G10_3 I1206_G18_11 I1206_G18_3n VDD VSS AOI21_X1
XI1206_I169_XP I1206_P18_11 I1206_P10_3 I1206_P18_3n VDD VSS NAND2_X1
XI1206_I170_XG I1206_P19_12 I1206_G11_4 I1206_G19_12 I1206_G19_4n VDD VSS AOI21_X1
XI1206_I170_XP I1206_P19_12 I1206_P11_4 I1206_P19_4n VDD VSS NAND2_X1
XI1206_I171_XG I1206_P20_13 I1206_G12_5 I1206_G20_13 I1206_G20_5n VDD VSS AOI21_X1
XI1206_I171_XP I1206_P20_13 I1206_P12_5 I1206_P20_5n VDD VSS NAND2_X1
XI1206_I172_XG I1206_P21_14 I1206_G13_6 I1206_G21_14 I1206_G21_6n VDD VSS AOI21_X1
XI1206_I172_XP I1206_P21_14 I1206_P13_6 I1206_P21_6n VDD VSS NAND2_X1
XI1206_I173_XG I1206_P22_15 I1206_G14_7 I1206_G22_15 I1206_G22_7n VDD VSS AOI21_X1
XI1206_I173_XP I1206_P22_15 I1206_P14_7 I1206_P22_7n VDD VSS NAND2_X1
XI1206_I174_XG I1206_P23_16 I1206_G15_8 I1206_G23_16 I1206_G23_8n VDD VSS AOI21_X1
XI1206_I174_XP I1206_P23_16 I1206_P15_8 I1206_P23_8n VDD VSS NAND2_X1
XI1206_I175_XG I1206_P24_17 I1206_G16_9 I1206_G24_17 I1206_G24_9n VDD VSS AOI21_X1
XI1206_I175_XP I1206_P24_17 I1206_P16_9 I1206_P24_9n VDD VSS NAND2_X1
XI1206_I176_XG I1206_P25_18 I1206_G17_10 I1206_G25_18 I1206_G25_10n VDD VSS AOI21_X1
XI1206_I176_XP I1206_P25_18 I1206_P17_10 I1206_P25_10n VDD VSS NAND2_X1
XI1206_I177_XG I1206_P26_19 I1206_G18_11 I1206_G26_19 I1206_G26_11n VDD VSS AOI21_X1
XI1206_I177_XP I1206_P26_19 I1206_P18_11 I1206_P26_11n VDD VSS NAND2_X1
XI1206_I178_XG I1206_P27_20 I1206_G19_12 I1206_G27_20 I1206_G27_12n VDD VSS AOI21_X1
XI1206_I178_XP I1206_P27_20 I1206_P19_12 I1206_P27_12n VDD VSS NAND2_X1
XI1206_I179_XG I1206_P28_21 I1206_G20_13 I1206_G28_21 I1206_G28_13n VDD VSS AOI21_X1
XI1206_I179_XP I1206_P28_21 I1206_P20_13 I1206_P28_13n VDD VSS NAND2_X1
XI1206_I180_XG I1206_P29_22 I1206_G21_14 I1206_G29_22 I1206_G29_14n VDD VSS AOI21_X1
XI1206_I180_XP I1206_P29_22 I1206_P21_14 I1206_P29_14n VDD VSS NAND2_X1
XI1206_I181_XG I1206_P30_23 I1206_G22_15 I1206_G30_23 I1206_G30_15n VDD VSS AOI21_X1
XI1206_I181_XP I1206_P30_23 I1206_P22_15 I1206_P30_15n VDD VSS NAND2_X1
XI1206_I182_XG I1206_P31_24 I1206_G23_16 I1206_G31_24 I1206_G31_16n VDD VSS AOI21_X1
XI1206_I182_XP I1206_P31_24 I1206_P23_16 I1206_P31_16n VDD VSS NAND2_X1
XI1206_I183_XG I1206_P16_1n I1206_G0_0n I1206_G16_1n I1206_G16_0 VDD VSS OAI21_X1
XI1206_I184_XG I1206_P17_2n I1206_G1_0n I1206_G17_2n I1206_G17_0 VDD VSS OAI21_X1
XI1206_I185_XG I1206_P18_3n I1206_G2_0n I1206_G18_3n I1206_G18_0 VDD VSS OAI21_X1
XI1206_I186_XG I1206_P19_4n I1206_G3_0n I1206_G19_4n I1206_G19_0 VDD VSS OAI21_X1
XI1206_I187 I1206_G4_0 I1206_G4_0n VDD VSS INV_X1
XI1206_I188_XG I1206_P20_5n I1206_G4_0n I1206_G20_5n I1206_G20_0 VDD VSS OAI21_X1
XI1206_I189 I1206_G5_0 I1206_G5_0n VDD VSS INV_X1
XI1206_I190_XG I1206_P21_6n I1206_G5_0n I1206_G21_6n I1206_G21_0 VDD VSS OAI21_X1
XI1206_I191 I1206_G6_0 I1206_G6_0n VDD VSS INV_X1
XI1206_I192_XG I1206_P22_7n I1206_G6_0n I1206_G22_7n I1206_G22_0 VDD VSS OAI21_X1
XI1206_I193 I1206_G7_0 I1206_G7_0n VDD VSS INV_X1
XI1206_I194_XG I1206_P23_8n I1206_G7_0n I1206_G23_8n I1206_G23_0 VDD VSS OAI21_X1
XI1206_I195_XG I1206_P24_9n I1206_G8_0n I1206_G24_9n I1206_G24_0 VDD VSS OAI21_X1
XI1206_I196_XG I1206_P25_10n I1206_G9_0n I1206_G25_10n I1206_G25_0 VDD VSS OAI21_X1
XI1206_I197_XG I1206_P26_11n I1206_G10_0n I1206_G26_11n I1206_G26_0 VDD VSS OAI21_X1
XI1206_I198_XG I1206_P27_12n I1206_G11_0n I1206_G27_12n I1206_G27_0 VDD VSS OAI21_X1
XI1206_I199_XG I1206_P28_13n I1206_G12_0n I1206_G28_13n I1206_G28_0 VDD VSS OAI21_X1
XI1206_I200_XG I1206_P29_14n I1206_G13_0n I1206_G29_14n I1206_G29_0 VDD VSS OAI21_X1
XI1206_I201_XG I1206_P30_15n I1206_G14_0n I1206_G30_15n c14_m VDD VSS OAI21_X1
XI1206_I202_XG I1206_P31_16n I1206_G15_0n I1206_G31_16n c14_o VDD VSS OAI21_X1
XI1206_I203 I1206_pn0 qu18_b3_5 p14_0 VDD VSS XNOR2_X1
XI1206_I204 I1206_pn1 I1206_G0_0 p14_1 VDD VSS XNOR2_X1
XI1206_I205 I1206_pn2 I1206_G1_0 p14_2 VDD VSS XNOR2_X1
XI1206_I206 I1206_pn3 I1206_G2_0n p14_3 VDD VSS XOR2_X1
XI1206_I207 I1206_pn4 I1206_G3_0n p14_4 VDD VSS XOR2_X1
XI1206_I208 I1206_pn5 I1206_G4_0 p14_5 VDD VSS XNOR2_X1
XI1206_I209 I1206_pn6 I1206_G5_0 p14_6 VDD VSS XNOR2_X1
XI1206_I210 I1206_pn7 I1206_G6_0 p14_7 VDD VSS XNOR2_X1
XI1206_I211 I1206_pn8 I1206_G7_0 p14_8 VDD VSS XNOR2_X1
XI1206_I212 I1206_pn9 I1206_G8_0n p14_9 VDD VSS XOR2_X1
XI1206_I213 I1206_pn10 I1206_G9_0n p14_10 VDD VSS XOR2_X1
XI1206_I214 I1206_pn11 I1206_G10_0n p14_11 VDD VSS XOR2_X1
XI1206_I215 I1206_pn12 I1206_G11_0n p14_12 VDD VSS XOR2_X1
XI1206_I216 I1206_pn13 I1206_G12_0n p14_13 VDD VSS XOR2_X1
XI1206_I217 I1206_pn14 I1206_G13_0n p14_14 VDD VSS XOR2_X1
XI1206_I218 I1206_pn15 I1206_G14_0n p14_15 VDD VSS XOR2_X1
XI1206_I219 I1206_pn16 I1206_G15_0n p14_16 VDD VSS XOR2_X1
XI1206_I220 I1206_pn17 I1206_G16_0 p14_17 VDD VSS XNOR2_X1
XI1206_I221 I1206_pn18 I1206_G17_0 p14_18 VDD VSS XNOR2_X1
XI1206_I222 I1206_pn19 I1206_G18_0 p14_19 VDD VSS XNOR2_X1
XI1206_I223 I1206_pn20 I1206_G19_0 p14_20 VDD VSS XNOR2_X1
XI1206_I224 I1206_pn21 I1206_G20_0 p14_21 VDD VSS XNOR2_X1
XI1206_I225 I1206_pn22 I1206_G21_0 p14_22 VDD VSS XNOR2_X1
XI1206_I226 I1206_pn23 I1206_G22_0 p14_23 VDD VSS XNOR2_X1
XI1206_I227 I1206_pn24 I1206_G23_0 p14_24 VDD VSS XNOR2_X1
XI1206_I228 I1206_pn25 I1206_G24_0 p14_25 VDD VSS XNOR2_X1
XI1206_I229 I1206_pn26 I1206_G25_0 p14_26 VDD VSS XNOR2_X1
XI1206_I230 I1206_pn27 I1206_G26_0 p14_27 VDD VSS XNOR2_X1
XI1206_I231 I1206_pn28 I1206_G27_0 p14_28 VDD VSS XNOR2_X1
XI1206_I232 I1206_pn29 I1206_G28_0 p14_29 VDD VSS XNOR2_X1
XI1206_I233 I1206_pn30 I1206_G29_0 p14_30 VDD VSS XNOR2_X1
XI1206_I234 I1206_pn31 c14_m p14_31 VDD VSS XNOR2_X1
XI1207 p13_31 qu18_b3_5 h14 VDD VSS XOR2_X1
XI1208 h14 c14_o p14_32 VDD VSS XOR2_X1
XI1209 p14_32 qu17 VDD VSS INV_X4
XI1210 qu17 qu17_b0 VDD VSS INV_X1
XI1211 qu17_b0 qu17_b1_0 VDD VSS INV_X4
XI1212 qu17_b1_0 qu17_b2_0 VDD VSS INV_X4
XI1213 qu17_b1_0 qu17_b2_1 VDD VSS INV_X4
XI1214 qu17_b2_0 qu17_b3_0 VDD VSS INV_X4
XI1215 qu17_b2_0 qu17_b3_1 VDD VSS INV_X4
XI1216 qu17_b2_0 qu17_b3_2 VDD VSS INV_X4
XI1217 qu17_b2_1 qu17_b3_3 VDD VSS INV_X4
XI1218 qu17_b2_1 qu17_b3_4 VDD VSS INV_X4
XI1219 qu17_b2_1 qu17_b3_5 VDD VSS INV_X4
XI1220 B_0_b3_2 qu17_b3_0 b15_0 VDD VSS XOR2_X1
XI1221 dd1_b3_2 qu17_b3_0 b15_1 VDD VSS XOR2_X1
XI1222 dd2_b3_2 qu17_b3_0 b15_2 VDD VSS XOR2_X1
XI1223 dd3_b3_2 qu17_b3_0 b15_3 VDD VSS XOR2_X1
XI1224 dd4_b3_2 qu17_b3_0 b15_4 VDD VSS XOR2_X1
XI1225 dd5_b3_2 qu17_b3_0 b15_5 VDD VSS XOR2_X1
XI1226 dd6_b3_2 qu17_b3_1 b15_6 VDD VSS XOR2_X1
XI1227 dd7_b3_2 qu17_b3_1 b15_7 VDD VSS XOR2_X1
XI1228 dd8_b3_2 qu17_b3_1 b15_8 VDD VSS XOR2_X1
XI1229 dd9_b3_2 qu17_b3_1 b15_9 VDD VSS XOR2_X1
XI1230 dd10_b3_2 qu17_b3_1 b15_10 VDD VSS XOR2_X1
XI1231 dd11_b3_2 qu17_b3_1 b15_11 VDD VSS XOR2_X1
XI1232 dd12_b3_2 qu17_b3_2 b15_12 VDD VSS XOR2_X1
XI1233 dd13_b3_2 qu17_b3_2 b15_13 VDD VSS XOR2_X1
XI1234 dd14_b3_2 qu17_b3_2 b15_14 VDD VSS XOR2_X1
XI1235 dd15_b3_2 qu17_b3_2 b15_15 VDD VSS XOR2_X1
XI1236 dd16_b3_2 qu17_b3_2 b15_16 VDD VSS XOR2_X1
XI1237 dd17_b3_2 qu17_b3_2 b15_17 VDD VSS XOR2_X1
XI1238 dd18_b3_2 qu17_b3_3 b15_18 VDD VSS XOR2_X1
XI1239 dd19_b3_2 qu17_b3_3 b15_19 VDD VSS XOR2_X1
XI1240 dd20_b3_2 qu17_b3_3 b15_20 VDD VSS XOR2_X1
XI1241 dd21_b3_2 qu17_b3_3 b15_21 VDD VSS XOR2_X1
XI1242 dd22_b3_2 qu17_b3_3 b15_22 VDD VSS XOR2_X1
XI1243 dd23_b3_2 qu17_b3_3 b15_23 VDD VSS XOR2_X1
XI1244 dd24_b3_2 qu17_b3_4 b15_24 VDD VSS XOR2_X1
XI1245 dd25_b3_2 qu17_b3_4 b15_25 VDD VSS XOR2_X1
XI1246 dd26_b3_2 qu17_b3_4 b15_26 VDD VSS XOR2_X1
XI1247 dd27_b3_2 qu17_b3_4 b15_27 VDD VSS XOR2_X1
XI1248 dd28_b3_2 qu17_b3_4 b15_28 VDD VSS XOR2_X1
XI1249 dd29_b3_2 qu17_b3_4 b15_29 VDD VSS XOR2_X1
XI1250 dd30_b3_2 qu17_b3_5 b15_30 VDD VSS XOR2_X1
XI1251 dd31_b3_2 qu17_b3_5 b15_31 VDD VSS XOR2_X1
XI1252_I0 aa16 b15_0 I1252_gn0 VDD VSS NAND2_X1
XI1252_I1 p14_0 b15_1 I1252_gn1 VDD VSS NAND2_X1
XI1252_I2 p14_1 b15_2 I1252_gn2 VDD VSS NAND2_X1
XI1252_I3 p14_2 b15_3 I1252_gn3 VDD VSS NAND2_X1
XI1252_I4 p14_3 b15_4 I1252_gn4 VDD VSS NAND2_X1
XI1252_I5 p14_4 b15_5 I1252_gn5 VDD VSS NAND2_X1
XI1252_I6 p14_5 b15_6 I1252_gn6 VDD VSS NAND2_X1
XI1252_I7 p14_6 b15_7 I1252_gn7 VDD VSS NAND2_X1
XI1252_I8 p14_7 b15_8 I1252_gn8 VDD VSS NAND2_X1
XI1252_I9 p14_8 b15_9 I1252_gn9 VDD VSS NAND2_X1
XI1252_I10 p14_9 b15_10 I1252_gn10 VDD VSS NAND2_X1
XI1252_I11 p14_10 b15_11 I1252_gn11 VDD VSS NAND2_X1
XI1252_I12 p14_11 b15_12 I1252_gn12 VDD VSS NAND2_X1
XI1252_I13 p14_12 b15_13 I1252_gn13 VDD VSS NAND2_X1
XI1252_I14 p14_13 b15_14 I1252_gn14 VDD VSS NAND2_X1
XI1252_I15 p14_14 b15_15 I1252_gn15 VDD VSS NAND2_X1
XI1252_I16 p14_15 b15_16 I1252_gn16 VDD VSS NAND2_X1
XI1252_I17 p14_16 b15_17 I1252_gn17 VDD VSS NAND2_X1
XI1252_I18 p14_17 b15_18 I1252_gn18 VDD VSS NAND2_X1
XI1252_I19 p14_18 b15_19 I1252_gn19 VDD VSS NAND2_X1
XI1252_I20 p14_19 b15_20 I1252_gn20 VDD VSS NAND2_X1
XI1252_I21 p14_20 b15_21 I1252_gn21 VDD VSS NAND2_X1
XI1252_I22 p14_21 b15_22 I1252_gn22 VDD VSS NAND2_X1
XI1252_I23 p14_22 b15_23 I1252_gn23 VDD VSS NAND2_X1
XI1252_I24 p14_23 b15_24 I1252_gn24 VDD VSS NAND2_X1
XI1252_I25 p14_24 b15_25 I1252_gn25 VDD VSS NAND2_X1
XI1252_I26 p14_25 b15_26 I1252_gn26 VDD VSS NAND2_X1
XI1252_I27 p14_26 b15_27 I1252_gn27 VDD VSS NAND2_X1
XI1252_I28 p14_27 b15_28 I1252_gn28 VDD VSS NAND2_X1
XI1252_I29 p14_28 b15_29 I1252_gn29 VDD VSS NAND2_X1
XI1252_I30 p14_29 b15_30 I1252_gn30 VDD VSS NAND2_X1
XI1252_I31 p14_30 b15_31 I1252_gn31 VDD VSS NAND2_X1
XI1252_I32 aa16 b15_0 I1252_pn0 VDD VSS XNOR2_X1
XI1252_I33 p14_0 b15_1 I1252_pn1 VDD VSS XNOR2_X1
XI1252_I34 p14_1 b15_2 I1252_pn2 VDD VSS XNOR2_X1
XI1252_I35 p14_2 b15_3 I1252_pn3 VDD VSS XNOR2_X1
XI1252_I36 p14_3 b15_4 I1252_pn4 VDD VSS XNOR2_X1
XI1252_I37 p14_4 b15_5 I1252_pn5 VDD VSS XNOR2_X1
XI1252_I38 p14_5 b15_6 I1252_pn6 VDD VSS XNOR2_X1
XI1252_I39 p14_6 b15_7 I1252_pn7 VDD VSS XNOR2_X1
XI1252_I40 p14_7 b15_8 I1252_pn8 VDD VSS XNOR2_X1
XI1252_I41 p14_8 b15_9 I1252_pn9 VDD VSS XNOR2_X1
XI1252_I42 p14_9 b15_10 I1252_pn10 VDD VSS XNOR2_X1
XI1252_I43 p14_10 b15_11 I1252_pn11 VDD VSS XNOR2_X1
XI1252_I44 p14_11 b15_12 I1252_pn12 VDD VSS XNOR2_X1
XI1252_I45 p14_12 b15_13 I1252_pn13 VDD VSS XNOR2_X1
XI1252_I46 p14_13 b15_14 I1252_pn14 VDD VSS XNOR2_X1
XI1252_I47 p14_14 b15_15 I1252_pn15 VDD VSS XNOR2_X1
XI1252_I48 p14_15 b15_16 I1252_pn16 VDD VSS XNOR2_X1
XI1252_I49 p14_16 b15_17 I1252_pn17 VDD VSS XNOR2_X1
XI1252_I50 p14_17 b15_18 I1252_pn18 VDD VSS XNOR2_X1
XI1252_I51 p14_18 b15_19 I1252_pn19 VDD VSS XNOR2_X1
XI1252_I52 p14_19 b15_20 I1252_pn20 VDD VSS XNOR2_X1
XI1252_I53 p14_20 b15_21 I1252_pn21 VDD VSS XNOR2_X1
XI1252_I54 p14_21 b15_22 I1252_pn22 VDD VSS XNOR2_X1
XI1252_I55 p14_22 b15_23 I1252_pn23 VDD VSS XNOR2_X1
XI1252_I56 p14_23 b15_24 I1252_pn24 VDD VSS XNOR2_X1
XI1252_I57 p14_24 b15_25 I1252_pn25 VDD VSS XNOR2_X1
XI1252_I58 p14_25 b15_26 I1252_pn26 VDD VSS XNOR2_X1
XI1252_I59 p14_26 b15_27 I1252_pn27 VDD VSS XNOR2_X1
XI1252_I60 p14_27 b15_28 I1252_pn28 VDD VSS XNOR2_X1
XI1252_I61 p14_28 b15_29 I1252_pn29 VDD VSS XNOR2_X1
XI1252_I62 p14_29 b15_30 I1252_pn30 VDD VSS XNOR2_X1
XI1252_I63 p14_30 b15_31 I1252_pn31 VDD VSS XNOR2_X1
XI1252_I64 qu17_b3_5 I1252_cinn VDD VSS INV_X1
XI1252_I65_XG I1252_pn0 I1252_cinn I1252_gn0 I1252_G0_0 VDD VSS OAI21_X1
XI1252_I66 I1252_G0_0 I1252_G0_0n VDD VSS INV_X1
XI1252_I67_XG I1252_pn1 I1252_G0_0n I1252_gn1 I1252_G1_0 VDD VSS OAI21_X1
XI1252_I68_XG I1252_pn2 I1252_gn1 I1252_gn2 I1252_G2_1 VDD VSS OAI21_X1
XI1252_I68_XP I1252_pn2 I1252_pn1 I1252_P2_1 VDD VSS NOR2_X1
XI1252_I69_XG I1252_pn3 I1252_gn2 I1252_gn3 I1252_G3_2 VDD VSS OAI21_X1
XI1252_I69_XP I1252_pn3 I1252_pn2 I1252_P3_2 VDD VSS NOR2_X1
XI1252_I70_XG I1252_pn4 I1252_gn3 I1252_gn4 I1252_G4_3 VDD VSS OAI21_X1
XI1252_I70_XP I1252_pn4 I1252_pn3 I1252_P4_3 VDD VSS NOR2_X1
XI1252_I71_XG I1252_pn5 I1252_gn4 I1252_gn5 I1252_G5_4 VDD VSS OAI21_X1
XI1252_I71_XP I1252_pn5 I1252_pn4 I1252_P5_4 VDD VSS NOR2_X1
XI1252_I72_XG I1252_pn6 I1252_gn5 I1252_gn6 I1252_G6_5 VDD VSS OAI21_X1
XI1252_I72_XP I1252_pn6 I1252_pn5 I1252_P6_5 VDD VSS NOR2_X1
XI1252_I73_XG I1252_pn7 I1252_gn6 I1252_gn7 I1252_G7_6 VDD VSS OAI21_X1
XI1252_I73_XP I1252_pn7 I1252_pn6 I1252_P7_6 VDD VSS NOR2_X1
XI1252_I74_XG I1252_pn8 I1252_gn7 I1252_gn8 I1252_G8_7 VDD VSS OAI21_X1
XI1252_I74_XP I1252_pn8 I1252_pn7 I1252_P8_7 VDD VSS NOR2_X1
XI1252_I75_XG I1252_pn9 I1252_gn8 I1252_gn9 I1252_G9_8 VDD VSS OAI21_X1
XI1252_I75_XP I1252_pn9 I1252_pn8 I1252_P9_8 VDD VSS NOR2_X1
XI1252_I76_XG I1252_pn10 I1252_gn9 I1252_gn10 I1252_G10_9 VDD VSS OAI21_X1
XI1252_I76_XP I1252_pn10 I1252_pn9 I1252_P10_9 VDD VSS NOR2_X1
XI1252_I77_XG I1252_pn11 I1252_gn10 I1252_gn11 I1252_G11_10 VDD VSS OAI21_X1
XI1252_I77_XP I1252_pn11 I1252_pn10 I1252_P11_10 VDD VSS NOR2_X1
XI1252_I78_XG I1252_pn12 I1252_gn11 I1252_gn12 I1252_G12_11 VDD VSS OAI21_X1
XI1252_I78_XP I1252_pn12 I1252_pn11 I1252_P12_11 VDD VSS NOR2_X1
XI1252_I79_XG I1252_pn13 I1252_gn12 I1252_gn13 I1252_G13_12 VDD VSS OAI21_X1
XI1252_I79_XP I1252_pn13 I1252_pn12 I1252_P13_12 VDD VSS NOR2_X1
XI1252_I80_XG I1252_pn14 I1252_gn13 I1252_gn14 I1252_G14_13 VDD VSS OAI21_X1
XI1252_I80_XP I1252_pn14 I1252_pn13 I1252_P14_13 VDD VSS NOR2_X1
XI1252_I81_XG I1252_pn15 I1252_gn14 I1252_gn15 I1252_G15_14 VDD VSS OAI21_X1
XI1252_I81_XP I1252_pn15 I1252_pn14 I1252_P15_14 VDD VSS NOR2_X1
XI1252_I82_XG I1252_pn16 I1252_gn15 I1252_gn16 I1252_G16_15 VDD VSS OAI21_X1
XI1252_I82_XP I1252_pn16 I1252_pn15 I1252_P16_15 VDD VSS NOR2_X1
XI1252_I83_XG I1252_pn17 I1252_gn16 I1252_gn17 I1252_G17_16 VDD VSS OAI21_X1
XI1252_I83_XP I1252_pn17 I1252_pn16 I1252_P17_16 VDD VSS NOR2_X1
XI1252_I84_XG I1252_pn18 I1252_gn17 I1252_gn18 I1252_G18_17 VDD VSS OAI21_X1
XI1252_I84_XP I1252_pn18 I1252_pn17 I1252_P18_17 VDD VSS NOR2_X1
XI1252_I85_XG I1252_pn19 I1252_gn18 I1252_gn19 I1252_G19_18 VDD VSS OAI21_X1
XI1252_I85_XP I1252_pn19 I1252_pn18 I1252_P19_18 VDD VSS NOR2_X1
XI1252_I86_XG I1252_pn20 I1252_gn19 I1252_gn20 I1252_G20_19 VDD VSS OAI21_X1
XI1252_I86_XP I1252_pn20 I1252_pn19 I1252_P20_19 VDD VSS NOR2_X1
XI1252_I87_XG I1252_pn21 I1252_gn20 I1252_gn21 I1252_G21_20 VDD VSS OAI21_X1
XI1252_I87_XP I1252_pn21 I1252_pn20 I1252_P21_20 VDD VSS NOR2_X1
XI1252_I88_XG I1252_pn22 I1252_gn21 I1252_gn22 I1252_G22_21 VDD VSS OAI21_X1
XI1252_I88_XP I1252_pn22 I1252_pn21 I1252_P22_21 VDD VSS NOR2_X1
XI1252_I89_XG I1252_pn23 I1252_gn22 I1252_gn23 I1252_G23_22 VDD VSS OAI21_X1
XI1252_I89_XP I1252_pn23 I1252_pn22 I1252_P23_22 VDD VSS NOR2_X1
XI1252_I90_XG I1252_pn24 I1252_gn23 I1252_gn24 I1252_G24_23 VDD VSS OAI21_X1
XI1252_I90_XP I1252_pn24 I1252_pn23 I1252_P24_23 VDD VSS NOR2_X1
XI1252_I91_XG I1252_pn25 I1252_gn24 I1252_gn25 I1252_G25_24 VDD VSS OAI21_X1
XI1252_I91_XP I1252_pn25 I1252_pn24 I1252_P25_24 VDD VSS NOR2_X1
XI1252_I92_XG I1252_pn26 I1252_gn25 I1252_gn26 I1252_G26_25 VDD VSS OAI21_X1
XI1252_I92_XP I1252_pn26 I1252_pn25 I1252_P26_25 VDD VSS NOR2_X1
XI1252_I93_XG I1252_pn27 I1252_gn26 I1252_gn27 I1252_G27_26 VDD VSS OAI21_X1
XI1252_I93_XP I1252_pn27 I1252_pn26 I1252_P27_26 VDD VSS NOR2_X1
XI1252_I94_XG I1252_pn28 I1252_gn27 I1252_gn28 I1252_G28_27 VDD VSS OAI21_X1
XI1252_I94_XP I1252_pn28 I1252_pn27 I1252_P28_27 VDD VSS NOR2_X1
XI1252_I95_XG I1252_pn29 I1252_gn28 I1252_gn29 I1252_G29_28 VDD VSS OAI21_X1
XI1252_I95_XP I1252_pn29 I1252_pn28 I1252_P29_28 VDD VSS NOR2_X1
XI1252_I96_XG I1252_pn30 I1252_gn29 I1252_gn30 I1252_G30_29 VDD VSS OAI21_X1
XI1252_I96_XP I1252_pn30 I1252_pn29 I1252_P30_29 VDD VSS NOR2_X1
XI1252_I97_XG I1252_pn31 I1252_gn30 I1252_gn31 I1252_G31_30 VDD VSS OAI21_X1
XI1252_I97_XP I1252_pn31 I1252_pn30 I1252_P31_30 VDD VSS NOR2_X1
XI1252_I98_XG I1252_P2_1 I1252_G0_0 I1252_G2_1 I1252_G2_0n VDD VSS AOI21_X1
XI1252_I99_XG I1252_P3_2 I1252_G1_0 I1252_G3_2 I1252_G3_0n VDD VSS AOI21_X1
XI1252_I100_XG I1252_P4_3 I1252_G2_1 I1252_G4_3 I1252_G4_1n VDD VSS AOI21_X1
XI1252_I100_XP I1252_P4_3 I1252_P2_1 I1252_P4_1n VDD VSS NAND2_X1
XI1252_I101_XG I1252_P5_4 I1252_G3_2 I1252_G5_4 I1252_G5_2n VDD VSS AOI21_X1
XI1252_I101_XP I1252_P5_4 I1252_P3_2 I1252_P5_2n VDD VSS NAND2_X1
XI1252_I102_XG I1252_P6_5 I1252_G4_3 I1252_G6_5 I1252_G6_3n VDD VSS AOI21_X1
XI1252_I102_XP I1252_P6_5 I1252_P4_3 I1252_P6_3n VDD VSS NAND2_X1
XI1252_I103_XG I1252_P7_6 I1252_G5_4 I1252_G7_6 I1252_G7_4n VDD VSS AOI21_X1
XI1252_I103_XP I1252_P7_6 I1252_P5_4 I1252_P7_4n VDD VSS NAND2_X1
XI1252_I104_XG I1252_P8_7 I1252_G6_5 I1252_G8_7 I1252_G8_5n VDD VSS AOI21_X1
XI1252_I104_XP I1252_P8_7 I1252_P6_5 I1252_P8_5n VDD VSS NAND2_X1
XI1252_I105_XG I1252_P9_8 I1252_G7_6 I1252_G9_8 I1252_G9_6n VDD VSS AOI21_X1
XI1252_I105_XP I1252_P9_8 I1252_P7_6 I1252_P9_6n VDD VSS NAND2_X1
XI1252_I106_XG I1252_P10_9 I1252_G8_7 I1252_G10_9 I1252_G10_7n VDD VSS AOI21_X1
XI1252_I106_XP I1252_P10_9 I1252_P8_7 I1252_P10_7n VDD VSS NAND2_X1
XI1252_I107_XG I1252_P11_10 I1252_G9_8 I1252_G11_10 I1252_G11_8n VDD VSS AOI21_X1
XI1252_I107_XP I1252_P11_10 I1252_P9_8 I1252_P11_8n VDD VSS NAND2_X1
XI1252_I108_XG I1252_P12_11 I1252_G10_9 I1252_G12_11 I1252_G12_9n VDD VSS AOI21_X1
XI1252_I108_XP I1252_P12_11 I1252_P10_9 I1252_P12_9n VDD VSS NAND2_X1
XI1252_I109_XG I1252_P13_12 I1252_G11_10 I1252_G13_12 I1252_G13_10n VDD VSS AOI21_X1
XI1252_I109_XP I1252_P13_12 I1252_P11_10 I1252_P13_10n VDD VSS NAND2_X1
XI1252_I110_XG I1252_P14_13 I1252_G12_11 I1252_G14_13 I1252_G14_11n VDD VSS AOI21_X1
XI1252_I110_XP I1252_P14_13 I1252_P12_11 I1252_P14_11n VDD VSS NAND2_X1
XI1252_I111_XG I1252_P15_14 I1252_G13_12 I1252_G15_14 I1252_G15_12n VDD VSS AOI21_X1
XI1252_I111_XP I1252_P15_14 I1252_P13_12 I1252_P15_12n VDD VSS NAND2_X1
XI1252_I112_XG I1252_P16_15 I1252_G14_13 I1252_G16_15 I1252_G16_13n VDD VSS AOI21_X1
XI1252_I112_XP I1252_P16_15 I1252_P14_13 I1252_P16_13n VDD VSS NAND2_X1
XI1252_I113_XG I1252_P17_16 I1252_G15_14 I1252_G17_16 I1252_G17_14n VDD VSS AOI21_X1
XI1252_I113_XP I1252_P17_16 I1252_P15_14 I1252_P17_14n VDD VSS NAND2_X1
XI1252_I114_XG I1252_P18_17 I1252_G16_15 I1252_G18_17 I1252_G18_15n VDD VSS AOI21_X1
XI1252_I114_XP I1252_P18_17 I1252_P16_15 I1252_P18_15n VDD VSS NAND2_X1
XI1252_I115_XG I1252_P19_18 I1252_G17_16 I1252_G19_18 I1252_G19_16n VDD VSS AOI21_X1
XI1252_I115_XP I1252_P19_18 I1252_P17_16 I1252_P19_16n VDD VSS NAND2_X1
XI1252_I116_XG I1252_P20_19 I1252_G18_17 I1252_G20_19 I1252_G20_17n VDD VSS AOI21_X1
XI1252_I116_XP I1252_P20_19 I1252_P18_17 I1252_P20_17n VDD VSS NAND2_X1
XI1252_I117_XG I1252_P21_20 I1252_G19_18 I1252_G21_20 I1252_G21_18n VDD VSS AOI21_X1
XI1252_I117_XP I1252_P21_20 I1252_P19_18 I1252_P21_18n VDD VSS NAND2_X1
XI1252_I118_XG I1252_P22_21 I1252_G20_19 I1252_G22_21 I1252_G22_19n VDD VSS AOI21_X1
XI1252_I118_XP I1252_P22_21 I1252_P20_19 I1252_P22_19n VDD VSS NAND2_X1
XI1252_I119_XG I1252_P23_22 I1252_G21_20 I1252_G23_22 I1252_G23_20n VDD VSS AOI21_X1
XI1252_I119_XP I1252_P23_22 I1252_P21_20 I1252_P23_20n VDD VSS NAND2_X1
XI1252_I120_XG I1252_P24_23 I1252_G22_21 I1252_G24_23 I1252_G24_21n VDD VSS AOI21_X1
XI1252_I120_XP I1252_P24_23 I1252_P22_21 I1252_P24_21n VDD VSS NAND2_X1
XI1252_I121_XG I1252_P25_24 I1252_G23_22 I1252_G25_24 I1252_G25_22n VDD VSS AOI21_X1
XI1252_I121_XP I1252_P25_24 I1252_P23_22 I1252_P25_22n VDD VSS NAND2_X1
XI1252_I122_XG I1252_P26_25 I1252_G24_23 I1252_G26_25 I1252_G26_23n VDD VSS AOI21_X1
XI1252_I122_XP I1252_P26_25 I1252_P24_23 I1252_P26_23n VDD VSS NAND2_X1
XI1252_I123_XG I1252_P27_26 I1252_G25_24 I1252_G27_26 I1252_G27_24n VDD VSS AOI21_X1
XI1252_I123_XP I1252_P27_26 I1252_P25_24 I1252_P27_24n VDD VSS NAND2_X1
XI1252_I124_XG I1252_P28_27 I1252_G26_25 I1252_G28_27 I1252_G28_25n VDD VSS AOI21_X1
XI1252_I124_XP I1252_P28_27 I1252_P26_25 I1252_P28_25n VDD VSS NAND2_X1
XI1252_I125_XG I1252_P29_28 I1252_G27_26 I1252_G29_28 I1252_G29_26n VDD VSS AOI21_X1
XI1252_I125_XP I1252_P29_28 I1252_P27_26 I1252_P29_26n VDD VSS NAND2_X1
XI1252_I126_XG I1252_P30_29 I1252_G28_27 I1252_G30_29 I1252_G30_27n VDD VSS AOI21_X1
XI1252_I126_XP I1252_P30_29 I1252_P28_27 I1252_P30_27n VDD VSS NAND2_X1
XI1252_I127_XG I1252_P31_30 I1252_G29_28 I1252_G31_30 I1252_G31_28n VDD VSS AOI21_X1
XI1252_I127_XP I1252_P31_30 I1252_P29_28 I1252_P31_28n VDD VSS NAND2_X1
XI1252_I128_XG I1252_P4_1n I1252_G0_0n I1252_G4_1n I1252_G4_0 VDD VSS OAI21_X1
XI1252_I129 I1252_G1_0 I1252_G1_0n VDD VSS INV_X1
XI1252_I130_XG I1252_P5_2n I1252_G1_0n I1252_G5_2n I1252_G5_0 VDD VSS OAI21_X1
XI1252_I131_XG I1252_P6_3n I1252_G2_0n I1252_G6_3n I1252_G6_0 VDD VSS OAI21_X1
XI1252_I132_XG I1252_P7_4n I1252_G3_0n I1252_G7_4n I1252_G7_0 VDD VSS OAI21_X1
XI1252_I133_XG I1252_P8_5n I1252_G4_1n I1252_G8_5n I1252_G8_1 VDD VSS OAI21_X1
XI1252_I133_XP I1252_P8_5n I1252_P4_1n I1252_P8_1 VDD VSS NOR2_X1
XI1252_I134_XG I1252_P9_6n I1252_G5_2n I1252_G9_6n I1252_G9_2 VDD VSS OAI21_X1
XI1252_I134_XP I1252_P9_6n I1252_P5_2n I1252_P9_2 VDD VSS NOR2_X1
XI1252_I135_XG I1252_P10_7n I1252_G6_3n I1252_G10_7n I1252_G10_3 VDD VSS OAI21_X1
XI1252_I135_XP I1252_P10_7n I1252_P6_3n I1252_P10_3 VDD VSS NOR2_X1
XI1252_I136_XG I1252_P11_8n I1252_G7_4n I1252_G11_8n I1252_G11_4 VDD VSS OAI21_X1
XI1252_I136_XP I1252_P11_8n I1252_P7_4n I1252_P11_4 VDD VSS NOR2_X1
XI1252_I137_XG I1252_P12_9n I1252_G8_5n I1252_G12_9n I1252_G12_5 VDD VSS OAI21_X1
XI1252_I137_XP I1252_P12_9n I1252_P8_5n I1252_P12_5 VDD VSS NOR2_X1
XI1252_I138_XG I1252_P13_10n I1252_G9_6n I1252_G13_10n I1252_G13_6 VDD VSS OAI21_X1
XI1252_I138_XP I1252_P13_10n I1252_P9_6n I1252_P13_6 VDD VSS NOR2_X1
XI1252_I139_XG I1252_P14_11n I1252_G10_7n I1252_G14_11n I1252_G14_7 VDD VSS OAI21_X1
XI1252_I139_XP I1252_P14_11n I1252_P10_7n I1252_P14_7 VDD VSS NOR2_X1
XI1252_I140_XG I1252_P15_12n I1252_G11_8n I1252_G15_12n I1252_G15_8 VDD VSS OAI21_X1
XI1252_I140_XP I1252_P15_12n I1252_P11_8n I1252_P15_8 VDD VSS NOR2_X1
XI1252_I141_XG I1252_P16_13n I1252_G12_9n I1252_G16_13n I1252_G16_9 VDD VSS OAI21_X1
XI1252_I141_XP I1252_P16_13n I1252_P12_9n I1252_P16_9 VDD VSS NOR2_X1
XI1252_I142_XG I1252_P17_14n I1252_G13_10n I1252_G17_14n I1252_G17_10 VDD VSS OAI21_X1
XI1252_I142_XP I1252_P17_14n I1252_P13_10n I1252_P17_10 VDD VSS NOR2_X1
XI1252_I143_XG I1252_P18_15n I1252_G14_11n I1252_G18_15n I1252_G18_11 VDD VSS OAI21_X1
XI1252_I143_XP I1252_P18_15n I1252_P14_11n I1252_P18_11 VDD VSS NOR2_X1
XI1252_I144_XG I1252_P19_16n I1252_G15_12n I1252_G19_16n I1252_G19_12 VDD VSS OAI21_X1
XI1252_I144_XP I1252_P19_16n I1252_P15_12n I1252_P19_12 VDD VSS NOR2_X1
XI1252_I145_XG I1252_P20_17n I1252_G16_13n I1252_G20_17n I1252_G20_13 VDD VSS OAI21_X1
XI1252_I145_XP I1252_P20_17n I1252_P16_13n I1252_P20_13 VDD VSS NOR2_X1
XI1252_I146_XG I1252_P21_18n I1252_G17_14n I1252_G21_18n I1252_G21_14 VDD VSS OAI21_X1
XI1252_I146_XP I1252_P21_18n I1252_P17_14n I1252_P21_14 VDD VSS NOR2_X1
XI1252_I147_XG I1252_P22_19n I1252_G18_15n I1252_G22_19n I1252_G22_15 VDD VSS OAI21_X1
XI1252_I147_XP I1252_P22_19n I1252_P18_15n I1252_P22_15 VDD VSS NOR2_X1
XI1252_I148_XG I1252_P23_20n I1252_G19_16n I1252_G23_20n I1252_G23_16 VDD VSS OAI21_X1
XI1252_I148_XP I1252_P23_20n I1252_P19_16n I1252_P23_16 VDD VSS NOR2_X1
XI1252_I149_XG I1252_P24_21n I1252_G20_17n I1252_G24_21n I1252_G24_17 VDD VSS OAI21_X1
XI1252_I149_XP I1252_P24_21n I1252_P20_17n I1252_P24_17 VDD VSS NOR2_X1
XI1252_I150_XG I1252_P25_22n I1252_G21_18n I1252_G25_22n I1252_G25_18 VDD VSS OAI21_X1
XI1252_I150_XP I1252_P25_22n I1252_P21_18n I1252_P25_18 VDD VSS NOR2_X1
XI1252_I151_XG I1252_P26_23n I1252_G22_19n I1252_G26_23n I1252_G26_19 VDD VSS OAI21_X1
XI1252_I151_XP I1252_P26_23n I1252_P22_19n I1252_P26_19 VDD VSS NOR2_X1
XI1252_I152_XG I1252_P27_24n I1252_G23_20n I1252_G27_24n I1252_G27_20 VDD VSS OAI21_X1
XI1252_I152_XP I1252_P27_24n I1252_P23_20n I1252_P27_20 VDD VSS NOR2_X1
XI1252_I153_XG I1252_P28_25n I1252_G24_21n I1252_G28_25n I1252_G28_21 VDD VSS OAI21_X1
XI1252_I153_XP I1252_P28_25n I1252_P24_21n I1252_P28_21 VDD VSS NOR2_X1
XI1252_I154_XG I1252_P29_26n I1252_G25_22n I1252_G29_26n I1252_G29_22 VDD VSS OAI21_X1
XI1252_I154_XP I1252_P29_26n I1252_P25_22n I1252_P29_22 VDD VSS NOR2_X1
XI1252_I155_XG I1252_P30_27n I1252_G26_23n I1252_G30_27n I1252_G30_23 VDD VSS OAI21_X1
XI1252_I155_XP I1252_P30_27n I1252_P26_23n I1252_P30_23 VDD VSS NOR2_X1
XI1252_I156_XG I1252_P31_28n I1252_G27_24n I1252_G31_28n I1252_G31_24 VDD VSS OAI21_X1
XI1252_I156_XP I1252_P31_28n I1252_P27_24n I1252_P31_24 VDD VSS NOR2_X1
XI1252_I157_XG I1252_P8_1 I1252_G0_0 I1252_G8_1 I1252_G8_0n VDD VSS AOI21_X1
XI1252_I158_XG I1252_P9_2 I1252_G1_0 I1252_G9_2 I1252_G9_0n VDD VSS AOI21_X1
XI1252_I159 I1252_G2_0n I1252_G2_0np VDD VSS INV_X1
XI1252_I160_XG I1252_P10_3 I1252_G2_0np I1252_G10_3 I1252_G10_0n VDD VSS AOI21_X1
XI1252_I161 I1252_G3_0n I1252_G3_0np VDD VSS INV_X1
XI1252_I162_XG I1252_P11_4 I1252_G3_0np I1252_G11_4 I1252_G11_0n VDD VSS AOI21_X1
XI1252_I163_XG I1252_P12_5 I1252_G4_0 I1252_G12_5 I1252_G12_0n VDD VSS AOI21_X1
XI1252_I164_XG I1252_P13_6 I1252_G5_0 I1252_G13_6 I1252_G13_0n VDD VSS AOI21_X1
XI1252_I165_XG I1252_P14_7 I1252_G6_0 I1252_G14_7 I1252_G14_0n VDD VSS AOI21_X1
XI1252_I166_XG I1252_P15_8 I1252_G7_0 I1252_G15_8 I1252_G15_0n VDD VSS AOI21_X1
XI1252_I167_XG I1252_P16_9 I1252_G8_1 I1252_G16_9 I1252_G16_1n VDD VSS AOI21_X1
XI1252_I167_XP I1252_P16_9 I1252_P8_1 I1252_P16_1n VDD VSS NAND2_X1
XI1252_I168_XG I1252_P17_10 I1252_G9_2 I1252_G17_10 I1252_G17_2n VDD VSS AOI21_X1
XI1252_I168_XP I1252_P17_10 I1252_P9_2 I1252_P17_2n VDD VSS NAND2_X1
XI1252_I169_XG I1252_P18_11 I1252_G10_3 I1252_G18_11 I1252_G18_3n VDD VSS AOI21_X1
XI1252_I169_XP I1252_P18_11 I1252_P10_3 I1252_P18_3n VDD VSS NAND2_X1
XI1252_I170_XG I1252_P19_12 I1252_G11_4 I1252_G19_12 I1252_G19_4n VDD VSS AOI21_X1
XI1252_I170_XP I1252_P19_12 I1252_P11_4 I1252_P19_4n VDD VSS NAND2_X1
XI1252_I171_XG I1252_P20_13 I1252_G12_5 I1252_G20_13 I1252_G20_5n VDD VSS AOI21_X1
XI1252_I171_XP I1252_P20_13 I1252_P12_5 I1252_P20_5n VDD VSS NAND2_X1
XI1252_I172_XG I1252_P21_14 I1252_G13_6 I1252_G21_14 I1252_G21_6n VDD VSS AOI21_X1
XI1252_I172_XP I1252_P21_14 I1252_P13_6 I1252_P21_6n VDD VSS NAND2_X1
XI1252_I173_XG I1252_P22_15 I1252_G14_7 I1252_G22_15 I1252_G22_7n VDD VSS AOI21_X1
XI1252_I173_XP I1252_P22_15 I1252_P14_7 I1252_P22_7n VDD VSS NAND2_X1
XI1252_I174_XG I1252_P23_16 I1252_G15_8 I1252_G23_16 I1252_G23_8n VDD VSS AOI21_X1
XI1252_I174_XP I1252_P23_16 I1252_P15_8 I1252_P23_8n VDD VSS NAND2_X1
XI1252_I175_XG I1252_P24_17 I1252_G16_9 I1252_G24_17 I1252_G24_9n VDD VSS AOI21_X1
XI1252_I175_XP I1252_P24_17 I1252_P16_9 I1252_P24_9n VDD VSS NAND2_X1
XI1252_I176_XG I1252_P25_18 I1252_G17_10 I1252_G25_18 I1252_G25_10n VDD VSS AOI21_X1
XI1252_I176_XP I1252_P25_18 I1252_P17_10 I1252_P25_10n VDD VSS NAND2_X1
XI1252_I177_XG I1252_P26_19 I1252_G18_11 I1252_G26_19 I1252_G26_11n VDD VSS AOI21_X1
XI1252_I177_XP I1252_P26_19 I1252_P18_11 I1252_P26_11n VDD VSS NAND2_X1
XI1252_I178_XG I1252_P27_20 I1252_G19_12 I1252_G27_20 I1252_G27_12n VDD VSS AOI21_X1
XI1252_I178_XP I1252_P27_20 I1252_P19_12 I1252_P27_12n VDD VSS NAND2_X1
XI1252_I179_XG I1252_P28_21 I1252_G20_13 I1252_G28_21 I1252_G28_13n VDD VSS AOI21_X1
XI1252_I179_XP I1252_P28_21 I1252_P20_13 I1252_P28_13n VDD VSS NAND2_X1
XI1252_I180_XG I1252_P29_22 I1252_G21_14 I1252_G29_22 I1252_G29_14n VDD VSS AOI21_X1
XI1252_I180_XP I1252_P29_22 I1252_P21_14 I1252_P29_14n VDD VSS NAND2_X1
XI1252_I181_XG I1252_P30_23 I1252_G22_15 I1252_G30_23 I1252_G30_15n VDD VSS AOI21_X1
XI1252_I181_XP I1252_P30_23 I1252_P22_15 I1252_P30_15n VDD VSS NAND2_X1
XI1252_I182_XG I1252_P31_24 I1252_G23_16 I1252_G31_24 I1252_G31_16n VDD VSS AOI21_X1
XI1252_I182_XP I1252_P31_24 I1252_P23_16 I1252_P31_16n VDD VSS NAND2_X1
XI1252_I183_XG I1252_P16_1n I1252_G0_0n I1252_G16_1n I1252_G16_0 VDD VSS OAI21_X1
XI1252_I184_XG I1252_P17_2n I1252_G1_0n I1252_G17_2n I1252_G17_0 VDD VSS OAI21_X1
XI1252_I185_XG I1252_P18_3n I1252_G2_0n I1252_G18_3n I1252_G18_0 VDD VSS OAI21_X1
XI1252_I186_XG I1252_P19_4n I1252_G3_0n I1252_G19_4n I1252_G19_0 VDD VSS OAI21_X1
XI1252_I187 I1252_G4_0 I1252_G4_0n VDD VSS INV_X1
XI1252_I188_XG I1252_P20_5n I1252_G4_0n I1252_G20_5n I1252_G20_0 VDD VSS OAI21_X1
XI1252_I189 I1252_G5_0 I1252_G5_0n VDD VSS INV_X1
XI1252_I190_XG I1252_P21_6n I1252_G5_0n I1252_G21_6n I1252_G21_0 VDD VSS OAI21_X1
XI1252_I191 I1252_G6_0 I1252_G6_0n VDD VSS INV_X1
XI1252_I192_XG I1252_P22_7n I1252_G6_0n I1252_G22_7n I1252_G22_0 VDD VSS OAI21_X1
XI1252_I193 I1252_G7_0 I1252_G7_0n VDD VSS INV_X1
XI1252_I194_XG I1252_P23_8n I1252_G7_0n I1252_G23_8n I1252_G23_0 VDD VSS OAI21_X1
XI1252_I195_XG I1252_P24_9n I1252_G8_0n I1252_G24_9n I1252_G24_0 VDD VSS OAI21_X1
XI1252_I196_XG I1252_P25_10n I1252_G9_0n I1252_G25_10n I1252_G25_0 VDD VSS OAI21_X1
XI1252_I197_XG I1252_P26_11n I1252_G10_0n I1252_G26_11n I1252_G26_0 VDD VSS OAI21_X1
XI1252_I198_XG I1252_P27_12n I1252_G11_0n I1252_G27_12n I1252_G27_0 VDD VSS OAI21_X1
XI1252_I199_XG I1252_P28_13n I1252_G12_0n I1252_G28_13n I1252_G28_0 VDD VSS OAI21_X1
XI1252_I200_XG I1252_P29_14n I1252_G13_0n I1252_G29_14n I1252_G29_0 VDD VSS OAI21_X1
XI1252_I201_XG I1252_P30_15n I1252_G14_0n I1252_G30_15n c15_m VDD VSS OAI21_X1
XI1252_I202_XG I1252_P31_16n I1252_G15_0n I1252_G31_16n c15_o VDD VSS OAI21_X1
XI1252_I203 I1252_pn0 qu17_b3_5 p15_0 VDD VSS XNOR2_X1
XI1252_I204 I1252_pn1 I1252_G0_0 p15_1 VDD VSS XNOR2_X1
XI1252_I205 I1252_pn2 I1252_G1_0 p15_2 VDD VSS XNOR2_X1
XI1252_I206 I1252_pn3 I1252_G2_0n p15_3 VDD VSS XOR2_X1
XI1252_I207 I1252_pn4 I1252_G3_0n p15_4 VDD VSS XOR2_X1
XI1252_I208 I1252_pn5 I1252_G4_0 p15_5 VDD VSS XNOR2_X1
XI1252_I209 I1252_pn6 I1252_G5_0 p15_6 VDD VSS XNOR2_X1
XI1252_I210 I1252_pn7 I1252_G6_0 p15_7 VDD VSS XNOR2_X1
XI1252_I211 I1252_pn8 I1252_G7_0 p15_8 VDD VSS XNOR2_X1
XI1252_I212 I1252_pn9 I1252_G8_0n p15_9 VDD VSS XOR2_X1
XI1252_I213 I1252_pn10 I1252_G9_0n p15_10 VDD VSS XOR2_X1
XI1252_I214 I1252_pn11 I1252_G10_0n p15_11 VDD VSS XOR2_X1
XI1252_I215 I1252_pn12 I1252_G11_0n p15_12 VDD VSS XOR2_X1
XI1252_I216 I1252_pn13 I1252_G12_0n p15_13 VDD VSS XOR2_X1
XI1252_I217 I1252_pn14 I1252_G13_0n p15_14 VDD VSS XOR2_X1
XI1252_I218 I1252_pn15 I1252_G14_0n p15_15 VDD VSS XOR2_X1
XI1252_I219 I1252_pn16 I1252_G15_0n p15_16 VDD VSS XOR2_X1
XI1252_I220 I1252_pn17 I1252_G16_0 p15_17 VDD VSS XNOR2_X1
XI1252_I221 I1252_pn18 I1252_G17_0 p15_18 VDD VSS XNOR2_X1
XI1252_I222 I1252_pn19 I1252_G18_0 p15_19 VDD VSS XNOR2_X1
XI1252_I223 I1252_pn20 I1252_G19_0 p15_20 VDD VSS XNOR2_X1
XI1252_I224 I1252_pn21 I1252_G20_0 p15_21 VDD VSS XNOR2_X1
XI1252_I225 I1252_pn22 I1252_G21_0 p15_22 VDD VSS XNOR2_X1
XI1252_I226 I1252_pn23 I1252_G22_0 p15_23 VDD VSS XNOR2_X1
XI1252_I227 I1252_pn24 I1252_G23_0 p15_24 VDD VSS XNOR2_X1
XI1252_I228 I1252_pn25 I1252_G24_0 p15_25 VDD VSS XNOR2_X1
XI1252_I229 I1252_pn26 I1252_G25_0 p15_26 VDD VSS XNOR2_X1
XI1252_I230 I1252_pn27 I1252_G26_0 p15_27 VDD VSS XNOR2_X1
XI1252_I231 I1252_pn28 I1252_G27_0 p15_28 VDD VSS XNOR2_X1
XI1252_I232 I1252_pn29 I1252_G28_0 p15_29 VDD VSS XNOR2_X1
XI1252_I233 I1252_pn30 I1252_G29_0 p15_30 VDD VSS XNOR2_X1
XI1252_I234 I1252_pn31 c15_m p15_31 VDD VSS XNOR2_X1
XI1253 p14_31 qu17_b3_5 h15 VDD VSS XOR2_X1
XI1254 h15 c15_o p15_32 VDD VSS XOR2_X1
XI1255 p15_32 qu16 VDD VSS INV_X4
XI1256 qu16 qu16_b0 VDD VSS INV_X1
XI1257 qu16_b0 qu16_b1_0 VDD VSS INV_X4
XI1258 qu16_b1_0 qu16_b2_0 VDD VSS INV_X4
XI1259 qu16_b1_0 qu16_b2_1 VDD VSS INV_X4
XI1260 qu16_b2_0 qu16_b3_0 VDD VSS INV_X4
XI1261 qu16_b2_0 qu16_b3_1 VDD VSS INV_X4
XI1262 qu16_b2_0 qu16_b3_2 VDD VSS INV_X4
XI1263 qu16_b2_1 qu16_b3_3 VDD VSS INV_X4
XI1264 qu16_b2_1 qu16_b3_4 VDD VSS INV_X4
XI1265 qu16_b2_1 qu16_b3_5 VDD VSS INV_X4
XI1266 B_0_b3_2 qu16_b3_0 b16_0 VDD VSS XOR2_X1
XI1267 dd1_b3_2 qu16_b3_0 b16_1 VDD VSS XOR2_X1
XI1268 dd2_b3_2 qu16_b3_0 b16_2 VDD VSS XOR2_X1
XI1269 dd3_b3_2 qu16_b3_0 b16_3 VDD VSS XOR2_X1
XI1270 dd4_b3_2 qu16_b3_0 b16_4 VDD VSS XOR2_X1
XI1271 dd5_b3_2 qu16_b3_0 b16_5 VDD VSS XOR2_X1
XI1272 dd6_b3_2 qu16_b3_1 b16_6 VDD VSS XOR2_X1
XI1273 dd7_b3_2 qu16_b3_1 b16_7 VDD VSS XOR2_X1
XI1274 dd8_b3_2 qu16_b3_1 b16_8 VDD VSS XOR2_X1
XI1275 dd9_b3_2 qu16_b3_1 b16_9 VDD VSS XOR2_X1
XI1276 dd10_b3_2 qu16_b3_1 b16_10 VDD VSS XOR2_X1
XI1277 dd11_b3_2 qu16_b3_1 b16_11 VDD VSS XOR2_X1
XI1278 dd12_b3_2 qu16_b3_2 b16_12 VDD VSS XOR2_X1
XI1279 dd13_b3_2 qu16_b3_2 b16_13 VDD VSS XOR2_X1
XI1280 dd14_b3_2 qu16_b3_2 b16_14 VDD VSS XOR2_X1
XI1281 dd15_b3_2 qu16_b3_2 b16_15 VDD VSS XOR2_X1
XI1282 dd16_b3_2 qu16_b3_2 b16_16 VDD VSS XOR2_X1
XI1283 dd17_b3_2 qu16_b3_2 b16_17 VDD VSS XOR2_X1
XI1284 dd18_b3_2 qu16_b3_3 b16_18 VDD VSS XOR2_X1
XI1285 dd19_b3_2 qu16_b3_3 b16_19 VDD VSS XOR2_X1
XI1286 dd20_b3_2 qu16_b3_3 b16_20 VDD VSS XOR2_X1
XI1287 dd21_b3_2 qu16_b3_3 b16_21 VDD VSS XOR2_X1
XI1288 dd22_b3_2 qu16_b3_3 b16_22 VDD VSS XOR2_X1
XI1289 dd23_b3_2 qu16_b3_3 b16_23 VDD VSS XOR2_X1
XI1290 dd24_b3_2 qu16_b3_4 b16_24 VDD VSS XOR2_X1
XI1291 dd25_b3_2 qu16_b3_4 b16_25 VDD VSS XOR2_X1
XI1292 dd26_b3_2 qu16_b3_4 b16_26 VDD VSS XOR2_X1
XI1293 dd27_b3_2 qu16_b3_4 b16_27 VDD VSS XOR2_X1
XI1294 dd28_b3_2 qu16_b3_4 b16_28 VDD VSS XOR2_X1
XI1295 dd29_b3_2 qu16_b3_4 b16_29 VDD VSS XOR2_X1
XI1296 dd30_b3_2 qu16_b3_5 b16_30 VDD VSS XOR2_X1
XI1297 dd31_b3_2 qu16_b3_5 b16_31 VDD VSS XOR2_X1
XI1298_I0 aa15 b16_0 I1298_gn0 VDD VSS NAND2_X1
XI1298_I1 p15_0 b16_1 I1298_gn1 VDD VSS NAND2_X1
XI1298_I2 p15_1 b16_2 I1298_gn2 VDD VSS NAND2_X1
XI1298_I3 p15_2 b16_3 I1298_gn3 VDD VSS NAND2_X1
XI1298_I4 p15_3 b16_4 I1298_gn4 VDD VSS NAND2_X1
XI1298_I5 p15_4 b16_5 I1298_gn5 VDD VSS NAND2_X1
XI1298_I6 p15_5 b16_6 I1298_gn6 VDD VSS NAND2_X1
XI1298_I7 p15_6 b16_7 I1298_gn7 VDD VSS NAND2_X1
XI1298_I8 p15_7 b16_8 I1298_gn8 VDD VSS NAND2_X1
XI1298_I9 p15_8 b16_9 I1298_gn9 VDD VSS NAND2_X1
XI1298_I10 p15_9 b16_10 I1298_gn10 VDD VSS NAND2_X1
XI1298_I11 p15_10 b16_11 I1298_gn11 VDD VSS NAND2_X1
XI1298_I12 p15_11 b16_12 I1298_gn12 VDD VSS NAND2_X1
XI1298_I13 p15_12 b16_13 I1298_gn13 VDD VSS NAND2_X1
XI1298_I14 p15_13 b16_14 I1298_gn14 VDD VSS NAND2_X1
XI1298_I15 p15_14 b16_15 I1298_gn15 VDD VSS NAND2_X1
XI1298_I16 p15_15 b16_16 I1298_gn16 VDD VSS NAND2_X1
XI1298_I17 p15_16 b16_17 I1298_gn17 VDD VSS NAND2_X1
XI1298_I18 p15_17 b16_18 I1298_gn18 VDD VSS NAND2_X1
XI1298_I19 p15_18 b16_19 I1298_gn19 VDD VSS NAND2_X1
XI1298_I20 p15_19 b16_20 I1298_gn20 VDD VSS NAND2_X1
XI1298_I21 p15_20 b16_21 I1298_gn21 VDD VSS NAND2_X1
XI1298_I22 p15_21 b16_22 I1298_gn22 VDD VSS NAND2_X1
XI1298_I23 p15_22 b16_23 I1298_gn23 VDD VSS NAND2_X1
XI1298_I24 p15_23 b16_24 I1298_gn24 VDD VSS NAND2_X1
XI1298_I25 p15_24 b16_25 I1298_gn25 VDD VSS NAND2_X1
XI1298_I26 p15_25 b16_26 I1298_gn26 VDD VSS NAND2_X1
XI1298_I27 p15_26 b16_27 I1298_gn27 VDD VSS NAND2_X1
XI1298_I28 p15_27 b16_28 I1298_gn28 VDD VSS NAND2_X1
XI1298_I29 p15_28 b16_29 I1298_gn29 VDD VSS NAND2_X1
XI1298_I30 p15_29 b16_30 I1298_gn30 VDD VSS NAND2_X1
XI1298_I31 p15_30 b16_31 I1298_gn31 VDD VSS NAND2_X1
XI1298_I32 aa15 b16_0 I1298_pn0 VDD VSS XNOR2_X1
XI1298_I33 p15_0 b16_1 I1298_pn1 VDD VSS XNOR2_X1
XI1298_I34 p15_1 b16_2 I1298_pn2 VDD VSS XNOR2_X1
XI1298_I35 p15_2 b16_3 I1298_pn3 VDD VSS XNOR2_X1
XI1298_I36 p15_3 b16_4 I1298_pn4 VDD VSS XNOR2_X1
XI1298_I37 p15_4 b16_5 I1298_pn5 VDD VSS XNOR2_X1
XI1298_I38 p15_5 b16_6 I1298_pn6 VDD VSS XNOR2_X1
XI1298_I39 p15_6 b16_7 I1298_pn7 VDD VSS XNOR2_X1
XI1298_I40 p15_7 b16_8 I1298_pn8 VDD VSS XNOR2_X1
XI1298_I41 p15_8 b16_9 I1298_pn9 VDD VSS XNOR2_X1
XI1298_I42 p15_9 b16_10 I1298_pn10 VDD VSS XNOR2_X1
XI1298_I43 p15_10 b16_11 I1298_pn11 VDD VSS XNOR2_X1
XI1298_I44 p15_11 b16_12 I1298_pn12 VDD VSS XNOR2_X1
XI1298_I45 p15_12 b16_13 I1298_pn13 VDD VSS XNOR2_X1
XI1298_I46 p15_13 b16_14 I1298_pn14 VDD VSS XNOR2_X1
XI1298_I47 p15_14 b16_15 I1298_pn15 VDD VSS XNOR2_X1
XI1298_I48 p15_15 b16_16 I1298_pn16 VDD VSS XNOR2_X1
XI1298_I49 p15_16 b16_17 I1298_pn17 VDD VSS XNOR2_X1
XI1298_I50 p15_17 b16_18 I1298_pn18 VDD VSS XNOR2_X1
XI1298_I51 p15_18 b16_19 I1298_pn19 VDD VSS XNOR2_X1
XI1298_I52 p15_19 b16_20 I1298_pn20 VDD VSS XNOR2_X1
XI1298_I53 p15_20 b16_21 I1298_pn21 VDD VSS XNOR2_X1
XI1298_I54 p15_21 b16_22 I1298_pn22 VDD VSS XNOR2_X1
XI1298_I55 p15_22 b16_23 I1298_pn23 VDD VSS XNOR2_X1
XI1298_I56 p15_23 b16_24 I1298_pn24 VDD VSS XNOR2_X1
XI1298_I57 p15_24 b16_25 I1298_pn25 VDD VSS XNOR2_X1
XI1298_I58 p15_25 b16_26 I1298_pn26 VDD VSS XNOR2_X1
XI1298_I59 p15_26 b16_27 I1298_pn27 VDD VSS XNOR2_X1
XI1298_I60 p15_27 b16_28 I1298_pn28 VDD VSS XNOR2_X1
XI1298_I61 p15_28 b16_29 I1298_pn29 VDD VSS XNOR2_X1
XI1298_I62 p15_29 b16_30 I1298_pn30 VDD VSS XNOR2_X1
XI1298_I63 p15_30 b16_31 I1298_pn31 VDD VSS XNOR2_X1
XI1298_I64 qu16_b3_5 I1298_cinn VDD VSS INV_X1
XI1298_I65_XG I1298_pn0 I1298_cinn I1298_gn0 I1298_G0_0 VDD VSS OAI21_X1
XI1298_I66 I1298_G0_0 I1298_G0_0n VDD VSS INV_X1
XI1298_I67_XG I1298_pn1 I1298_G0_0n I1298_gn1 I1298_G1_0 VDD VSS OAI21_X1
XI1298_I68_XG I1298_pn2 I1298_gn1 I1298_gn2 I1298_G2_1 VDD VSS OAI21_X1
XI1298_I68_XP I1298_pn2 I1298_pn1 I1298_P2_1 VDD VSS NOR2_X1
XI1298_I69_XG I1298_pn3 I1298_gn2 I1298_gn3 I1298_G3_2 VDD VSS OAI21_X1
XI1298_I69_XP I1298_pn3 I1298_pn2 I1298_P3_2 VDD VSS NOR2_X1
XI1298_I70_XG I1298_pn4 I1298_gn3 I1298_gn4 I1298_G4_3 VDD VSS OAI21_X1
XI1298_I70_XP I1298_pn4 I1298_pn3 I1298_P4_3 VDD VSS NOR2_X1
XI1298_I71_XG I1298_pn5 I1298_gn4 I1298_gn5 I1298_G5_4 VDD VSS OAI21_X1
XI1298_I71_XP I1298_pn5 I1298_pn4 I1298_P5_4 VDD VSS NOR2_X1
XI1298_I72_XG I1298_pn6 I1298_gn5 I1298_gn6 I1298_G6_5 VDD VSS OAI21_X1
XI1298_I72_XP I1298_pn6 I1298_pn5 I1298_P6_5 VDD VSS NOR2_X1
XI1298_I73_XG I1298_pn7 I1298_gn6 I1298_gn7 I1298_G7_6 VDD VSS OAI21_X1
XI1298_I73_XP I1298_pn7 I1298_pn6 I1298_P7_6 VDD VSS NOR2_X1
XI1298_I74_XG I1298_pn8 I1298_gn7 I1298_gn8 I1298_G8_7 VDD VSS OAI21_X1
XI1298_I74_XP I1298_pn8 I1298_pn7 I1298_P8_7 VDD VSS NOR2_X1
XI1298_I75_XG I1298_pn9 I1298_gn8 I1298_gn9 I1298_G9_8 VDD VSS OAI21_X1
XI1298_I75_XP I1298_pn9 I1298_pn8 I1298_P9_8 VDD VSS NOR2_X1
XI1298_I76_XG I1298_pn10 I1298_gn9 I1298_gn10 I1298_G10_9 VDD VSS OAI21_X1
XI1298_I76_XP I1298_pn10 I1298_pn9 I1298_P10_9 VDD VSS NOR2_X1
XI1298_I77_XG I1298_pn11 I1298_gn10 I1298_gn11 I1298_G11_10 VDD VSS OAI21_X1
XI1298_I77_XP I1298_pn11 I1298_pn10 I1298_P11_10 VDD VSS NOR2_X1
XI1298_I78_XG I1298_pn12 I1298_gn11 I1298_gn12 I1298_G12_11 VDD VSS OAI21_X1
XI1298_I78_XP I1298_pn12 I1298_pn11 I1298_P12_11 VDD VSS NOR2_X1
XI1298_I79_XG I1298_pn13 I1298_gn12 I1298_gn13 I1298_G13_12 VDD VSS OAI21_X1
XI1298_I79_XP I1298_pn13 I1298_pn12 I1298_P13_12 VDD VSS NOR2_X1
XI1298_I80_XG I1298_pn14 I1298_gn13 I1298_gn14 I1298_G14_13 VDD VSS OAI21_X1
XI1298_I80_XP I1298_pn14 I1298_pn13 I1298_P14_13 VDD VSS NOR2_X1
XI1298_I81_XG I1298_pn15 I1298_gn14 I1298_gn15 I1298_G15_14 VDD VSS OAI21_X1
XI1298_I81_XP I1298_pn15 I1298_pn14 I1298_P15_14 VDD VSS NOR2_X1
XI1298_I82_XG I1298_pn16 I1298_gn15 I1298_gn16 I1298_G16_15 VDD VSS OAI21_X1
XI1298_I82_XP I1298_pn16 I1298_pn15 I1298_P16_15 VDD VSS NOR2_X1
XI1298_I83_XG I1298_pn17 I1298_gn16 I1298_gn17 I1298_G17_16 VDD VSS OAI21_X1
XI1298_I83_XP I1298_pn17 I1298_pn16 I1298_P17_16 VDD VSS NOR2_X1
XI1298_I84_XG I1298_pn18 I1298_gn17 I1298_gn18 I1298_G18_17 VDD VSS OAI21_X1
XI1298_I84_XP I1298_pn18 I1298_pn17 I1298_P18_17 VDD VSS NOR2_X1
XI1298_I85_XG I1298_pn19 I1298_gn18 I1298_gn19 I1298_G19_18 VDD VSS OAI21_X1
XI1298_I85_XP I1298_pn19 I1298_pn18 I1298_P19_18 VDD VSS NOR2_X1
XI1298_I86_XG I1298_pn20 I1298_gn19 I1298_gn20 I1298_G20_19 VDD VSS OAI21_X1
XI1298_I86_XP I1298_pn20 I1298_pn19 I1298_P20_19 VDD VSS NOR2_X1
XI1298_I87_XG I1298_pn21 I1298_gn20 I1298_gn21 I1298_G21_20 VDD VSS OAI21_X1
XI1298_I87_XP I1298_pn21 I1298_pn20 I1298_P21_20 VDD VSS NOR2_X1
XI1298_I88_XG I1298_pn22 I1298_gn21 I1298_gn22 I1298_G22_21 VDD VSS OAI21_X1
XI1298_I88_XP I1298_pn22 I1298_pn21 I1298_P22_21 VDD VSS NOR2_X1
XI1298_I89_XG I1298_pn23 I1298_gn22 I1298_gn23 I1298_G23_22 VDD VSS OAI21_X1
XI1298_I89_XP I1298_pn23 I1298_pn22 I1298_P23_22 VDD VSS NOR2_X1
XI1298_I90_XG I1298_pn24 I1298_gn23 I1298_gn24 I1298_G24_23 VDD VSS OAI21_X1
XI1298_I90_XP I1298_pn24 I1298_pn23 I1298_P24_23 VDD VSS NOR2_X1
XI1298_I91_XG I1298_pn25 I1298_gn24 I1298_gn25 I1298_G25_24 VDD VSS OAI21_X1
XI1298_I91_XP I1298_pn25 I1298_pn24 I1298_P25_24 VDD VSS NOR2_X1
XI1298_I92_XG I1298_pn26 I1298_gn25 I1298_gn26 I1298_G26_25 VDD VSS OAI21_X1
XI1298_I92_XP I1298_pn26 I1298_pn25 I1298_P26_25 VDD VSS NOR2_X1
XI1298_I93_XG I1298_pn27 I1298_gn26 I1298_gn27 I1298_G27_26 VDD VSS OAI21_X1
XI1298_I93_XP I1298_pn27 I1298_pn26 I1298_P27_26 VDD VSS NOR2_X1
XI1298_I94_XG I1298_pn28 I1298_gn27 I1298_gn28 I1298_G28_27 VDD VSS OAI21_X1
XI1298_I94_XP I1298_pn28 I1298_pn27 I1298_P28_27 VDD VSS NOR2_X1
XI1298_I95_XG I1298_pn29 I1298_gn28 I1298_gn29 I1298_G29_28 VDD VSS OAI21_X1
XI1298_I95_XP I1298_pn29 I1298_pn28 I1298_P29_28 VDD VSS NOR2_X1
XI1298_I96_XG I1298_pn30 I1298_gn29 I1298_gn30 I1298_G30_29 VDD VSS OAI21_X1
XI1298_I96_XP I1298_pn30 I1298_pn29 I1298_P30_29 VDD VSS NOR2_X1
XI1298_I97_XG I1298_pn31 I1298_gn30 I1298_gn31 I1298_G31_30 VDD VSS OAI21_X1
XI1298_I97_XP I1298_pn31 I1298_pn30 I1298_P31_30 VDD VSS NOR2_X1
XI1298_I98_XG I1298_P2_1 I1298_G0_0 I1298_G2_1 I1298_G2_0n VDD VSS AOI21_X1
XI1298_I99_XG I1298_P3_2 I1298_G1_0 I1298_G3_2 I1298_G3_0n VDD VSS AOI21_X1
XI1298_I100_XG I1298_P4_3 I1298_G2_1 I1298_G4_3 I1298_G4_1n VDD VSS AOI21_X1
XI1298_I100_XP I1298_P4_3 I1298_P2_1 I1298_P4_1n VDD VSS NAND2_X1
XI1298_I101_XG I1298_P5_4 I1298_G3_2 I1298_G5_4 I1298_G5_2n VDD VSS AOI21_X1
XI1298_I101_XP I1298_P5_4 I1298_P3_2 I1298_P5_2n VDD VSS NAND2_X1
XI1298_I102_XG I1298_P6_5 I1298_G4_3 I1298_G6_5 I1298_G6_3n VDD VSS AOI21_X1
XI1298_I102_XP I1298_P6_5 I1298_P4_3 I1298_P6_3n VDD VSS NAND2_X1
XI1298_I103_XG I1298_P7_6 I1298_G5_4 I1298_G7_6 I1298_G7_4n VDD VSS AOI21_X1
XI1298_I103_XP I1298_P7_6 I1298_P5_4 I1298_P7_4n VDD VSS NAND2_X1
XI1298_I104_XG I1298_P8_7 I1298_G6_5 I1298_G8_7 I1298_G8_5n VDD VSS AOI21_X1
XI1298_I104_XP I1298_P8_7 I1298_P6_5 I1298_P8_5n VDD VSS NAND2_X1
XI1298_I105_XG I1298_P9_8 I1298_G7_6 I1298_G9_8 I1298_G9_6n VDD VSS AOI21_X1
XI1298_I105_XP I1298_P9_8 I1298_P7_6 I1298_P9_6n VDD VSS NAND2_X1
XI1298_I106_XG I1298_P10_9 I1298_G8_7 I1298_G10_9 I1298_G10_7n VDD VSS AOI21_X1
XI1298_I106_XP I1298_P10_9 I1298_P8_7 I1298_P10_7n VDD VSS NAND2_X1
XI1298_I107_XG I1298_P11_10 I1298_G9_8 I1298_G11_10 I1298_G11_8n VDD VSS AOI21_X1
XI1298_I107_XP I1298_P11_10 I1298_P9_8 I1298_P11_8n VDD VSS NAND2_X1
XI1298_I108_XG I1298_P12_11 I1298_G10_9 I1298_G12_11 I1298_G12_9n VDD VSS AOI21_X1
XI1298_I108_XP I1298_P12_11 I1298_P10_9 I1298_P12_9n VDD VSS NAND2_X1
XI1298_I109_XG I1298_P13_12 I1298_G11_10 I1298_G13_12 I1298_G13_10n VDD VSS AOI21_X1
XI1298_I109_XP I1298_P13_12 I1298_P11_10 I1298_P13_10n VDD VSS NAND2_X1
XI1298_I110_XG I1298_P14_13 I1298_G12_11 I1298_G14_13 I1298_G14_11n VDD VSS AOI21_X1
XI1298_I110_XP I1298_P14_13 I1298_P12_11 I1298_P14_11n VDD VSS NAND2_X1
XI1298_I111_XG I1298_P15_14 I1298_G13_12 I1298_G15_14 I1298_G15_12n VDD VSS AOI21_X1
XI1298_I111_XP I1298_P15_14 I1298_P13_12 I1298_P15_12n VDD VSS NAND2_X1
XI1298_I112_XG I1298_P16_15 I1298_G14_13 I1298_G16_15 I1298_G16_13n VDD VSS AOI21_X1
XI1298_I112_XP I1298_P16_15 I1298_P14_13 I1298_P16_13n VDD VSS NAND2_X1
XI1298_I113_XG I1298_P17_16 I1298_G15_14 I1298_G17_16 I1298_G17_14n VDD VSS AOI21_X1
XI1298_I113_XP I1298_P17_16 I1298_P15_14 I1298_P17_14n VDD VSS NAND2_X1
XI1298_I114_XG I1298_P18_17 I1298_G16_15 I1298_G18_17 I1298_G18_15n VDD VSS AOI21_X1
XI1298_I114_XP I1298_P18_17 I1298_P16_15 I1298_P18_15n VDD VSS NAND2_X1
XI1298_I115_XG I1298_P19_18 I1298_G17_16 I1298_G19_18 I1298_G19_16n VDD VSS AOI21_X1
XI1298_I115_XP I1298_P19_18 I1298_P17_16 I1298_P19_16n VDD VSS NAND2_X1
XI1298_I116_XG I1298_P20_19 I1298_G18_17 I1298_G20_19 I1298_G20_17n VDD VSS AOI21_X1
XI1298_I116_XP I1298_P20_19 I1298_P18_17 I1298_P20_17n VDD VSS NAND2_X1
XI1298_I117_XG I1298_P21_20 I1298_G19_18 I1298_G21_20 I1298_G21_18n VDD VSS AOI21_X1
XI1298_I117_XP I1298_P21_20 I1298_P19_18 I1298_P21_18n VDD VSS NAND2_X1
XI1298_I118_XG I1298_P22_21 I1298_G20_19 I1298_G22_21 I1298_G22_19n VDD VSS AOI21_X1
XI1298_I118_XP I1298_P22_21 I1298_P20_19 I1298_P22_19n VDD VSS NAND2_X1
XI1298_I119_XG I1298_P23_22 I1298_G21_20 I1298_G23_22 I1298_G23_20n VDD VSS AOI21_X1
XI1298_I119_XP I1298_P23_22 I1298_P21_20 I1298_P23_20n VDD VSS NAND2_X1
XI1298_I120_XG I1298_P24_23 I1298_G22_21 I1298_G24_23 I1298_G24_21n VDD VSS AOI21_X1
XI1298_I120_XP I1298_P24_23 I1298_P22_21 I1298_P24_21n VDD VSS NAND2_X1
XI1298_I121_XG I1298_P25_24 I1298_G23_22 I1298_G25_24 I1298_G25_22n VDD VSS AOI21_X1
XI1298_I121_XP I1298_P25_24 I1298_P23_22 I1298_P25_22n VDD VSS NAND2_X1
XI1298_I122_XG I1298_P26_25 I1298_G24_23 I1298_G26_25 I1298_G26_23n VDD VSS AOI21_X1
XI1298_I122_XP I1298_P26_25 I1298_P24_23 I1298_P26_23n VDD VSS NAND2_X1
XI1298_I123_XG I1298_P27_26 I1298_G25_24 I1298_G27_26 I1298_G27_24n VDD VSS AOI21_X1
XI1298_I123_XP I1298_P27_26 I1298_P25_24 I1298_P27_24n VDD VSS NAND2_X1
XI1298_I124_XG I1298_P28_27 I1298_G26_25 I1298_G28_27 I1298_G28_25n VDD VSS AOI21_X1
XI1298_I124_XP I1298_P28_27 I1298_P26_25 I1298_P28_25n VDD VSS NAND2_X1
XI1298_I125_XG I1298_P29_28 I1298_G27_26 I1298_G29_28 I1298_G29_26n VDD VSS AOI21_X1
XI1298_I125_XP I1298_P29_28 I1298_P27_26 I1298_P29_26n VDD VSS NAND2_X1
XI1298_I126_XG I1298_P30_29 I1298_G28_27 I1298_G30_29 I1298_G30_27n VDD VSS AOI21_X1
XI1298_I126_XP I1298_P30_29 I1298_P28_27 I1298_P30_27n VDD VSS NAND2_X1
XI1298_I127_XG I1298_P31_30 I1298_G29_28 I1298_G31_30 I1298_G31_28n VDD VSS AOI21_X1
XI1298_I127_XP I1298_P31_30 I1298_P29_28 I1298_P31_28n VDD VSS NAND2_X1
XI1298_I128_XG I1298_P4_1n I1298_G0_0n I1298_G4_1n I1298_G4_0 VDD VSS OAI21_X1
XI1298_I129 I1298_G1_0 I1298_G1_0n VDD VSS INV_X1
XI1298_I130_XG I1298_P5_2n I1298_G1_0n I1298_G5_2n I1298_G5_0 VDD VSS OAI21_X1
XI1298_I131_XG I1298_P6_3n I1298_G2_0n I1298_G6_3n I1298_G6_0 VDD VSS OAI21_X1
XI1298_I132_XG I1298_P7_4n I1298_G3_0n I1298_G7_4n I1298_G7_0 VDD VSS OAI21_X1
XI1298_I133_XG I1298_P8_5n I1298_G4_1n I1298_G8_5n I1298_G8_1 VDD VSS OAI21_X1
XI1298_I133_XP I1298_P8_5n I1298_P4_1n I1298_P8_1 VDD VSS NOR2_X1
XI1298_I134_XG I1298_P9_6n I1298_G5_2n I1298_G9_6n I1298_G9_2 VDD VSS OAI21_X1
XI1298_I134_XP I1298_P9_6n I1298_P5_2n I1298_P9_2 VDD VSS NOR2_X1
XI1298_I135_XG I1298_P10_7n I1298_G6_3n I1298_G10_7n I1298_G10_3 VDD VSS OAI21_X1
XI1298_I135_XP I1298_P10_7n I1298_P6_3n I1298_P10_3 VDD VSS NOR2_X1
XI1298_I136_XG I1298_P11_8n I1298_G7_4n I1298_G11_8n I1298_G11_4 VDD VSS OAI21_X1
XI1298_I136_XP I1298_P11_8n I1298_P7_4n I1298_P11_4 VDD VSS NOR2_X1
XI1298_I137_XG I1298_P12_9n I1298_G8_5n I1298_G12_9n I1298_G12_5 VDD VSS OAI21_X1
XI1298_I137_XP I1298_P12_9n I1298_P8_5n I1298_P12_5 VDD VSS NOR2_X1
XI1298_I138_XG I1298_P13_10n I1298_G9_6n I1298_G13_10n I1298_G13_6 VDD VSS OAI21_X1
XI1298_I138_XP I1298_P13_10n I1298_P9_6n I1298_P13_6 VDD VSS NOR2_X1
XI1298_I139_XG I1298_P14_11n I1298_G10_7n I1298_G14_11n I1298_G14_7 VDD VSS OAI21_X1
XI1298_I139_XP I1298_P14_11n I1298_P10_7n I1298_P14_7 VDD VSS NOR2_X1
XI1298_I140_XG I1298_P15_12n I1298_G11_8n I1298_G15_12n I1298_G15_8 VDD VSS OAI21_X1
XI1298_I140_XP I1298_P15_12n I1298_P11_8n I1298_P15_8 VDD VSS NOR2_X1
XI1298_I141_XG I1298_P16_13n I1298_G12_9n I1298_G16_13n I1298_G16_9 VDD VSS OAI21_X1
XI1298_I141_XP I1298_P16_13n I1298_P12_9n I1298_P16_9 VDD VSS NOR2_X1
XI1298_I142_XG I1298_P17_14n I1298_G13_10n I1298_G17_14n I1298_G17_10 VDD VSS OAI21_X1
XI1298_I142_XP I1298_P17_14n I1298_P13_10n I1298_P17_10 VDD VSS NOR2_X1
XI1298_I143_XG I1298_P18_15n I1298_G14_11n I1298_G18_15n I1298_G18_11 VDD VSS OAI21_X1
XI1298_I143_XP I1298_P18_15n I1298_P14_11n I1298_P18_11 VDD VSS NOR2_X1
XI1298_I144_XG I1298_P19_16n I1298_G15_12n I1298_G19_16n I1298_G19_12 VDD VSS OAI21_X1
XI1298_I144_XP I1298_P19_16n I1298_P15_12n I1298_P19_12 VDD VSS NOR2_X1
XI1298_I145_XG I1298_P20_17n I1298_G16_13n I1298_G20_17n I1298_G20_13 VDD VSS OAI21_X1
XI1298_I145_XP I1298_P20_17n I1298_P16_13n I1298_P20_13 VDD VSS NOR2_X1
XI1298_I146_XG I1298_P21_18n I1298_G17_14n I1298_G21_18n I1298_G21_14 VDD VSS OAI21_X1
XI1298_I146_XP I1298_P21_18n I1298_P17_14n I1298_P21_14 VDD VSS NOR2_X1
XI1298_I147_XG I1298_P22_19n I1298_G18_15n I1298_G22_19n I1298_G22_15 VDD VSS OAI21_X1
XI1298_I147_XP I1298_P22_19n I1298_P18_15n I1298_P22_15 VDD VSS NOR2_X1
XI1298_I148_XG I1298_P23_20n I1298_G19_16n I1298_G23_20n I1298_G23_16 VDD VSS OAI21_X1
XI1298_I148_XP I1298_P23_20n I1298_P19_16n I1298_P23_16 VDD VSS NOR2_X1
XI1298_I149_XG I1298_P24_21n I1298_G20_17n I1298_G24_21n I1298_G24_17 VDD VSS OAI21_X1
XI1298_I149_XP I1298_P24_21n I1298_P20_17n I1298_P24_17 VDD VSS NOR2_X1
XI1298_I150_XG I1298_P25_22n I1298_G21_18n I1298_G25_22n I1298_G25_18 VDD VSS OAI21_X1
XI1298_I150_XP I1298_P25_22n I1298_P21_18n I1298_P25_18 VDD VSS NOR2_X1
XI1298_I151_XG I1298_P26_23n I1298_G22_19n I1298_G26_23n I1298_G26_19 VDD VSS OAI21_X1
XI1298_I151_XP I1298_P26_23n I1298_P22_19n I1298_P26_19 VDD VSS NOR2_X1
XI1298_I152_XG I1298_P27_24n I1298_G23_20n I1298_G27_24n I1298_G27_20 VDD VSS OAI21_X1
XI1298_I152_XP I1298_P27_24n I1298_P23_20n I1298_P27_20 VDD VSS NOR2_X1
XI1298_I153_XG I1298_P28_25n I1298_G24_21n I1298_G28_25n I1298_G28_21 VDD VSS OAI21_X1
XI1298_I153_XP I1298_P28_25n I1298_P24_21n I1298_P28_21 VDD VSS NOR2_X1
XI1298_I154_XG I1298_P29_26n I1298_G25_22n I1298_G29_26n I1298_G29_22 VDD VSS OAI21_X1
XI1298_I154_XP I1298_P29_26n I1298_P25_22n I1298_P29_22 VDD VSS NOR2_X1
XI1298_I155_XG I1298_P30_27n I1298_G26_23n I1298_G30_27n I1298_G30_23 VDD VSS OAI21_X1
XI1298_I155_XP I1298_P30_27n I1298_P26_23n I1298_P30_23 VDD VSS NOR2_X1
XI1298_I156_XG I1298_P31_28n I1298_G27_24n I1298_G31_28n I1298_G31_24 VDD VSS OAI21_X1
XI1298_I156_XP I1298_P31_28n I1298_P27_24n I1298_P31_24 VDD VSS NOR2_X1
XI1298_I157_XG I1298_P8_1 I1298_G0_0 I1298_G8_1 I1298_G8_0n VDD VSS AOI21_X1
XI1298_I158_XG I1298_P9_2 I1298_G1_0 I1298_G9_2 I1298_G9_0n VDD VSS AOI21_X1
XI1298_I159 I1298_G2_0n I1298_G2_0np VDD VSS INV_X1
XI1298_I160_XG I1298_P10_3 I1298_G2_0np I1298_G10_3 I1298_G10_0n VDD VSS AOI21_X1
XI1298_I161 I1298_G3_0n I1298_G3_0np VDD VSS INV_X1
XI1298_I162_XG I1298_P11_4 I1298_G3_0np I1298_G11_4 I1298_G11_0n VDD VSS AOI21_X1
XI1298_I163_XG I1298_P12_5 I1298_G4_0 I1298_G12_5 I1298_G12_0n VDD VSS AOI21_X1
XI1298_I164_XG I1298_P13_6 I1298_G5_0 I1298_G13_6 I1298_G13_0n VDD VSS AOI21_X1
XI1298_I165_XG I1298_P14_7 I1298_G6_0 I1298_G14_7 I1298_G14_0n VDD VSS AOI21_X1
XI1298_I166_XG I1298_P15_8 I1298_G7_0 I1298_G15_8 I1298_G15_0n VDD VSS AOI21_X1
XI1298_I167_XG I1298_P16_9 I1298_G8_1 I1298_G16_9 I1298_G16_1n VDD VSS AOI21_X1
XI1298_I167_XP I1298_P16_9 I1298_P8_1 I1298_P16_1n VDD VSS NAND2_X1
XI1298_I168_XG I1298_P17_10 I1298_G9_2 I1298_G17_10 I1298_G17_2n VDD VSS AOI21_X1
XI1298_I168_XP I1298_P17_10 I1298_P9_2 I1298_P17_2n VDD VSS NAND2_X1
XI1298_I169_XG I1298_P18_11 I1298_G10_3 I1298_G18_11 I1298_G18_3n VDD VSS AOI21_X1
XI1298_I169_XP I1298_P18_11 I1298_P10_3 I1298_P18_3n VDD VSS NAND2_X1
XI1298_I170_XG I1298_P19_12 I1298_G11_4 I1298_G19_12 I1298_G19_4n VDD VSS AOI21_X1
XI1298_I170_XP I1298_P19_12 I1298_P11_4 I1298_P19_4n VDD VSS NAND2_X1
XI1298_I171_XG I1298_P20_13 I1298_G12_5 I1298_G20_13 I1298_G20_5n VDD VSS AOI21_X1
XI1298_I171_XP I1298_P20_13 I1298_P12_5 I1298_P20_5n VDD VSS NAND2_X1
XI1298_I172_XG I1298_P21_14 I1298_G13_6 I1298_G21_14 I1298_G21_6n VDD VSS AOI21_X1
XI1298_I172_XP I1298_P21_14 I1298_P13_6 I1298_P21_6n VDD VSS NAND2_X1
XI1298_I173_XG I1298_P22_15 I1298_G14_7 I1298_G22_15 I1298_G22_7n VDD VSS AOI21_X1
XI1298_I173_XP I1298_P22_15 I1298_P14_7 I1298_P22_7n VDD VSS NAND2_X1
XI1298_I174_XG I1298_P23_16 I1298_G15_8 I1298_G23_16 I1298_G23_8n VDD VSS AOI21_X1
XI1298_I174_XP I1298_P23_16 I1298_P15_8 I1298_P23_8n VDD VSS NAND2_X1
XI1298_I175_XG I1298_P24_17 I1298_G16_9 I1298_G24_17 I1298_G24_9n VDD VSS AOI21_X1
XI1298_I175_XP I1298_P24_17 I1298_P16_9 I1298_P24_9n VDD VSS NAND2_X1
XI1298_I176_XG I1298_P25_18 I1298_G17_10 I1298_G25_18 I1298_G25_10n VDD VSS AOI21_X1
XI1298_I176_XP I1298_P25_18 I1298_P17_10 I1298_P25_10n VDD VSS NAND2_X1
XI1298_I177_XG I1298_P26_19 I1298_G18_11 I1298_G26_19 I1298_G26_11n VDD VSS AOI21_X1
XI1298_I177_XP I1298_P26_19 I1298_P18_11 I1298_P26_11n VDD VSS NAND2_X1
XI1298_I178_XG I1298_P27_20 I1298_G19_12 I1298_G27_20 I1298_G27_12n VDD VSS AOI21_X1
XI1298_I178_XP I1298_P27_20 I1298_P19_12 I1298_P27_12n VDD VSS NAND2_X1
XI1298_I179_XG I1298_P28_21 I1298_G20_13 I1298_G28_21 I1298_G28_13n VDD VSS AOI21_X1
XI1298_I179_XP I1298_P28_21 I1298_P20_13 I1298_P28_13n VDD VSS NAND2_X1
XI1298_I180_XG I1298_P29_22 I1298_G21_14 I1298_G29_22 I1298_G29_14n VDD VSS AOI21_X1
XI1298_I180_XP I1298_P29_22 I1298_P21_14 I1298_P29_14n VDD VSS NAND2_X1
XI1298_I181_XG I1298_P30_23 I1298_G22_15 I1298_G30_23 I1298_G30_15n VDD VSS AOI21_X1
XI1298_I181_XP I1298_P30_23 I1298_P22_15 I1298_P30_15n VDD VSS NAND2_X1
XI1298_I182_XG I1298_P31_24 I1298_G23_16 I1298_G31_24 I1298_G31_16n VDD VSS AOI21_X1
XI1298_I182_XP I1298_P31_24 I1298_P23_16 I1298_P31_16n VDD VSS NAND2_X1
XI1298_I183_XG I1298_P16_1n I1298_G0_0n I1298_G16_1n I1298_G16_0 VDD VSS OAI21_X1
XI1298_I184_XG I1298_P17_2n I1298_G1_0n I1298_G17_2n I1298_G17_0 VDD VSS OAI21_X1
XI1298_I185_XG I1298_P18_3n I1298_G2_0n I1298_G18_3n I1298_G18_0 VDD VSS OAI21_X1
XI1298_I186_XG I1298_P19_4n I1298_G3_0n I1298_G19_4n I1298_G19_0 VDD VSS OAI21_X1
XI1298_I187 I1298_G4_0 I1298_G4_0n VDD VSS INV_X1
XI1298_I188_XG I1298_P20_5n I1298_G4_0n I1298_G20_5n I1298_G20_0 VDD VSS OAI21_X1
XI1298_I189 I1298_G5_0 I1298_G5_0n VDD VSS INV_X1
XI1298_I190_XG I1298_P21_6n I1298_G5_0n I1298_G21_6n I1298_G21_0 VDD VSS OAI21_X1
XI1298_I191 I1298_G6_0 I1298_G6_0n VDD VSS INV_X1
XI1298_I192_XG I1298_P22_7n I1298_G6_0n I1298_G22_7n I1298_G22_0 VDD VSS OAI21_X1
XI1298_I193 I1298_G7_0 I1298_G7_0n VDD VSS INV_X1
XI1298_I194_XG I1298_P23_8n I1298_G7_0n I1298_G23_8n I1298_G23_0 VDD VSS OAI21_X1
XI1298_I195_XG I1298_P24_9n I1298_G8_0n I1298_G24_9n I1298_G24_0 VDD VSS OAI21_X1
XI1298_I196_XG I1298_P25_10n I1298_G9_0n I1298_G25_10n I1298_G25_0 VDD VSS OAI21_X1
XI1298_I197_XG I1298_P26_11n I1298_G10_0n I1298_G26_11n I1298_G26_0 VDD VSS OAI21_X1
XI1298_I198_XG I1298_P27_12n I1298_G11_0n I1298_G27_12n I1298_G27_0 VDD VSS OAI21_X1
XI1298_I199_XG I1298_P28_13n I1298_G12_0n I1298_G28_13n I1298_G28_0 VDD VSS OAI21_X1
XI1298_I200_XG I1298_P29_14n I1298_G13_0n I1298_G29_14n I1298_G29_0 VDD VSS OAI21_X1
XI1298_I201_XG I1298_P30_15n I1298_G14_0n I1298_G30_15n c16_m VDD VSS OAI21_X1
XI1298_I202_XG I1298_P31_16n I1298_G15_0n I1298_G31_16n c16_o VDD VSS OAI21_X1
XI1298_I203 I1298_pn0 qu16_b3_5 p16_0 VDD VSS XNOR2_X1
XI1298_I204 I1298_pn1 I1298_G0_0 p16_1 VDD VSS XNOR2_X1
XI1298_I205 I1298_pn2 I1298_G1_0 p16_2 VDD VSS XNOR2_X1
XI1298_I206 I1298_pn3 I1298_G2_0n p16_3 VDD VSS XOR2_X1
XI1298_I207 I1298_pn4 I1298_G3_0n p16_4 VDD VSS XOR2_X1
XI1298_I208 I1298_pn5 I1298_G4_0 p16_5 VDD VSS XNOR2_X1
XI1298_I209 I1298_pn6 I1298_G5_0 p16_6 VDD VSS XNOR2_X1
XI1298_I210 I1298_pn7 I1298_G6_0 p16_7 VDD VSS XNOR2_X1
XI1298_I211 I1298_pn8 I1298_G7_0 p16_8 VDD VSS XNOR2_X1
XI1298_I212 I1298_pn9 I1298_G8_0n p16_9 VDD VSS XOR2_X1
XI1298_I213 I1298_pn10 I1298_G9_0n p16_10 VDD VSS XOR2_X1
XI1298_I214 I1298_pn11 I1298_G10_0n p16_11 VDD VSS XOR2_X1
XI1298_I215 I1298_pn12 I1298_G11_0n p16_12 VDD VSS XOR2_X1
XI1298_I216 I1298_pn13 I1298_G12_0n p16_13 VDD VSS XOR2_X1
XI1298_I217 I1298_pn14 I1298_G13_0n p16_14 VDD VSS XOR2_X1
XI1298_I218 I1298_pn15 I1298_G14_0n p16_15 VDD VSS XOR2_X1
XI1298_I219 I1298_pn16 I1298_G15_0n p16_16 VDD VSS XOR2_X1
XI1298_I220 I1298_pn17 I1298_G16_0 p16_17 VDD VSS XNOR2_X1
XI1298_I221 I1298_pn18 I1298_G17_0 p16_18 VDD VSS XNOR2_X1
XI1298_I222 I1298_pn19 I1298_G18_0 p16_19 VDD VSS XNOR2_X1
XI1298_I223 I1298_pn20 I1298_G19_0 p16_20 VDD VSS XNOR2_X1
XI1298_I224 I1298_pn21 I1298_G20_0 p16_21 VDD VSS XNOR2_X1
XI1298_I225 I1298_pn22 I1298_G21_0 p16_22 VDD VSS XNOR2_X1
XI1298_I226 I1298_pn23 I1298_G22_0 p16_23 VDD VSS XNOR2_X1
XI1298_I227 I1298_pn24 I1298_G23_0 p16_24 VDD VSS XNOR2_X1
XI1298_I228 I1298_pn25 I1298_G24_0 p16_25 VDD VSS XNOR2_X1
XI1298_I229 I1298_pn26 I1298_G25_0 p16_26 VDD VSS XNOR2_X1
XI1298_I230 I1298_pn27 I1298_G26_0 p16_27 VDD VSS XNOR2_X1
XI1298_I231 I1298_pn28 I1298_G27_0 p16_28 VDD VSS XNOR2_X1
XI1298_I232 I1298_pn29 I1298_G28_0 p16_29 VDD VSS XNOR2_X1
XI1298_I233 I1298_pn30 I1298_G29_0 p16_30 VDD VSS XNOR2_X1
XI1298_I234 I1298_pn31 c16_m p16_31 VDD VSS XNOR2_X1
XI1299 p15_31 qu16_b3_5 h16 VDD VSS XOR2_X1
XI1300 h16 c16_o p16_32 VDD VSS XOR2_X1
XI1301 p16_32 qu15 VDD VSS INV_X4
XI1302 qu15 qu15_b0 VDD VSS INV_X1
XI1303 qu15_b0 qu15_b1_0 VDD VSS INV_X4
XI1304 qu15_b1_0 qu15_b2_0 VDD VSS INV_X4
XI1305 qu15_b1_0 qu15_b2_1 VDD VSS INV_X4
XI1306 qu15_b2_0 qu15_b3_0 VDD VSS INV_X4
XI1307 qu15_b2_0 qu15_b3_1 VDD VSS INV_X4
XI1308 qu15_b2_0 qu15_b3_2 VDD VSS INV_X4
XI1309 qu15_b2_1 qu15_b3_3 VDD VSS INV_X4
XI1310 qu15_b2_1 qu15_b3_4 VDD VSS INV_X4
XI1311 qu15_b2_1 qu15_b3_5 VDD VSS INV_X4
XI1312 B_0_b3_3 qu15_b3_0 b17_0 VDD VSS XOR2_X1
XI1313 dd1_b3_3 qu15_b3_0 b17_1 VDD VSS XOR2_X1
XI1314 dd2_b3_3 qu15_b3_0 b17_2 VDD VSS XOR2_X1
XI1315 dd3_b3_3 qu15_b3_0 b17_3 VDD VSS XOR2_X1
XI1316 dd4_b3_3 qu15_b3_0 b17_4 VDD VSS XOR2_X1
XI1317 dd5_b3_3 qu15_b3_0 b17_5 VDD VSS XOR2_X1
XI1318 dd6_b3_3 qu15_b3_1 b17_6 VDD VSS XOR2_X1
XI1319 dd7_b3_3 qu15_b3_1 b17_7 VDD VSS XOR2_X1
XI1320 dd8_b3_3 qu15_b3_1 b17_8 VDD VSS XOR2_X1
XI1321 dd9_b3_3 qu15_b3_1 b17_9 VDD VSS XOR2_X1
XI1322 dd10_b3_3 qu15_b3_1 b17_10 VDD VSS XOR2_X1
XI1323 dd11_b3_3 qu15_b3_1 b17_11 VDD VSS XOR2_X1
XI1324 dd12_b3_3 qu15_b3_2 b17_12 VDD VSS XOR2_X1
XI1325 dd13_b3_3 qu15_b3_2 b17_13 VDD VSS XOR2_X1
XI1326 dd14_b3_3 qu15_b3_2 b17_14 VDD VSS XOR2_X1
XI1327 dd15_b3_3 qu15_b3_2 b17_15 VDD VSS XOR2_X1
XI1328 dd16_b3_3 qu15_b3_2 b17_16 VDD VSS XOR2_X1
XI1329 dd17_b3_3 qu15_b3_2 b17_17 VDD VSS XOR2_X1
XI1330 dd18_b3_3 qu15_b3_3 b17_18 VDD VSS XOR2_X1
XI1331 dd19_b3_3 qu15_b3_3 b17_19 VDD VSS XOR2_X1
XI1332 dd20_b3_3 qu15_b3_3 b17_20 VDD VSS XOR2_X1
XI1333 dd21_b3_3 qu15_b3_3 b17_21 VDD VSS XOR2_X1
XI1334 dd22_b3_3 qu15_b3_3 b17_22 VDD VSS XOR2_X1
XI1335 dd23_b3_3 qu15_b3_3 b17_23 VDD VSS XOR2_X1
XI1336 dd24_b3_3 qu15_b3_4 b17_24 VDD VSS XOR2_X1
XI1337 dd25_b3_3 qu15_b3_4 b17_25 VDD VSS XOR2_X1
XI1338 dd26_b3_3 qu15_b3_4 b17_26 VDD VSS XOR2_X1
XI1339 dd27_b3_3 qu15_b3_4 b17_27 VDD VSS XOR2_X1
XI1340 dd28_b3_3 qu15_b3_4 b17_28 VDD VSS XOR2_X1
XI1341 dd29_b3_3 qu15_b3_4 b17_29 VDD VSS XOR2_X1
XI1342 dd30_b3_3 qu15_b3_5 b17_30 VDD VSS XOR2_X1
XI1343 dd31_b3_3 qu15_b3_5 b17_31 VDD VSS XOR2_X1
XI1344_I0 aa14 b17_0 I1344_gn0 VDD VSS NAND2_X1
XI1344_I1 p16_0 b17_1 I1344_gn1 VDD VSS NAND2_X1
XI1344_I2 p16_1 b17_2 I1344_gn2 VDD VSS NAND2_X1
XI1344_I3 p16_2 b17_3 I1344_gn3 VDD VSS NAND2_X1
XI1344_I4 p16_3 b17_4 I1344_gn4 VDD VSS NAND2_X1
XI1344_I5 p16_4 b17_5 I1344_gn5 VDD VSS NAND2_X1
XI1344_I6 p16_5 b17_6 I1344_gn6 VDD VSS NAND2_X1
XI1344_I7 p16_6 b17_7 I1344_gn7 VDD VSS NAND2_X1
XI1344_I8 p16_7 b17_8 I1344_gn8 VDD VSS NAND2_X1
XI1344_I9 p16_8 b17_9 I1344_gn9 VDD VSS NAND2_X1
XI1344_I10 p16_9 b17_10 I1344_gn10 VDD VSS NAND2_X1
XI1344_I11 p16_10 b17_11 I1344_gn11 VDD VSS NAND2_X1
XI1344_I12 p16_11 b17_12 I1344_gn12 VDD VSS NAND2_X1
XI1344_I13 p16_12 b17_13 I1344_gn13 VDD VSS NAND2_X1
XI1344_I14 p16_13 b17_14 I1344_gn14 VDD VSS NAND2_X1
XI1344_I15 p16_14 b17_15 I1344_gn15 VDD VSS NAND2_X1
XI1344_I16 p16_15 b17_16 I1344_gn16 VDD VSS NAND2_X1
XI1344_I17 p16_16 b17_17 I1344_gn17 VDD VSS NAND2_X1
XI1344_I18 p16_17 b17_18 I1344_gn18 VDD VSS NAND2_X1
XI1344_I19 p16_18 b17_19 I1344_gn19 VDD VSS NAND2_X1
XI1344_I20 p16_19 b17_20 I1344_gn20 VDD VSS NAND2_X1
XI1344_I21 p16_20 b17_21 I1344_gn21 VDD VSS NAND2_X1
XI1344_I22 p16_21 b17_22 I1344_gn22 VDD VSS NAND2_X1
XI1344_I23 p16_22 b17_23 I1344_gn23 VDD VSS NAND2_X1
XI1344_I24 p16_23 b17_24 I1344_gn24 VDD VSS NAND2_X1
XI1344_I25 p16_24 b17_25 I1344_gn25 VDD VSS NAND2_X1
XI1344_I26 p16_25 b17_26 I1344_gn26 VDD VSS NAND2_X1
XI1344_I27 p16_26 b17_27 I1344_gn27 VDD VSS NAND2_X1
XI1344_I28 p16_27 b17_28 I1344_gn28 VDD VSS NAND2_X1
XI1344_I29 p16_28 b17_29 I1344_gn29 VDD VSS NAND2_X1
XI1344_I30 p16_29 b17_30 I1344_gn30 VDD VSS NAND2_X1
XI1344_I31 p16_30 b17_31 I1344_gn31 VDD VSS NAND2_X1
XI1344_I32 aa14 b17_0 I1344_pn0 VDD VSS XNOR2_X1
XI1344_I33 p16_0 b17_1 I1344_pn1 VDD VSS XNOR2_X1
XI1344_I34 p16_1 b17_2 I1344_pn2 VDD VSS XNOR2_X1
XI1344_I35 p16_2 b17_3 I1344_pn3 VDD VSS XNOR2_X1
XI1344_I36 p16_3 b17_4 I1344_pn4 VDD VSS XNOR2_X1
XI1344_I37 p16_4 b17_5 I1344_pn5 VDD VSS XNOR2_X1
XI1344_I38 p16_5 b17_6 I1344_pn6 VDD VSS XNOR2_X1
XI1344_I39 p16_6 b17_7 I1344_pn7 VDD VSS XNOR2_X1
XI1344_I40 p16_7 b17_8 I1344_pn8 VDD VSS XNOR2_X1
XI1344_I41 p16_8 b17_9 I1344_pn9 VDD VSS XNOR2_X1
XI1344_I42 p16_9 b17_10 I1344_pn10 VDD VSS XNOR2_X1
XI1344_I43 p16_10 b17_11 I1344_pn11 VDD VSS XNOR2_X1
XI1344_I44 p16_11 b17_12 I1344_pn12 VDD VSS XNOR2_X1
XI1344_I45 p16_12 b17_13 I1344_pn13 VDD VSS XNOR2_X1
XI1344_I46 p16_13 b17_14 I1344_pn14 VDD VSS XNOR2_X1
XI1344_I47 p16_14 b17_15 I1344_pn15 VDD VSS XNOR2_X1
XI1344_I48 p16_15 b17_16 I1344_pn16 VDD VSS XNOR2_X1
XI1344_I49 p16_16 b17_17 I1344_pn17 VDD VSS XNOR2_X1
XI1344_I50 p16_17 b17_18 I1344_pn18 VDD VSS XNOR2_X1
XI1344_I51 p16_18 b17_19 I1344_pn19 VDD VSS XNOR2_X1
XI1344_I52 p16_19 b17_20 I1344_pn20 VDD VSS XNOR2_X1
XI1344_I53 p16_20 b17_21 I1344_pn21 VDD VSS XNOR2_X1
XI1344_I54 p16_21 b17_22 I1344_pn22 VDD VSS XNOR2_X1
XI1344_I55 p16_22 b17_23 I1344_pn23 VDD VSS XNOR2_X1
XI1344_I56 p16_23 b17_24 I1344_pn24 VDD VSS XNOR2_X1
XI1344_I57 p16_24 b17_25 I1344_pn25 VDD VSS XNOR2_X1
XI1344_I58 p16_25 b17_26 I1344_pn26 VDD VSS XNOR2_X1
XI1344_I59 p16_26 b17_27 I1344_pn27 VDD VSS XNOR2_X1
XI1344_I60 p16_27 b17_28 I1344_pn28 VDD VSS XNOR2_X1
XI1344_I61 p16_28 b17_29 I1344_pn29 VDD VSS XNOR2_X1
XI1344_I62 p16_29 b17_30 I1344_pn30 VDD VSS XNOR2_X1
XI1344_I63 p16_30 b17_31 I1344_pn31 VDD VSS XNOR2_X1
XI1344_I64 qu15_b3_5 I1344_cinn VDD VSS INV_X1
XI1344_I65_XG I1344_pn0 I1344_cinn I1344_gn0 I1344_G0_0 VDD VSS OAI21_X1
XI1344_I66 I1344_G0_0 I1344_G0_0n VDD VSS INV_X1
XI1344_I67_XG I1344_pn1 I1344_G0_0n I1344_gn1 I1344_G1_0 VDD VSS OAI21_X1
XI1344_I68_XG I1344_pn2 I1344_gn1 I1344_gn2 I1344_G2_1 VDD VSS OAI21_X1
XI1344_I68_XP I1344_pn2 I1344_pn1 I1344_P2_1 VDD VSS NOR2_X1
XI1344_I69_XG I1344_pn3 I1344_gn2 I1344_gn3 I1344_G3_2 VDD VSS OAI21_X1
XI1344_I69_XP I1344_pn3 I1344_pn2 I1344_P3_2 VDD VSS NOR2_X1
XI1344_I70_XG I1344_pn4 I1344_gn3 I1344_gn4 I1344_G4_3 VDD VSS OAI21_X1
XI1344_I70_XP I1344_pn4 I1344_pn3 I1344_P4_3 VDD VSS NOR2_X1
XI1344_I71_XG I1344_pn5 I1344_gn4 I1344_gn5 I1344_G5_4 VDD VSS OAI21_X1
XI1344_I71_XP I1344_pn5 I1344_pn4 I1344_P5_4 VDD VSS NOR2_X1
XI1344_I72_XG I1344_pn6 I1344_gn5 I1344_gn6 I1344_G6_5 VDD VSS OAI21_X1
XI1344_I72_XP I1344_pn6 I1344_pn5 I1344_P6_5 VDD VSS NOR2_X1
XI1344_I73_XG I1344_pn7 I1344_gn6 I1344_gn7 I1344_G7_6 VDD VSS OAI21_X1
XI1344_I73_XP I1344_pn7 I1344_pn6 I1344_P7_6 VDD VSS NOR2_X1
XI1344_I74_XG I1344_pn8 I1344_gn7 I1344_gn8 I1344_G8_7 VDD VSS OAI21_X1
XI1344_I74_XP I1344_pn8 I1344_pn7 I1344_P8_7 VDD VSS NOR2_X1
XI1344_I75_XG I1344_pn9 I1344_gn8 I1344_gn9 I1344_G9_8 VDD VSS OAI21_X1
XI1344_I75_XP I1344_pn9 I1344_pn8 I1344_P9_8 VDD VSS NOR2_X1
XI1344_I76_XG I1344_pn10 I1344_gn9 I1344_gn10 I1344_G10_9 VDD VSS OAI21_X1
XI1344_I76_XP I1344_pn10 I1344_pn9 I1344_P10_9 VDD VSS NOR2_X1
XI1344_I77_XG I1344_pn11 I1344_gn10 I1344_gn11 I1344_G11_10 VDD VSS OAI21_X1
XI1344_I77_XP I1344_pn11 I1344_pn10 I1344_P11_10 VDD VSS NOR2_X1
XI1344_I78_XG I1344_pn12 I1344_gn11 I1344_gn12 I1344_G12_11 VDD VSS OAI21_X1
XI1344_I78_XP I1344_pn12 I1344_pn11 I1344_P12_11 VDD VSS NOR2_X1
XI1344_I79_XG I1344_pn13 I1344_gn12 I1344_gn13 I1344_G13_12 VDD VSS OAI21_X1
XI1344_I79_XP I1344_pn13 I1344_pn12 I1344_P13_12 VDD VSS NOR2_X1
XI1344_I80_XG I1344_pn14 I1344_gn13 I1344_gn14 I1344_G14_13 VDD VSS OAI21_X1
XI1344_I80_XP I1344_pn14 I1344_pn13 I1344_P14_13 VDD VSS NOR2_X1
XI1344_I81_XG I1344_pn15 I1344_gn14 I1344_gn15 I1344_G15_14 VDD VSS OAI21_X1
XI1344_I81_XP I1344_pn15 I1344_pn14 I1344_P15_14 VDD VSS NOR2_X1
XI1344_I82_XG I1344_pn16 I1344_gn15 I1344_gn16 I1344_G16_15 VDD VSS OAI21_X1
XI1344_I82_XP I1344_pn16 I1344_pn15 I1344_P16_15 VDD VSS NOR2_X1
XI1344_I83_XG I1344_pn17 I1344_gn16 I1344_gn17 I1344_G17_16 VDD VSS OAI21_X1
XI1344_I83_XP I1344_pn17 I1344_pn16 I1344_P17_16 VDD VSS NOR2_X1
XI1344_I84_XG I1344_pn18 I1344_gn17 I1344_gn18 I1344_G18_17 VDD VSS OAI21_X1
XI1344_I84_XP I1344_pn18 I1344_pn17 I1344_P18_17 VDD VSS NOR2_X1
XI1344_I85_XG I1344_pn19 I1344_gn18 I1344_gn19 I1344_G19_18 VDD VSS OAI21_X1
XI1344_I85_XP I1344_pn19 I1344_pn18 I1344_P19_18 VDD VSS NOR2_X1
XI1344_I86_XG I1344_pn20 I1344_gn19 I1344_gn20 I1344_G20_19 VDD VSS OAI21_X1
XI1344_I86_XP I1344_pn20 I1344_pn19 I1344_P20_19 VDD VSS NOR2_X1
XI1344_I87_XG I1344_pn21 I1344_gn20 I1344_gn21 I1344_G21_20 VDD VSS OAI21_X1
XI1344_I87_XP I1344_pn21 I1344_pn20 I1344_P21_20 VDD VSS NOR2_X1
XI1344_I88_XG I1344_pn22 I1344_gn21 I1344_gn22 I1344_G22_21 VDD VSS OAI21_X1
XI1344_I88_XP I1344_pn22 I1344_pn21 I1344_P22_21 VDD VSS NOR2_X1
XI1344_I89_XG I1344_pn23 I1344_gn22 I1344_gn23 I1344_G23_22 VDD VSS OAI21_X1
XI1344_I89_XP I1344_pn23 I1344_pn22 I1344_P23_22 VDD VSS NOR2_X1
XI1344_I90_XG I1344_pn24 I1344_gn23 I1344_gn24 I1344_G24_23 VDD VSS OAI21_X1
XI1344_I90_XP I1344_pn24 I1344_pn23 I1344_P24_23 VDD VSS NOR2_X1
XI1344_I91_XG I1344_pn25 I1344_gn24 I1344_gn25 I1344_G25_24 VDD VSS OAI21_X1
XI1344_I91_XP I1344_pn25 I1344_pn24 I1344_P25_24 VDD VSS NOR2_X1
XI1344_I92_XG I1344_pn26 I1344_gn25 I1344_gn26 I1344_G26_25 VDD VSS OAI21_X1
XI1344_I92_XP I1344_pn26 I1344_pn25 I1344_P26_25 VDD VSS NOR2_X1
XI1344_I93_XG I1344_pn27 I1344_gn26 I1344_gn27 I1344_G27_26 VDD VSS OAI21_X1
XI1344_I93_XP I1344_pn27 I1344_pn26 I1344_P27_26 VDD VSS NOR2_X1
XI1344_I94_XG I1344_pn28 I1344_gn27 I1344_gn28 I1344_G28_27 VDD VSS OAI21_X1
XI1344_I94_XP I1344_pn28 I1344_pn27 I1344_P28_27 VDD VSS NOR2_X1
XI1344_I95_XG I1344_pn29 I1344_gn28 I1344_gn29 I1344_G29_28 VDD VSS OAI21_X1
XI1344_I95_XP I1344_pn29 I1344_pn28 I1344_P29_28 VDD VSS NOR2_X1
XI1344_I96_XG I1344_pn30 I1344_gn29 I1344_gn30 I1344_G30_29 VDD VSS OAI21_X1
XI1344_I96_XP I1344_pn30 I1344_pn29 I1344_P30_29 VDD VSS NOR2_X1
XI1344_I97_XG I1344_pn31 I1344_gn30 I1344_gn31 I1344_G31_30 VDD VSS OAI21_X1
XI1344_I97_XP I1344_pn31 I1344_pn30 I1344_P31_30 VDD VSS NOR2_X1
XI1344_I98_XG I1344_P2_1 I1344_G0_0 I1344_G2_1 I1344_G2_0n VDD VSS AOI21_X1
XI1344_I99_XG I1344_P3_2 I1344_G1_0 I1344_G3_2 I1344_G3_0n VDD VSS AOI21_X1
XI1344_I100_XG I1344_P4_3 I1344_G2_1 I1344_G4_3 I1344_G4_1n VDD VSS AOI21_X1
XI1344_I100_XP I1344_P4_3 I1344_P2_1 I1344_P4_1n VDD VSS NAND2_X1
XI1344_I101_XG I1344_P5_4 I1344_G3_2 I1344_G5_4 I1344_G5_2n VDD VSS AOI21_X1
XI1344_I101_XP I1344_P5_4 I1344_P3_2 I1344_P5_2n VDD VSS NAND2_X1
XI1344_I102_XG I1344_P6_5 I1344_G4_3 I1344_G6_5 I1344_G6_3n VDD VSS AOI21_X1
XI1344_I102_XP I1344_P6_5 I1344_P4_3 I1344_P6_3n VDD VSS NAND2_X1
XI1344_I103_XG I1344_P7_6 I1344_G5_4 I1344_G7_6 I1344_G7_4n VDD VSS AOI21_X1
XI1344_I103_XP I1344_P7_6 I1344_P5_4 I1344_P7_4n VDD VSS NAND2_X1
XI1344_I104_XG I1344_P8_7 I1344_G6_5 I1344_G8_7 I1344_G8_5n VDD VSS AOI21_X1
XI1344_I104_XP I1344_P8_7 I1344_P6_5 I1344_P8_5n VDD VSS NAND2_X1
XI1344_I105_XG I1344_P9_8 I1344_G7_6 I1344_G9_8 I1344_G9_6n VDD VSS AOI21_X1
XI1344_I105_XP I1344_P9_8 I1344_P7_6 I1344_P9_6n VDD VSS NAND2_X1
XI1344_I106_XG I1344_P10_9 I1344_G8_7 I1344_G10_9 I1344_G10_7n VDD VSS AOI21_X1
XI1344_I106_XP I1344_P10_9 I1344_P8_7 I1344_P10_7n VDD VSS NAND2_X1
XI1344_I107_XG I1344_P11_10 I1344_G9_8 I1344_G11_10 I1344_G11_8n VDD VSS AOI21_X1
XI1344_I107_XP I1344_P11_10 I1344_P9_8 I1344_P11_8n VDD VSS NAND2_X1
XI1344_I108_XG I1344_P12_11 I1344_G10_9 I1344_G12_11 I1344_G12_9n VDD VSS AOI21_X1
XI1344_I108_XP I1344_P12_11 I1344_P10_9 I1344_P12_9n VDD VSS NAND2_X1
XI1344_I109_XG I1344_P13_12 I1344_G11_10 I1344_G13_12 I1344_G13_10n VDD VSS AOI21_X1
XI1344_I109_XP I1344_P13_12 I1344_P11_10 I1344_P13_10n VDD VSS NAND2_X1
XI1344_I110_XG I1344_P14_13 I1344_G12_11 I1344_G14_13 I1344_G14_11n VDD VSS AOI21_X1
XI1344_I110_XP I1344_P14_13 I1344_P12_11 I1344_P14_11n VDD VSS NAND2_X1
XI1344_I111_XG I1344_P15_14 I1344_G13_12 I1344_G15_14 I1344_G15_12n VDD VSS AOI21_X1
XI1344_I111_XP I1344_P15_14 I1344_P13_12 I1344_P15_12n VDD VSS NAND2_X1
XI1344_I112_XG I1344_P16_15 I1344_G14_13 I1344_G16_15 I1344_G16_13n VDD VSS AOI21_X1
XI1344_I112_XP I1344_P16_15 I1344_P14_13 I1344_P16_13n VDD VSS NAND2_X1
XI1344_I113_XG I1344_P17_16 I1344_G15_14 I1344_G17_16 I1344_G17_14n VDD VSS AOI21_X1
XI1344_I113_XP I1344_P17_16 I1344_P15_14 I1344_P17_14n VDD VSS NAND2_X1
XI1344_I114_XG I1344_P18_17 I1344_G16_15 I1344_G18_17 I1344_G18_15n VDD VSS AOI21_X1
XI1344_I114_XP I1344_P18_17 I1344_P16_15 I1344_P18_15n VDD VSS NAND2_X1
XI1344_I115_XG I1344_P19_18 I1344_G17_16 I1344_G19_18 I1344_G19_16n VDD VSS AOI21_X1
XI1344_I115_XP I1344_P19_18 I1344_P17_16 I1344_P19_16n VDD VSS NAND2_X1
XI1344_I116_XG I1344_P20_19 I1344_G18_17 I1344_G20_19 I1344_G20_17n VDD VSS AOI21_X1
XI1344_I116_XP I1344_P20_19 I1344_P18_17 I1344_P20_17n VDD VSS NAND2_X1
XI1344_I117_XG I1344_P21_20 I1344_G19_18 I1344_G21_20 I1344_G21_18n VDD VSS AOI21_X1
XI1344_I117_XP I1344_P21_20 I1344_P19_18 I1344_P21_18n VDD VSS NAND2_X1
XI1344_I118_XG I1344_P22_21 I1344_G20_19 I1344_G22_21 I1344_G22_19n VDD VSS AOI21_X1
XI1344_I118_XP I1344_P22_21 I1344_P20_19 I1344_P22_19n VDD VSS NAND2_X1
XI1344_I119_XG I1344_P23_22 I1344_G21_20 I1344_G23_22 I1344_G23_20n VDD VSS AOI21_X1
XI1344_I119_XP I1344_P23_22 I1344_P21_20 I1344_P23_20n VDD VSS NAND2_X1
XI1344_I120_XG I1344_P24_23 I1344_G22_21 I1344_G24_23 I1344_G24_21n VDD VSS AOI21_X1
XI1344_I120_XP I1344_P24_23 I1344_P22_21 I1344_P24_21n VDD VSS NAND2_X1
XI1344_I121_XG I1344_P25_24 I1344_G23_22 I1344_G25_24 I1344_G25_22n VDD VSS AOI21_X1
XI1344_I121_XP I1344_P25_24 I1344_P23_22 I1344_P25_22n VDD VSS NAND2_X1
XI1344_I122_XG I1344_P26_25 I1344_G24_23 I1344_G26_25 I1344_G26_23n VDD VSS AOI21_X1
XI1344_I122_XP I1344_P26_25 I1344_P24_23 I1344_P26_23n VDD VSS NAND2_X1
XI1344_I123_XG I1344_P27_26 I1344_G25_24 I1344_G27_26 I1344_G27_24n VDD VSS AOI21_X1
XI1344_I123_XP I1344_P27_26 I1344_P25_24 I1344_P27_24n VDD VSS NAND2_X1
XI1344_I124_XG I1344_P28_27 I1344_G26_25 I1344_G28_27 I1344_G28_25n VDD VSS AOI21_X1
XI1344_I124_XP I1344_P28_27 I1344_P26_25 I1344_P28_25n VDD VSS NAND2_X1
XI1344_I125_XG I1344_P29_28 I1344_G27_26 I1344_G29_28 I1344_G29_26n VDD VSS AOI21_X1
XI1344_I125_XP I1344_P29_28 I1344_P27_26 I1344_P29_26n VDD VSS NAND2_X1
XI1344_I126_XG I1344_P30_29 I1344_G28_27 I1344_G30_29 I1344_G30_27n VDD VSS AOI21_X1
XI1344_I126_XP I1344_P30_29 I1344_P28_27 I1344_P30_27n VDD VSS NAND2_X1
XI1344_I127_XG I1344_P31_30 I1344_G29_28 I1344_G31_30 I1344_G31_28n VDD VSS AOI21_X1
XI1344_I127_XP I1344_P31_30 I1344_P29_28 I1344_P31_28n VDD VSS NAND2_X1
XI1344_I128_XG I1344_P4_1n I1344_G0_0n I1344_G4_1n I1344_G4_0 VDD VSS OAI21_X1
XI1344_I129 I1344_G1_0 I1344_G1_0n VDD VSS INV_X1
XI1344_I130_XG I1344_P5_2n I1344_G1_0n I1344_G5_2n I1344_G5_0 VDD VSS OAI21_X1
XI1344_I131_XG I1344_P6_3n I1344_G2_0n I1344_G6_3n I1344_G6_0 VDD VSS OAI21_X1
XI1344_I132_XG I1344_P7_4n I1344_G3_0n I1344_G7_4n I1344_G7_0 VDD VSS OAI21_X1
XI1344_I133_XG I1344_P8_5n I1344_G4_1n I1344_G8_5n I1344_G8_1 VDD VSS OAI21_X1
XI1344_I133_XP I1344_P8_5n I1344_P4_1n I1344_P8_1 VDD VSS NOR2_X1
XI1344_I134_XG I1344_P9_6n I1344_G5_2n I1344_G9_6n I1344_G9_2 VDD VSS OAI21_X1
XI1344_I134_XP I1344_P9_6n I1344_P5_2n I1344_P9_2 VDD VSS NOR2_X1
XI1344_I135_XG I1344_P10_7n I1344_G6_3n I1344_G10_7n I1344_G10_3 VDD VSS OAI21_X1
XI1344_I135_XP I1344_P10_7n I1344_P6_3n I1344_P10_3 VDD VSS NOR2_X1
XI1344_I136_XG I1344_P11_8n I1344_G7_4n I1344_G11_8n I1344_G11_4 VDD VSS OAI21_X1
XI1344_I136_XP I1344_P11_8n I1344_P7_4n I1344_P11_4 VDD VSS NOR2_X1
XI1344_I137_XG I1344_P12_9n I1344_G8_5n I1344_G12_9n I1344_G12_5 VDD VSS OAI21_X1
XI1344_I137_XP I1344_P12_9n I1344_P8_5n I1344_P12_5 VDD VSS NOR2_X1
XI1344_I138_XG I1344_P13_10n I1344_G9_6n I1344_G13_10n I1344_G13_6 VDD VSS OAI21_X1
XI1344_I138_XP I1344_P13_10n I1344_P9_6n I1344_P13_6 VDD VSS NOR2_X1
XI1344_I139_XG I1344_P14_11n I1344_G10_7n I1344_G14_11n I1344_G14_7 VDD VSS OAI21_X1
XI1344_I139_XP I1344_P14_11n I1344_P10_7n I1344_P14_7 VDD VSS NOR2_X1
XI1344_I140_XG I1344_P15_12n I1344_G11_8n I1344_G15_12n I1344_G15_8 VDD VSS OAI21_X1
XI1344_I140_XP I1344_P15_12n I1344_P11_8n I1344_P15_8 VDD VSS NOR2_X1
XI1344_I141_XG I1344_P16_13n I1344_G12_9n I1344_G16_13n I1344_G16_9 VDD VSS OAI21_X1
XI1344_I141_XP I1344_P16_13n I1344_P12_9n I1344_P16_9 VDD VSS NOR2_X1
XI1344_I142_XG I1344_P17_14n I1344_G13_10n I1344_G17_14n I1344_G17_10 VDD VSS OAI21_X1
XI1344_I142_XP I1344_P17_14n I1344_P13_10n I1344_P17_10 VDD VSS NOR2_X1
XI1344_I143_XG I1344_P18_15n I1344_G14_11n I1344_G18_15n I1344_G18_11 VDD VSS OAI21_X1
XI1344_I143_XP I1344_P18_15n I1344_P14_11n I1344_P18_11 VDD VSS NOR2_X1
XI1344_I144_XG I1344_P19_16n I1344_G15_12n I1344_G19_16n I1344_G19_12 VDD VSS OAI21_X1
XI1344_I144_XP I1344_P19_16n I1344_P15_12n I1344_P19_12 VDD VSS NOR2_X1
XI1344_I145_XG I1344_P20_17n I1344_G16_13n I1344_G20_17n I1344_G20_13 VDD VSS OAI21_X1
XI1344_I145_XP I1344_P20_17n I1344_P16_13n I1344_P20_13 VDD VSS NOR2_X1
XI1344_I146_XG I1344_P21_18n I1344_G17_14n I1344_G21_18n I1344_G21_14 VDD VSS OAI21_X1
XI1344_I146_XP I1344_P21_18n I1344_P17_14n I1344_P21_14 VDD VSS NOR2_X1
XI1344_I147_XG I1344_P22_19n I1344_G18_15n I1344_G22_19n I1344_G22_15 VDD VSS OAI21_X1
XI1344_I147_XP I1344_P22_19n I1344_P18_15n I1344_P22_15 VDD VSS NOR2_X1
XI1344_I148_XG I1344_P23_20n I1344_G19_16n I1344_G23_20n I1344_G23_16 VDD VSS OAI21_X1
XI1344_I148_XP I1344_P23_20n I1344_P19_16n I1344_P23_16 VDD VSS NOR2_X1
XI1344_I149_XG I1344_P24_21n I1344_G20_17n I1344_G24_21n I1344_G24_17 VDD VSS OAI21_X1
XI1344_I149_XP I1344_P24_21n I1344_P20_17n I1344_P24_17 VDD VSS NOR2_X1
XI1344_I150_XG I1344_P25_22n I1344_G21_18n I1344_G25_22n I1344_G25_18 VDD VSS OAI21_X1
XI1344_I150_XP I1344_P25_22n I1344_P21_18n I1344_P25_18 VDD VSS NOR2_X1
XI1344_I151_XG I1344_P26_23n I1344_G22_19n I1344_G26_23n I1344_G26_19 VDD VSS OAI21_X1
XI1344_I151_XP I1344_P26_23n I1344_P22_19n I1344_P26_19 VDD VSS NOR2_X1
XI1344_I152_XG I1344_P27_24n I1344_G23_20n I1344_G27_24n I1344_G27_20 VDD VSS OAI21_X1
XI1344_I152_XP I1344_P27_24n I1344_P23_20n I1344_P27_20 VDD VSS NOR2_X1
XI1344_I153_XG I1344_P28_25n I1344_G24_21n I1344_G28_25n I1344_G28_21 VDD VSS OAI21_X1
XI1344_I153_XP I1344_P28_25n I1344_P24_21n I1344_P28_21 VDD VSS NOR2_X1
XI1344_I154_XG I1344_P29_26n I1344_G25_22n I1344_G29_26n I1344_G29_22 VDD VSS OAI21_X1
XI1344_I154_XP I1344_P29_26n I1344_P25_22n I1344_P29_22 VDD VSS NOR2_X1
XI1344_I155_XG I1344_P30_27n I1344_G26_23n I1344_G30_27n I1344_G30_23 VDD VSS OAI21_X1
XI1344_I155_XP I1344_P30_27n I1344_P26_23n I1344_P30_23 VDD VSS NOR2_X1
XI1344_I156_XG I1344_P31_28n I1344_G27_24n I1344_G31_28n I1344_G31_24 VDD VSS OAI21_X1
XI1344_I156_XP I1344_P31_28n I1344_P27_24n I1344_P31_24 VDD VSS NOR2_X1
XI1344_I157_XG I1344_P8_1 I1344_G0_0 I1344_G8_1 I1344_G8_0n VDD VSS AOI21_X1
XI1344_I158_XG I1344_P9_2 I1344_G1_0 I1344_G9_2 I1344_G9_0n VDD VSS AOI21_X1
XI1344_I159 I1344_G2_0n I1344_G2_0np VDD VSS INV_X1
XI1344_I160_XG I1344_P10_3 I1344_G2_0np I1344_G10_3 I1344_G10_0n VDD VSS AOI21_X1
XI1344_I161 I1344_G3_0n I1344_G3_0np VDD VSS INV_X1
XI1344_I162_XG I1344_P11_4 I1344_G3_0np I1344_G11_4 I1344_G11_0n VDD VSS AOI21_X1
XI1344_I163_XG I1344_P12_5 I1344_G4_0 I1344_G12_5 I1344_G12_0n VDD VSS AOI21_X1
XI1344_I164_XG I1344_P13_6 I1344_G5_0 I1344_G13_6 I1344_G13_0n VDD VSS AOI21_X1
XI1344_I165_XG I1344_P14_7 I1344_G6_0 I1344_G14_7 I1344_G14_0n VDD VSS AOI21_X1
XI1344_I166_XG I1344_P15_8 I1344_G7_0 I1344_G15_8 I1344_G15_0n VDD VSS AOI21_X1
XI1344_I167_XG I1344_P16_9 I1344_G8_1 I1344_G16_9 I1344_G16_1n VDD VSS AOI21_X1
XI1344_I167_XP I1344_P16_9 I1344_P8_1 I1344_P16_1n VDD VSS NAND2_X1
XI1344_I168_XG I1344_P17_10 I1344_G9_2 I1344_G17_10 I1344_G17_2n VDD VSS AOI21_X1
XI1344_I168_XP I1344_P17_10 I1344_P9_2 I1344_P17_2n VDD VSS NAND2_X1
XI1344_I169_XG I1344_P18_11 I1344_G10_3 I1344_G18_11 I1344_G18_3n VDD VSS AOI21_X1
XI1344_I169_XP I1344_P18_11 I1344_P10_3 I1344_P18_3n VDD VSS NAND2_X1
XI1344_I170_XG I1344_P19_12 I1344_G11_4 I1344_G19_12 I1344_G19_4n VDD VSS AOI21_X1
XI1344_I170_XP I1344_P19_12 I1344_P11_4 I1344_P19_4n VDD VSS NAND2_X1
XI1344_I171_XG I1344_P20_13 I1344_G12_5 I1344_G20_13 I1344_G20_5n VDD VSS AOI21_X1
XI1344_I171_XP I1344_P20_13 I1344_P12_5 I1344_P20_5n VDD VSS NAND2_X1
XI1344_I172_XG I1344_P21_14 I1344_G13_6 I1344_G21_14 I1344_G21_6n VDD VSS AOI21_X1
XI1344_I172_XP I1344_P21_14 I1344_P13_6 I1344_P21_6n VDD VSS NAND2_X1
XI1344_I173_XG I1344_P22_15 I1344_G14_7 I1344_G22_15 I1344_G22_7n VDD VSS AOI21_X1
XI1344_I173_XP I1344_P22_15 I1344_P14_7 I1344_P22_7n VDD VSS NAND2_X1
XI1344_I174_XG I1344_P23_16 I1344_G15_8 I1344_G23_16 I1344_G23_8n VDD VSS AOI21_X1
XI1344_I174_XP I1344_P23_16 I1344_P15_8 I1344_P23_8n VDD VSS NAND2_X1
XI1344_I175_XG I1344_P24_17 I1344_G16_9 I1344_G24_17 I1344_G24_9n VDD VSS AOI21_X1
XI1344_I175_XP I1344_P24_17 I1344_P16_9 I1344_P24_9n VDD VSS NAND2_X1
XI1344_I176_XG I1344_P25_18 I1344_G17_10 I1344_G25_18 I1344_G25_10n VDD VSS AOI21_X1
XI1344_I176_XP I1344_P25_18 I1344_P17_10 I1344_P25_10n VDD VSS NAND2_X1
XI1344_I177_XG I1344_P26_19 I1344_G18_11 I1344_G26_19 I1344_G26_11n VDD VSS AOI21_X1
XI1344_I177_XP I1344_P26_19 I1344_P18_11 I1344_P26_11n VDD VSS NAND2_X1
XI1344_I178_XG I1344_P27_20 I1344_G19_12 I1344_G27_20 I1344_G27_12n VDD VSS AOI21_X1
XI1344_I178_XP I1344_P27_20 I1344_P19_12 I1344_P27_12n VDD VSS NAND2_X1
XI1344_I179_XG I1344_P28_21 I1344_G20_13 I1344_G28_21 I1344_G28_13n VDD VSS AOI21_X1
XI1344_I179_XP I1344_P28_21 I1344_P20_13 I1344_P28_13n VDD VSS NAND2_X1
XI1344_I180_XG I1344_P29_22 I1344_G21_14 I1344_G29_22 I1344_G29_14n VDD VSS AOI21_X1
XI1344_I180_XP I1344_P29_22 I1344_P21_14 I1344_P29_14n VDD VSS NAND2_X1
XI1344_I181_XG I1344_P30_23 I1344_G22_15 I1344_G30_23 I1344_G30_15n VDD VSS AOI21_X1
XI1344_I181_XP I1344_P30_23 I1344_P22_15 I1344_P30_15n VDD VSS NAND2_X1
XI1344_I182_XG I1344_P31_24 I1344_G23_16 I1344_G31_24 I1344_G31_16n VDD VSS AOI21_X1
XI1344_I182_XP I1344_P31_24 I1344_P23_16 I1344_P31_16n VDD VSS NAND2_X1
XI1344_I183_XG I1344_P16_1n I1344_G0_0n I1344_G16_1n I1344_G16_0 VDD VSS OAI21_X1
XI1344_I184_XG I1344_P17_2n I1344_G1_0n I1344_G17_2n I1344_G17_0 VDD VSS OAI21_X1
XI1344_I185_XG I1344_P18_3n I1344_G2_0n I1344_G18_3n I1344_G18_0 VDD VSS OAI21_X1
XI1344_I186_XG I1344_P19_4n I1344_G3_0n I1344_G19_4n I1344_G19_0 VDD VSS OAI21_X1
XI1344_I187 I1344_G4_0 I1344_G4_0n VDD VSS INV_X1
XI1344_I188_XG I1344_P20_5n I1344_G4_0n I1344_G20_5n I1344_G20_0 VDD VSS OAI21_X1
XI1344_I189 I1344_G5_0 I1344_G5_0n VDD VSS INV_X1
XI1344_I190_XG I1344_P21_6n I1344_G5_0n I1344_G21_6n I1344_G21_0 VDD VSS OAI21_X1
XI1344_I191 I1344_G6_0 I1344_G6_0n VDD VSS INV_X1
XI1344_I192_XG I1344_P22_7n I1344_G6_0n I1344_G22_7n I1344_G22_0 VDD VSS OAI21_X1
XI1344_I193 I1344_G7_0 I1344_G7_0n VDD VSS INV_X1
XI1344_I194_XG I1344_P23_8n I1344_G7_0n I1344_G23_8n I1344_G23_0 VDD VSS OAI21_X1
XI1344_I195_XG I1344_P24_9n I1344_G8_0n I1344_G24_9n I1344_G24_0 VDD VSS OAI21_X1
XI1344_I196_XG I1344_P25_10n I1344_G9_0n I1344_G25_10n I1344_G25_0 VDD VSS OAI21_X1
XI1344_I197_XG I1344_P26_11n I1344_G10_0n I1344_G26_11n I1344_G26_0 VDD VSS OAI21_X1
XI1344_I198_XG I1344_P27_12n I1344_G11_0n I1344_G27_12n I1344_G27_0 VDD VSS OAI21_X1
XI1344_I199_XG I1344_P28_13n I1344_G12_0n I1344_G28_13n I1344_G28_0 VDD VSS OAI21_X1
XI1344_I200_XG I1344_P29_14n I1344_G13_0n I1344_G29_14n I1344_G29_0 VDD VSS OAI21_X1
XI1344_I201_XG I1344_P30_15n I1344_G14_0n I1344_G30_15n c17_m VDD VSS OAI21_X1
XI1344_I202_XG I1344_P31_16n I1344_G15_0n I1344_G31_16n c17_o VDD VSS OAI21_X1
XI1344_I203 I1344_pn0 qu15_b3_5 p17_0 VDD VSS XNOR2_X1
XI1344_I204 I1344_pn1 I1344_G0_0 p17_1 VDD VSS XNOR2_X1
XI1344_I205 I1344_pn2 I1344_G1_0 p17_2 VDD VSS XNOR2_X1
XI1344_I206 I1344_pn3 I1344_G2_0n p17_3 VDD VSS XOR2_X1
XI1344_I207 I1344_pn4 I1344_G3_0n p17_4 VDD VSS XOR2_X1
XI1344_I208 I1344_pn5 I1344_G4_0 p17_5 VDD VSS XNOR2_X1
XI1344_I209 I1344_pn6 I1344_G5_0 p17_6 VDD VSS XNOR2_X1
XI1344_I210 I1344_pn7 I1344_G6_0 p17_7 VDD VSS XNOR2_X1
XI1344_I211 I1344_pn8 I1344_G7_0 p17_8 VDD VSS XNOR2_X1
XI1344_I212 I1344_pn9 I1344_G8_0n p17_9 VDD VSS XOR2_X1
XI1344_I213 I1344_pn10 I1344_G9_0n p17_10 VDD VSS XOR2_X1
XI1344_I214 I1344_pn11 I1344_G10_0n p17_11 VDD VSS XOR2_X1
XI1344_I215 I1344_pn12 I1344_G11_0n p17_12 VDD VSS XOR2_X1
XI1344_I216 I1344_pn13 I1344_G12_0n p17_13 VDD VSS XOR2_X1
XI1344_I217 I1344_pn14 I1344_G13_0n p17_14 VDD VSS XOR2_X1
XI1344_I218 I1344_pn15 I1344_G14_0n p17_15 VDD VSS XOR2_X1
XI1344_I219 I1344_pn16 I1344_G15_0n p17_16 VDD VSS XOR2_X1
XI1344_I220 I1344_pn17 I1344_G16_0 p17_17 VDD VSS XNOR2_X1
XI1344_I221 I1344_pn18 I1344_G17_0 p17_18 VDD VSS XNOR2_X1
XI1344_I222 I1344_pn19 I1344_G18_0 p17_19 VDD VSS XNOR2_X1
XI1344_I223 I1344_pn20 I1344_G19_0 p17_20 VDD VSS XNOR2_X1
XI1344_I224 I1344_pn21 I1344_G20_0 p17_21 VDD VSS XNOR2_X1
XI1344_I225 I1344_pn22 I1344_G21_0 p17_22 VDD VSS XNOR2_X1
XI1344_I226 I1344_pn23 I1344_G22_0 p17_23 VDD VSS XNOR2_X1
XI1344_I227 I1344_pn24 I1344_G23_0 p17_24 VDD VSS XNOR2_X1
XI1344_I228 I1344_pn25 I1344_G24_0 p17_25 VDD VSS XNOR2_X1
XI1344_I229 I1344_pn26 I1344_G25_0 p17_26 VDD VSS XNOR2_X1
XI1344_I230 I1344_pn27 I1344_G26_0 p17_27 VDD VSS XNOR2_X1
XI1344_I231 I1344_pn28 I1344_G27_0 p17_28 VDD VSS XNOR2_X1
XI1344_I232 I1344_pn29 I1344_G28_0 p17_29 VDD VSS XNOR2_X1
XI1344_I233 I1344_pn30 I1344_G29_0 p17_30 VDD VSS XNOR2_X1
XI1344_I234 I1344_pn31 c17_m p17_31 VDD VSS XNOR2_X1
XI1345 p16_31 qu15_b3_5 h17 VDD VSS XOR2_X1
XI1346 h17 c17_o p17_32 VDD VSS XOR2_X1
XI1347 p17_32 qu14 VDD VSS INV_X4
XI1348 qu14 qu14_b0 VDD VSS INV_X1
XI1349 qu14_b0 qu14_b1_0 VDD VSS INV_X4
XI1350 qu14_b1_0 qu14_b2_0 VDD VSS INV_X4
XI1351 qu14_b1_0 qu14_b2_1 VDD VSS INV_X4
XI1352 qu14_b2_0 qu14_b3_0 VDD VSS INV_X4
XI1353 qu14_b2_0 qu14_b3_1 VDD VSS INV_X4
XI1354 qu14_b2_0 qu14_b3_2 VDD VSS INV_X4
XI1355 qu14_b2_1 qu14_b3_3 VDD VSS INV_X4
XI1356 qu14_b2_1 qu14_b3_4 VDD VSS INV_X4
XI1357 qu14_b2_1 qu14_b3_5 VDD VSS INV_X4
XI1358 B_0_b3_3 qu14_b3_0 b18_0 VDD VSS XOR2_X1
XI1359 dd1_b3_3 qu14_b3_0 b18_1 VDD VSS XOR2_X1
XI1360 dd2_b3_3 qu14_b3_0 b18_2 VDD VSS XOR2_X1
XI1361 dd3_b3_3 qu14_b3_0 b18_3 VDD VSS XOR2_X1
XI1362 dd4_b3_3 qu14_b3_0 b18_4 VDD VSS XOR2_X1
XI1363 dd5_b3_3 qu14_b3_0 b18_5 VDD VSS XOR2_X1
XI1364 dd6_b3_3 qu14_b3_1 b18_6 VDD VSS XOR2_X1
XI1365 dd7_b3_3 qu14_b3_1 b18_7 VDD VSS XOR2_X1
XI1366 dd8_b3_3 qu14_b3_1 b18_8 VDD VSS XOR2_X1
XI1367 dd9_b3_3 qu14_b3_1 b18_9 VDD VSS XOR2_X1
XI1368 dd10_b3_3 qu14_b3_1 b18_10 VDD VSS XOR2_X1
XI1369 dd11_b3_3 qu14_b3_1 b18_11 VDD VSS XOR2_X1
XI1370 dd12_b3_3 qu14_b3_2 b18_12 VDD VSS XOR2_X1
XI1371 dd13_b3_3 qu14_b3_2 b18_13 VDD VSS XOR2_X1
XI1372 dd14_b3_3 qu14_b3_2 b18_14 VDD VSS XOR2_X1
XI1373 dd15_b3_3 qu14_b3_2 b18_15 VDD VSS XOR2_X1
XI1374 dd16_b3_3 qu14_b3_2 b18_16 VDD VSS XOR2_X1
XI1375 dd17_b3_3 qu14_b3_2 b18_17 VDD VSS XOR2_X1
XI1376 dd18_b3_3 qu14_b3_3 b18_18 VDD VSS XOR2_X1
XI1377 dd19_b3_3 qu14_b3_3 b18_19 VDD VSS XOR2_X1
XI1378 dd20_b3_3 qu14_b3_3 b18_20 VDD VSS XOR2_X1
XI1379 dd21_b3_3 qu14_b3_3 b18_21 VDD VSS XOR2_X1
XI1380 dd22_b3_3 qu14_b3_3 b18_22 VDD VSS XOR2_X1
XI1381 dd23_b3_3 qu14_b3_3 b18_23 VDD VSS XOR2_X1
XI1382 dd24_b3_3 qu14_b3_4 b18_24 VDD VSS XOR2_X1
XI1383 dd25_b3_3 qu14_b3_4 b18_25 VDD VSS XOR2_X1
XI1384 dd26_b3_3 qu14_b3_4 b18_26 VDD VSS XOR2_X1
XI1385 dd27_b3_3 qu14_b3_4 b18_27 VDD VSS XOR2_X1
XI1386 dd28_b3_3 qu14_b3_4 b18_28 VDD VSS XOR2_X1
XI1387 dd29_b3_3 qu14_b3_4 b18_29 VDD VSS XOR2_X1
XI1388 dd30_b3_3 qu14_b3_5 b18_30 VDD VSS XOR2_X1
XI1389 dd31_b3_3 qu14_b3_5 b18_31 VDD VSS XOR2_X1
XI1390_I0 aa13 b18_0 I1390_gn0 VDD VSS NAND2_X1
XI1390_I1 p17_0 b18_1 I1390_gn1 VDD VSS NAND2_X1
XI1390_I2 p17_1 b18_2 I1390_gn2 VDD VSS NAND2_X1
XI1390_I3 p17_2 b18_3 I1390_gn3 VDD VSS NAND2_X1
XI1390_I4 p17_3 b18_4 I1390_gn4 VDD VSS NAND2_X1
XI1390_I5 p17_4 b18_5 I1390_gn5 VDD VSS NAND2_X1
XI1390_I6 p17_5 b18_6 I1390_gn6 VDD VSS NAND2_X1
XI1390_I7 p17_6 b18_7 I1390_gn7 VDD VSS NAND2_X1
XI1390_I8 p17_7 b18_8 I1390_gn8 VDD VSS NAND2_X1
XI1390_I9 p17_8 b18_9 I1390_gn9 VDD VSS NAND2_X1
XI1390_I10 p17_9 b18_10 I1390_gn10 VDD VSS NAND2_X1
XI1390_I11 p17_10 b18_11 I1390_gn11 VDD VSS NAND2_X1
XI1390_I12 p17_11 b18_12 I1390_gn12 VDD VSS NAND2_X1
XI1390_I13 p17_12 b18_13 I1390_gn13 VDD VSS NAND2_X1
XI1390_I14 p17_13 b18_14 I1390_gn14 VDD VSS NAND2_X1
XI1390_I15 p17_14 b18_15 I1390_gn15 VDD VSS NAND2_X1
XI1390_I16 p17_15 b18_16 I1390_gn16 VDD VSS NAND2_X1
XI1390_I17 p17_16 b18_17 I1390_gn17 VDD VSS NAND2_X1
XI1390_I18 p17_17 b18_18 I1390_gn18 VDD VSS NAND2_X1
XI1390_I19 p17_18 b18_19 I1390_gn19 VDD VSS NAND2_X1
XI1390_I20 p17_19 b18_20 I1390_gn20 VDD VSS NAND2_X1
XI1390_I21 p17_20 b18_21 I1390_gn21 VDD VSS NAND2_X1
XI1390_I22 p17_21 b18_22 I1390_gn22 VDD VSS NAND2_X1
XI1390_I23 p17_22 b18_23 I1390_gn23 VDD VSS NAND2_X1
XI1390_I24 p17_23 b18_24 I1390_gn24 VDD VSS NAND2_X1
XI1390_I25 p17_24 b18_25 I1390_gn25 VDD VSS NAND2_X1
XI1390_I26 p17_25 b18_26 I1390_gn26 VDD VSS NAND2_X1
XI1390_I27 p17_26 b18_27 I1390_gn27 VDD VSS NAND2_X1
XI1390_I28 p17_27 b18_28 I1390_gn28 VDD VSS NAND2_X1
XI1390_I29 p17_28 b18_29 I1390_gn29 VDD VSS NAND2_X1
XI1390_I30 p17_29 b18_30 I1390_gn30 VDD VSS NAND2_X1
XI1390_I31 p17_30 b18_31 I1390_gn31 VDD VSS NAND2_X1
XI1390_I32 aa13 b18_0 I1390_pn0 VDD VSS XNOR2_X1
XI1390_I33 p17_0 b18_1 I1390_pn1 VDD VSS XNOR2_X1
XI1390_I34 p17_1 b18_2 I1390_pn2 VDD VSS XNOR2_X1
XI1390_I35 p17_2 b18_3 I1390_pn3 VDD VSS XNOR2_X1
XI1390_I36 p17_3 b18_4 I1390_pn4 VDD VSS XNOR2_X1
XI1390_I37 p17_4 b18_5 I1390_pn5 VDD VSS XNOR2_X1
XI1390_I38 p17_5 b18_6 I1390_pn6 VDD VSS XNOR2_X1
XI1390_I39 p17_6 b18_7 I1390_pn7 VDD VSS XNOR2_X1
XI1390_I40 p17_7 b18_8 I1390_pn8 VDD VSS XNOR2_X1
XI1390_I41 p17_8 b18_9 I1390_pn9 VDD VSS XNOR2_X1
XI1390_I42 p17_9 b18_10 I1390_pn10 VDD VSS XNOR2_X1
XI1390_I43 p17_10 b18_11 I1390_pn11 VDD VSS XNOR2_X1
XI1390_I44 p17_11 b18_12 I1390_pn12 VDD VSS XNOR2_X1
XI1390_I45 p17_12 b18_13 I1390_pn13 VDD VSS XNOR2_X1
XI1390_I46 p17_13 b18_14 I1390_pn14 VDD VSS XNOR2_X1
XI1390_I47 p17_14 b18_15 I1390_pn15 VDD VSS XNOR2_X1
XI1390_I48 p17_15 b18_16 I1390_pn16 VDD VSS XNOR2_X1
XI1390_I49 p17_16 b18_17 I1390_pn17 VDD VSS XNOR2_X1
XI1390_I50 p17_17 b18_18 I1390_pn18 VDD VSS XNOR2_X1
XI1390_I51 p17_18 b18_19 I1390_pn19 VDD VSS XNOR2_X1
XI1390_I52 p17_19 b18_20 I1390_pn20 VDD VSS XNOR2_X1
XI1390_I53 p17_20 b18_21 I1390_pn21 VDD VSS XNOR2_X1
XI1390_I54 p17_21 b18_22 I1390_pn22 VDD VSS XNOR2_X1
XI1390_I55 p17_22 b18_23 I1390_pn23 VDD VSS XNOR2_X1
XI1390_I56 p17_23 b18_24 I1390_pn24 VDD VSS XNOR2_X1
XI1390_I57 p17_24 b18_25 I1390_pn25 VDD VSS XNOR2_X1
XI1390_I58 p17_25 b18_26 I1390_pn26 VDD VSS XNOR2_X1
XI1390_I59 p17_26 b18_27 I1390_pn27 VDD VSS XNOR2_X1
XI1390_I60 p17_27 b18_28 I1390_pn28 VDD VSS XNOR2_X1
XI1390_I61 p17_28 b18_29 I1390_pn29 VDD VSS XNOR2_X1
XI1390_I62 p17_29 b18_30 I1390_pn30 VDD VSS XNOR2_X1
XI1390_I63 p17_30 b18_31 I1390_pn31 VDD VSS XNOR2_X1
XI1390_I64 qu14_b3_5 I1390_cinn VDD VSS INV_X1
XI1390_I65_XG I1390_pn0 I1390_cinn I1390_gn0 I1390_G0_0 VDD VSS OAI21_X1
XI1390_I66 I1390_G0_0 I1390_G0_0n VDD VSS INV_X1
XI1390_I67_XG I1390_pn1 I1390_G0_0n I1390_gn1 I1390_G1_0 VDD VSS OAI21_X1
XI1390_I68_XG I1390_pn2 I1390_gn1 I1390_gn2 I1390_G2_1 VDD VSS OAI21_X1
XI1390_I68_XP I1390_pn2 I1390_pn1 I1390_P2_1 VDD VSS NOR2_X1
XI1390_I69_XG I1390_pn3 I1390_gn2 I1390_gn3 I1390_G3_2 VDD VSS OAI21_X1
XI1390_I69_XP I1390_pn3 I1390_pn2 I1390_P3_2 VDD VSS NOR2_X1
XI1390_I70_XG I1390_pn4 I1390_gn3 I1390_gn4 I1390_G4_3 VDD VSS OAI21_X1
XI1390_I70_XP I1390_pn4 I1390_pn3 I1390_P4_3 VDD VSS NOR2_X1
XI1390_I71_XG I1390_pn5 I1390_gn4 I1390_gn5 I1390_G5_4 VDD VSS OAI21_X1
XI1390_I71_XP I1390_pn5 I1390_pn4 I1390_P5_4 VDD VSS NOR2_X1
XI1390_I72_XG I1390_pn6 I1390_gn5 I1390_gn6 I1390_G6_5 VDD VSS OAI21_X1
XI1390_I72_XP I1390_pn6 I1390_pn5 I1390_P6_5 VDD VSS NOR2_X1
XI1390_I73_XG I1390_pn7 I1390_gn6 I1390_gn7 I1390_G7_6 VDD VSS OAI21_X1
XI1390_I73_XP I1390_pn7 I1390_pn6 I1390_P7_6 VDD VSS NOR2_X1
XI1390_I74_XG I1390_pn8 I1390_gn7 I1390_gn8 I1390_G8_7 VDD VSS OAI21_X1
XI1390_I74_XP I1390_pn8 I1390_pn7 I1390_P8_7 VDD VSS NOR2_X1
XI1390_I75_XG I1390_pn9 I1390_gn8 I1390_gn9 I1390_G9_8 VDD VSS OAI21_X1
XI1390_I75_XP I1390_pn9 I1390_pn8 I1390_P9_8 VDD VSS NOR2_X1
XI1390_I76_XG I1390_pn10 I1390_gn9 I1390_gn10 I1390_G10_9 VDD VSS OAI21_X1
XI1390_I76_XP I1390_pn10 I1390_pn9 I1390_P10_9 VDD VSS NOR2_X1
XI1390_I77_XG I1390_pn11 I1390_gn10 I1390_gn11 I1390_G11_10 VDD VSS OAI21_X1
XI1390_I77_XP I1390_pn11 I1390_pn10 I1390_P11_10 VDD VSS NOR2_X1
XI1390_I78_XG I1390_pn12 I1390_gn11 I1390_gn12 I1390_G12_11 VDD VSS OAI21_X1
XI1390_I78_XP I1390_pn12 I1390_pn11 I1390_P12_11 VDD VSS NOR2_X1
XI1390_I79_XG I1390_pn13 I1390_gn12 I1390_gn13 I1390_G13_12 VDD VSS OAI21_X1
XI1390_I79_XP I1390_pn13 I1390_pn12 I1390_P13_12 VDD VSS NOR2_X1
XI1390_I80_XG I1390_pn14 I1390_gn13 I1390_gn14 I1390_G14_13 VDD VSS OAI21_X1
XI1390_I80_XP I1390_pn14 I1390_pn13 I1390_P14_13 VDD VSS NOR2_X1
XI1390_I81_XG I1390_pn15 I1390_gn14 I1390_gn15 I1390_G15_14 VDD VSS OAI21_X1
XI1390_I81_XP I1390_pn15 I1390_pn14 I1390_P15_14 VDD VSS NOR2_X1
XI1390_I82_XG I1390_pn16 I1390_gn15 I1390_gn16 I1390_G16_15 VDD VSS OAI21_X1
XI1390_I82_XP I1390_pn16 I1390_pn15 I1390_P16_15 VDD VSS NOR2_X1
XI1390_I83_XG I1390_pn17 I1390_gn16 I1390_gn17 I1390_G17_16 VDD VSS OAI21_X1
XI1390_I83_XP I1390_pn17 I1390_pn16 I1390_P17_16 VDD VSS NOR2_X1
XI1390_I84_XG I1390_pn18 I1390_gn17 I1390_gn18 I1390_G18_17 VDD VSS OAI21_X1
XI1390_I84_XP I1390_pn18 I1390_pn17 I1390_P18_17 VDD VSS NOR2_X1
XI1390_I85_XG I1390_pn19 I1390_gn18 I1390_gn19 I1390_G19_18 VDD VSS OAI21_X1
XI1390_I85_XP I1390_pn19 I1390_pn18 I1390_P19_18 VDD VSS NOR2_X1
XI1390_I86_XG I1390_pn20 I1390_gn19 I1390_gn20 I1390_G20_19 VDD VSS OAI21_X1
XI1390_I86_XP I1390_pn20 I1390_pn19 I1390_P20_19 VDD VSS NOR2_X1
XI1390_I87_XG I1390_pn21 I1390_gn20 I1390_gn21 I1390_G21_20 VDD VSS OAI21_X1
XI1390_I87_XP I1390_pn21 I1390_pn20 I1390_P21_20 VDD VSS NOR2_X1
XI1390_I88_XG I1390_pn22 I1390_gn21 I1390_gn22 I1390_G22_21 VDD VSS OAI21_X1
XI1390_I88_XP I1390_pn22 I1390_pn21 I1390_P22_21 VDD VSS NOR2_X1
XI1390_I89_XG I1390_pn23 I1390_gn22 I1390_gn23 I1390_G23_22 VDD VSS OAI21_X1
XI1390_I89_XP I1390_pn23 I1390_pn22 I1390_P23_22 VDD VSS NOR2_X1
XI1390_I90_XG I1390_pn24 I1390_gn23 I1390_gn24 I1390_G24_23 VDD VSS OAI21_X1
XI1390_I90_XP I1390_pn24 I1390_pn23 I1390_P24_23 VDD VSS NOR2_X1
XI1390_I91_XG I1390_pn25 I1390_gn24 I1390_gn25 I1390_G25_24 VDD VSS OAI21_X1
XI1390_I91_XP I1390_pn25 I1390_pn24 I1390_P25_24 VDD VSS NOR2_X1
XI1390_I92_XG I1390_pn26 I1390_gn25 I1390_gn26 I1390_G26_25 VDD VSS OAI21_X1
XI1390_I92_XP I1390_pn26 I1390_pn25 I1390_P26_25 VDD VSS NOR2_X1
XI1390_I93_XG I1390_pn27 I1390_gn26 I1390_gn27 I1390_G27_26 VDD VSS OAI21_X1
XI1390_I93_XP I1390_pn27 I1390_pn26 I1390_P27_26 VDD VSS NOR2_X1
XI1390_I94_XG I1390_pn28 I1390_gn27 I1390_gn28 I1390_G28_27 VDD VSS OAI21_X1
XI1390_I94_XP I1390_pn28 I1390_pn27 I1390_P28_27 VDD VSS NOR2_X1
XI1390_I95_XG I1390_pn29 I1390_gn28 I1390_gn29 I1390_G29_28 VDD VSS OAI21_X1
XI1390_I95_XP I1390_pn29 I1390_pn28 I1390_P29_28 VDD VSS NOR2_X1
XI1390_I96_XG I1390_pn30 I1390_gn29 I1390_gn30 I1390_G30_29 VDD VSS OAI21_X1
XI1390_I96_XP I1390_pn30 I1390_pn29 I1390_P30_29 VDD VSS NOR2_X1
XI1390_I97_XG I1390_pn31 I1390_gn30 I1390_gn31 I1390_G31_30 VDD VSS OAI21_X1
XI1390_I97_XP I1390_pn31 I1390_pn30 I1390_P31_30 VDD VSS NOR2_X1
XI1390_I98_XG I1390_P2_1 I1390_G0_0 I1390_G2_1 I1390_G2_0n VDD VSS AOI21_X1
XI1390_I99_XG I1390_P3_2 I1390_G1_0 I1390_G3_2 I1390_G3_0n VDD VSS AOI21_X1
XI1390_I100_XG I1390_P4_3 I1390_G2_1 I1390_G4_3 I1390_G4_1n VDD VSS AOI21_X1
XI1390_I100_XP I1390_P4_3 I1390_P2_1 I1390_P4_1n VDD VSS NAND2_X1
XI1390_I101_XG I1390_P5_4 I1390_G3_2 I1390_G5_4 I1390_G5_2n VDD VSS AOI21_X1
XI1390_I101_XP I1390_P5_4 I1390_P3_2 I1390_P5_2n VDD VSS NAND2_X1
XI1390_I102_XG I1390_P6_5 I1390_G4_3 I1390_G6_5 I1390_G6_3n VDD VSS AOI21_X1
XI1390_I102_XP I1390_P6_5 I1390_P4_3 I1390_P6_3n VDD VSS NAND2_X1
XI1390_I103_XG I1390_P7_6 I1390_G5_4 I1390_G7_6 I1390_G7_4n VDD VSS AOI21_X1
XI1390_I103_XP I1390_P7_6 I1390_P5_4 I1390_P7_4n VDD VSS NAND2_X1
XI1390_I104_XG I1390_P8_7 I1390_G6_5 I1390_G8_7 I1390_G8_5n VDD VSS AOI21_X1
XI1390_I104_XP I1390_P8_7 I1390_P6_5 I1390_P8_5n VDD VSS NAND2_X1
XI1390_I105_XG I1390_P9_8 I1390_G7_6 I1390_G9_8 I1390_G9_6n VDD VSS AOI21_X1
XI1390_I105_XP I1390_P9_8 I1390_P7_6 I1390_P9_6n VDD VSS NAND2_X1
XI1390_I106_XG I1390_P10_9 I1390_G8_7 I1390_G10_9 I1390_G10_7n VDD VSS AOI21_X1
XI1390_I106_XP I1390_P10_9 I1390_P8_7 I1390_P10_7n VDD VSS NAND2_X1
XI1390_I107_XG I1390_P11_10 I1390_G9_8 I1390_G11_10 I1390_G11_8n VDD VSS AOI21_X1
XI1390_I107_XP I1390_P11_10 I1390_P9_8 I1390_P11_8n VDD VSS NAND2_X1
XI1390_I108_XG I1390_P12_11 I1390_G10_9 I1390_G12_11 I1390_G12_9n VDD VSS AOI21_X1
XI1390_I108_XP I1390_P12_11 I1390_P10_9 I1390_P12_9n VDD VSS NAND2_X1
XI1390_I109_XG I1390_P13_12 I1390_G11_10 I1390_G13_12 I1390_G13_10n VDD VSS AOI21_X1
XI1390_I109_XP I1390_P13_12 I1390_P11_10 I1390_P13_10n VDD VSS NAND2_X1
XI1390_I110_XG I1390_P14_13 I1390_G12_11 I1390_G14_13 I1390_G14_11n VDD VSS AOI21_X1
XI1390_I110_XP I1390_P14_13 I1390_P12_11 I1390_P14_11n VDD VSS NAND2_X1
XI1390_I111_XG I1390_P15_14 I1390_G13_12 I1390_G15_14 I1390_G15_12n VDD VSS AOI21_X1
XI1390_I111_XP I1390_P15_14 I1390_P13_12 I1390_P15_12n VDD VSS NAND2_X1
XI1390_I112_XG I1390_P16_15 I1390_G14_13 I1390_G16_15 I1390_G16_13n VDD VSS AOI21_X1
XI1390_I112_XP I1390_P16_15 I1390_P14_13 I1390_P16_13n VDD VSS NAND2_X1
XI1390_I113_XG I1390_P17_16 I1390_G15_14 I1390_G17_16 I1390_G17_14n VDD VSS AOI21_X1
XI1390_I113_XP I1390_P17_16 I1390_P15_14 I1390_P17_14n VDD VSS NAND2_X1
XI1390_I114_XG I1390_P18_17 I1390_G16_15 I1390_G18_17 I1390_G18_15n VDD VSS AOI21_X1
XI1390_I114_XP I1390_P18_17 I1390_P16_15 I1390_P18_15n VDD VSS NAND2_X1
XI1390_I115_XG I1390_P19_18 I1390_G17_16 I1390_G19_18 I1390_G19_16n VDD VSS AOI21_X1
XI1390_I115_XP I1390_P19_18 I1390_P17_16 I1390_P19_16n VDD VSS NAND2_X1
XI1390_I116_XG I1390_P20_19 I1390_G18_17 I1390_G20_19 I1390_G20_17n VDD VSS AOI21_X1
XI1390_I116_XP I1390_P20_19 I1390_P18_17 I1390_P20_17n VDD VSS NAND2_X1
XI1390_I117_XG I1390_P21_20 I1390_G19_18 I1390_G21_20 I1390_G21_18n VDD VSS AOI21_X1
XI1390_I117_XP I1390_P21_20 I1390_P19_18 I1390_P21_18n VDD VSS NAND2_X1
XI1390_I118_XG I1390_P22_21 I1390_G20_19 I1390_G22_21 I1390_G22_19n VDD VSS AOI21_X1
XI1390_I118_XP I1390_P22_21 I1390_P20_19 I1390_P22_19n VDD VSS NAND2_X1
XI1390_I119_XG I1390_P23_22 I1390_G21_20 I1390_G23_22 I1390_G23_20n VDD VSS AOI21_X1
XI1390_I119_XP I1390_P23_22 I1390_P21_20 I1390_P23_20n VDD VSS NAND2_X1
XI1390_I120_XG I1390_P24_23 I1390_G22_21 I1390_G24_23 I1390_G24_21n VDD VSS AOI21_X1
XI1390_I120_XP I1390_P24_23 I1390_P22_21 I1390_P24_21n VDD VSS NAND2_X1
XI1390_I121_XG I1390_P25_24 I1390_G23_22 I1390_G25_24 I1390_G25_22n VDD VSS AOI21_X1
XI1390_I121_XP I1390_P25_24 I1390_P23_22 I1390_P25_22n VDD VSS NAND2_X1
XI1390_I122_XG I1390_P26_25 I1390_G24_23 I1390_G26_25 I1390_G26_23n VDD VSS AOI21_X1
XI1390_I122_XP I1390_P26_25 I1390_P24_23 I1390_P26_23n VDD VSS NAND2_X1
XI1390_I123_XG I1390_P27_26 I1390_G25_24 I1390_G27_26 I1390_G27_24n VDD VSS AOI21_X1
XI1390_I123_XP I1390_P27_26 I1390_P25_24 I1390_P27_24n VDD VSS NAND2_X1
XI1390_I124_XG I1390_P28_27 I1390_G26_25 I1390_G28_27 I1390_G28_25n VDD VSS AOI21_X1
XI1390_I124_XP I1390_P28_27 I1390_P26_25 I1390_P28_25n VDD VSS NAND2_X1
XI1390_I125_XG I1390_P29_28 I1390_G27_26 I1390_G29_28 I1390_G29_26n VDD VSS AOI21_X1
XI1390_I125_XP I1390_P29_28 I1390_P27_26 I1390_P29_26n VDD VSS NAND2_X1
XI1390_I126_XG I1390_P30_29 I1390_G28_27 I1390_G30_29 I1390_G30_27n VDD VSS AOI21_X1
XI1390_I126_XP I1390_P30_29 I1390_P28_27 I1390_P30_27n VDD VSS NAND2_X1
XI1390_I127_XG I1390_P31_30 I1390_G29_28 I1390_G31_30 I1390_G31_28n VDD VSS AOI21_X1
XI1390_I127_XP I1390_P31_30 I1390_P29_28 I1390_P31_28n VDD VSS NAND2_X1
XI1390_I128_XG I1390_P4_1n I1390_G0_0n I1390_G4_1n I1390_G4_0 VDD VSS OAI21_X1
XI1390_I129 I1390_G1_0 I1390_G1_0n VDD VSS INV_X1
XI1390_I130_XG I1390_P5_2n I1390_G1_0n I1390_G5_2n I1390_G5_0 VDD VSS OAI21_X1
XI1390_I131_XG I1390_P6_3n I1390_G2_0n I1390_G6_3n I1390_G6_0 VDD VSS OAI21_X1
XI1390_I132_XG I1390_P7_4n I1390_G3_0n I1390_G7_4n I1390_G7_0 VDD VSS OAI21_X1
XI1390_I133_XG I1390_P8_5n I1390_G4_1n I1390_G8_5n I1390_G8_1 VDD VSS OAI21_X1
XI1390_I133_XP I1390_P8_5n I1390_P4_1n I1390_P8_1 VDD VSS NOR2_X1
XI1390_I134_XG I1390_P9_6n I1390_G5_2n I1390_G9_6n I1390_G9_2 VDD VSS OAI21_X1
XI1390_I134_XP I1390_P9_6n I1390_P5_2n I1390_P9_2 VDD VSS NOR2_X1
XI1390_I135_XG I1390_P10_7n I1390_G6_3n I1390_G10_7n I1390_G10_3 VDD VSS OAI21_X1
XI1390_I135_XP I1390_P10_7n I1390_P6_3n I1390_P10_3 VDD VSS NOR2_X1
XI1390_I136_XG I1390_P11_8n I1390_G7_4n I1390_G11_8n I1390_G11_4 VDD VSS OAI21_X1
XI1390_I136_XP I1390_P11_8n I1390_P7_4n I1390_P11_4 VDD VSS NOR2_X1
XI1390_I137_XG I1390_P12_9n I1390_G8_5n I1390_G12_9n I1390_G12_5 VDD VSS OAI21_X1
XI1390_I137_XP I1390_P12_9n I1390_P8_5n I1390_P12_5 VDD VSS NOR2_X1
XI1390_I138_XG I1390_P13_10n I1390_G9_6n I1390_G13_10n I1390_G13_6 VDD VSS OAI21_X1
XI1390_I138_XP I1390_P13_10n I1390_P9_6n I1390_P13_6 VDD VSS NOR2_X1
XI1390_I139_XG I1390_P14_11n I1390_G10_7n I1390_G14_11n I1390_G14_7 VDD VSS OAI21_X1
XI1390_I139_XP I1390_P14_11n I1390_P10_7n I1390_P14_7 VDD VSS NOR2_X1
XI1390_I140_XG I1390_P15_12n I1390_G11_8n I1390_G15_12n I1390_G15_8 VDD VSS OAI21_X1
XI1390_I140_XP I1390_P15_12n I1390_P11_8n I1390_P15_8 VDD VSS NOR2_X1
XI1390_I141_XG I1390_P16_13n I1390_G12_9n I1390_G16_13n I1390_G16_9 VDD VSS OAI21_X1
XI1390_I141_XP I1390_P16_13n I1390_P12_9n I1390_P16_9 VDD VSS NOR2_X1
XI1390_I142_XG I1390_P17_14n I1390_G13_10n I1390_G17_14n I1390_G17_10 VDD VSS OAI21_X1
XI1390_I142_XP I1390_P17_14n I1390_P13_10n I1390_P17_10 VDD VSS NOR2_X1
XI1390_I143_XG I1390_P18_15n I1390_G14_11n I1390_G18_15n I1390_G18_11 VDD VSS OAI21_X1
XI1390_I143_XP I1390_P18_15n I1390_P14_11n I1390_P18_11 VDD VSS NOR2_X1
XI1390_I144_XG I1390_P19_16n I1390_G15_12n I1390_G19_16n I1390_G19_12 VDD VSS OAI21_X1
XI1390_I144_XP I1390_P19_16n I1390_P15_12n I1390_P19_12 VDD VSS NOR2_X1
XI1390_I145_XG I1390_P20_17n I1390_G16_13n I1390_G20_17n I1390_G20_13 VDD VSS OAI21_X1
XI1390_I145_XP I1390_P20_17n I1390_P16_13n I1390_P20_13 VDD VSS NOR2_X1
XI1390_I146_XG I1390_P21_18n I1390_G17_14n I1390_G21_18n I1390_G21_14 VDD VSS OAI21_X1
XI1390_I146_XP I1390_P21_18n I1390_P17_14n I1390_P21_14 VDD VSS NOR2_X1
XI1390_I147_XG I1390_P22_19n I1390_G18_15n I1390_G22_19n I1390_G22_15 VDD VSS OAI21_X1
XI1390_I147_XP I1390_P22_19n I1390_P18_15n I1390_P22_15 VDD VSS NOR2_X1
XI1390_I148_XG I1390_P23_20n I1390_G19_16n I1390_G23_20n I1390_G23_16 VDD VSS OAI21_X1
XI1390_I148_XP I1390_P23_20n I1390_P19_16n I1390_P23_16 VDD VSS NOR2_X1
XI1390_I149_XG I1390_P24_21n I1390_G20_17n I1390_G24_21n I1390_G24_17 VDD VSS OAI21_X1
XI1390_I149_XP I1390_P24_21n I1390_P20_17n I1390_P24_17 VDD VSS NOR2_X1
XI1390_I150_XG I1390_P25_22n I1390_G21_18n I1390_G25_22n I1390_G25_18 VDD VSS OAI21_X1
XI1390_I150_XP I1390_P25_22n I1390_P21_18n I1390_P25_18 VDD VSS NOR2_X1
XI1390_I151_XG I1390_P26_23n I1390_G22_19n I1390_G26_23n I1390_G26_19 VDD VSS OAI21_X1
XI1390_I151_XP I1390_P26_23n I1390_P22_19n I1390_P26_19 VDD VSS NOR2_X1
XI1390_I152_XG I1390_P27_24n I1390_G23_20n I1390_G27_24n I1390_G27_20 VDD VSS OAI21_X1
XI1390_I152_XP I1390_P27_24n I1390_P23_20n I1390_P27_20 VDD VSS NOR2_X1
XI1390_I153_XG I1390_P28_25n I1390_G24_21n I1390_G28_25n I1390_G28_21 VDD VSS OAI21_X1
XI1390_I153_XP I1390_P28_25n I1390_P24_21n I1390_P28_21 VDD VSS NOR2_X1
XI1390_I154_XG I1390_P29_26n I1390_G25_22n I1390_G29_26n I1390_G29_22 VDD VSS OAI21_X1
XI1390_I154_XP I1390_P29_26n I1390_P25_22n I1390_P29_22 VDD VSS NOR2_X1
XI1390_I155_XG I1390_P30_27n I1390_G26_23n I1390_G30_27n I1390_G30_23 VDD VSS OAI21_X1
XI1390_I155_XP I1390_P30_27n I1390_P26_23n I1390_P30_23 VDD VSS NOR2_X1
XI1390_I156_XG I1390_P31_28n I1390_G27_24n I1390_G31_28n I1390_G31_24 VDD VSS OAI21_X1
XI1390_I156_XP I1390_P31_28n I1390_P27_24n I1390_P31_24 VDD VSS NOR2_X1
XI1390_I157_XG I1390_P8_1 I1390_G0_0 I1390_G8_1 I1390_G8_0n VDD VSS AOI21_X1
XI1390_I158_XG I1390_P9_2 I1390_G1_0 I1390_G9_2 I1390_G9_0n VDD VSS AOI21_X1
XI1390_I159 I1390_G2_0n I1390_G2_0np VDD VSS INV_X1
XI1390_I160_XG I1390_P10_3 I1390_G2_0np I1390_G10_3 I1390_G10_0n VDD VSS AOI21_X1
XI1390_I161 I1390_G3_0n I1390_G3_0np VDD VSS INV_X1
XI1390_I162_XG I1390_P11_4 I1390_G3_0np I1390_G11_4 I1390_G11_0n VDD VSS AOI21_X1
XI1390_I163_XG I1390_P12_5 I1390_G4_0 I1390_G12_5 I1390_G12_0n VDD VSS AOI21_X1
XI1390_I164_XG I1390_P13_6 I1390_G5_0 I1390_G13_6 I1390_G13_0n VDD VSS AOI21_X1
XI1390_I165_XG I1390_P14_7 I1390_G6_0 I1390_G14_7 I1390_G14_0n VDD VSS AOI21_X1
XI1390_I166_XG I1390_P15_8 I1390_G7_0 I1390_G15_8 I1390_G15_0n VDD VSS AOI21_X1
XI1390_I167_XG I1390_P16_9 I1390_G8_1 I1390_G16_9 I1390_G16_1n VDD VSS AOI21_X1
XI1390_I167_XP I1390_P16_9 I1390_P8_1 I1390_P16_1n VDD VSS NAND2_X1
XI1390_I168_XG I1390_P17_10 I1390_G9_2 I1390_G17_10 I1390_G17_2n VDD VSS AOI21_X1
XI1390_I168_XP I1390_P17_10 I1390_P9_2 I1390_P17_2n VDD VSS NAND2_X1
XI1390_I169_XG I1390_P18_11 I1390_G10_3 I1390_G18_11 I1390_G18_3n VDD VSS AOI21_X1
XI1390_I169_XP I1390_P18_11 I1390_P10_3 I1390_P18_3n VDD VSS NAND2_X1
XI1390_I170_XG I1390_P19_12 I1390_G11_4 I1390_G19_12 I1390_G19_4n VDD VSS AOI21_X1
XI1390_I170_XP I1390_P19_12 I1390_P11_4 I1390_P19_4n VDD VSS NAND2_X1
XI1390_I171_XG I1390_P20_13 I1390_G12_5 I1390_G20_13 I1390_G20_5n VDD VSS AOI21_X1
XI1390_I171_XP I1390_P20_13 I1390_P12_5 I1390_P20_5n VDD VSS NAND2_X1
XI1390_I172_XG I1390_P21_14 I1390_G13_6 I1390_G21_14 I1390_G21_6n VDD VSS AOI21_X1
XI1390_I172_XP I1390_P21_14 I1390_P13_6 I1390_P21_6n VDD VSS NAND2_X1
XI1390_I173_XG I1390_P22_15 I1390_G14_7 I1390_G22_15 I1390_G22_7n VDD VSS AOI21_X1
XI1390_I173_XP I1390_P22_15 I1390_P14_7 I1390_P22_7n VDD VSS NAND2_X1
XI1390_I174_XG I1390_P23_16 I1390_G15_8 I1390_G23_16 I1390_G23_8n VDD VSS AOI21_X1
XI1390_I174_XP I1390_P23_16 I1390_P15_8 I1390_P23_8n VDD VSS NAND2_X1
XI1390_I175_XG I1390_P24_17 I1390_G16_9 I1390_G24_17 I1390_G24_9n VDD VSS AOI21_X1
XI1390_I175_XP I1390_P24_17 I1390_P16_9 I1390_P24_9n VDD VSS NAND2_X1
XI1390_I176_XG I1390_P25_18 I1390_G17_10 I1390_G25_18 I1390_G25_10n VDD VSS AOI21_X1
XI1390_I176_XP I1390_P25_18 I1390_P17_10 I1390_P25_10n VDD VSS NAND2_X1
XI1390_I177_XG I1390_P26_19 I1390_G18_11 I1390_G26_19 I1390_G26_11n VDD VSS AOI21_X1
XI1390_I177_XP I1390_P26_19 I1390_P18_11 I1390_P26_11n VDD VSS NAND2_X1
XI1390_I178_XG I1390_P27_20 I1390_G19_12 I1390_G27_20 I1390_G27_12n VDD VSS AOI21_X1
XI1390_I178_XP I1390_P27_20 I1390_P19_12 I1390_P27_12n VDD VSS NAND2_X1
XI1390_I179_XG I1390_P28_21 I1390_G20_13 I1390_G28_21 I1390_G28_13n VDD VSS AOI21_X1
XI1390_I179_XP I1390_P28_21 I1390_P20_13 I1390_P28_13n VDD VSS NAND2_X1
XI1390_I180_XG I1390_P29_22 I1390_G21_14 I1390_G29_22 I1390_G29_14n VDD VSS AOI21_X1
XI1390_I180_XP I1390_P29_22 I1390_P21_14 I1390_P29_14n VDD VSS NAND2_X1
XI1390_I181_XG I1390_P30_23 I1390_G22_15 I1390_G30_23 I1390_G30_15n VDD VSS AOI21_X1
XI1390_I181_XP I1390_P30_23 I1390_P22_15 I1390_P30_15n VDD VSS NAND2_X1
XI1390_I182_XG I1390_P31_24 I1390_G23_16 I1390_G31_24 I1390_G31_16n VDD VSS AOI21_X1
XI1390_I182_XP I1390_P31_24 I1390_P23_16 I1390_P31_16n VDD VSS NAND2_X1
XI1390_I183_XG I1390_P16_1n I1390_G0_0n I1390_G16_1n I1390_G16_0 VDD VSS OAI21_X1
XI1390_I184_XG I1390_P17_2n I1390_G1_0n I1390_G17_2n I1390_G17_0 VDD VSS OAI21_X1
XI1390_I185_XG I1390_P18_3n I1390_G2_0n I1390_G18_3n I1390_G18_0 VDD VSS OAI21_X1
XI1390_I186_XG I1390_P19_4n I1390_G3_0n I1390_G19_4n I1390_G19_0 VDD VSS OAI21_X1
XI1390_I187 I1390_G4_0 I1390_G4_0n VDD VSS INV_X1
XI1390_I188_XG I1390_P20_5n I1390_G4_0n I1390_G20_5n I1390_G20_0 VDD VSS OAI21_X1
XI1390_I189 I1390_G5_0 I1390_G5_0n VDD VSS INV_X1
XI1390_I190_XG I1390_P21_6n I1390_G5_0n I1390_G21_6n I1390_G21_0 VDD VSS OAI21_X1
XI1390_I191 I1390_G6_0 I1390_G6_0n VDD VSS INV_X1
XI1390_I192_XG I1390_P22_7n I1390_G6_0n I1390_G22_7n I1390_G22_0 VDD VSS OAI21_X1
XI1390_I193 I1390_G7_0 I1390_G7_0n VDD VSS INV_X1
XI1390_I194_XG I1390_P23_8n I1390_G7_0n I1390_G23_8n I1390_G23_0 VDD VSS OAI21_X1
XI1390_I195_XG I1390_P24_9n I1390_G8_0n I1390_G24_9n I1390_G24_0 VDD VSS OAI21_X1
XI1390_I196_XG I1390_P25_10n I1390_G9_0n I1390_G25_10n I1390_G25_0 VDD VSS OAI21_X1
XI1390_I197_XG I1390_P26_11n I1390_G10_0n I1390_G26_11n I1390_G26_0 VDD VSS OAI21_X1
XI1390_I198_XG I1390_P27_12n I1390_G11_0n I1390_G27_12n I1390_G27_0 VDD VSS OAI21_X1
XI1390_I199_XG I1390_P28_13n I1390_G12_0n I1390_G28_13n I1390_G28_0 VDD VSS OAI21_X1
XI1390_I200_XG I1390_P29_14n I1390_G13_0n I1390_G29_14n I1390_G29_0 VDD VSS OAI21_X1
XI1390_I201_XG I1390_P30_15n I1390_G14_0n I1390_G30_15n c18_m VDD VSS OAI21_X1
XI1390_I202_XG I1390_P31_16n I1390_G15_0n I1390_G31_16n c18_o VDD VSS OAI21_X1
XI1390_I203 I1390_pn0 qu14_b3_5 p18_0 VDD VSS XNOR2_X1
XI1390_I204 I1390_pn1 I1390_G0_0 p18_1 VDD VSS XNOR2_X1
XI1390_I205 I1390_pn2 I1390_G1_0 p18_2 VDD VSS XNOR2_X1
XI1390_I206 I1390_pn3 I1390_G2_0n p18_3 VDD VSS XOR2_X1
XI1390_I207 I1390_pn4 I1390_G3_0n p18_4 VDD VSS XOR2_X1
XI1390_I208 I1390_pn5 I1390_G4_0 p18_5 VDD VSS XNOR2_X1
XI1390_I209 I1390_pn6 I1390_G5_0 p18_6 VDD VSS XNOR2_X1
XI1390_I210 I1390_pn7 I1390_G6_0 p18_7 VDD VSS XNOR2_X1
XI1390_I211 I1390_pn8 I1390_G7_0 p18_8 VDD VSS XNOR2_X1
XI1390_I212 I1390_pn9 I1390_G8_0n p18_9 VDD VSS XOR2_X1
XI1390_I213 I1390_pn10 I1390_G9_0n p18_10 VDD VSS XOR2_X1
XI1390_I214 I1390_pn11 I1390_G10_0n p18_11 VDD VSS XOR2_X1
XI1390_I215 I1390_pn12 I1390_G11_0n p18_12 VDD VSS XOR2_X1
XI1390_I216 I1390_pn13 I1390_G12_0n p18_13 VDD VSS XOR2_X1
XI1390_I217 I1390_pn14 I1390_G13_0n p18_14 VDD VSS XOR2_X1
XI1390_I218 I1390_pn15 I1390_G14_0n p18_15 VDD VSS XOR2_X1
XI1390_I219 I1390_pn16 I1390_G15_0n p18_16 VDD VSS XOR2_X1
XI1390_I220 I1390_pn17 I1390_G16_0 p18_17 VDD VSS XNOR2_X1
XI1390_I221 I1390_pn18 I1390_G17_0 p18_18 VDD VSS XNOR2_X1
XI1390_I222 I1390_pn19 I1390_G18_0 p18_19 VDD VSS XNOR2_X1
XI1390_I223 I1390_pn20 I1390_G19_0 p18_20 VDD VSS XNOR2_X1
XI1390_I224 I1390_pn21 I1390_G20_0 p18_21 VDD VSS XNOR2_X1
XI1390_I225 I1390_pn22 I1390_G21_0 p18_22 VDD VSS XNOR2_X1
XI1390_I226 I1390_pn23 I1390_G22_0 p18_23 VDD VSS XNOR2_X1
XI1390_I227 I1390_pn24 I1390_G23_0 p18_24 VDD VSS XNOR2_X1
XI1390_I228 I1390_pn25 I1390_G24_0 p18_25 VDD VSS XNOR2_X1
XI1390_I229 I1390_pn26 I1390_G25_0 p18_26 VDD VSS XNOR2_X1
XI1390_I230 I1390_pn27 I1390_G26_0 p18_27 VDD VSS XNOR2_X1
XI1390_I231 I1390_pn28 I1390_G27_0 p18_28 VDD VSS XNOR2_X1
XI1390_I232 I1390_pn29 I1390_G28_0 p18_29 VDD VSS XNOR2_X1
XI1390_I233 I1390_pn30 I1390_G29_0 p18_30 VDD VSS XNOR2_X1
XI1390_I234 I1390_pn31 c18_m p18_31 VDD VSS XNOR2_X1
XI1391 p17_31 qu14_b3_5 h18 VDD VSS XOR2_X1
XI1392 h18 c18_o p18_32 VDD VSS XOR2_X1
XI1393 p18_32 qu13 VDD VSS INV_X4
XI1394 qu13 qu13_b0 VDD VSS INV_X1
XI1395 qu13_b0 qu13_b1_0 VDD VSS INV_X4
XI1396 qu13_b1_0 qu13_b2_0 VDD VSS INV_X4
XI1397 qu13_b1_0 qu13_b2_1 VDD VSS INV_X4
XI1398 qu13_b2_0 qu13_b3_0 VDD VSS INV_X4
XI1399 qu13_b2_0 qu13_b3_1 VDD VSS INV_X4
XI1400 qu13_b2_0 qu13_b3_2 VDD VSS INV_X4
XI1401 qu13_b2_1 qu13_b3_3 VDD VSS INV_X4
XI1402 qu13_b2_1 qu13_b3_4 VDD VSS INV_X4
XI1403 qu13_b2_1 qu13_b3_5 VDD VSS INV_X4
XI1404 B_0_b3_3 qu13_b3_0 b19_0 VDD VSS XOR2_X1
XI1405 dd1_b3_3 qu13_b3_0 b19_1 VDD VSS XOR2_X1
XI1406 dd2_b3_3 qu13_b3_0 b19_2 VDD VSS XOR2_X1
XI1407 dd3_b3_3 qu13_b3_0 b19_3 VDD VSS XOR2_X1
XI1408 dd4_b3_3 qu13_b3_0 b19_4 VDD VSS XOR2_X1
XI1409 dd5_b3_3 qu13_b3_0 b19_5 VDD VSS XOR2_X1
XI1410 dd6_b3_3 qu13_b3_1 b19_6 VDD VSS XOR2_X1
XI1411 dd7_b3_3 qu13_b3_1 b19_7 VDD VSS XOR2_X1
XI1412 dd8_b3_3 qu13_b3_1 b19_8 VDD VSS XOR2_X1
XI1413 dd9_b3_3 qu13_b3_1 b19_9 VDD VSS XOR2_X1
XI1414 dd10_b3_3 qu13_b3_1 b19_10 VDD VSS XOR2_X1
XI1415 dd11_b3_3 qu13_b3_1 b19_11 VDD VSS XOR2_X1
XI1416 dd12_b3_3 qu13_b3_2 b19_12 VDD VSS XOR2_X1
XI1417 dd13_b3_3 qu13_b3_2 b19_13 VDD VSS XOR2_X1
XI1418 dd14_b3_3 qu13_b3_2 b19_14 VDD VSS XOR2_X1
XI1419 dd15_b3_3 qu13_b3_2 b19_15 VDD VSS XOR2_X1
XI1420 dd16_b3_3 qu13_b3_2 b19_16 VDD VSS XOR2_X1
XI1421 dd17_b3_3 qu13_b3_2 b19_17 VDD VSS XOR2_X1
XI1422 dd18_b3_3 qu13_b3_3 b19_18 VDD VSS XOR2_X1
XI1423 dd19_b3_3 qu13_b3_3 b19_19 VDD VSS XOR2_X1
XI1424 dd20_b3_3 qu13_b3_3 b19_20 VDD VSS XOR2_X1
XI1425 dd21_b3_3 qu13_b3_3 b19_21 VDD VSS XOR2_X1
XI1426 dd22_b3_3 qu13_b3_3 b19_22 VDD VSS XOR2_X1
XI1427 dd23_b3_3 qu13_b3_3 b19_23 VDD VSS XOR2_X1
XI1428 dd24_b3_3 qu13_b3_4 b19_24 VDD VSS XOR2_X1
XI1429 dd25_b3_3 qu13_b3_4 b19_25 VDD VSS XOR2_X1
XI1430 dd26_b3_3 qu13_b3_4 b19_26 VDD VSS XOR2_X1
XI1431 dd27_b3_3 qu13_b3_4 b19_27 VDD VSS XOR2_X1
XI1432 dd28_b3_3 qu13_b3_4 b19_28 VDD VSS XOR2_X1
XI1433 dd29_b3_3 qu13_b3_4 b19_29 VDD VSS XOR2_X1
XI1434 dd30_b3_3 qu13_b3_5 b19_30 VDD VSS XOR2_X1
XI1435 dd31_b3_3 qu13_b3_5 b19_31 VDD VSS XOR2_X1
XI1436_I0 aa12 b19_0 I1436_gn0 VDD VSS NAND2_X1
XI1436_I1 p18_0 b19_1 I1436_gn1 VDD VSS NAND2_X1
XI1436_I2 p18_1 b19_2 I1436_gn2 VDD VSS NAND2_X1
XI1436_I3 p18_2 b19_3 I1436_gn3 VDD VSS NAND2_X1
XI1436_I4 p18_3 b19_4 I1436_gn4 VDD VSS NAND2_X1
XI1436_I5 p18_4 b19_5 I1436_gn5 VDD VSS NAND2_X1
XI1436_I6 p18_5 b19_6 I1436_gn6 VDD VSS NAND2_X1
XI1436_I7 p18_6 b19_7 I1436_gn7 VDD VSS NAND2_X1
XI1436_I8 p18_7 b19_8 I1436_gn8 VDD VSS NAND2_X1
XI1436_I9 p18_8 b19_9 I1436_gn9 VDD VSS NAND2_X1
XI1436_I10 p18_9 b19_10 I1436_gn10 VDD VSS NAND2_X1
XI1436_I11 p18_10 b19_11 I1436_gn11 VDD VSS NAND2_X1
XI1436_I12 p18_11 b19_12 I1436_gn12 VDD VSS NAND2_X1
XI1436_I13 p18_12 b19_13 I1436_gn13 VDD VSS NAND2_X1
XI1436_I14 p18_13 b19_14 I1436_gn14 VDD VSS NAND2_X1
XI1436_I15 p18_14 b19_15 I1436_gn15 VDD VSS NAND2_X1
XI1436_I16 p18_15 b19_16 I1436_gn16 VDD VSS NAND2_X1
XI1436_I17 p18_16 b19_17 I1436_gn17 VDD VSS NAND2_X1
XI1436_I18 p18_17 b19_18 I1436_gn18 VDD VSS NAND2_X1
XI1436_I19 p18_18 b19_19 I1436_gn19 VDD VSS NAND2_X1
XI1436_I20 p18_19 b19_20 I1436_gn20 VDD VSS NAND2_X1
XI1436_I21 p18_20 b19_21 I1436_gn21 VDD VSS NAND2_X1
XI1436_I22 p18_21 b19_22 I1436_gn22 VDD VSS NAND2_X1
XI1436_I23 p18_22 b19_23 I1436_gn23 VDD VSS NAND2_X1
XI1436_I24 p18_23 b19_24 I1436_gn24 VDD VSS NAND2_X1
XI1436_I25 p18_24 b19_25 I1436_gn25 VDD VSS NAND2_X1
XI1436_I26 p18_25 b19_26 I1436_gn26 VDD VSS NAND2_X1
XI1436_I27 p18_26 b19_27 I1436_gn27 VDD VSS NAND2_X1
XI1436_I28 p18_27 b19_28 I1436_gn28 VDD VSS NAND2_X1
XI1436_I29 p18_28 b19_29 I1436_gn29 VDD VSS NAND2_X1
XI1436_I30 p18_29 b19_30 I1436_gn30 VDD VSS NAND2_X1
XI1436_I31 p18_30 b19_31 I1436_gn31 VDD VSS NAND2_X1
XI1436_I32 aa12 b19_0 I1436_pn0 VDD VSS XNOR2_X1
XI1436_I33 p18_0 b19_1 I1436_pn1 VDD VSS XNOR2_X1
XI1436_I34 p18_1 b19_2 I1436_pn2 VDD VSS XNOR2_X1
XI1436_I35 p18_2 b19_3 I1436_pn3 VDD VSS XNOR2_X1
XI1436_I36 p18_3 b19_4 I1436_pn4 VDD VSS XNOR2_X1
XI1436_I37 p18_4 b19_5 I1436_pn5 VDD VSS XNOR2_X1
XI1436_I38 p18_5 b19_6 I1436_pn6 VDD VSS XNOR2_X1
XI1436_I39 p18_6 b19_7 I1436_pn7 VDD VSS XNOR2_X1
XI1436_I40 p18_7 b19_8 I1436_pn8 VDD VSS XNOR2_X1
XI1436_I41 p18_8 b19_9 I1436_pn9 VDD VSS XNOR2_X1
XI1436_I42 p18_9 b19_10 I1436_pn10 VDD VSS XNOR2_X1
XI1436_I43 p18_10 b19_11 I1436_pn11 VDD VSS XNOR2_X1
XI1436_I44 p18_11 b19_12 I1436_pn12 VDD VSS XNOR2_X1
XI1436_I45 p18_12 b19_13 I1436_pn13 VDD VSS XNOR2_X1
XI1436_I46 p18_13 b19_14 I1436_pn14 VDD VSS XNOR2_X1
XI1436_I47 p18_14 b19_15 I1436_pn15 VDD VSS XNOR2_X1
XI1436_I48 p18_15 b19_16 I1436_pn16 VDD VSS XNOR2_X1
XI1436_I49 p18_16 b19_17 I1436_pn17 VDD VSS XNOR2_X1
XI1436_I50 p18_17 b19_18 I1436_pn18 VDD VSS XNOR2_X1
XI1436_I51 p18_18 b19_19 I1436_pn19 VDD VSS XNOR2_X1
XI1436_I52 p18_19 b19_20 I1436_pn20 VDD VSS XNOR2_X1
XI1436_I53 p18_20 b19_21 I1436_pn21 VDD VSS XNOR2_X1
XI1436_I54 p18_21 b19_22 I1436_pn22 VDD VSS XNOR2_X1
XI1436_I55 p18_22 b19_23 I1436_pn23 VDD VSS XNOR2_X1
XI1436_I56 p18_23 b19_24 I1436_pn24 VDD VSS XNOR2_X1
XI1436_I57 p18_24 b19_25 I1436_pn25 VDD VSS XNOR2_X1
XI1436_I58 p18_25 b19_26 I1436_pn26 VDD VSS XNOR2_X1
XI1436_I59 p18_26 b19_27 I1436_pn27 VDD VSS XNOR2_X1
XI1436_I60 p18_27 b19_28 I1436_pn28 VDD VSS XNOR2_X1
XI1436_I61 p18_28 b19_29 I1436_pn29 VDD VSS XNOR2_X1
XI1436_I62 p18_29 b19_30 I1436_pn30 VDD VSS XNOR2_X1
XI1436_I63 p18_30 b19_31 I1436_pn31 VDD VSS XNOR2_X1
XI1436_I64 qu13_b3_5 I1436_cinn VDD VSS INV_X1
XI1436_I65_XG I1436_pn0 I1436_cinn I1436_gn0 I1436_G0_0 VDD VSS OAI21_X1
XI1436_I66 I1436_G0_0 I1436_G0_0n VDD VSS INV_X1
XI1436_I67_XG I1436_pn1 I1436_G0_0n I1436_gn1 I1436_G1_0 VDD VSS OAI21_X1
XI1436_I68_XG I1436_pn2 I1436_gn1 I1436_gn2 I1436_G2_1 VDD VSS OAI21_X1
XI1436_I68_XP I1436_pn2 I1436_pn1 I1436_P2_1 VDD VSS NOR2_X1
XI1436_I69_XG I1436_pn3 I1436_gn2 I1436_gn3 I1436_G3_2 VDD VSS OAI21_X1
XI1436_I69_XP I1436_pn3 I1436_pn2 I1436_P3_2 VDD VSS NOR2_X1
XI1436_I70_XG I1436_pn4 I1436_gn3 I1436_gn4 I1436_G4_3 VDD VSS OAI21_X1
XI1436_I70_XP I1436_pn4 I1436_pn3 I1436_P4_3 VDD VSS NOR2_X1
XI1436_I71_XG I1436_pn5 I1436_gn4 I1436_gn5 I1436_G5_4 VDD VSS OAI21_X1
XI1436_I71_XP I1436_pn5 I1436_pn4 I1436_P5_4 VDD VSS NOR2_X1
XI1436_I72_XG I1436_pn6 I1436_gn5 I1436_gn6 I1436_G6_5 VDD VSS OAI21_X1
XI1436_I72_XP I1436_pn6 I1436_pn5 I1436_P6_5 VDD VSS NOR2_X1
XI1436_I73_XG I1436_pn7 I1436_gn6 I1436_gn7 I1436_G7_6 VDD VSS OAI21_X1
XI1436_I73_XP I1436_pn7 I1436_pn6 I1436_P7_6 VDD VSS NOR2_X1
XI1436_I74_XG I1436_pn8 I1436_gn7 I1436_gn8 I1436_G8_7 VDD VSS OAI21_X1
XI1436_I74_XP I1436_pn8 I1436_pn7 I1436_P8_7 VDD VSS NOR2_X1
XI1436_I75_XG I1436_pn9 I1436_gn8 I1436_gn9 I1436_G9_8 VDD VSS OAI21_X1
XI1436_I75_XP I1436_pn9 I1436_pn8 I1436_P9_8 VDD VSS NOR2_X1
XI1436_I76_XG I1436_pn10 I1436_gn9 I1436_gn10 I1436_G10_9 VDD VSS OAI21_X1
XI1436_I76_XP I1436_pn10 I1436_pn9 I1436_P10_9 VDD VSS NOR2_X1
XI1436_I77_XG I1436_pn11 I1436_gn10 I1436_gn11 I1436_G11_10 VDD VSS OAI21_X1
XI1436_I77_XP I1436_pn11 I1436_pn10 I1436_P11_10 VDD VSS NOR2_X1
XI1436_I78_XG I1436_pn12 I1436_gn11 I1436_gn12 I1436_G12_11 VDD VSS OAI21_X1
XI1436_I78_XP I1436_pn12 I1436_pn11 I1436_P12_11 VDD VSS NOR2_X1
XI1436_I79_XG I1436_pn13 I1436_gn12 I1436_gn13 I1436_G13_12 VDD VSS OAI21_X1
XI1436_I79_XP I1436_pn13 I1436_pn12 I1436_P13_12 VDD VSS NOR2_X1
XI1436_I80_XG I1436_pn14 I1436_gn13 I1436_gn14 I1436_G14_13 VDD VSS OAI21_X1
XI1436_I80_XP I1436_pn14 I1436_pn13 I1436_P14_13 VDD VSS NOR2_X1
XI1436_I81_XG I1436_pn15 I1436_gn14 I1436_gn15 I1436_G15_14 VDD VSS OAI21_X1
XI1436_I81_XP I1436_pn15 I1436_pn14 I1436_P15_14 VDD VSS NOR2_X1
XI1436_I82_XG I1436_pn16 I1436_gn15 I1436_gn16 I1436_G16_15 VDD VSS OAI21_X1
XI1436_I82_XP I1436_pn16 I1436_pn15 I1436_P16_15 VDD VSS NOR2_X1
XI1436_I83_XG I1436_pn17 I1436_gn16 I1436_gn17 I1436_G17_16 VDD VSS OAI21_X1
XI1436_I83_XP I1436_pn17 I1436_pn16 I1436_P17_16 VDD VSS NOR2_X1
XI1436_I84_XG I1436_pn18 I1436_gn17 I1436_gn18 I1436_G18_17 VDD VSS OAI21_X1
XI1436_I84_XP I1436_pn18 I1436_pn17 I1436_P18_17 VDD VSS NOR2_X1
XI1436_I85_XG I1436_pn19 I1436_gn18 I1436_gn19 I1436_G19_18 VDD VSS OAI21_X1
XI1436_I85_XP I1436_pn19 I1436_pn18 I1436_P19_18 VDD VSS NOR2_X1
XI1436_I86_XG I1436_pn20 I1436_gn19 I1436_gn20 I1436_G20_19 VDD VSS OAI21_X1
XI1436_I86_XP I1436_pn20 I1436_pn19 I1436_P20_19 VDD VSS NOR2_X1
XI1436_I87_XG I1436_pn21 I1436_gn20 I1436_gn21 I1436_G21_20 VDD VSS OAI21_X1
XI1436_I87_XP I1436_pn21 I1436_pn20 I1436_P21_20 VDD VSS NOR2_X1
XI1436_I88_XG I1436_pn22 I1436_gn21 I1436_gn22 I1436_G22_21 VDD VSS OAI21_X1
XI1436_I88_XP I1436_pn22 I1436_pn21 I1436_P22_21 VDD VSS NOR2_X1
XI1436_I89_XG I1436_pn23 I1436_gn22 I1436_gn23 I1436_G23_22 VDD VSS OAI21_X1
XI1436_I89_XP I1436_pn23 I1436_pn22 I1436_P23_22 VDD VSS NOR2_X1
XI1436_I90_XG I1436_pn24 I1436_gn23 I1436_gn24 I1436_G24_23 VDD VSS OAI21_X1
XI1436_I90_XP I1436_pn24 I1436_pn23 I1436_P24_23 VDD VSS NOR2_X1
XI1436_I91_XG I1436_pn25 I1436_gn24 I1436_gn25 I1436_G25_24 VDD VSS OAI21_X1
XI1436_I91_XP I1436_pn25 I1436_pn24 I1436_P25_24 VDD VSS NOR2_X1
XI1436_I92_XG I1436_pn26 I1436_gn25 I1436_gn26 I1436_G26_25 VDD VSS OAI21_X1
XI1436_I92_XP I1436_pn26 I1436_pn25 I1436_P26_25 VDD VSS NOR2_X1
XI1436_I93_XG I1436_pn27 I1436_gn26 I1436_gn27 I1436_G27_26 VDD VSS OAI21_X1
XI1436_I93_XP I1436_pn27 I1436_pn26 I1436_P27_26 VDD VSS NOR2_X1
XI1436_I94_XG I1436_pn28 I1436_gn27 I1436_gn28 I1436_G28_27 VDD VSS OAI21_X1
XI1436_I94_XP I1436_pn28 I1436_pn27 I1436_P28_27 VDD VSS NOR2_X1
XI1436_I95_XG I1436_pn29 I1436_gn28 I1436_gn29 I1436_G29_28 VDD VSS OAI21_X1
XI1436_I95_XP I1436_pn29 I1436_pn28 I1436_P29_28 VDD VSS NOR2_X1
XI1436_I96_XG I1436_pn30 I1436_gn29 I1436_gn30 I1436_G30_29 VDD VSS OAI21_X1
XI1436_I96_XP I1436_pn30 I1436_pn29 I1436_P30_29 VDD VSS NOR2_X1
XI1436_I97_XG I1436_pn31 I1436_gn30 I1436_gn31 I1436_G31_30 VDD VSS OAI21_X1
XI1436_I97_XP I1436_pn31 I1436_pn30 I1436_P31_30 VDD VSS NOR2_X1
XI1436_I98_XG I1436_P2_1 I1436_G0_0 I1436_G2_1 I1436_G2_0n VDD VSS AOI21_X1
XI1436_I99_XG I1436_P3_2 I1436_G1_0 I1436_G3_2 I1436_G3_0n VDD VSS AOI21_X1
XI1436_I100_XG I1436_P4_3 I1436_G2_1 I1436_G4_3 I1436_G4_1n VDD VSS AOI21_X1
XI1436_I100_XP I1436_P4_3 I1436_P2_1 I1436_P4_1n VDD VSS NAND2_X1
XI1436_I101_XG I1436_P5_4 I1436_G3_2 I1436_G5_4 I1436_G5_2n VDD VSS AOI21_X1
XI1436_I101_XP I1436_P5_4 I1436_P3_2 I1436_P5_2n VDD VSS NAND2_X1
XI1436_I102_XG I1436_P6_5 I1436_G4_3 I1436_G6_5 I1436_G6_3n VDD VSS AOI21_X1
XI1436_I102_XP I1436_P6_5 I1436_P4_3 I1436_P6_3n VDD VSS NAND2_X1
XI1436_I103_XG I1436_P7_6 I1436_G5_4 I1436_G7_6 I1436_G7_4n VDD VSS AOI21_X1
XI1436_I103_XP I1436_P7_6 I1436_P5_4 I1436_P7_4n VDD VSS NAND2_X1
XI1436_I104_XG I1436_P8_7 I1436_G6_5 I1436_G8_7 I1436_G8_5n VDD VSS AOI21_X1
XI1436_I104_XP I1436_P8_7 I1436_P6_5 I1436_P8_5n VDD VSS NAND2_X1
XI1436_I105_XG I1436_P9_8 I1436_G7_6 I1436_G9_8 I1436_G9_6n VDD VSS AOI21_X1
XI1436_I105_XP I1436_P9_8 I1436_P7_6 I1436_P9_6n VDD VSS NAND2_X1
XI1436_I106_XG I1436_P10_9 I1436_G8_7 I1436_G10_9 I1436_G10_7n VDD VSS AOI21_X1
XI1436_I106_XP I1436_P10_9 I1436_P8_7 I1436_P10_7n VDD VSS NAND2_X1
XI1436_I107_XG I1436_P11_10 I1436_G9_8 I1436_G11_10 I1436_G11_8n VDD VSS AOI21_X1
XI1436_I107_XP I1436_P11_10 I1436_P9_8 I1436_P11_8n VDD VSS NAND2_X1
XI1436_I108_XG I1436_P12_11 I1436_G10_9 I1436_G12_11 I1436_G12_9n VDD VSS AOI21_X1
XI1436_I108_XP I1436_P12_11 I1436_P10_9 I1436_P12_9n VDD VSS NAND2_X1
XI1436_I109_XG I1436_P13_12 I1436_G11_10 I1436_G13_12 I1436_G13_10n VDD VSS AOI21_X1
XI1436_I109_XP I1436_P13_12 I1436_P11_10 I1436_P13_10n VDD VSS NAND2_X1
XI1436_I110_XG I1436_P14_13 I1436_G12_11 I1436_G14_13 I1436_G14_11n VDD VSS AOI21_X1
XI1436_I110_XP I1436_P14_13 I1436_P12_11 I1436_P14_11n VDD VSS NAND2_X1
XI1436_I111_XG I1436_P15_14 I1436_G13_12 I1436_G15_14 I1436_G15_12n VDD VSS AOI21_X1
XI1436_I111_XP I1436_P15_14 I1436_P13_12 I1436_P15_12n VDD VSS NAND2_X1
XI1436_I112_XG I1436_P16_15 I1436_G14_13 I1436_G16_15 I1436_G16_13n VDD VSS AOI21_X1
XI1436_I112_XP I1436_P16_15 I1436_P14_13 I1436_P16_13n VDD VSS NAND2_X1
XI1436_I113_XG I1436_P17_16 I1436_G15_14 I1436_G17_16 I1436_G17_14n VDD VSS AOI21_X1
XI1436_I113_XP I1436_P17_16 I1436_P15_14 I1436_P17_14n VDD VSS NAND2_X1
XI1436_I114_XG I1436_P18_17 I1436_G16_15 I1436_G18_17 I1436_G18_15n VDD VSS AOI21_X1
XI1436_I114_XP I1436_P18_17 I1436_P16_15 I1436_P18_15n VDD VSS NAND2_X1
XI1436_I115_XG I1436_P19_18 I1436_G17_16 I1436_G19_18 I1436_G19_16n VDD VSS AOI21_X1
XI1436_I115_XP I1436_P19_18 I1436_P17_16 I1436_P19_16n VDD VSS NAND2_X1
XI1436_I116_XG I1436_P20_19 I1436_G18_17 I1436_G20_19 I1436_G20_17n VDD VSS AOI21_X1
XI1436_I116_XP I1436_P20_19 I1436_P18_17 I1436_P20_17n VDD VSS NAND2_X1
XI1436_I117_XG I1436_P21_20 I1436_G19_18 I1436_G21_20 I1436_G21_18n VDD VSS AOI21_X1
XI1436_I117_XP I1436_P21_20 I1436_P19_18 I1436_P21_18n VDD VSS NAND2_X1
XI1436_I118_XG I1436_P22_21 I1436_G20_19 I1436_G22_21 I1436_G22_19n VDD VSS AOI21_X1
XI1436_I118_XP I1436_P22_21 I1436_P20_19 I1436_P22_19n VDD VSS NAND2_X1
XI1436_I119_XG I1436_P23_22 I1436_G21_20 I1436_G23_22 I1436_G23_20n VDD VSS AOI21_X1
XI1436_I119_XP I1436_P23_22 I1436_P21_20 I1436_P23_20n VDD VSS NAND2_X1
XI1436_I120_XG I1436_P24_23 I1436_G22_21 I1436_G24_23 I1436_G24_21n VDD VSS AOI21_X1
XI1436_I120_XP I1436_P24_23 I1436_P22_21 I1436_P24_21n VDD VSS NAND2_X1
XI1436_I121_XG I1436_P25_24 I1436_G23_22 I1436_G25_24 I1436_G25_22n VDD VSS AOI21_X1
XI1436_I121_XP I1436_P25_24 I1436_P23_22 I1436_P25_22n VDD VSS NAND2_X1
XI1436_I122_XG I1436_P26_25 I1436_G24_23 I1436_G26_25 I1436_G26_23n VDD VSS AOI21_X1
XI1436_I122_XP I1436_P26_25 I1436_P24_23 I1436_P26_23n VDD VSS NAND2_X1
XI1436_I123_XG I1436_P27_26 I1436_G25_24 I1436_G27_26 I1436_G27_24n VDD VSS AOI21_X1
XI1436_I123_XP I1436_P27_26 I1436_P25_24 I1436_P27_24n VDD VSS NAND2_X1
XI1436_I124_XG I1436_P28_27 I1436_G26_25 I1436_G28_27 I1436_G28_25n VDD VSS AOI21_X1
XI1436_I124_XP I1436_P28_27 I1436_P26_25 I1436_P28_25n VDD VSS NAND2_X1
XI1436_I125_XG I1436_P29_28 I1436_G27_26 I1436_G29_28 I1436_G29_26n VDD VSS AOI21_X1
XI1436_I125_XP I1436_P29_28 I1436_P27_26 I1436_P29_26n VDD VSS NAND2_X1
XI1436_I126_XG I1436_P30_29 I1436_G28_27 I1436_G30_29 I1436_G30_27n VDD VSS AOI21_X1
XI1436_I126_XP I1436_P30_29 I1436_P28_27 I1436_P30_27n VDD VSS NAND2_X1
XI1436_I127_XG I1436_P31_30 I1436_G29_28 I1436_G31_30 I1436_G31_28n VDD VSS AOI21_X1
XI1436_I127_XP I1436_P31_30 I1436_P29_28 I1436_P31_28n VDD VSS NAND2_X1
XI1436_I128_XG I1436_P4_1n I1436_G0_0n I1436_G4_1n I1436_G4_0 VDD VSS OAI21_X1
XI1436_I129 I1436_G1_0 I1436_G1_0n VDD VSS INV_X1
XI1436_I130_XG I1436_P5_2n I1436_G1_0n I1436_G5_2n I1436_G5_0 VDD VSS OAI21_X1
XI1436_I131_XG I1436_P6_3n I1436_G2_0n I1436_G6_3n I1436_G6_0 VDD VSS OAI21_X1
XI1436_I132_XG I1436_P7_4n I1436_G3_0n I1436_G7_4n I1436_G7_0 VDD VSS OAI21_X1
XI1436_I133_XG I1436_P8_5n I1436_G4_1n I1436_G8_5n I1436_G8_1 VDD VSS OAI21_X1
XI1436_I133_XP I1436_P8_5n I1436_P4_1n I1436_P8_1 VDD VSS NOR2_X1
XI1436_I134_XG I1436_P9_6n I1436_G5_2n I1436_G9_6n I1436_G9_2 VDD VSS OAI21_X1
XI1436_I134_XP I1436_P9_6n I1436_P5_2n I1436_P9_2 VDD VSS NOR2_X1
XI1436_I135_XG I1436_P10_7n I1436_G6_3n I1436_G10_7n I1436_G10_3 VDD VSS OAI21_X1
XI1436_I135_XP I1436_P10_7n I1436_P6_3n I1436_P10_3 VDD VSS NOR2_X1
XI1436_I136_XG I1436_P11_8n I1436_G7_4n I1436_G11_8n I1436_G11_4 VDD VSS OAI21_X1
XI1436_I136_XP I1436_P11_8n I1436_P7_4n I1436_P11_4 VDD VSS NOR2_X1
XI1436_I137_XG I1436_P12_9n I1436_G8_5n I1436_G12_9n I1436_G12_5 VDD VSS OAI21_X1
XI1436_I137_XP I1436_P12_9n I1436_P8_5n I1436_P12_5 VDD VSS NOR2_X1
XI1436_I138_XG I1436_P13_10n I1436_G9_6n I1436_G13_10n I1436_G13_6 VDD VSS OAI21_X1
XI1436_I138_XP I1436_P13_10n I1436_P9_6n I1436_P13_6 VDD VSS NOR2_X1
XI1436_I139_XG I1436_P14_11n I1436_G10_7n I1436_G14_11n I1436_G14_7 VDD VSS OAI21_X1
XI1436_I139_XP I1436_P14_11n I1436_P10_7n I1436_P14_7 VDD VSS NOR2_X1
XI1436_I140_XG I1436_P15_12n I1436_G11_8n I1436_G15_12n I1436_G15_8 VDD VSS OAI21_X1
XI1436_I140_XP I1436_P15_12n I1436_P11_8n I1436_P15_8 VDD VSS NOR2_X1
XI1436_I141_XG I1436_P16_13n I1436_G12_9n I1436_G16_13n I1436_G16_9 VDD VSS OAI21_X1
XI1436_I141_XP I1436_P16_13n I1436_P12_9n I1436_P16_9 VDD VSS NOR2_X1
XI1436_I142_XG I1436_P17_14n I1436_G13_10n I1436_G17_14n I1436_G17_10 VDD VSS OAI21_X1
XI1436_I142_XP I1436_P17_14n I1436_P13_10n I1436_P17_10 VDD VSS NOR2_X1
XI1436_I143_XG I1436_P18_15n I1436_G14_11n I1436_G18_15n I1436_G18_11 VDD VSS OAI21_X1
XI1436_I143_XP I1436_P18_15n I1436_P14_11n I1436_P18_11 VDD VSS NOR2_X1
XI1436_I144_XG I1436_P19_16n I1436_G15_12n I1436_G19_16n I1436_G19_12 VDD VSS OAI21_X1
XI1436_I144_XP I1436_P19_16n I1436_P15_12n I1436_P19_12 VDD VSS NOR2_X1
XI1436_I145_XG I1436_P20_17n I1436_G16_13n I1436_G20_17n I1436_G20_13 VDD VSS OAI21_X1
XI1436_I145_XP I1436_P20_17n I1436_P16_13n I1436_P20_13 VDD VSS NOR2_X1
XI1436_I146_XG I1436_P21_18n I1436_G17_14n I1436_G21_18n I1436_G21_14 VDD VSS OAI21_X1
XI1436_I146_XP I1436_P21_18n I1436_P17_14n I1436_P21_14 VDD VSS NOR2_X1
XI1436_I147_XG I1436_P22_19n I1436_G18_15n I1436_G22_19n I1436_G22_15 VDD VSS OAI21_X1
XI1436_I147_XP I1436_P22_19n I1436_P18_15n I1436_P22_15 VDD VSS NOR2_X1
XI1436_I148_XG I1436_P23_20n I1436_G19_16n I1436_G23_20n I1436_G23_16 VDD VSS OAI21_X1
XI1436_I148_XP I1436_P23_20n I1436_P19_16n I1436_P23_16 VDD VSS NOR2_X1
XI1436_I149_XG I1436_P24_21n I1436_G20_17n I1436_G24_21n I1436_G24_17 VDD VSS OAI21_X1
XI1436_I149_XP I1436_P24_21n I1436_P20_17n I1436_P24_17 VDD VSS NOR2_X1
XI1436_I150_XG I1436_P25_22n I1436_G21_18n I1436_G25_22n I1436_G25_18 VDD VSS OAI21_X1
XI1436_I150_XP I1436_P25_22n I1436_P21_18n I1436_P25_18 VDD VSS NOR2_X1
XI1436_I151_XG I1436_P26_23n I1436_G22_19n I1436_G26_23n I1436_G26_19 VDD VSS OAI21_X1
XI1436_I151_XP I1436_P26_23n I1436_P22_19n I1436_P26_19 VDD VSS NOR2_X1
XI1436_I152_XG I1436_P27_24n I1436_G23_20n I1436_G27_24n I1436_G27_20 VDD VSS OAI21_X1
XI1436_I152_XP I1436_P27_24n I1436_P23_20n I1436_P27_20 VDD VSS NOR2_X1
XI1436_I153_XG I1436_P28_25n I1436_G24_21n I1436_G28_25n I1436_G28_21 VDD VSS OAI21_X1
XI1436_I153_XP I1436_P28_25n I1436_P24_21n I1436_P28_21 VDD VSS NOR2_X1
XI1436_I154_XG I1436_P29_26n I1436_G25_22n I1436_G29_26n I1436_G29_22 VDD VSS OAI21_X1
XI1436_I154_XP I1436_P29_26n I1436_P25_22n I1436_P29_22 VDD VSS NOR2_X1
XI1436_I155_XG I1436_P30_27n I1436_G26_23n I1436_G30_27n I1436_G30_23 VDD VSS OAI21_X1
XI1436_I155_XP I1436_P30_27n I1436_P26_23n I1436_P30_23 VDD VSS NOR2_X1
XI1436_I156_XG I1436_P31_28n I1436_G27_24n I1436_G31_28n I1436_G31_24 VDD VSS OAI21_X1
XI1436_I156_XP I1436_P31_28n I1436_P27_24n I1436_P31_24 VDD VSS NOR2_X1
XI1436_I157_XG I1436_P8_1 I1436_G0_0 I1436_G8_1 I1436_G8_0n VDD VSS AOI21_X1
XI1436_I158_XG I1436_P9_2 I1436_G1_0 I1436_G9_2 I1436_G9_0n VDD VSS AOI21_X1
XI1436_I159 I1436_G2_0n I1436_G2_0np VDD VSS INV_X1
XI1436_I160_XG I1436_P10_3 I1436_G2_0np I1436_G10_3 I1436_G10_0n VDD VSS AOI21_X1
XI1436_I161 I1436_G3_0n I1436_G3_0np VDD VSS INV_X1
XI1436_I162_XG I1436_P11_4 I1436_G3_0np I1436_G11_4 I1436_G11_0n VDD VSS AOI21_X1
XI1436_I163_XG I1436_P12_5 I1436_G4_0 I1436_G12_5 I1436_G12_0n VDD VSS AOI21_X1
XI1436_I164_XG I1436_P13_6 I1436_G5_0 I1436_G13_6 I1436_G13_0n VDD VSS AOI21_X1
XI1436_I165_XG I1436_P14_7 I1436_G6_0 I1436_G14_7 I1436_G14_0n VDD VSS AOI21_X1
XI1436_I166_XG I1436_P15_8 I1436_G7_0 I1436_G15_8 I1436_G15_0n VDD VSS AOI21_X1
XI1436_I167_XG I1436_P16_9 I1436_G8_1 I1436_G16_9 I1436_G16_1n VDD VSS AOI21_X1
XI1436_I167_XP I1436_P16_9 I1436_P8_1 I1436_P16_1n VDD VSS NAND2_X1
XI1436_I168_XG I1436_P17_10 I1436_G9_2 I1436_G17_10 I1436_G17_2n VDD VSS AOI21_X1
XI1436_I168_XP I1436_P17_10 I1436_P9_2 I1436_P17_2n VDD VSS NAND2_X1
XI1436_I169_XG I1436_P18_11 I1436_G10_3 I1436_G18_11 I1436_G18_3n VDD VSS AOI21_X1
XI1436_I169_XP I1436_P18_11 I1436_P10_3 I1436_P18_3n VDD VSS NAND2_X1
XI1436_I170_XG I1436_P19_12 I1436_G11_4 I1436_G19_12 I1436_G19_4n VDD VSS AOI21_X1
XI1436_I170_XP I1436_P19_12 I1436_P11_4 I1436_P19_4n VDD VSS NAND2_X1
XI1436_I171_XG I1436_P20_13 I1436_G12_5 I1436_G20_13 I1436_G20_5n VDD VSS AOI21_X1
XI1436_I171_XP I1436_P20_13 I1436_P12_5 I1436_P20_5n VDD VSS NAND2_X1
XI1436_I172_XG I1436_P21_14 I1436_G13_6 I1436_G21_14 I1436_G21_6n VDD VSS AOI21_X1
XI1436_I172_XP I1436_P21_14 I1436_P13_6 I1436_P21_6n VDD VSS NAND2_X1
XI1436_I173_XG I1436_P22_15 I1436_G14_7 I1436_G22_15 I1436_G22_7n VDD VSS AOI21_X1
XI1436_I173_XP I1436_P22_15 I1436_P14_7 I1436_P22_7n VDD VSS NAND2_X1
XI1436_I174_XG I1436_P23_16 I1436_G15_8 I1436_G23_16 I1436_G23_8n VDD VSS AOI21_X1
XI1436_I174_XP I1436_P23_16 I1436_P15_8 I1436_P23_8n VDD VSS NAND2_X1
XI1436_I175_XG I1436_P24_17 I1436_G16_9 I1436_G24_17 I1436_G24_9n VDD VSS AOI21_X1
XI1436_I175_XP I1436_P24_17 I1436_P16_9 I1436_P24_9n VDD VSS NAND2_X1
XI1436_I176_XG I1436_P25_18 I1436_G17_10 I1436_G25_18 I1436_G25_10n VDD VSS AOI21_X1
XI1436_I176_XP I1436_P25_18 I1436_P17_10 I1436_P25_10n VDD VSS NAND2_X1
XI1436_I177_XG I1436_P26_19 I1436_G18_11 I1436_G26_19 I1436_G26_11n VDD VSS AOI21_X1
XI1436_I177_XP I1436_P26_19 I1436_P18_11 I1436_P26_11n VDD VSS NAND2_X1
XI1436_I178_XG I1436_P27_20 I1436_G19_12 I1436_G27_20 I1436_G27_12n VDD VSS AOI21_X1
XI1436_I178_XP I1436_P27_20 I1436_P19_12 I1436_P27_12n VDD VSS NAND2_X1
XI1436_I179_XG I1436_P28_21 I1436_G20_13 I1436_G28_21 I1436_G28_13n VDD VSS AOI21_X1
XI1436_I179_XP I1436_P28_21 I1436_P20_13 I1436_P28_13n VDD VSS NAND2_X1
XI1436_I180_XG I1436_P29_22 I1436_G21_14 I1436_G29_22 I1436_G29_14n VDD VSS AOI21_X1
XI1436_I180_XP I1436_P29_22 I1436_P21_14 I1436_P29_14n VDD VSS NAND2_X1
XI1436_I181_XG I1436_P30_23 I1436_G22_15 I1436_G30_23 I1436_G30_15n VDD VSS AOI21_X1
XI1436_I181_XP I1436_P30_23 I1436_P22_15 I1436_P30_15n VDD VSS NAND2_X1
XI1436_I182_XG I1436_P31_24 I1436_G23_16 I1436_G31_24 I1436_G31_16n VDD VSS AOI21_X1
XI1436_I182_XP I1436_P31_24 I1436_P23_16 I1436_P31_16n VDD VSS NAND2_X1
XI1436_I183_XG I1436_P16_1n I1436_G0_0n I1436_G16_1n I1436_G16_0 VDD VSS OAI21_X1
XI1436_I184_XG I1436_P17_2n I1436_G1_0n I1436_G17_2n I1436_G17_0 VDD VSS OAI21_X1
XI1436_I185_XG I1436_P18_3n I1436_G2_0n I1436_G18_3n I1436_G18_0 VDD VSS OAI21_X1
XI1436_I186_XG I1436_P19_4n I1436_G3_0n I1436_G19_4n I1436_G19_0 VDD VSS OAI21_X1
XI1436_I187 I1436_G4_0 I1436_G4_0n VDD VSS INV_X1
XI1436_I188_XG I1436_P20_5n I1436_G4_0n I1436_G20_5n I1436_G20_0 VDD VSS OAI21_X1
XI1436_I189 I1436_G5_0 I1436_G5_0n VDD VSS INV_X1
XI1436_I190_XG I1436_P21_6n I1436_G5_0n I1436_G21_6n I1436_G21_0 VDD VSS OAI21_X1
XI1436_I191 I1436_G6_0 I1436_G6_0n VDD VSS INV_X1
XI1436_I192_XG I1436_P22_7n I1436_G6_0n I1436_G22_7n I1436_G22_0 VDD VSS OAI21_X1
XI1436_I193 I1436_G7_0 I1436_G7_0n VDD VSS INV_X1
XI1436_I194_XG I1436_P23_8n I1436_G7_0n I1436_G23_8n I1436_G23_0 VDD VSS OAI21_X1
XI1436_I195_XG I1436_P24_9n I1436_G8_0n I1436_G24_9n I1436_G24_0 VDD VSS OAI21_X1
XI1436_I196_XG I1436_P25_10n I1436_G9_0n I1436_G25_10n I1436_G25_0 VDD VSS OAI21_X1
XI1436_I197_XG I1436_P26_11n I1436_G10_0n I1436_G26_11n I1436_G26_0 VDD VSS OAI21_X1
XI1436_I198_XG I1436_P27_12n I1436_G11_0n I1436_G27_12n I1436_G27_0 VDD VSS OAI21_X1
XI1436_I199_XG I1436_P28_13n I1436_G12_0n I1436_G28_13n I1436_G28_0 VDD VSS OAI21_X1
XI1436_I200_XG I1436_P29_14n I1436_G13_0n I1436_G29_14n I1436_G29_0 VDD VSS OAI21_X1
XI1436_I201_XG I1436_P30_15n I1436_G14_0n I1436_G30_15n c19_m VDD VSS OAI21_X1
XI1436_I202_XG I1436_P31_16n I1436_G15_0n I1436_G31_16n c19_o VDD VSS OAI21_X1
XI1436_I203 I1436_pn0 qu13_b3_5 p19_0 VDD VSS XNOR2_X1
XI1436_I204 I1436_pn1 I1436_G0_0 p19_1 VDD VSS XNOR2_X1
XI1436_I205 I1436_pn2 I1436_G1_0 p19_2 VDD VSS XNOR2_X1
XI1436_I206 I1436_pn3 I1436_G2_0n p19_3 VDD VSS XOR2_X1
XI1436_I207 I1436_pn4 I1436_G3_0n p19_4 VDD VSS XOR2_X1
XI1436_I208 I1436_pn5 I1436_G4_0 p19_5 VDD VSS XNOR2_X1
XI1436_I209 I1436_pn6 I1436_G5_0 p19_6 VDD VSS XNOR2_X1
XI1436_I210 I1436_pn7 I1436_G6_0 p19_7 VDD VSS XNOR2_X1
XI1436_I211 I1436_pn8 I1436_G7_0 p19_8 VDD VSS XNOR2_X1
XI1436_I212 I1436_pn9 I1436_G8_0n p19_9 VDD VSS XOR2_X1
XI1436_I213 I1436_pn10 I1436_G9_0n p19_10 VDD VSS XOR2_X1
XI1436_I214 I1436_pn11 I1436_G10_0n p19_11 VDD VSS XOR2_X1
XI1436_I215 I1436_pn12 I1436_G11_0n p19_12 VDD VSS XOR2_X1
XI1436_I216 I1436_pn13 I1436_G12_0n p19_13 VDD VSS XOR2_X1
XI1436_I217 I1436_pn14 I1436_G13_0n p19_14 VDD VSS XOR2_X1
XI1436_I218 I1436_pn15 I1436_G14_0n p19_15 VDD VSS XOR2_X1
XI1436_I219 I1436_pn16 I1436_G15_0n p19_16 VDD VSS XOR2_X1
XI1436_I220 I1436_pn17 I1436_G16_0 p19_17 VDD VSS XNOR2_X1
XI1436_I221 I1436_pn18 I1436_G17_0 p19_18 VDD VSS XNOR2_X1
XI1436_I222 I1436_pn19 I1436_G18_0 p19_19 VDD VSS XNOR2_X1
XI1436_I223 I1436_pn20 I1436_G19_0 p19_20 VDD VSS XNOR2_X1
XI1436_I224 I1436_pn21 I1436_G20_0 p19_21 VDD VSS XNOR2_X1
XI1436_I225 I1436_pn22 I1436_G21_0 p19_22 VDD VSS XNOR2_X1
XI1436_I226 I1436_pn23 I1436_G22_0 p19_23 VDD VSS XNOR2_X1
XI1436_I227 I1436_pn24 I1436_G23_0 p19_24 VDD VSS XNOR2_X1
XI1436_I228 I1436_pn25 I1436_G24_0 p19_25 VDD VSS XNOR2_X1
XI1436_I229 I1436_pn26 I1436_G25_0 p19_26 VDD VSS XNOR2_X1
XI1436_I230 I1436_pn27 I1436_G26_0 p19_27 VDD VSS XNOR2_X1
XI1436_I231 I1436_pn28 I1436_G27_0 p19_28 VDD VSS XNOR2_X1
XI1436_I232 I1436_pn29 I1436_G28_0 p19_29 VDD VSS XNOR2_X1
XI1436_I233 I1436_pn30 I1436_G29_0 p19_30 VDD VSS XNOR2_X1
XI1436_I234 I1436_pn31 c19_m p19_31 VDD VSS XNOR2_X1
XI1437 p18_31 qu13_b3_5 h19 VDD VSS XOR2_X1
XI1438 h19 c19_o p19_32 VDD VSS XOR2_X1
XI1439 p19_32 qu12 VDD VSS INV_X4
XI1440 qu12 qu12_b0 VDD VSS INV_X1
XI1441 qu12_b0 qu12_b1_0 VDD VSS INV_X4
XI1442 qu12_b1_0 qu12_b2_0 VDD VSS INV_X4
XI1443 qu12_b1_0 qu12_b2_1 VDD VSS INV_X4
XI1444 qu12_b2_0 qu12_b3_0 VDD VSS INV_X4
XI1445 qu12_b2_0 qu12_b3_1 VDD VSS INV_X4
XI1446 qu12_b2_0 qu12_b3_2 VDD VSS INV_X4
XI1447 qu12_b2_1 qu12_b3_3 VDD VSS INV_X4
XI1448 qu12_b2_1 qu12_b3_4 VDD VSS INV_X4
XI1449 qu12_b2_1 qu12_b3_5 VDD VSS INV_X4
XI1450 B_0_b3_3 qu12_b3_0 b20_0 VDD VSS XOR2_X1
XI1451 dd1_b3_3 qu12_b3_0 b20_1 VDD VSS XOR2_X1
XI1452 dd2_b3_3 qu12_b3_0 b20_2 VDD VSS XOR2_X1
XI1453 dd3_b3_3 qu12_b3_0 b20_3 VDD VSS XOR2_X1
XI1454 dd4_b3_3 qu12_b3_0 b20_4 VDD VSS XOR2_X1
XI1455 dd5_b3_3 qu12_b3_0 b20_5 VDD VSS XOR2_X1
XI1456 dd6_b3_3 qu12_b3_1 b20_6 VDD VSS XOR2_X1
XI1457 dd7_b3_3 qu12_b3_1 b20_7 VDD VSS XOR2_X1
XI1458 dd8_b3_3 qu12_b3_1 b20_8 VDD VSS XOR2_X1
XI1459 dd9_b3_3 qu12_b3_1 b20_9 VDD VSS XOR2_X1
XI1460 dd10_b3_3 qu12_b3_1 b20_10 VDD VSS XOR2_X1
XI1461 dd11_b3_3 qu12_b3_1 b20_11 VDD VSS XOR2_X1
XI1462 dd12_b3_3 qu12_b3_2 b20_12 VDD VSS XOR2_X1
XI1463 dd13_b3_3 qu12_b3_2 b20_13 VDD VSS XOR2_X1
XI1464 dd14_b3_3 qu12_b3_2 b20_14 VDD VSS XOR2_X1
XI1465 dd15_b3_3 qu12_b3_2 b20_15 VDD VSS XOR2_X1
XI1466 dd16_b3_3 qu12_b3_2 b20_16 VDD VSS XOR2_X1
XI1467 dd17_b3_3 qu12_b3_2 b20_17 VDD VSS XOR2_X1
XI1468 dd18_b3_3 qu12_b3_3 b20_18 VDD VSS XOR2_X1
XI1469 dd19_b3_3 qu12_b3_3 b20_19 VDD VSS XOR2_X1
XI1470 dd20_b3_3 qu12_b3_3 b20_20 VDD VSS XOR2_X1
XI1471 dd21_b3_3 qu12_b3_3 b20_21 VDD VSS XOR2_X1
XI1472 dd22_b3_3 qu12_b3_3 b20_22 VDD VSS XOR2_X1
XI1473 dd23_b3_3 qu12_b3_3 b20_23 VDD VSS XOR2_X1
XI1474 dd24_b3_3 qu12_b3_4 b20_24 VDD VSS XOR2_X1
XI1475 dd25_b3_3 qu12_b3_4 b20_25 VDD VSS XOR2_X1
XI1476 dd26_b3_3 qu12_b3_4 b20_26 VDD VSS XOR2_X1
XI1477 dd27_b3_3 qu12_b3_4 b20_27 VDD VSS XOR2_X1
XI1478 dd28_b3_3 qu12_b3_4 b20_28 VDD VSS XOR2_X1
XI1479 dd29_b3_3 qu12_b3_4 b20_29 VDD VSS XOR2_X1
XI1480 dd30_b3_3 qu12_b3_5 b20_30 VDD VSS XOR2_X1
XI1481 dd31_b3_3 qu12_b3_5 b20_31 VDD VSS XOR2_X1
XI1482_I0 aa11 b20_0 I1482_gn0 VDD VSS NAND2_X1
XI1482_I1 p19_0 b20_1 I1482_gn1 VDD VSS NAND2_X1
XI1482_I2 p19_1 b20_2 I1482_gn2 VDD VSS NAND2_X1
XI1482_I3 p19_2 b20_3 I1482_gn3 VDD VSS NAND2_X1
XI1482_I4 p19_3 b20_4 I1482_gn4 VDD VSS NAND2_X1
XI1482_I5 p19_4 b20_5 I1482_gn5 VDD VSS NAND2_X1
XI1482_I6 p19_5 b20_6 I1482_gn6 VDD VSS NAND2_X1
XI1482_I7 p19_6 b20_7 I1482_gn7 VDD VSS NAND2_X1
XI1482_I8 p19_7 b20_8 I1482_gn8 VDD VSS NAND2_X1
XI1482_I9 p19_8 b20_9 I1482_gn9 VDD VSS NAND2_X1
XI1482_I10 p19_9 b20_10 I1482_gn10 VDD VSS NAND2_X1
XI1482_I11 p19_10 b20_11 I1482_gn11 VDD VSS NAND2_X1
XI1482_I12 p19_11 b20_12 I1482_gn12 VDD VSS NAND2_X1
XI1482_I13 p19_12 b20_13 I1482_gn13 VDD VSS NAND2_X1
XI1482_I14 p19_13 b20_14 I1482_gn14 VDD VSS NAND2_X1
XI1482_I15 p19_14 b20_15 I1482_gn15 VDD VSS NAND2_X1
XI1482_I16 p19_15 b20_16 I1482_gn16 VDD VSS NAND2_X1
XI1482_I17 p19_16 b20_17 I1482_gn17 VDD VSS NAND2_X1
XI1482_I18 p19_17 b20_18 I1482_gn18 VDD VSS NAND2_X1
XI1482_I19 p19_18 b20_19 I1482_gn19 VDD VSS NAND2_X1
XI1482_I20 p19_19 b20_20 I1482_gn20 VDD VSS NAND2_X1
XI1482_I21 p19_20 b20_21 I1482_gn21 VDD VSS NAND2_X1
XI1482_I22 p19_21 b20_22 I1482_gn22 VDD VSS NAND2_X1
XI1482_I23 p19_22 b20_23 I1482_gn23 VDD VSS NAND2_X1
XI1482_I24 p19_23 b20_24 I1482_gn24 VDD VSS NAND2_X1
XI1482_I25 p19_24 b20_25 I1482_gn25 VDD VSS NAND2_X1
XI1482_I26 p19_25 b20_26 I1482_gn26 VDD VSS NAND2_X1
XI1482_I27 p19_26 b20_27 I1482_gn27 VDD VSS NAND2_X1
XI1482_I28 p19_27 b20_28 I1482_gn28 VDD VSS NAND2_X1
XI1482_I29 p19_28 b20_29 I1482_gn29 VDD VSS NAND2_X1
XI1482_I30 p19_29 b20_30 I1482_gn30 VDD VSS NAND2_X1
XI1482_I31 p19_30 b20_31 I1482_gn31 VDD VSS NAND2_X1
XI1482_I32 aa11 b20_0 I1482_pn0 VDD VSS XNOR2_X1
XI1482_I33 p19_0 b20_1 I1482_pn1 VDD VSS XNOR2_X1
XI1482_I34 p19_1 b20_2 I1482_pn2 VDD VSS XNOR2_X1
XI1482_I35 p19_2 b20_3 I1482_pn3 VDD VSS XNOR2_X1
XI1482_I36 p19_3 b20_4 I1482_pn4 VDD VSS XNOR2_X1
XI1482_I37 p19_4 b20_5 I1482_pn5 VDD VSS XNOR2_X1
XI1482_I38 p19_5 b20_6 I1482_pn6 VDD VSS XNOR2_X1
XI1482_I39 p19_6 b20_7 I1482_pn7 VDD VSS XNOR2_X1
XI1482_I40 p19_7 b20_8 I1482_pn8 VDD VSS XNOR2_X1
XI1482_I41 p19_8 b20_9 I1482_pn9 VDD VSS XNOR2_X1
XI1482_I42 p19_9 b20_10 I1482_pn10 VDD VSS XNOR2_X1
XI1482_I43 p19_10 b20_11 I1482_pn11 VDD VSS XNOR2_X1
XI1482_I44 p19_11 b20_12 I1482_pn12 VDD VSS XNOR2_X1
XI1482_I45 p19_12 b20_13 I1482_pn13 VDD VSS XNOR2_X1
XI1482_I46 p19_13 b20_14 I1482_pn14 VDD VSS XNOR2_X1
XI1482_I47 p19_14 b20_15 I1482_pn15 VDD VSS XNOR2_X1
XI1482_I48 p19_15 b20_16 I1482_pn16 VDD VSS XNOR2_X1
XI1482_I49 p19_16 b20_17 I1482_pn17 VDD VSS XNOR2_X1
XI1482_I50 p19_17 b20_18 I1482_pn18 VDD VSS XNOR2_X1
XI1482_I51 p19_18 b20_19 I1482_pn19 VDD VSS XNOR2_X1
XI1482_I52 p19_19 b20_20 I1482_pn20 VDD VSS XNOR2_X1
XI1482_I53 p19_20 b20_21 I1482_pn21 VDD VSS XNOR2_X1
XI1482_I54 p19_21 b20_22 I1482_pn22 VDD VSS XNOR2_X1
XI1482_I55 p19_22 b20_23 I1482_pn23 VDD VSS XNOR2_X1
XI1482_I56 p19_23 b20_24 I1482_pn24 VDD VSS XNOR2_X1
XI1482_I57 p19_24 b20_25 I1482_pn25 VDD VSS XNOR2_X1
XI1482_I58 p19_25 b20_26 I1482_pn26 VDD VSS XNOR2_X1
XI1482_I59 p19_26 b20_27 I1482_pn27 VDD VSS XNOR2_X1
XI1482_I60 p19_27 b20_28 I1482_pn28 VDD VSS XNOR2_X1
XI1482_I61 p19_28 b20_29 I1482_pn29 VDD VSS XNOR2_X1
XI1482_I62 p19_29 b20_30 I1482_pn30 VDD VSS XNOR2_X1
XI1482_I63 p19_30 b20_31 I1482_pn31 VDD VSS XNOR2_X1
XI1482_I64 qu12_b3_5 I1482_cinn VDD VSS INV_X1
XI1482_I65_XG I1482_pn0 I1482_cinn I1482_gn0 I1482_G0_0 VDD VSS OAI21_X1
XI1482_I66 I1482_G0_0 I1482_G0_0n VDD VSS INV_X1
XI1482_I67_XG I1482_pn1 I1482_G0_0n I1482_gn1 I1482_G1_0 VDD VSS OAI21_X1
XI1482_I68_XG I1482_pn2 I1482_gn1 I1482_gn2 I1482_G2_1 VDD VSS OAI21_X1
XI1482_I68_XP I1482_pn2 I1482_pn1 I1482_P2_1 VDD VSS NOR2_X1
XI1482_I69_XG I1482_pn3 I1482_gn2 I1482_gn3 I1482_G3_2 VDD VSS OAI21_X1
XI1482_I69_XP I1482_pn3 I1482_pn2 I1482_P3_2 VDD VSS NOR2_X1
XI1482_I70_XG I1482_pn4 I1482_gn3 I1482_gn4 I1482_G4_3 VDD VSS OAI21_X1
XI1482_I70_XP I1482_pn4 I1482_pn3 I1482_P4_3 VDD VSS NOR2_X1
XI1482_I71_XG I1482_pn5 I1482_gn4 I1482_gn5 I1482_G5_4 VDD VSS OAI21_X1
XI1482_I71_XP I1482_pn5 I1482_pn4 I1482_P5_4 VDD VSS NOR2_X1
XI1482_I72_XG I1482_pn6 I1482_gn5 I1482_gn6 I1482_G6_5 VDD VSS OAI21_X1
XI1482_I72_XP I1482_pn6 I1482_pn5 I1482_P6_5 VDD VSS NOR2_X1
XI1482_I73_XG I1482_pn7 I1482_gn6 I1482_gn7 I1482_G7_6 VDD VSS OAI21_X1
XI1482_I73_XP I1482_pn7 I1482_pn6 I1482_P7_6 VDD VSS NOR2_X1
XI1482_I74_XG I1482_pn8 I1482_gn7 I1482_gn8 I1482_G8_7 VDD VSS OAI21_X1
XI1482_I74_XP I1482_pn8 I1482_pn7 I1482_P8_7 VDD VSS NOR2_X1
XI1482_I75_XG I1482_pn9 I1482_gn8 I1482_gn9 I1482_G9_8 VDD VSS OAI21_X1
XI1482_I75_XP I1482_pn9 I1482_pn8 I1482_P9_8 VDD VSS NOR2_X1
XI1482_I76_XG I1482_pn10 I1482_gn9 I1482_gn10 I1482_G10_9 VDD VSS OAI21_X1
XI1482_I76_XP I1482_pn10 I1482_pn9 I1482_P10_9 VDD VSS NOR2_X1
XI1482_I77_XG I1482_pn11 I1482_gn10 I1482_gn11 I1482_G11_10 VDD VSS OAI21_X1
XI1482_I77_XP I1482_pn11 I1482_pn10 I1482_P11_10 VDD VSS NOR2_X1
XI1482_I78_XG I1482_pn12 I1482_gn11 I1482_gn12 I1482_G12_11 VDD VSS OAI21_X1
XI1482_I78_XP I1482_pn12 I1482_pn11 I1482_P12_11 VDD VSS NOR2_X1
XI1482_I79_XG I1482_pn13 I1482_gn12 I1482_gn13 I1482_G13_12 VDD VSS OAI21_X1
XI1482_I79_XP I1482_pn13 I1482_pn12 I1482_P13_12 VDD VSS NOR2_X1
XI1482_I80_XG I1482_pn14 I1482_gn13 I1482_gn14 I1482_G14_13 VDD VSS OAI21_X1
XI1482_I80_XP I1482_pn14 I1482_pn13 I1482_P14_13 VDD VSS NOR2_X1
XI1482_I81_XG I1482_pn15 I1482_gn14 I1482_gn15 I1482_G15_14 VDD VSS OAI21_X1
XI1482_I81_XP I1482_pn15 I1482_pn14 I1482_P15_14 VDD VSS NOR2_X1
XI1482_I82_XG I1482_pn16 I1482_gn15 I1482_gn16 I1482_G16_15 VDD VSS OAI21_X1
XI1482_I82_XP I1482_pn16 I1482_pn15 I1482_P16_15 VDD VSS NOR2_X1
XI1482_I83_XG I1482_pn17 I1482_gn16 I1482_gn17 I1482_G17_16 VDD VSS OAI21_X1
XI1482_I83_XP I1482_pn17 I1482_pn16 I1482_P17_16 VDD VSS NOR2_X1
XI1482_I84_XG I1482_pn18 I1482_gn17 I1482_gn18 I1482_G18_17 VDD VSS OAI21_X1
XI1482_I84_XP I1482_pn18 I1482_pn17 I1482_P18_17 VDD VSS NOR2_X1
XI1482_I85_XG I1482_pn19 I1482_gn18 I1482_gn19 I1482_G19_18 VDD VSS OAI21_X1
XI1482_I85_XP I1482_pn19 I1482_pn18 I1482_P19_18 VDD VSS NOR2_X1
XI1482_I86_XG I1482_pn20 I1482_gn19 I1482_gn20 I1482_G20_19 VDD VSS OAI21_X1
XI1482_I86_XP I1482_pn20 I1482_pn19 I1482_P20_19 VDD VSS NOR2_X1
XI1482_I87_XG I1482_pn21 I1482_gn20 I1482_gn21 I1482_G21_20 VDD VSS OAI21_X1
XI1482_I87_XP I1482_pn21 I1482_pn20 I1482_P21_20 VDD VSS NOR2_X1
XI1482_I88_XG I1482_pn22 I1482_gn21 I1482_gn22 I1482_G22_21 VDD VSS OAI21_X1
XI1482_I88_XP I1482_pn22 I1482_pn21 I1482_P22_21 VDD VSS NOR2_X1
XI1482_I89_XG I1482_pn23 I1482_gn22 I1482_gn23 I1482_G23_22 VDD VSS OAI21_X1
XI1482_I89_XP I1482_pn23 I1482_pn22 I1482_P23_22 VDD VSS NOR2_X1
XI1482_I90_XG I1482_pn24 I1482_gn23 I1482_gn24 I1482_G24_23 VDD VSS OAI21_X1
XI1482_I90_XP I1482_pn24 I1482_pn23 I1482_P24_23 VDD VSS NOR2_X1
XI1482_I91_XG I1482_pn25 I1482_gn24 I1482_gn25 I1482_G25_24 VDD VSS OAI21_X1
XI1482_I91_XP I1482_pn25 I1482_pn24 I1482_P25_24 VDD VSS NOR2_X1
XI1482_I92_XG I1482_pn26 I1482_gn25 I1482_gn26 I1482_G26_25 VDD VSS OAI21_X1
XI1482_I92_XP I1482_pn26 I1482_pn25 I1482_P26_25 VDD VSS NOR2_X1
XI1482_I93_XG I1482_pn27 I1482_gn26 I1482_gn27 I1482_G27_26 VDD VSS OAI21_X1
XI1482_I93_XP I1482_pn27 I1482_pn26 I1482_P27_26 VDD VSS NOR2_X1
XI1482_I94_XG I1482_pn28 I1482_gn27 I1482_gn28 I1482_G28_27 VDD VSS OAI21_X1
XI1482_I94_XP I1482_pn28 I1482_pn27 I1482_P28_27 VDD VSS NOR2_X1
XI1482_I95_XG I1482_pn29 I1482_gn28 I1482_gn29 I1482_G29_28 VDD VSS OAI21_X1
XI1482_I95_XP I1482_pn29 I1482_pn28 I1482_P29_28 VDD VSS NOR2_X1
XI1482_I96_XG I1482_pn30 I1482_gn29 I1482_gn30 I1482_G30_29 VDD VSS OAI21_X1
XI1482_I96_XP I1482_pn30 I1482_pn29 I1482_P30_29 VDD VSS NOR2_X1
XI1482_I97_XG I1482_pn31 I1482_gn30 I1482_gn31 I1482_G31_30 VDD VSS OAI21_X1
XI1482_I97_XP I1482_pn31 I1482_pn30 I1482_P31_30 VDD VSS NOR2_X1
XI1482_I98_XG I1482_P2_1 I1482_G0_0 I1482_G2_1 I1482_G2_0n VDD VSS AOI21_X1
XI1482_I99_XG I1482_P3_2 I1482_G1_0 I1482_G3_2 I1482_G3_0n VDD VSS AOI21_X1
XI1482_I100_XG I1482_P4_3 I1482_G2_1 I1482_G4_3 I1482_G4_1n VDD VSS AOI21_X1
XI1482_I100_XP I1482_P4_3 I1482_P2_1 I1482_P4_1n VDD VSS NAND2_X1
XI1482_I101_XG I1482_P5_4 I1482_G3_2 I1482_G5_4 I1482_G5_2n VDD VSS AOI21_X1
XI1482_I101_XP I1482_P5_4 I1482_P3_2 I1482_P5_2n VDD VSS NAND2_X1
XI1482_I102_XG I1482_P6_5 I1482_G4_3 I1482_G6_5 I1482_G6_3n VDD VSS AOI21_X1
XI1482_I102_XP I1482_P6_5 I1482_P4_3 I1482_P6_3n VDD VSS NAND2_X1
XI1482_I103_XG I1482_P7_6 I1482_G5_4 I1482_G7_6 I1482_G7_4n VDD VSS AOI21_X1
XI1482_I103_XP I1482_P7_6 I1482_P5_4 I1482_P7_4n VDD VSS NAND2_X1
XI1482_I104_XG I1482_P8_7 I1482_G6_5 I1482_G8_7 I1482_G8_5n VDD VSS AOI21_X1
XI1482_I104_XP I1482_P8_7 I1482_P6_5 I1482_P8_5n VDD VSS NAND2_X1
XI1482_I105_XG I1482_P9_8 I1482_G7_6 I1482_G9_8 I1482_G9_6n VDD VSS AOI21_X1
XI1482_I105_XP I1482_P9_8 I1482_P7_6 I1482_P9_6n VDD VSS NAND2_X1
XI1482_I106_XG I1482_P10_9 I1482_G8_7 I1482_G10_9 I1482_G10_7n VDD VSS AOI21_X1
XI1482_I106_XP I1482_P10_9 I1482_P8_7 I1482_P10_7n VDD VSS NAND2_X1
XI1482_I107_XG I1482_P11_10 I1482_G9_8 I1482_G11_10 I1482_G11_8n VDD VSS AOI21_X1
XI1482_I107_XP I1482_P11_10 I1482_P9_8 I1482_P11_8n VDD VSS NAND2_X1
XI1482_I108_XG I1482_P12_11 I1482_G10_9 I1482_G12_11 I1482_G12_9n VDD VSS AOI21_X1
XI1482_I108_XP I1482_P12_11 I1482_P10_9 I1482_P12_9n VDD VSS NAND2_X1
XI1482_I109_XG I1482_P13_12 I1482_G11_10 I1482_G13_12 I1482_G13_10n VDD VSS AOI21_X1
XI1482_I109_XP I1482_P13_12 I1482_P11_10 I1482_P13_10n VDD VSS NAND2_X1
XI1482_I110_XG I1482_P14_13 I1482_G12_11 I1482_G14_13 I1482_G14_11n VDD VSS AOI21_X1
XI1482_I110_XP I1482_P14_13 I1482_P12_11 I1482_P14_11n VDD VSS NAND2_X1
XI1482_I111_XG I1482_P15_14 I1482_G13_12 I1482_G15_14 I1482_G15_12n VDD VSS AOI21_X1
XI1482_I111_XP I1482_P15_14 I1482_P13_12 I1482_P15_12n VDD VSS NAND2_X1
XI1482_I112_XG I1482_P16_15 I1482_G14_13 I1482_G16_15 I1482_G16_13n VDD VSS AOI21_X1
XI1482_I112_XP I1482_P16_15 I1482_P14_13 I1482_P16_13n VDD VSS NAND2_X1
XI1482_I113_XG I1482_P17_16 I1482_G15_14 I1482_G17_16 I1482_G17_14n VDD VSS AOI21_X1
XI1482_I113_XP I1482_P17_16 I1482_P15_14 I1482_P17_14n VDD VSS NAND2_X1
XI1482_I114_XG I1482_P18_17 I1482_G16_15 I1482_G18_17 I1482_G18_15n VDD VSS AOI21_X1
XI1482_I114_XP I1482_P18_17 I1482_P16_15 I1482_P18_15n VDD VSS NAND2_X1
XI1482_I115_XG I1482_P19_18 I1482_G17_16 I1482_G19_18 I1482_G19_16n VDD VSS AOI21_X1
XI1482_I115_XP I1482_P19_18 I1482_P17_16 I1482_P19_16n VDD VSS NAND2_X1
XI1482_I116_XG I1482_P20_19 I1482_G18_17 I1482_G20_19 I1482_G20_17n VDD VSS AOI21_X1
XI1482_I116_XP I1482_P20_19 I1482_P18_17 I1482_P20_17n VDD VSS NAND2_X1
XI1482_I117_XG I1482_P21_20 I1482_G19_18 I1482_G21_20 I1482_G21_18n VDD VSS AOI21_X1
XI1482_I117_XP I1482_P21_20 I1482_P19_18 I1482_P21_18n VDD VSS NAND2_X1
XI1482_I118_XG I1482_P22_21 I1482_G20_19 I1482_G22_21 I1482_G22_19n VDD VSS AOI21_X1
XI1482_I118_XP I1482_P22_21 I1482_P20_19 I1482_P22_19n VDD VSS NAND2_X1
XI1482_I119_XG I1482_P23_22 I1482_G21_20 I1482_G23_22 I1482_G23_20n VDD VSS AOI21_X1
XI1482_I119_XP I1482_P23_22 I1482_P21_20 I1482_P23_20n VDD VSS NAND2_X1
XI1482_I120_XG I1482_P24_23 I1482_G22_21 I1482_G24_23 I1482_G24_21n VDD VSS AOI21_X1
XI1482_I120_XP I1482_P24_23 I1482_P22_21 I1482_P24_21n VDD VSS NAND2_X1
XI1482_I121_XG I1482_P25_24 I1482_G23_22 I1482_G25_24 I1482_G25_22n VDD VSS AOI21_X1
XI1482_I121_XP I1482_P25_24 I1482_P23_22 I1482_P25_22n VDD VSS NAND2_X1
XI1482_I122_XG I1482_P26_25 I1482_G24_23 I1482_G26_25 I1482_G26_23n VDD VSS AOI21_X1
XI1482_I122_XP I1482_P26_25 I1482_P24_23 I1482_P26_23n VDD VSS NAND2_X1
XI1482_I123_XG I1482_P27_26 I1482_G25_24 I1482_G27_26 I1482_G27_24n VDD VSS AOI21_X1
XI1482_I123_XP I1482_P27_26 I1482_P25_24 I1482_P27_24n VDD VSS NAND2_X1
XI1482_I124_XG I1482_P28_27 I1482_G26_25 I1482_G28_27 I1482_G28_25n VDD VSS AOI21_X1
XI1482_I124_XP I1482_P28_27 I1482_P26_25 I1482_P28_25n VDD VSS NAND2_X1
XI1482_I125_XG I1482_P29_28 I1482_G27_26 I1482_G29_28 I1482_G29_26n VDD VSS AOI21_X1
XI1482_I125_XP I1482_P29_28 I1482_P27_26 I1482_P29_26n VDD VSS NAND2_X1
XI1482_I126_XG I1482_P30_29 I1482_G28_27 I1482_G30_29 I1482_G30_27n VDD VSS AOI21_X1
XI1482_I126_XP I1482_P30_29 I1482_P28_27 I1482_P30_27n VDD VSS NAND2_X1
XI1482_I127_XG I1482_P31_30 I1482_G29_28 I1482_G31_30 I1482_G31_28n VDD VSS AOI21_X1
XI1482_I127_XP I1482_P31_30 I1482_P29_28 I1482_P31_28n VDD VSS NAND2_X1
XI1482_I128_XG I1482_P4_1n I1482_G0_0n I1482_G4_1n I1482_G4_0 VDD VSS OAI21_X1
XI1482_I129 I1482_G1_0 I1482_G1_0n VDD VSS INV_X1
XI1482_I130_XG I1482_P5_2n I1482_G1_0n I1482_G5_2n I1482_G5_0 VDD VSS OAI21_X1
XI1482_I131_XG I1482_P6_3n I1482_G2_0n I1482_G6_3n I1482_G6_0 VDD VSS OAI21_X1
XI1482_I132_XG I1482_P7_4n I1482_G3_0n I1482_G7_4n I1482_G7_0 VDD VSS OAI21_X1
XI1482_I133_XG I1482_P8_5n I1482_G4_1n I1482_G8_5n I1482_G8_1 VDD VSS OAI21_X1
XI1482_I133_XP I1482_P8_5n I1482_P4_1n I1482_P8_1 VDD VSS NOR2_X1
XI1482_I134_XG I1482_P9_6n I1482_G5_2n I1482_G9_6n I1482_G9_2 VDD VSS OAI21_X1
XI1482_I134_XP I1482_P9_6n I1482_P5_2n I1482_P9_2 VDD VSS NOR2_X1
XI1482_I135_XG I1482_P10_7n I1482_G6_3n I1482_G10_7n I1482_G10_3 VDD VSS OAI21_X1
XI1482_I135_XP I1482_P10_7n I1482_P6_3n I1482_P10_3 VDD VSS NOR2_X1
XI1482_I136_XG I1482_P11_8n I1482_G7_4n I1482_G11_8n I1482_G11_4 VDD VSS OAI21_X1
XI1482_I136_XP I1482_P11_8n I1482_P7_4n I1482_P11_4 VDD VSS NOR2_X1
XI1482_I137_XG I1482_P12_9n I1482_G8_5n I1482_G12_9n I1482_G12_5 VDD VSS OAI21_X1
XI1482_I137_XP I1482_P12_9n I1482_P8_5n I1482_P12_5 VDD VSS NOR2_X1
XI1482_I138_XG I1482_P13_10n I1482_G9_6n I1482_G13_10n I1482_G13_6 VDD VSS OAI21_X1
XI1482_I138_XP I1482_P13_10n I1482_P9_6n I1482_P13_6 VDD VSS NOR2_X1
XI1482_I139_XG I1482_P14_11n I1482_G10_7n I1482_G14_11n I1482_G14_7 VDD VSS OAI21_X1
XI1482_I139_XP I1482_P14_11n I1482_P10_7n I1482_P14_7 VDD VSS NOR2_X1
XI1482_I140_XG I1482_P15_12n I1482_G11_8n I1482_G15_12n I1482_G15_8 VDD VSS OAI21_X1
XI1482_I140_XP I1482_P15_12n I1482_P11_8n I1482_P15_8 VDD VSS NOR2_X1
XI1482_I141_XG I1482_P16_13n I1482_G12_9n I1482_G16_13n I1482_G16_9 VDD VSS OAI21_X1
XI1482_I141_XP I1482_P16_13n I1482_P12_9n I1482_P16_9 VDD VSS NOR2_X1
XI1482_I142_XG I1482_P17_14n I1482_G13_10n I1482_G17_14n I1482_G17_10 VDD VSS OAI21_X1
XI1482_I142_XP I1482_P17_14n I1482_P13_10n I1482_P17_10 VDD VSS NOR2_X1
XI1482_I143_XG I1482_P18_15n I1482_G14_11n I1482_G18_15n I1482_G18_11 VDD VSS OAI21_X1
XI1482_I143_XP I1482_P18_15n I1482_P14_11n I1482_P18_11 VDD VSS NOR2_X1
XI1482_I144_XG I1482_P19_16n I1482_G15_12n I1482_G19_16n I1482_G19_12 VDD VSS OAI21_X1
XI1482_I144_XP I1482_P19_16n I1482_P15_12n I1482_P19_12 VDD VSS NOR2_X1
XI1482_I145_XG I1482_P20_17n I1482_G16_13n I1482_G20_17n I1482_G20_13 VDD VSS OAI21_X1
XI1482_I145_XP I1482_P20_17n I1482_P16_13n I1482_P20_13 VDD VSS NOR2_X1
XI1482_I146_XG I1482_P21_18n I1482_G17_14n I1482_G21_18n I1482_G21_14 VDD VSS OAI21_X1
XI1482_I146_XP I1482_P21_18n I1482_P17_14n I1482_P21_14 VDD VSS NOR2_X1
XI1482_I147_XG I1482_P22_19n I1482_G18_15n I1482_G22_19n I1482_G22_15 VDD VSS OAI21_X1
XI1482_I147_XP I1482_P22_19n I1482_P18_15n I1482_P22_15 VDD VSS NOR2_X1
XI1482_I148_XG I1482_P23_20n I1482_G19_16n I1482_G23_20n I1482_G23_16 VDD VSS OAI21_X1
XI1482_I148_XP I1482_P23_20n I1482_P19_16n I1482_P23_16 VDD VSS NOR2_X1
XI1482_I149_XG I1482_P24_21n I1482_G20_17n I1482_G24_21n I1482_G24_17 VDD VSS OAI21_X1
XI1482_I149_XP I1482_P24_21n I1482_P20_17n I1482_P24_17 VDD VSS NOR2_X1
XI1482_I150_XG I1482_P25_22n I1482_G21_18n I1482_G25_22n I1482_G25_18 VDD VSS OAI21_X1
XI1482_I150_XP I1482_P25_22n I1482_P21_18n I1482_P25_18 VDD VSS NOR2_X1
XI1482_I151_XG I1482_P26_23n I1482_G22_19n I1482_G26_23n I1482_G26_19 VDD VSS OAI21_X1
XI1482_I151_XP I1482_P26_23n I1482_P22_19n I1482_P26_19 VDD VSS NOR2_X1
XI1482_I152_XG I1482_P27_24n I1482_G23_20n I1482_G27_24n I1482_G27_20 VDD VSS OAI21_X1
XI1482_I152_XP I1482_P27_24n I1482_P23_20n I1482_P27_20 VDD VSS NOR2_X1
XI1482_I153_XG I1482_P28_25n I1482_G24_21n I1482_G28_25n I1482_G28_21 VDD VSS OAI21_X1
XI1482_I153_XP I1482_P28_25n I1482_P24_21n I1482_P28_21 VDD VSS NOR2_X1
XI1482_I154_XG I1482_P29_26n I1482_G25_22n I1482_G29_26n I1482_G29_22 VDD VSS OAI21_X1
XI1482_I154_XP I1482_P29_26n I1482_P25_22n I1482_P29_22 VDD VSS NOR2_X1
XI1482_I155_XG I1482_P30_27n I1482_G26_23n I1482_G30_27n I1482_G30_23 VDD VSS OAI21_X1
XI1482_I155_XP I1482_P30_27n I1482_P26_23n I1482_P30_23 VDD VSS NOR2_X1
XI1482_I156_XG I1482_P31_28n I1482_G27_24n I1482_G31_28n I1482_G31_24 VDD VSS OAI21_X1
XI1482_I156_XP I1482_P31_28n I1482_P27_24n I1482_P31_24 VDD VSS NOR2_X1
XI1482_I157_XG I1482_P8_1 I1482_G0_0 I1482_G8_1 I1482_G8_0n VDD VSS AOI21_X1
XI1482_I158_XG I1482_P9_2 I1482_G1_0 I1482_G9_2 I1482_G9_0n VDD VSS AOI21_X1
XI1482_I159 I1482_G2_0n I1482_G2_0np VDD VSS INV_X1
XI1482_I160_XG I1482_P10_3 I1482_G2_0np I1482_G10_3 I1482_G10_0n VDD VSS AOI21_X1
XI1482_I161 I1482_G3_0n I1482_G3_0np VDD VSS INV_X1
XI1482_I162_XG I1482_P11_4 I1482_G3_0np I1482_G11_4 I1482_G11_0n VDD VSS AOI21_X1
XI1482_I163_XG I1482_P12_5 I1482_G4_0 I1482_G12_5 I1482_G12_0n VDD VSS AOI21_X1
XI1482_I164_XG I1482_P13_6 I1482_G5_0 I1482_G13_6 I1482_G13_0n VDD VSS AOI21_X1
XI1482_I165_XG I1482_P14_7 I1482_G6_0 I1482_G14_7 I1482_G14_0n VDD VSS AOI21_X1
XI1482_I166_XG I1482_P15_8 I1482_G7_0 I1482_G15_8 I1482_G15_0n VDD VSS AOI21_X1
XI1482_I167_XG I1482_P16_9 I1482_G8_1 I1482_G16_9 I1482_G16_1n VDD VSS AOI21_X1
XI1482_I167_XP I1482_P16_9 I1482_P8_1 I1482_P16_1n VDD VSS NAND2_X1
XI1482_I168_XG I1482_P17_10 I1482_G9_2 I1482_G17_10 I1482_G17_2n VDD VSS AOI21_X1
XI1482_I168_XP I1482_P17_10 I1482_P9_2 I1482_P17_2n VDD VSS NAND2_X1
XI1482_I169_XG I1482_P18_11 I1482_G10_3 I1482_G18_11 I1482_G18_3n VDD VSS AOI21_X1
XI1482_I169_XP I1482_P18_11 I1482_P10_3 I1482_P18_3n VDD VSS NAND2_X1
XI1482_I170_XG I1482_P19_12 I1482_G11_4 I1482_G19_12 I1482_G19_4n VDD VSS AOI21_X1
XI1482_I170_XP I1482_P19_12 I1482_P11_4 I1482_P19_4n VDD VSS NAND2_X1
XI1482_I171_XG I1482_P20_13 I1482_G12_5 I1482_G20_13 I1482_G20_5n VDD VSS AOI21_X1
XI1482_I171_XP I1482_P20_13 I1482_P12_5 I1482_P20_5n VDD VSS NAND2_X1
XI1482_I172_XG I1482_P21_14 I1482_G13_6 I1482_G21_14 I1482_G21_6n VDD VSS AOI21_X1
XI1482_I172_XP I1482_P21_14 I1482_P13_6 I1482_P21_6n VDD VSS NAND2_X1
XI1482_I173_XG I1482_P22_15 I1482_G14_7 I1482_G22_15 I1482_G22_7n VDD VSS AOI21_X1
XI1482_I173_XP I1482_P22_15 I1482_P14_7 I1482_P22_7n VDD VSS NAND2_X1
XI1482_I174_XG I1482_P23_16 I1482_G15_8 I1482_G23_16 I1482_G23_8n VDD VSS AOI21_X1
XI1482_I174_XP I1482_P23_16 I1482_P15_8 I1482_P23_8n VDD VSS NAND2_X1
XI1482_I175_XG I1482_P24_17 I1482_G16_9 I1482_G24_17 I1482_G24_9n VDD VSS AOI21_X1
XI1482_I175_XP I1482_P24_17 I1482_P16_9 I1482_P24_9n VDD VSS NAND2_X1
XI1482_I176_XG I1482_P25_18 I1482_G17_10 I1482_G25_18 I1482_G25_10n VDD VSS AOI21_X1
XI1482_I176_XP I1482_P25_18 I1482_P17_10 I1482_P25_10n VDD VSS NAND2_X1
XI1482_I177_XG I1482_P26_19 I1482_G18_11 I1482_G26_19 I1482_G26_11n VDD VSS AOI21_X1
XI1482_I177_XP I1482_P26_19 I1482_P18_11 I1482_P26_11n VDD VSS NAND2_X1
XI1482_I178_XG I1482_P27_20 I1482_G19_12 I1482_G27_20 I1482_G27_12n VDD VSS AOI21_X1
XI1482_I178_XP I1482_P27_20 I1482_P19_12 I1482_P27_12n VDD VSS NAND2_X1
XI1482_I179_XG I1482_P28_21 I1482_G20_13 I1482_G28_21 I1482_G28_13n VDD VSS AOI21_X1
XI1482_I179_XP I1482_P28_21 I1482_P20_13 I1482_P28_13n VDD VSS NAND2_X1
XI1482_I180_XG I1482_P29_22 I1482_G21_14 I1482_G29_22 I1482_G29_14n VDD VSS AOI21_X1
XI1482_I180_XP I1482_P29_22 I1482_P21_14 I1482_P29_14n VDD VSS NAND2_X1
XI1482_I181_XG I1482_P30_23 I1482_G22_15 I1482_G30_23 I1482_G30_15n VDD VSS AOI21_X1
XI1482_I181_XP I1482_P30_23 I1482_P22_15 I1482_P30_15n VDD VSS NAND2_X1
XI1482_I182_XG I1482_P31_24 I1482_G23_16 I1482_G31_24 I1482_G31_16n VDD VSS AOI21_X1
XI1482_I182_XP I1482_P31_24 I1482_P23_16 I1482_P31_16n VDD VSS NAND2_X1
XI1482_I183_XG I1482_P16_1n I1482_G0_0n I1482_G16_1n I1482_G16_0 VDD VSS OAI21_X1
XI1482_I184_XG I1482_P17_2n I1482_G1_0n I1482_G17_2n I1482_G17_0 VDD VSS OAI21_X1
XI1482_I185_XG I1482_P18_3n I1482_G2_0n I1482_G18_3n I1482_G18_0 VDD VSS OAI21_X1
XI1482_I186_XG I1482_P19_4n I1482_G3_0n I1482_G19_4n I1482_G19_0 VDD VSS OAI21_X1
XI1482_I187 I1482_G4_0 I1482_G4_0n VDD VSS INV_X1
XI1482_I188_XG I1482_P20_5n I1482_G4_0n I1482_G20_5n I1482_G20_0 VDD VSS OAI21_X1
XI1482_I189 I1482_G5_0 I1482_G5_0n VDD VSS INV_X1
XI1482_I190_XG I1482_P21_6n I1482_G5_0n I1482_G21_6n I1482_G21_0 VDD VSS OAI21_X1
XI1482_I191 I1482_G6_0 I1482_G6_0n VDD VSS INV_X1
XI1482_I192_XG I1482_P22_7n I1482_G6_0n I1482_G22_7n I1482_G22_0 VDD VSS OAI21_X1
XI1482_I193 I1482_G7_0 I1482_G7_0n VDD VSS INV_X1
XI1482_I194_XG I1482_P23_8n I1482_G7_0n I1482_G23_8n I1482_G23_0 VDD VSS OAI21_X1
XI1482_I195_XG I1482_P24_9n I1482_G8_0n I1482_G24_9n I1482_G24_0 VDD VSS OAI21_X1
XI1482_I196_XG I1482_P25_10n I1482_G9_0n I1482_G25_10n I1482_G25_0 VDD VSS OAI21_X1
XI1482_I197_XG I1482_P26_11n I1482_G10_0n I1482_G26_11n I1482_G26_0 VDD VSS OAI21_X1
XI1482_I198_XG I1482_P27_12n I1482_G11_0n I1482_G27_12n I1482_G27_0 VDD VSS OAI21_X1
XI1482_I199_XG I1482_P28_13n I1482_G12_0n I1482_G28_13n I1482_G28_0 VDD VSS OAI21_X1
XI1482_I200_XG I1482_P29_14n I1482_G13_0n I1482_G29_14n I1482_G29_0 VDD VSS OAI21_X1
XI1482_I201_XG I1482_P30_15n I1482_G14_0n I1482_G30_15n c20_m VDD VSS OAI21_X1
XI1482_I202_XG I1482_P31_16n I1482_G15_0n I1482_G31_16n c20_o VDD VSS OAI21_X1
XI1482_I203 I1482_pn0 qu12_b3_5 p20_0 VDD VSS XNOR2_X1
XI1482_I204 I1482_pn1 I1482_G0_0 p20_1 VDD VSS XNOR2_X1
XI1482_I205 I1482_pn2 I1482_G1_0 p20_2 VDD VSS XNOR2_X1
XI1482_I206 I1482_pn3 I1482_G2_0n p20_3 VDD VSS XOR2_X1
XI1482_I207 I1482_pn4 I1482_G3_0n p20_4 VDD VSS XOR2_X1
XI1482_I208 I1482_pn5 I1482_G4_0 p20_5 VDD VSS XNOR2_X1
XI1482_I209 I1482_pn6 I1482_G5_0 p20_6 VDD VSS XNOR2_X1
XI1482_I210 I1482_pn7 I1482_G6_0 p20_7 VDD VSS XNOR2_X1
XI1482_I211 I1482_pn8 I1482_G7_0 p20_8 VDD VSS XNOR2_X1
XI1482_I212 I1482_pn9 I1482_G8_0n p20_9 VDD VSS XOR2_X1
XI1482_I213 I1482_pn10 I1482_G9_0n p20_10 VDD VSS XOR2_X1
XI1482_I214 I1482_pn11 I1482_G10_0n p20_11 VDD VSS XOR2_X1
XI1482_I215 I1482_pn12 I1482_G11_0n p20_12 VDD VSS XOR2_X1
XI1482_I216 I1482_pn13 I1482_G12_0n p20_13 VDD VSS XOR2_X1
XI1482_I217 I1482_pn14 I1482_G13_0n p20_14 VDD VSS XOR2_X1
XI1482_I218 I1482_pn15 I1482_G14_0n p20_15 VDD VSS XOR2_X1
XI1482_I219 I1482_pn16 I1482_G15_0n p20_16 VDD VSS XOR2_X1
XI1482_I220 I1482_pn17 I1482_G16_0 p20_17 VDD VSS XNOR2_X1
XI1482_I221 I1482_pn18 I1482_G17_0 p20_18 VDD VSS XNOR2_X1
XI1482_I222 I1482_pn19 I1482_G18_0 p20_19 VDD VSS XNOR2_X1
XI1482_I223 I1482_pn20 I1482_G19_0 p20_20 VDD VSS XNOR2_X1
XI1482_I224 I1482_pn21 I1482_G20_0 p20_21 VDD VSS XNOR2_X1
XI1482_I225 I1482_pn22 I1482_G21_0 p20_22 VDD VSS XNOR2_X1
XI1482_I226 I1482_pn23 I1482_G22_0 p20_23 VDD VSS XNOR2_X1
XI1482_I227 I1482_pn24 I1482_G23_0 p20_24 VDD VSS XNOR2_X1
XI1482_I228 I1482_pn25 I1482_G24_0 p20_25 VDD VSS XNOR2_X1
XI1482_I229 I1482_pn26 I1482_G25_0 p20_26 VDD VSS XNOR2_X1
XI1482_I230 I1482_pn27 I1482_G26_0 p20_27 VDD VSS XNOR2_X1
XI1482_I231 I1482_pn28 I1482_G27_0 p20_28 VDD VSS XNOR2_X1
XI1482_I232 I1482_pn29 I1482_G28_0 p20_29 VDD VSS XNOR2_X1
XI1482_I233 I1482_pn30 I1482_G29_0 p20_30 VDD VSS XNOR2_X1
XI1482_I234 I1482_pn31 c20_m p20_31 VDD VSS XNOR2_X1
XI1483 p19_31 qu12_b3_5 h20 VDD VSS XOR2_X1
XI1484 h20 c20_o p20_32 VDD VSS XOR2_X1
XI1485 p20_32 qu11 VDD VSS INV_X4
XI1486 qu11 qu11_b0 VDD VSS INV_X1
XI1487 qu11_b0 qu11_b1_0 VDD VSS INV_X4
XI1488 qu11_b1_0 qu11_b2_0 VDD VSS INV_X4
XI1489 qu11_b1_0 qu11_b2_1 VDD VSS INV_X4
XI1490 qu11_b2_0 qu11_b3_0 VDD VSS INV_X4
XI1491 qu11_b2_0 qu11_b3_1 VDD VSS INV_X4
XI1492 qu11_b2_0 qu11_b3_2 VDD VSS INV_X4
XI1493 qu11_b2_1 qu11_b3_3 VDD VSS INV_X4
XI1494 qu11_b2_1 qu11_b3_4 VDD VSS INV_X4
XI1495 qu11_b2_1 qu11_b3_5 VDD VSS INV_X4
XI1496 B_0_b3_3 qu11_b3_0 b21_0 VDD VSS XOR2_X1
XI1497 dd1_b3_3 qu11_b3_0 b21_1 VDD VSS XOR2_X1
XI1498 dd2_b3_3 qu11_b3_0 b21_2 VDD VSS XOR2_X1
XI1499 dd3_b3_3 qu11_b3_0 b21_3 VDD VSS XOR2_X1
XI1500 dd4_b3_3 qu11_b3_0 b21_4 VDD VSS XOR2_X1
XI1501 dd5_b3_3 qu11_b3_0 b21_5 VDD VSS XOR2_X1
XI1502 dd6_b3_3 qu11_b3_1 b21_6 VDD VSS XOR2_X1
XI1503 dd7_b3_3 qu11_b3_1 b21_7 VDD VSS XOR2_X1
XI1504 dd8_b3_3 qu11_b3_1 b21_8 VDD VSS XOR2_X1
XI1505 dd9_b3_3 qu11_b3_1 b21_9 VDD VSS XOR2_X1
XI1506 dd10_b3_3 qu11_b3_1 b21_10 VDD VSS XOR2_X1
XI1507 dd11_b3_3 qu11_b3_1 b21_11 VDD VSS XOR2_X1
XI1508 dd12_b3_3 qu11_b3_2 b21_12 VDD VSS XOR2_X1
XI1509 dd13_b3_3 qu11_b3_2 b21_13 VDD VSS XOR2_X1
XI1510 dd14_b3_3 qu11_b3_2 b21_14 VDD VSS XOR2_X1
XI1511 dd15_b3_3 qu11_b3_2 b21_15 VDD VSS XOR2_X1
XI1512 dd16_b3_3 qu11_b3_2 b21_16 VDD VSS XOR2_X1
XI1513 dd17_b3_3 qu11_b3_2 b21_17 VDD VSS XOR2_X1
XI1514 dd18_b3_3 qu11_b3_3 b21_18 VDD VSS XOR2_X1
XI1515 dd19_b3_3 qu11_b3_3 b21_19 VDD VSS XOR2_X1
XI1516 dd20_b3_3 qu11_b3_3 b21_20 VDD VSS XOR2_X1
XI1517 dd21_b3_3 qu11_b3_3 b21_21 VDD VSS XOR2_X1
XI1518 dd22_b3_3 qu11_b3_3 b21_22 VDD VSS XOR2_X1
XI1519 dd23_b3_3 qu11_b3_3 b21_23 VDD VSS XOR2_X1
XI1520 dd24_b3_3 qu11_b3_4 b21_24 VDD VSS XOR2_X1
XI1521 dd25_b3_3 qu11_b3_4 b21_25 VDD VSS XOR2_X1
XI1522 dd26_b3_3 qu11_b3_4 b21_26 VDD VSS XOR2_X1
XI1523 dd27_b3_3 qu11_b3_4 b21_27 VDD VSS XOR2_X1
XI1524 dd28_b3_3 qu11_b3_4 b21_28 VDD VSS XOR2_X1
XI1525 dd29_b3_3 qu11_b3_4 b21_29 VDD VSS XOR2_X1
XI1526 dd30_b3_3 qu11_b3_5 b21_30 VDD VSS XOR2_X1
XI1527 dd31_b3_3 qu11_b3_5 b21_31 VDD VSS XOR2_X1
XI1528_I0 aa10 b21_0 I1528_gn0 VDD VSS NAND2_X1
XI1528_I1 p20_0 b21_1 I1528_gn1 VDD VSS NAND2_X1
XI1528_I2 p20_1 b21_2 I1528_gn2 VDD VSS NAND2_X1
XI1528_I3 p20_2 b21_3 I1528_gn3 VDD VSS NAND2_X1
XI1528_I4 p20_3 b21_4 I1528_gn4 VDD VSS NAND2_X1
XI1528_I5 p20_4 b21_5 I1528_gn5 VDD VSS NAND2_X1
XI1528_I6 p20_5 b21_6 I1528_gn6 VDD VSS NAND2_X1
XI1528_I7 p20_6 b21_7 I1528_gn7 VDD VSS NAND2_X1
XI1528_I8 p20_7 b21_8 I1528_gn8 VDD VSS NAND2_X1
XI1528_I9 p20_8 b21_9 I1528_gn9 VDD VSS NAND2_X1
XI1528_I10 p20_9 b21_10 I1528_gn10 VDD VSS NAND2_X1
XI1528_I11 p20_10 b21_11 I1528_gn11 VDD VSS NAND2_X1
XI1528_I12 p20_11 b21_12 I1528_gn12 VDD VSS NAND2_X1
XI1528_I13 p20_12 b21_13 I1528_gn13 VDD VSS NAND2_X1
XI1528_I14 p20_13 b21_14 I1528_gn14 VDD VSS NAND2_X1
XI1528_I15 p20_14 b21_15 I1528_gn15 VDD VSS NAND2_X1
XI1528_I16 p20_15 b21_16 I1528_gn16 VDD VSS NAND2_X1
XI1528_I17 p20_16 b21_17 I1528_gn17 VDD VSS NAND2_X1
XI1528_I18 p20_17 b21_18 I1528_gn18 VDD VSS NAND2_X1
XI1528_I19 p20_18 b21_19 I1528_gn19 VDD VSS NAND2_X1
XI1528_I20 p20_19 b21_20 I1528_gn20 VDD VSS NAND2_X1
XI1528_I21 p20_20 b21_21 I1528_gn21 VDD VSS NAND2_X1
XI1528_I22 p20_21 b21_22 I1528_gn22 VDD VSS NAND2_X1
XI1528_I23 p20_22 b21_23 I1528_gn23 VDD VSS NAND2_X1
XI1528_I24 p20_23 b21_24 I1528_gn24 VDD VSS NAND2_X1
XI1528_I25 p20_24 b21_25 I1528_gn25 VDD VSS NAND2_X1
XI1528_I26 p20_25 b21_26 I1528_gn26 VDD VSS NAND2_X1
XI1528_I27 p20_26 b21_27 I1528_gn27 VDD VSS NAND2_X1
XI1528_I28 p20_27 b21_28 I1528_gn28 VDD VSS NAND2_X1
XI1528_I29 p20_28 b21_29 I1528_gn29 VDD VSS NAND2_X1
XI1528_I30 p20_29 b21_30 I1528_gn30 VDD VSS NAND2_X1
XI1528_I31 p20_30 b21_31 I1528_gn31 VDD VSS NAND2_X1
XI1528_I32 aa10 b21_0 I1528_pn0 VDD VSS XNOR2_X1
XI1528_I33 p20_0 b21_1 I1528_pn1 VDD VSS XNOR2_X1
XI1528_I34 p20_1 b21_2 I1528_pn2 VDD VSS XNOR2_X1
XI1528_I35 p20_2 b21_3 I1528_pn3 VDD VSS XNOR2_X1
XI1528_I36 p20_3 b21_4 I1528_pn4 VDD VSS XNOR2_X1
XI1528_I37 p20_4 b21_5 I1528_pn5 VDD VSS XNOR2_X1
XI1528_I38 p20_5 b21_6 I1528_pn6 VDD VSS XNOR2_X1
XI1528_I39 p20_6 b21_7 I1528_pn7 VDD VSS XNOR2_X1
XI1528_I40 p20_7 b21_8 I1528_pn8 VDD VSS XNOR2_X1
XI1528_I41 p20_8 b21_9 I1528_pn9 VDD VSS XNOR2_X1
XI1528_I42 p20_9 b21_10 I1528_pn10 VDD VSS XNOR2_X1
XI1528_I43 p20_10 b21_11 I1528_pn11 VDD VSS XNOR2_X1
XI1528_I44 p20_11 b21_12 I1528_pn12 VDD VSS XNOR2_X1
XI1528_I45 p20_12 b21_13 I1528_pn13 VDD VSS XNOR2_X1
XI1528_I46 p20_13 b21_14 I1528_pn14 VDD VSS XNOR2_X1
XI1528_I47 p20_14 b21_15 I1528_pn15 VDD VSS XNOR2_X1
XI1528_I48 p20_15 b21_16 I1528_pn16 VDD VSS XNOR2_X1
XI1528_I49 p20_16 b21_17 I1528_pn17 VDD VSS XNOR2_X1
XI1528_I50 p20_17 b21_18 I1528_pn18 VDD VSS XNOR2_X1
XI1528_I51 p20_18 b21_19 I1528_pn19 VDD VSS XNOR2_X1
XI1528_I52 p20_19 b21_20 I1528_pn20 VDD VSS XNOR2_X1
XI1528_I53 p20_20 b21_21 I1528_pn21 VDD VSS XNOR2_X1
XI1528_I54 p20_21 b21_22 I1528_pn22 VDD VSS XNOR2_X1
XI1528_I55 p20_22 b21_23 I1528_pn23 VDD VSS XNOR2_X1
XI1528_I56 p20_23 b21_24 I1528_pn24 VDD VSS XNOR2_X1
XI1528_I57 p20_24 b21_25 I1528_pn25 VDD VSS XNOR2_X1
XI1528_I58 p20_25 b21_26 I1528_pn26 VDD VSS XNOR2_X1
XI1528_I59 p20_26 b21_27 I1528_pn27 VDD VSS XNOR2_X1
XI1528_I60 p20_27 b21_28 I1528_pn28 VDD VSS XNOR2_X1
XI1528_I61 p20_28 b21_29 I1528_pn29 VDD VSS XNOR2_X1
XI1528_I62 p20_29 b21_30 I1528_pn30 VDD VSS XNOR2_X1
XI1528_I63 p20_30 b21_31 I1528_pn31 VDD VSS XNOR2_X1
XI1528_I64 qu11_b3_5 I1528_cinn VDD VSS INV_X1
XI1528_I65_XG I1528_pn0 I1528_cinn I1528_gn0 I1528_G0_0 VDD VSS OAI21_X1
XI1528_I66 I1528_G0_0 I1528_G0_0n VDD VSS INV_X1
XI1528_I67_XG I1528_pn1 I1528_G0_0n I1528_gn1 I1528_G1_0 VDD VSS OAI21_X1
XI1528_I68_XG I1528_pn2 I1528_gn1 I1528_gn2 I1528_G2_1 VDD VSS OAI21_X1
XI1528_I68_XP I1528_pn2 I1528_pn1 I1528_P2_1 VDD VSS NOR2_X1
XI1528_I69_XG I1528_pn3 I1528_gn2 I1528_gn3 I1528_G3_2 VDD VSS OAI21_X1
XI1528_I69_XP I1528_pn3 I1528_pn2 I1528_P3_2 VDD VSS NOR2_X1
XI1528_I70_XG I1528_pn4 I1528_gn3 I1528_gn4 I1528_G4_3 VDD VSS OAI21_X1
XI1528_I70_XP I1528_pn4 I1528_pn3 I1528_P4_3 VDD VSS NOR2_X1
XI1528_I71_XG I1528_pn5 I1528_gn4 I1528_gn5 I1528_G5_4 VDD VSS OAI21_X1
XI1528_I71_XP I1528_pn5 I1528_pn4 I1528_P5_4 VDD VSS NOR2_X1
XI1528_I72_XG I1528_pn6 I1528_gn5 I1528_gn6 I1528_G6_5 VDD VSS OAI21_X1
XI1528_I72_XP I1528_pn6 I1528_pn5 I1528_P6_5 VDD VSS NOR2_X1
XI1528_I73_XG I1528_pn7 I1528_gn6 I1528_gn7 I1528_G7_6 VDD VSS OAI21_X1
XI1528_I73_XP I1528_pn7 I1528_pn6 I1528_P7_6 VDD VSS NOR2_X1
XI1528_I74_XG I1528_pn8 I1528_gn7 I1528_gn8 I1528_G8_7 VDD VSS OAI21_X1
XI1528_I74_XP I1528_pn8 I1528_pn7 I1528_P8_7 VDD VSS NOR2_X1
XI1528_I75_XG I1528_pn9 I1528_gn8 I1528_gn9 I1528_G9_8 VDD VSS OAI21_X1
XI1528_I75_XP I1528_pn9 I1528_pn8 I1528_P9_8 VDD VSS NOR2_X1
XI1528_I76_XG I1528_pn10 I1528_gn9 I1528_gn10 I1528_G10_9 VDD VSS OAI21_X1
XI1528_I76_XP I1528_pn10 I1528_pn9 I1528_P10_9 VDD VSS NOR2_X1
XI1528_I77_XG I1528_pn11 I1528_gn10 I1528_gn11 I1528_G11_10 VDD VSS OAI21_X1
XI1528_I77_XP I1528_pn11 I1528_pn10 I1528_P11_10 VDD VSS NOR2_X1
XI1528_I78_XG I1528_pn12 I1528_gn11 I1528_gn12 I1528_G12_11 VDD VSS OAI21_X1
XI1528_I78_XP I1528_pn12 I1528_pn11 I1528_P12_11 VDD VSS NOR2_X1
XI1528_I79_XG I1528_pn13 I1528_gn12 I1528_gn13 I1528_G13_12 VDD VSS OAI21_X1
XI1528_I79_XP I1528_pn13 I1528_pn12 I1528_P13_12 VDD VSS NOR2_X1
XI1528_I80_XG I1528_pn14 I1528_gn13 I1528_gn14 I1528_G14_13 VDD VSS OAI21_X1
XI1528_I80_XP I1528_pn14 I1528_pn13 I1528_P14_13 VDD VSS NOR2_X1
XI1528_I81_XG I1528_pn15 I1528_gn14 I1528_gn15 I1528_G15_14 VDD VSS OAI21_X1
XI1528_I81_XP I1528_pn15 I1528_pn14 I1528_P15_14 VDD VSS NOR2_X1
XI1528_I82_XG I1528_pn16 I1528_gn15 I1528_gn16 I1528_G16_15 VDD VSS OAI21_X1
XI1528_I82_XP I1528_pn16 I1528_pn15 I1528_P16_15 VDD VSS NOR2_X1
XI1528_I83_XG I1528_pn17 I1528_gn16 I1528_gn17 I1528_G17_16 VDD VSS OAI21_X1
XI1528_I83_XP I1528_pn17 I1528_pn16 I1528_P17_16 VDD VSS NOR2_X1
XI1528_I84_XG I1528_pn18 I1528_gn17 I1528_gn18 I1528_G18_17 VDD VSS OAI21_X1
XI1528_I84_XP I1528_pn18 I1528_pn17 I1528_P18_17 VDD VSS NOR2_X1
XI1528_I85_XG I1528_pn19 I1528_gn18 I1528_gn19 I1528_G19_18 VDD VSS OAI21_X1
XI1528_I85_XP I1528_pn19 I1528_pn18 I1528_P19_18 VDD VSS NOR2_X1
XI1528_I86_XG I1528_pn20 I1528_gn19 I1528_gn20 I1528_G20_19 VDD VSS OAI21_X1
XI1528_I86_XP I1528_pn20 I1528_pn19 I1528_P20_19 VDD VSS NOR2_X1
XI1528_I87_XG I1528_pn21 I1528_gn20 I1528_gn21 I1528_G21_20 VDD VSS OAI21_X1
XI1528_I87_XP I1528_pn21 I1528_pn20 I1528_P21_20 VDD VSS NOR2_X1
XI1528_I88_XG I1528_pn22 I1528_gn21 I1528_gn22 I1528_G22_21 VDD VSS OAI21_X1
XI1528_I88_XP I1528_pn22 I1528_pn21 I1528_P22_21 VDD VSS NOR2_X1
XI1528_I89_XG I1528_pn23 I1528_gn22 I1528_gn23 I1528_G23_22 VDD VSS OAI21_X1
XI1528_I89_XP I1528_pn23 I1528_pn22 I1528_P23_22 VDD VSS NOR2_X1
XI1528_I90_XG I1528_pn24 I1528_gn23 I1528_gn24 I1528_G24_23 VDD VSS OAI21_X1
XI1528_I90_XP I1528_pn24 I1528_pn23 I1528_P24_23 VDD VSS NOR2_X1
XI1528_I91_XG I1528_pn25 I1528_gn24 I1528_gn25 I1528_G25_24 VDD VSS OAI21_X1
XI1528_I91_XP I1528_pn25 I1528_pn24 I1528_P25_24 VDD VSS NOR2_X1
XI1528_I92_XG I1528_pn26 I1528_gn25 I1528_gn26 I1528_G26_25 VDD VSS OAI21_X1
XI1528_I92_XP I1528_pn26 I1528_pn25 I1528_P26_25 VDD VSS NOR2_X1
XI1528_I93_XG I1528_pn27 I1528_gn26 I1528_gn27 I1528_G27_26 VDD VSS OAI21_X1
XI1528_I93_XP I1528_pn27 I1528_pn26 I1528_P27_26 VDD VSS NOR2_X1
XI1528_I94_XG I1528_pn28 I1528_gn27 I1528_gn28 I1528_G28_27 VDD VSS OAI21_X1
XI1528_I94_XP I1528_pn28 I1528_pn27 I1528_P28_27 VDD VSS NOR2_X1
XI1528_I95_XG I1528_pn29 I1528_gn28 I1528_gn29 I1528_G29_28 VDD VSS OAI21_X1
XI1528_I95_XP I1528_pn29 I1528_pn28 I1528_P29_28 VDD VSS NOR2_X1
XI1528_I96_XG I1528_pn30 I1528_gn29 I1528_gn30 I1528_G30_29 VDD VSS OAI21_X1
XI1528_I96_XP I1528_pn30 I1528_pn29 I1528_P30_29 VDD VSS NOR2_X1
XI1528_I97_XG I1528_pn31 I1528_gn30 I1528_gn31 I1528_G31_30 VDD VSS OAI21_X1
XI1528_I97_XP I1528_pn31 I1528_pn30 I1528_P31_30 VDD VSS NOR2_X1
XI1528_I98_XG I1528_P2_1 I1528_G0_0 I1528_G2_1 I1528_G2_0n VDD VSS AOI21_X1
XI1528_I99_XG I1528_P3_2 I1528_G1_0 I1528_G3_2 I1528_G3_0n VDD VSS AOI21_X1
XI1528_I100_XG I1528_P4_3 I1528_G2_1 I1528_G4_3 I1528_G4_1n VDD VSS AOI21_X1
XI1528_I100_XP I1528_P4_3 I1528_P2_1 I1528_P4_1n VDD VSS NAND2_X1
XI1528_I101_XG I1528_P5_4 I1528_G3_2 I1528_G5_4 I1528_G5_2n VDD VSS AOI21_X1
XI1528_I101_XP I1528_P5_4 I1528_P3_2 I1528_P5_2n VDD VSS NAND2_X1
XI1528_I102_XG I1528_P6_5 I1528_G4_3 I1528_G6_5 I1528_G6_3n VDD VSS AOI21_X1
XI1528_I102_XP I1528_P6_5 I1528_P4_3 I1528_P6_3n VDD VSS NAND2_X1
XI1528_I103_XG I1528_P7_6 I1528_G5_4 I1528_G7_6 I1528_G7_4n VDD VSS AOI21_X1
XI1528_I103_XP I1528_P7_6 I1528_P5_4 I1528_P7_4n VDD VSS NAND2_X1
XI1528_I104_XG I1528_P8_7 I1528_G6_5 I1528_G8_7 I1528_G8_5n VDD VSS AOI21_X1
XI1528_I104_XP I1528_P8_7 I1528_P6_5 I1528_P8_5n VDD VSS NAND2_X1
XI1528_I105_XG I1528_P9_8 I1528_G7_6 I1528_G9_8 I1528_G9_6n VDD VSS AOI21_X1
XI1528_I105_XP I1528_P9_8 I1528_P7_6 I1528_P9_6n VDD VSS NAND2_X1
XI1528_I106_XG I1528_P10_9 I1528_G8_7 I1528_G10_9 I1528_G10_7n VDD VSS AOI21_X1
XI1528_I106_XP I1528_P10_9 I1528_P8_7 I1528_P10_7n VDD VSS NAND2_X1
XI1528_I107_XG I1528_P11_10 I1528_G9_8 I1528_G11_10 I1528_G11_8n VDD VSS AOI21_X1
XI1528_I107_XP I1528_P11_10 I1528_P9_8 I1528_P11_8n VDD VSS NAND2_X1
XI1528_I108_XG I1528_P12_11 I1528_G10_9 I1528_G12_11 I1528_G12_9n VDD VSS AOI21_X1
XI1528_I108_XP I1528_P12_11 I1528_P10_9 I1528_P12_9n VDD VSS NAND2_X1
XI1528_I109_XG I1528_P13_12 I1528_G11_10 I1528_G13_12 I1528_G13_10n VDD VSS AOI21_X1
XI1528_I109_XP I1528_P13_12 I1528_P11_10 I1528_P13_10n VDD VSS NAND2_X1
XI1528_I110_XG I1528_P14_13 I1528_G12_11 I1528_G14_13 I1528_G14_11n VDD VSS AOI21_X1
XI1528_I110_XP I1528_P14_13 I1528_P12_11 I1528_P14_11n VDD VSS NAND2_X1
XI1528_I111_XG I1528_P15_14 I1528_G13_12 I1528_G15_14 I1528_G15_12n VDD VSS AOI21_X1
XI1528_I111_XP I1528_P15_14 I1528_P13_12 I1528_P15_12n VDD VSS NAND2_X1
XI1528_I112_XG I1528_P16_15 I1528_G14_13 I1528_G16_15 I1528_G16_13n VDD VSS AOI21_X1
XI1528_I112_XP I1528_P16_15 I1528_P14_13 I1528_P16_13n VDD VSS NAND2_X1
XI1528_I113_XG I1528_P17_16 I1528_G15_14 I1528_G17_16 I1528_G17_14n VDD VSS AOI21_X1
XI1528_I113_XP I1528_P17_16 I1528_P15_14 I1528_P17_14n VDD VSS NAND2_X1
XI1528_I114_XG I1528_P18_17 I1528_G16_15 I1528_G18_17 I1528_G18_15n VDD VSS AOI21_X1
XI1528_I114_XP I1528_P18_17 I1528_P16_15 I1528_P18_15n VDD VSS NAND2_X1
XI1528_I115_XG I1528_P19_18 I1528_G17_16 I1528_G19_18 I1528_G19_16n VDD VSS AOI21_X1
XI1528_I115_XP I1528_P19_18 I1528_P17_16 I1528_P19_16n VDD VSS NAND2_X1
XI1528_I116_XG I1528_P20_19 I1528_G18_17 I1528_G20_19 I1528_G20_17n VDD VSS AOI21_X1
XI1528_I116_XP I1528_P20_19 I1528_P18_17 I1528_P20_17n VDD VSS NAND2_X1
XI1528_I117_XG I1528_P21_20 I1528_G19_18 I1528_G21_20 I1528_G21_18n VDD VSS AOI21_X1
XI1528_I117_XP I1528_P21_20 I1528_P19_18 I1528_P21_18n VDD VSS NAND2_X1
XI1528_I118_XG I1528_P22_21 I1528_G20_19 I1528_G22_21 I1528_G22_19n VDD VSS AOI21_X1
XI1528_I118_XP I1528_P22_21 I1528_P20_19 I1528_P22_19n VDD VSS NAND2_X1
XI1528_I119_XG I1528_P23_22 I1528_G21_20 I1528_G23_22 I1528_G23_20n VDD VSS AOI21_X1
XI1528_I119_XP I1528_P23_22 I1528_P21_20 I1528_P23_20n VDD VSS NAND2_X1
XI1528_I120_XG I1528_P24_23 I1528_G22_21 I1528_G24_23 I1528_G24_21n VDD VSS AOI21_X1
XI1528_I120_XP I1528_P24_23 I1528_P22_21 I1528_P24_21n VDD VSS NAND2_X1
XI1528_I121_XG I1528_P25_24 I1528_G23_22 I1528_G25_24 I1528_G25_22n VDD VSS AOI21_X1
XI1528_I121_XP I1528_P25_24 I1528_P23_22 I1528_P25_22n VDD VSS NAND2_X1
XI1528_I122_XG I1528_P26_25 I1528_G24_23 I1528_G26_25 I1528_G26_23n VDD VSS AOI21_X1
XI1528_I122_XP I1528_P26_25 I1528_P24_23 I1528_P26_23n VDD VSS NAND2_X1
XI1528_I123_XG I1528_P27_26 I1528_G25_24 I1528_G27_26 I1528_G27_24n VDD VSS AOI21_X1
XI1528_I123_XP I1528_P27_26 I1528_P25_24 I1528_P27_24n VDD VSS NAND2_X1
XI1528_I124_XG I1528_P28_27 I1528_G26_25 I1528_G28_27 I1528_G28_25n VDD VSS AOI21_X1
XI1528_I124_XP I1528_P28_27 I1528_P26_25 I1528_P28_25n VDD VSS NAND2_X1
XI1528_I125_XG I1528_P29_28 I1528_G27_26 I1528_G29_28 I1528_G29_26n VDD VSS AOI21_X1
XI1528_I125_XP I1528_P29_28 I1528_P27_26 I1528_P29_26n VDD VSS NAND2_X1
XI1528_I126_XG I1528_P30_29 I1528_G28_27 I1528_G30_29 I1528_G30_27n VDD VSS AOI21_X1
XI1528_I126_XP I1528_P30_29 I1528_P28_27 I1528_P30_27n VDD VSS NAND2_X1
XI1528_I127_XG I1528_P31_30 I1528_G29_28 I1528_G31_30 I1528_G31_28n VDD VSS AOI21_X1
XI1528_I127_XP I1528_P31_30 I1528_P29_28 I1528_P31_28n VDD VSS NAND2_X1
XI1528_I128_XG I1528_P4_1n I1528_G0_0n I1528_G4_1n I1528_G4_0 VDD VSS OAI21_X1
XI1528_I129 I1528_G1_0 I1528_G1_0n VDD VSS INV_X1
XI1528_I130_XG I1528_P5_2n I1528_G1_0n I1528_G5_2n I1528_G5_0 VDD VSS OAI21_X1
XI1528_I131_XG I1528_P6_3n I1528_G2_0n I1528_G6_3n I1528_G6_0 VDD VSS OAI21_X1
XI1528_I132_XG I1528_P7_4n I1528_G3_0n I1528_G7_4n I1528_G7_0 VDD VSS OAI21_X1
XI1528_I133_XG I1528_P8_5n I1528_G4_1n I1528_G8_5n I1528_G8_1 VDD VSS OAI21_X1
XI1528_I133_XP I1528_P8_5n I1528_P4_1n I1528_P8_1 VDD VSS NOR2_X1
XI1528_I134_XG I1528_P9_6n I1528_G5_2n I1528_G9_6n I1528_G9_2 VDD VSS OAI21_X1
XI1528_I134_XP I1528_P9_6n I1528_P5_2n I1528_P9_2 VDD VSS NOR2_X1
XI1528_I135_XG I1528_P10_7n I1528_G6_3n I1528_G10_7n I1528_G10_3 VDD VSS OAI21_X1
XI1528_I135_XP I1528_P10_7n I1528_P6_3n I1528_P10_3 VDD VSS NOR2_X1
XI1528_I136_XG I1528_P11_8n I1528_G7_4n I1528_G11_8n I1528_G11_4 VDD VSS OAI21_X1
XI1528_I136_XP I1528_P11_8n I1528_P7_4n I1528_P11_4 VDD VSS NOR2_X1
XI1528_I137_XG I1528_P12_9n I1528_G8_5n I1528_G12_9n I1528_G12_5 VDD VSS OAI21_X1
XI1528_I137_XP I1528_P12_9n I1528_P8_5n I1528_P12_5 VDD VSS NOR2_X1
XI1528_I138_XG I1528_P13_10n I1528_G9_6n I1528_G13_10n I1528_G13_6 VDD VSS OAI21_X1
XI1528_I138_XP I1528_P13_10n I1528_P9_6n I1528_P13_6 VDD VSS NOR2_X1
XI1528_I139_XG I1528_P14_11n I1528_G10_7n I1528_G14_11n I1528_G14_7 VDD VSS OAI21_X1
XI1528_I139_XP I1528_P14_11n I1528_P10_7n I1528_P14_7 VDD VSS NOR2_X1
XI1528_I140_XG I1528_P15_12n I1528_G11_8n I1528_G15_12n I1528_G15_8 VDD VSS OAI21_X1
XI1528_I140_XP I1528_P15_12n I1528_P11_8n I1528_P15_8 VDD VSS NOR2_X1
XI1528_I141_XG I1528_P16_13n I1528_G12_9n I1528_G16_13n I1528_G16_9 VDD VSS OAI21_X1
XI1528_I141_XP I1528_P16_13n I1528_P12_9n I1528_P16_9 VDD VSS NOR2_X1
XI1528_I142_XG I1528_P17_14n I1528_G13_10n I1528_G17_14n I1528_G17_10 VDD VSS OAI21_X1
XI1528_I142_XP I1528_P17_14n I1528_P13_10n I1528_P17_10 VDD VSS NOR2_X1
XI1528_I143_XG I1528_P18_15n I1528_G14_11n I1528_G18_15n I1528_G18_11 VDD VSS OAI21_X1
XI1528_I143_XP I1528_P18_15n I1528_P14_11n I1528_P18_11 VDD VSS NOR2_X1
XI1528_I144_XG I1528_P19_16n I1528_G15_12n I1528_G19_16n I1528_G19_12 VDD VSS OAI21_X1
XI1528_I144_XP I1528_P19_16n I1528_P15_12n I1528_P19_12 VDD VSS NOR2_X1
XI1528_I145_XG I1528_P20_17n I1528_G16_13n I1528_G20_17n I1528_G20_13 VDD VSS OAI21_X1
XI1528_I145_XP I1528_P20_17n I1528_P16_13n I1528_P20_13 VDD VSS NOR2_X1
XI1528_I146_XG I1528_P21_18n I1528_G17_14n I1528_G21_18n I1528_G21_14 VDD VSS OAI21_X1
XI1528_I146_XP I1528_P21_18n I1528_P17_14n I1528_P21_14 VDD VSS NOR2_X1
XI1528_I147_XG I1528_P22_19n I1528_G18_15n I1528_G22_19n I1528_G22_15 VDD VSS OAI21_X1
XI1528_I147_XP I1528_P22_19n I1528_P18_15n I1528_P22_15 VDD VSS NOR2_X1
XI1528_I148_XG I1528_P23_20n I1528_G19_16n I1528_G23_20n I1528_G23_16 VDD VSS OAI21_X1
XI1528_I148_XP I1528_P23_20n I1528_P19_16n I1528_P23_16 VDD VSS NOR2_X1
XI1528_I149_XG I1528_P24_21n I1528_G20_17n I1528_G24_21n I1528_G24_17 VDD VSS OAI21_X1
XI1528_I149_XP I1528_P24_21n I1528_P20_17n I1528_P24_17 VDD VSS NOR2_X1
XI1528_I150_XG I1528_P25_22n I1528_G21_18n I1528_G25_22n I1528_G25_18 VDD VSS OAI21_X1
XI1528_I150_XP I1528_P25_22n I1528_P21_18n I1528_P25_18 VDD VSS NOR2_X1
XI1528_I151_XG I1528_P26_23n I1528_G22_19n I1528_G26_23n I1528_G26_19 VDD VSS OAI21_X1
XI1528_I151_XP I1528_P26_23n I1528_P22_19n I1528_P26_19 VDD VSS NOR2_X1
XI1528_I152_XG I1528_P27_24n I1528_G23_20n I1528_G27_24n I1528_G27_20 VDD VSS OAI21_X1
XI1528_I152_XP I1528_P27_24n I1528_P23_20n I1528_P27_20 VDD VSS NOR2_X1
XI1528_I153_XG I1528_P28_25n I1528_G24_21n I1528_G28_25n I1528_G28_21 VDD VSS OAI21_X1
XI1528_I153_XP I1528_P28_25n I1528_P24_21n I1528_P28_21 VDD VSS NOR2_X1
XI1528_I154_XG I1528_P29_26n I1528_G25_22n I1528_G29_26n I1528_G29_22 VDD VSS OAI21_X1
XI1528_I154_XP I1528_P29_26n I1528_P25_22n I1528_P29_22 VDD VSS NOR2_X1
XI1528_I155_XG I1528_P30_27n I1528_G26_23n I1528_G30_27n I1528_G30_23 VDD VSS OAI21_X1
XI1528_I155_XP I1528_P30_27n I1528_P26_23n I1528_P30_23 VDD VSS NOR2_X1
XI1528_I156_XG I1528_P31_28n I1528_G27_24n I1528_G31_28n I1528_G31_24 VDD VSS OAI21_X1
XI1528_I156_XP I1528_P31_28n I1528_P27_24n I1528_P31_24 VDD VSS NOR2_X1
XI1528_I157_XG I1528_P8_1 I1528_G0_0 I1528_G8_1 I1528_G8_0n VDD VSS AOI21_X1
XI1528_I158_XG I1528_P9_2 I1528_G1_0 I1528_G9_2 I1528_G9_0n VDD VSS AOI21_X1
XI1528_I159 I1528_G2_0n I1528_G2_0np VDD VSS INV_X1
XI1528_I160_XG I1528_P10_3 I1528_G2_0np I1528_G10_3 I1528_G10_0n VDD VSS AOI21_X1
XI1528_I161 I1528_G3_0n I1528_G3_0np VDD VSS INV_X1
XI1528_I162_XG I1528_P11_4 I1528_G3_0np I1528_G11_4 I1528_G11_0n VDD VSS AOI21_X1
XI1528_I163_XG I1528_P12_5 I1528_G4_0 I1528_G12_5 I1528_G12_0n VDD VSS AOI21_X1
XI1528_I164_XG I1528_P13_6 I1528_G5_0 I1528_G13_6 I1528_G13_0n VDD VSS AOI21_X1
XI1528_I165_XG I1528_P14_7 I1528_G6_0 I1528_G14_7 I1528_G14_0n VDD VSS AOI21_X1
XI1528_I166_XG I1528_P15_8 I1528_G7_0 I1528_G15_8 I1528_G15_0n VDD VSS AOI21_X1
XI1528_I167_XG I1528_P16_9 I1528_G8_1 I1528_G16_9 I1528_G16_1n VDD VSS AOI21_X1
XI1528_I167_XP I1528_P16_9 I1528_P8_1 I1528_P16_1n VDD VSS NAND2_X1
XI1528_I168_XG I1528_P17_10 I1528_G9_2 I1528_G17_10 I1528_G17_2n VDD VSS AOI21_X1
XI1528_I168_XP I1528_P17_10 I1528_P9_2 I1528_P17_2n VDD VSS NAND2_X1
XI1528_I169_XG I1528_P18_11 I1528_G10_3 I1528_G18_11 I1528_G18_3n VDD VSS AOI21_X1
XI1528_I169_XP I1528_P18_11 I1528_P10_3 I1528_P18_3n VDD VSS NAND2_X1
XI1528_I170_XG I1528_P19_12 I1528_G11_4 I1528_G19_12 I1528_G19_4n VDD VSS AOI21_X1
XI1528_I170_XP I1528_P19_12 I1528_P11_4 I1528_P19_4n VDD VSS NAND2_X1
XI1528_I171_XG I1528_P20_13 I1528_G12_5 I1528_G20_13 I1528_G20_5n VDD VSS AOI21_X1
XI1528_I171_XP I1528_P20_13 I1528_P12_5 I1528_P20_5n VDD VSS NAND2_X1
XI1528_I172_XG I1528_P21_14 I1528_G13_6 I1528_G21_14 I1528_G21_6n VDD VSS AOI21_X1
XI1528_I172_XP I1528_P21_14 I1528_P13_6 I1528_P21_6n VDD VSS NAND2_X1
XI1528_I173_XG I1528_P22_15 I1528_G14_7 I1528_G22_15 I1528_G22_7n VDD VSS AOI21_X1
XI1528_I173_XP I1528_P22_15 I1528_P14_7 I1528_P22_7n VDD VSS NAND2_X1
XI1528_I174_XG I1528_P23_16 I1528_G15_8 I1528_G23_16 I1528_G23_8n VDD VSS AOI21_X1
XI1528_I174_XP I1528_P23_16 I1528_P15_8 I1528_P23_8n VDD VSS NAND2_X1
XI1528_I175_XG I1528_P24_17 I1528_G16_9 I1528_G24_17 I1528_G24_9n VDD VSS AOI21_X1
XI1528_I175_XP I1528_P24_17 I1528_P16_9 I1528_P24_9n VDD VSS NAND2_X1
XI1528_I176_XG I1528_P25_18 I1528_G17_10 I1528_G25_18 I1528_G25_10n VDD VSS AOI21_X1
XI1528_I176_XP I1528_P25_18 I1528_P17_10 I1528_P25_10n VDD VSS NAND2_X1
XI1528_I177_XG I1528_P26_19 I1528_G18_11 I1528_G26_19 I1528_G26_11n VDD VSS AOI21_X1
XI1528_I177_XP I1528_P26_19 I1528_P18_11 I1528_P26_11n VDD VSS NAND2_X1
XI1528_I178_XG I1528_P27_20 I1528_G19_12 I1528_G27_20 I1528_G27_12n VDD VSS AOI21_X1
XI1528_I178_XP I1528_P27_20 I1528_P19_12 I1528_P27_12n VDD VSS NAND2_X1
XI1528_I179_XG I1528_P28_21 I1528_G20_13 I1528_G28_21 I1528_G28_13n VDD VSS AOI21_X1
XI1528_I179_XP I1528_P28_21 I1528_P20_13 I1528_P28_13n VDD VSS NAND2_X1
XI1528_I180_XG I1528_P29_22 I1528_G21_14 I1528_G29_22 I1528_G29_14n VDD VSS AOI21_X1
XI1528_I180_XP I1528_P29_22 I1528_P21_14 I1528_P29_14n VDD VSS NAND2_X1
XI1528_I181_XG I1528_P30_23 I1528_G22_15 I1528_G30_23 I1528_G30_15n VDD VSS AOI21_X1
XI1528_I181_XP I1528_P30_23 I1528_P22_15 I1528_P30_15n VDD VSS NAND2_X1
XI1528_I182_XG I1528_P31_24 I1528_G23_16 I1528_G31_24 I1528_G31_16n VDD VSS AOI21_X1
XI1528_I182_XP I1528_P31_24 I1528_P23_16 I1528_P31_16n VDD VSS NAND2_X1
XI1528_I183_XG I1528_P16_1n I1528_G0_0n I1528_G16_1n I1528_G16_0 VDD VSS OAI21_X1
XI1528_I184_XG I1528_P17_2n I1528_G1_0n I1528_G17_2n I1528_G17_0 VDD VSS OAI21_X1
XI1528_I185_XG I1528_P18_3n I1528_G2_0n I1528_G18_3n I1528_G18_0 VDD VSS OAI21_X1
XI1528_I186_XG I1528_P19_4n I1528_G3_0n I1528_G19_4n I1528_G19_0 VDD VSS OAI21_X1
XI1528_I187 I1528_G4_0 I1528_G4_0n VDD VSS INV_X1
XI1528_I188_XG I1528_P20_5n I1528_G4_0n I1528_G20_5n I1528_G20_0 VDD VSS OAI21_X1
XI1528_I189 I1528_G5_0 I1528_G5_0n VDD VSS INV_X1
XI1528_I190_XG I1528_P21_6n I1528_G5_0n I1528_G21_6n I1528_G21_0 VDD VSS OAI21_X1
XI1528_I191 I1528_G6_0 I1528_G6_0n VDD VSS INV_X1
XI1528_I192_XG I1528_P22_7n I1528_G6_0n I1528_G22_7n I1528_G22_0 VDD VSS OAI21_X1
XI1528_I193 I1528_G7_0 I1528_G7_0n VDD VSS INV_X1
XI1528_I194_XG I1528_P23_8n I1528_G7_0n I1528_G23_8n I1528_G23_0 VDD VSS OAI21_X1
XI1528_I195_XG I1528_P24_9n I1528_G8_0n I1528_G24_9n I1528_G24_0 VDD VSS OAI21_X1
XI1528_I196_XG I1528_P25_10n I1528_G9_0n I1528_G25_10n I1528_G25_0 VDD VSS OAI21_X1
XI1528_I197_XG I1528_P26_11n I1528_G10_0n I1528_G26_11n I1528_G26_0 VDD VSS OAI21_X1
XI1528_I198_XG I1528_P27_12n I1528_G11_0n I1528_G27_12n I1528_G27_0 VDD VSS OAI21_X1
XI1528_I199_XG I1528_P28_13n I1528_G12_0n I1528_G28_13n I1528_G28_0 VDD VSS OAI21_X1
XI1528_I200_XG I1528_P29_14n I1528_G13_0n I1528_G29_14n I1528_G29_0 VDD VSS OAI21_X1
XI1528_I201_XG I1528_P30_15n I1528_G14_0n I1528_G30_15n c21_m VDD VSS OAI21_X1
XI1528_I202_XG I1528_P31_16n I1528_G15_0n I1528_G31_16n c21_o VDD VSS OAI21_X1
XI1528_I203 I1528_pn0 qu11_b3_5 p21_0 VDD VSS XNOR2_X1
XI1528_I204 I1528_pn1 I1528_G0_0 p21_1 VDD VSS XNOR2_X1
XI1528_I205 I1528_pn2 I1528_G1_0 p21_2 VDD VSS XNOR2_X1
XI1528_I206 I1528_pn3 I1528_G2_0n p21_3 VDD VSS XOR2_X1
XI1528_I207 I1528_pn4 I1528_G3_0n p21_4 VDD VSS XOR2_X1
XI1528_I208 I1528_pn5 I1528_G4_0 p21_5 VDD VSS XNOR2_X1
XI1528_I209 I1528_pn6 I1528_G5_0 p21_6 VDD VSS XNOR2_X1
XI1528_I210 I1528_pn7 I1528_G6_0 p21_7 VDD VSS XNOR2_X1
XI1528_I211 I1528_pn8 I1528_G7_0 p21_8 VDD VSS XNOR2_X1
XI1528_I212 I1528_pn9 I1528_G8_0n p21_9 VDD VSS XOR2_X1
XI1528_I213 I1528_pn10 I1528_G9_0n p21_10 VDD VSS XOR2_X1
XI1528_I214 I1528_pn11 I1528_G10_0n p21_11 VDD VSS XOR2_X1
XI1528_I215 I1528_pn12 I1528_G11_0n p21_12 VDD VSS XOR2_X1
XI1528_I216 I1528_pn13 I1528_G12_0n p21_13 VDD VSS XOR2_X1
XI1528_I217 I1528_pn14 I1528_G13_0n p21_14 VDD VSS XOR2_X1
XI1528_I218 I1528_pn15 I1528_G14_0n p21_15 VDD VSS XOR2_X1
XI1528_I219 I1528_pn16 I1528_G15_0n p21_16 VDD VSS XOR2_X1
XI1528_I220 I1528_pn17 I1528_G16_0 p21_17 VDD VSS XNOR2_X1
XI1528_I221 I1528_pn18 I1528_G17_0 p21_18 VDD VSS XNOR2_X1
XI1528_I222 I1528_pn19 I1528_G18_0 p21_19 VDD VSS XNOR2_X1
XI1528_I223 I1528_pn20 I1528_G19_0 p21_20 VDD VSS XNOR2_X1
XI1528_I224 I1528_pn21 I1528_G20_0 p21_21 VDD VSS XNOR2_X1
XI1528_I225 I1528_pn22 I1528_G21_0 p21_22 VDD VSS XNOR2_X1
XI1528_I226 I1528_pn23 I1528_G22_0 p21_23 VDD VSS XNOR2_X1
XI1528_I227 I1528_pn24 I1528_G23_0 p21_24 VDD VSS XNOR2_X1
XI1528_I228 I1528_pn25 I1528_G24_0 p21_25 VDD VSS XNOR2_X1
XI1528_I229 I1528_pn26 I1528_G25_0 p21_26 VDD VSS XNOR2_X1
XI1528_I230 I1528_pn27 I1528_G26_0 p21_27 VDD VSS XNOR2_X1
XI1528_I231 I1528_pn28 I1528_G27_0 p21_28 VDD VSS XNOR2_X1
XI1528_I232 I1528_pn29 I1528_G28_0 p21_29 VDD VSS XNOR2_X1
XI1528_I233 I1528_pn30 I1528_G29_0 p21_30 VDD VSS XNOR2_X1
XI1528_I234 I1528_pn31 c21_m p21_31 VDD VSS XNOR2_X1
XI1529 p20_31 qu11_b3_5 h21 VDD VSS XOR2_X1
XI1530 h21 c21_o p21_32 VDD VSS XOR2_X1
XI1531 p21_32 qu10 VDD VSS INV_X4
XI1532 qu10 qu10_b0 VDD VSS INV_X1
XI1533 qu10_b0 qu10_b1_0 VDD VSS INV_X4
XI1534 qu10_b1_0 qu10_b2_0 VDD VSS INV_X4
XI1535 qu10_b1_0 qu10_b2_1 VDD VSS INV_X4
XI1536 qu10_b2_0 qu10_b3_0 VDD VSS INV_X4
XI1537 qu10_b2_0 qu10_b3_1 VDD VSS INV_X4
XI1538 qu10_b2_0 qu10_b3_2 VDD VSS INV_X4
XI1539 qu10_b2_1 qu10_b3_3 VDD VSS INV_X4
XI1540 qu10_b2_1 qu10_b3_4 VDD VSS INV_X4
XI1541 qu10_b2_1 qu10_b3_5 VDD VSS INV_X4
XI1542 B_0_b3_3 qu10_b3_0 b22_0 VDD VSS XOR2_X1
XI1543 dd1_b3_4 qu10_b3_0 b22_1 VDD VSS XOR2_X1
XI1544 dd2_b3_4 qu10_b3_0 b22_2 VDD VSS XOR2_X1
XI1545 dd3_b3_4 qu10_b3_0 b22_3 VDD VSS XOR2_X1
XI1546 dd4_b3_4 qu10_b3_0 b22_4 VDD VSS XOR2_X1
XI1547 dd5_b3_4 qu10_b3_0 b22_5 VDD VSS XOR2_X1
XI1548 dd6_b3_4 qu10_b3_1 b22_6 VDD VSS XOR2_X1
XI1549 dd7_b3_4 qu10_b3_1 b22_7 VDD VSS XOR2_X1
XI1550 dd8_b3_4 qu10_b3_1 b22_8 VDD VSS XOR2_X1
XI1551 dd9_b3_4 qu10_b3_1 b22_9 VDD VSS XOR2_X1
XI1552 dd10_b3_4 qu10_b3_1 b22_10 VDD VSS XOR2_X1
XI1553 dd11_b3_4 qu10_b3_1 b22_11 VDD VSS XOR2_X1
XI1554 dd12_b3_4 qu10_b3_2 b22_12 VDD VSS XOR2_X1
XI1555 dd13_b3_4 qu10_b3_2 b22_13 VDD VSS XOR2_X1
XI1556 dd14_b3_4 qu10_b3_2 b22_14 VDD VSS XOR2_X1
XI1557 dd15_b3_4 qu10_b3_2 b22_15 VDD VSS XOR2_X1
XI1558 dd16_b3_4 qu10_b3_2 b22_16 VDD VSS XOR2_X1
XI1559 dd17_b3_4 qu10_b3_2 b22_17 VDD VSS XOR2_X1
XI1560 dd18_b3_4 qu10_b3_3 b22_18 VDD VSS XOR2_X1
XI1561 dd19_b3_4 qu10_b3_3 b22_19 VDD VSS XOR2_X1
XI1562 dd20_b3_4 qu10_b3_3 b22_20 VDD VSS XOR2_X1
XI1563 dd21_b3_4 qu10_b3_3 b22_21 VDD VSS XOR2_X1
XI1564 dd22_b3_4 qu10_b3_3 b22_22 VDD VSS XOR2_X1
XI1565 dd23_b3_4 qu10_b3_3 b22_23 VDD VSS XOR2_X1
XI1566 dd24_b3_4 qu10_b3_4 b22_24 VDD VSS XOR2_X1
XI1567 dd25_b3_4 qu10_b3_4 b22_25 VDD VSS XOR2_X1
XI1568 dd26_b3_4 qu10_b3_4 b22_26 VDD VSS XOR2_X1
XI1569 dd27_b3_4 qu10_b3_4 b22_27 VDD VSS XOR2_X1
XI1570 dd28_b3_4 qu10_b3_4 b22_28 VDD VSS XOR2_X1
XI1571 dd29_b3_4 qu10_b3_4 b22_29 VDD VSS XOR2_X1
XI1572 dd30_b3_4 qu10_b3_5 b22_30 VDD VSS XOR2_X1
XI1573 dd31_b3_4 qu10_b3_5 b22_31 VDD VSS XOR2_X1
XI1574_I0 aa9 b22_0 I1574_gn0 VDD VSS NAND2_X1
XI1574_I1 p21_0 b22_1 I1574_gn1 VDD VSS NAND2_X1
XI1574_I2 p21_1 b22_2 I1574_gn2 VDD VSS NAND2_X1
XI1574_I3 p21_2 b22_3 I1574_gn3 VDD VSS NAND2_X1
XI1574_I4 p21_3 b22_4 I1574_gn4 VDD VSS NAND2_X1
XI1574_I5 p21_4 b22_5 I1574_gn5 VDD VSS NAND2_X1
XI1574_I6 p21_5 b22_6 I1574_gn6 VDD VSS NAND2_X1
XI1574_I7 p21_6 b22_7 I1574_gn7 VDD VSS NAND2_X1
XI1574_I8 p21_7 b22_8 I1574_gn8 VDD VSS NAND2_X1
XI1574_I9 p21_8 b22_9 I1574_gn9 VDD VSS NAND2_X1
XI1574_I10 p21_9 b22_10 I1574_gn10 VDD VSS NAND2_X1
XI1574_I11 p21_10 b22_11 I1574_gn11 VDD VSS NAND2_X1
XI1574_I12 p21_11 b22_12 I1574_gn12 VDD VSS NAND2_X1
XI1574_I13 p21_12 b22_13 I1574_gn13 VDD VSS NAND2_X1
XI1574_I14 p21_13 b22_14 I1574_gn14 VDD VSS NAND2_X1
XI1574_I15 p21_14 b22_15 I1574_gn15 VDD VSS NAND2_X1
XI1574_I16 p21_15 b22_16 I1574_gn16 VDD VSS NAND2_X1
XI1574_I17 p21_16 b22_17 I1574_gn17 VDD VSS NAND2_X1
XI1574_I18 p21_17 b22_18 I1574_gn18 VDD VSS NAND2_X1
XI1574_I19 p21_18 b22_19 I1574_gn19 VDD VSS NAND2_X1
XI1574_I20 p21_19 b22_20 I1574_gn20 VDD VSS NAND2_X1
XI1574_I21 p21_20 b22_21 I1574_gn21 VDD VSS NAND2_X1
XI1574_I22 p21_21 b22_22 I1574_gn22 VDD VSS NAND2_X1
XI1574_I23 p21_22 b22_23 I1574_gn23 VDD VSS NAND2_X1
XI1574_I24 p21_23 b22_24 I1574_gn24 VDD VSS NAND2_X1
XI1574_I25 p21_24 b22_25 I1574_gn25 VDD VSS NAND2_X1
XI1574_I26 p21_25 b22_26 I1574_gn26 VDD VSS NAND2_X1
XI1574_I27 p21_26 b22_27 I1574_gn27 VDD VSS NAND2_X1
XI1574_I28 p21_27 b22_28 I1574_gn28 VDD VSS NAND2_X1
XI1574_I29 p21_28 b22_29 I1574_gn29 VDD VSS NAND2_X1
XI1574_I30 p21_29 b22_30 I1574_gn30 VDD VSS NAND2_X1
XI1574_I31 p21_30 b22_31 I1574_gn31 VDD VSS NAND2_X1
XI1574_I32 aa9 b22_0 I1574_pn0 VDD VSS XNOR2_X1
XI1574_I33 p21_0 b22_1 I1574_pn1 VDD VSS XNOR2_X1
XI1574_I34 p21_1 b22_2 I1574_pn2 VDD VSS XNOR2_X1
XI1574_I35 p21_2 b22_3 I1574_pn3 VDD VSS XNOR2_X1
XI1574_I36 p21_3 b22_4 I1574_pn4 VDD VSS XNOR2_X1
XI1574_I37 p21_4 b22_5 I1574_pn5 VDD VSS XNOR2_X1
XI1574_I38 p21_5 b22_6 I1574_pn6 VDD VSS XNOR2_X1
XI1574_I39 p21_6 b22_7 I1574_pn7 VDD VSS XNOR2_X1
XI1574_I40 p21_7 b22_8 I1574_pn8 VDD VSS XNOR2_X1
XI1574_I41 p21_8 b22_9 I1574_pn9 VDD VSS XNOR2_X1
XI1574_I42 p21_9 b22_10 I1574_pn10 VDD VSS XNOR2_X1
XI1574_I43 p21_10 b22_11 I1574_pn11 VDD VSS XNOR2_X1
XI1574_I44 p21_11 b22_12 I1574_pn12 VDD VSS XNOR2_X1
XI1574_I45 p21_12 b22_13 I1574_pn13 VDD VSS XNOR2_X1
XI1574_I46 p21_13 b22_14 I1574_pn14 VDD VSS XNOR2_X1
XI1574_I47 p21_14 b22_15 I1574_pn15 VDD VSS XNOR2_X1
XI1574_I48 p21_15 b22_16 I1574_pn16 VDD VSS XNOR2_X1
XI1574_I49 p21_16 b22_17 I1574_pn17 VDD VSS XNOR2_X1
XI1574_I50 p21_17 b22_18 I1574_pn18 VDD VSS XNOR2_X1
XI1574_I51 p21_18 b22_19 I1574_pn19 VDD VSS XNOR2_X1
XI1574_I52 p21_19 b22_20 I1574_pn20 VDD VSS XNOR2_X1
XI1574_I53 p21_20 b22_21 I1574_pn21 VDD VSS XNOR2_X1
XI1574_I54 p21_21 b22_22 I1574_pn22 VDD VSS XNOR2_X1
XI1574_I55 p21_22 b22_23 I1574_pn23 VDD VSS XNOR2_X1
XI1574_I56 p21_23 b22_24 I1574_pn24 VDD VSS XNOR2_X1
XI1574_I57 p21_24 b22_25 I1574_pn25 VDD VSS XNOR2_X1
XI1574_I58 p21_25 b22_26 I1574_pn26 VDD VSS XNOR2_X1
XI1574_I59 p21_26 b22_27 I1574_pn27 VDD VSS XNOR2_X1
XI1574_I60 p21_27 b22_28 I1574_pn28 VDD VSS XNOR2_X1
XI1574_I61 p21_28 b22_29 I1574_pn29 VDD VSS XNOR2_X1
XI1574_I62 p21_29 b22_30 I1574_pn30 VDD VSS XNOR2_X1
XI1574_I63 p21_30 b22_31 I1574_pn31 VDD VSS XNOR2_X1
XI1574_I64 qu10_b3_5 I1574_cinn VDD VSS INV_X1
XI1574_I65_XG I1574_pn0 I1574_cinn I1574_gn0 I1574_G0_0 VDD VSS OAI21_X1
XI1574_I66 I1574_G0_0 I1574_G0_0n VDD VSS INV_X1
XI1574_I67_XG I1574_pn1 I1574_G0_0n I1574_gn1 I1574_G1_0 VDD VSS OAI21_X1
XI1574_I68_XG I1574_pn2 I1574_gn1 I1574_gn2 I1574_G2_1 VDD VSS OAI21_X1
XI1574_I68_XP I1574_pn2 I1574_pn1 I1574_P2_1 VDD VSS NOR2_X1
XI1574_I69_XG I1574_pn3 I1574_gn2 I1574_gn3 I1574_G3_2 VDD VSS OAI21_X1
XI1574_I69_XP I1574_pn3 I1574_pn2 I1574_P3_2 VDD VSS NOR2_X1
XI1574_I70_XG I1574_pn4 I1574_gn3 I1574_gn4 I1574_G4_3 VDD VSS OAI21_X1
XI1574_I70_XP I1574_pn4 I1574_pn3 I1574_P4_3 VDD VSS NOR2_X1
XI1574_I71_XG I1574_pn5 I1574_gn4 I1574_gn5 I1574_G5_4 VDD VSS OAI21_X1
XI1574_I71_XP I1574_pn5 I1574_pn4 I1574_P5_4 VDD VSS NOR2_X1
XI1574_I72_XG I1574_pn6 I1574_gn5 I1574_gn6 I1574_G6_5 VDD VSS OAI21_X1
XI1574_I72_XP I1574_pn6 I1574_pn5 I1574_P6_5 VDD VSS NOR2_X1
XI1574_I73_XG I1574_pn7 I1574_gn6 I1574_gn7 I1574_G7_6 VDD VSS OAI21_X1
XI1574_I73_XP I1574_pn7 I1574_pn6 I1574_P7_6 VDD VSS NOR2_X1
XI1574_I74_XG I1574_pn8 I1574_gn7 I1574_gn8 I1574_G8_7 VDD VSS OAI21_X1
XI1574_I74_XP I1574_pn8 I1574_pn7 I1574_P8_7 VDD VSS NOR2_X1
XI1574_I75_XG I1574_pn9 I1574_gn8 I1574_gn9 I1574_G9_8 VDD VSS OAI21_X1
XI1574_I75_XP I1574_pn9 I1574_pn8 I1574_P9_8 VDD VSS NOR2_X1
XI1574_I76_XG I1574_pn10 I1574_gn9 I1574_gn10 I1574_G10_9 VDD VSS OAI21_X1
XI1574_I76_XP I1574_pn10 I1574_pn9 I1574_P10_9 VDD VSS NOR2_X1
XI1574_I77_XG I1574_pn11 I1574_gn10 I1574_gn11 I1574_G11_10 VDD VSS OAI21_X1
XI1574_I77_XP I1574_pn11 I1574_pn10 I1574_P11_10 VDD VSS NOR2_X1
XI1574_I78_XG I1574_pn12 I1574_gn11 I1574_gn12 I1574_G12_11 VDD VSS OAI21_X1
XI1574_I78_XP I1574_pn12 I1574_pn11 I1574_P12_11 VDD VSS NOR2_X1
XI1574_I79_XG I1574_pn13 I1574_gn12 I1574_gn13 I1574_G13_12 VDD VSS OAI21_X1
XI1574_I79_XP I1574_pn13 I1574_pn12 I1574_P13_12 VDD VSS NOR2_X1
XI1574_I80_XG I1574_pn14 I1574_gn13 I1574_gn14 I1574_G14_13 VDD VSS OAI21_X1
XI1574_I80_XP I1574_pn14 I1574_pn13 I1574_P14_13 VDD VSS NOR2_X1
XI1574_I81_XG I1574_pn15 I1574_gn14 I1574_gn15 I1574_G15_14 VDD VSS OAI21_X1
XI1574_I81_XP I1574_pn15 I1574_pn14 I1574_P15_14 VDD VSS NOR2_X1
XI1574_I82_XG I1574_pn16 I1574_gn15 I1574_gn16 I1574_G16_15 VDD VSS OAI21_X1
XI1574_I82_XP I1574_pn16 I1574_pn15 I1574_P16_15 VDD VSS NOR2_X1
XI1574_I83_XG I1574_pn17 I1574_gn16 I1574_gn17 I1574_G17_16 VDD VSS OAI21_X1
XI1574_I83_XP I1574_pn17 I1574_pn16 I1574_P17_16 VDD VSS NOR2_X1
XI1574_I84_XG I1574_pn18 I1574_gn17 I1574_gn18 I1574_G18_17 VDD VSS OAI21_X1
XI1574_I84_XP I1574_pn18 I1574_pn17 I1574_P18_17 VDD VSS NOR2_X1
XI1574_I85_XG I1574_pn19 I1574_gn18 I1574_gn19 I1574_G19_18 VDD VSS OAI21_X1
XI1574_I85_XP I1574_pn19 I1574_pn18 I1574_P19_18 VDD VSS NOR2_X1
XI1574_I86_XG I1574_pn20 I1574_gn19 I1574_gn20 I1574_G20_19 VDD VSS OAI21_X1
XI1574_I86_XP I1574_pn20 I1574_pn19 I1574_P20_19 VDD VSS NOR2_X1
XI1574_I87_XG I1574_pn21 I1574_gn20 I1574_gn21 I1574_G21_20 VDD VSS OAI21_X1
XI1574_I87_XP I1574_pn21 I1574_pn20 I1574_P21_20 VDD VSS NOR2_X1
XI1574_I88_XG I1574_pn22 I1574_gn21 I1574_gn22 I1574_G22_21 VDD VSS OAI21_X1
XI1574_I88_XP I1574_pn22 I1574_pn21 I1574_P22_21 VDD VSS NOR2_X1
XI1574_I89_XG I1574_pn23 I1574_gn22 I1574_gn23 I1574_G23_22 VDD VSS OAI21_X1
XI1574_I89_XP I1574_pn23 I1574_pn22 I1574_P23_22 VDD VSS NOR2_X1
XI1574_I90_XG I1574_pn24 I1574_gn23 I1574_gn24 I1574_G24_23 VDD VSS OAI21_X1
XI1574_I90_XP I1574_pn24 I1574_pn23 I1574_P24_23 VDD VSS NOR2_X1
XI1574_I91_XG I1574_pn25 I1574_gn24 I1574_gn25 I1574_G25_24 VDD VSS OAI21_X1
XI1574_I91_XP I1574_pn25 I1574_pn24 I1574_P25_24 VDD VSS NOR2_X1
XI1574_I92_XG I1574_pn26 I1574_gn25 I1574_gn26 I1574_G26_25 VDD VSS OAI21_X1
XI1574_I92_XP I1574_pn26 I1574_pn25 I1574_P26_25 VDD VSS NOR2_X1
XI1574_I93_XG I1574_pn27 I1574_gn26 I1574_gn27 I1574_G27_26 VDD VSS OAI21_X1
XI1574_I93_XP I1574_pn27 I1574_pn26 I1574_P27_26 VDD VSS NOR2_X1
XI1574_I94_XG I1574_pn28 I1574_gn27 I1574_gn28 I1574_G28_27 VDD VSS OAI21_X1
XI1574_I94_XP I1574_pn28 I1574_pn27 I1574_P28_27 VDD VSS NOR2_X1
XI1574_I95_XG I1574_pn29 I1574_gn28 I1574_gn29 I1574_G29_28 VDD VSS OAI21_X1
XI1574_I95_XP I1574_pn29 I1574_pn28 I1574_P29_28 VDD VSS NOR2_X1
XI1574_I96_XG I1574_pn30 I1574_gn29 I1574_gn30 I1574_G30_29 VDD VSS OAI21_X1
XI1574_I96_XP I1574_pn30 I1574_pn29 I1574_P30_29 VDD VSS NOR2_X1
XI1574_I97_XG I1574_pn31 I1574_gn30 I1574_gn31 I1574_G31_30 VDD VSS OAI21_X1
XI1574_I97_XP I1574_pn31 I1574_pn30 I1574_P31_30 VDD VSS NOR2_X1
XI1574_I98_XG I1574_P2_1 I1574_G0_0 I1574_G2_1 I1574_G2_0n VDD VSS AOI21_X1
XI1574_I99_XG I1574_P3_2 I1574_G1_0 I1574_G3_2 I1574_G3_0n VDD VSS AOI21_X1
XI1574_I100_XG I1574_P4_3 I1574_G2_1 I1574_G4_3 I1574_G4_1n VDD VSS AOI21_X1
XI1574_I100_XP I1574_P4_3 I1574_P2_1 I1574_P4_1n VDD VSS NAND2_X1
XI1574_I101_XG I1574_P5_4 I1574_G3_2 I1574_G5_4 I1574_G5_2n VDD VSS AOI21_X1
XI1574_I101_XP I1574_P5_4 I1574_P3_2 I1574_P5_2n VDD VSS NAND2_X1
XI1574_I102_XG I1574_P6_5 I1574_G4_3 I1574_G6_5 I1574_G6_3n VDD VSS AOI21_X1
XI1574_I102_XP I1574_P6_5 I1574_P4_3 I1574_P6_3n VDD VSS NAND2_X1
XI1574_I103_XG I1574_P7_6 I1574_G5_4 I1574_G7_6 I1574_G7_4n VDD VSS AOI21_X1
XI1574_I103_XP I1574_P7_6 I1574_P5_4 I1574_P7_4n VDD VSS NAND2_X1
XI1574_I104_XG I1574_P8_7 I1574_G6_5 I1574_G8_7 I1574_G8_5n VDD VSS AOI21_X1
XI1574_I104_XP I1574_P8_7 I1574_P6_5 I1574_P8_5n VDD VSS NAND2_X1
XI1574_I105_XG I1574_P9_8 I1574_G7_6 I1574_G9_8 I1574_G9_6n VDD VSS AOI21_X1
XI1574_I105_XP I1574_P9_8 I1574_P7_6 I1574_P9_6n VDD VSS NAND2_X1
XI1574_I106_XG I1574_P10_9 I1574_G8_7 I1574_G10_9 I1574_G10_7n VDD VSS AOI21_X1
XI1574_I106_XP I1574_P10_9 I1574_P8_7 I1574_P10_7n VDD VSS NAND2_X1
XI1574_I107_XG I1574_P11_10 I1574_G9_8 I1574_G11_10 I1574_G11_8n VDD VSS AOI21_X1
XI1574_I107_XP I1574_P11_10 I1574_P9_8 I1574_P11_8n VDD VSS NAND2_X1
XI1574_I108_XG I1574_P12_11 I1574_G10_9 I1574_G12_11 I1574_G12_9n VDD VSS AOI21_X1
XI1574_I108_XP I1574_P12_11 I1574_P10_9 I1574_P12_9n VDD VSS NAND2_X1
XI1574_I109_XG I1574_P13_12 I1574_G11_10 I1574_G13_12 I1574_G13_10n VDD VSS AOI21_X1
XI1574_I109_XP I1574_P13_12 I1574_P11_10 I1574_P13_10n VDD VSS NAND2_X1
XI1574_I110_XG I1574_P14_13 I1574_G12_11 I1574_G14_13 I1574_G14_11n VDD VSS AOI21_X1
XI1574_I110_XP I1574_P14_13 I1574_P12_11 I1574_P14_11n VDD VSS NAND2_X1
XI1574_I111_XG I1574_P15_14 I1574_G13_12 I1574_G15_14 I1574_G15_12n VDD VSS AOI21_X1
XI1574_I111_XP I1574_P15_14 I1574_P13_12 I1574_P15_12n VDD VSS NAND2_X1
XI1574_I112_XG I1574_P16_15 I1574_G14_13 I1574_G16_15 I1574_G16_13n VDD VSS AOI21_X1
XI1574_I112_XP I1574_P16_15 I1574_P14_13 I1574_P16_13n VDD VSS NAND2_X1
XI1574_I113_XG I1574_P17_16 I1574_G15_14 I1574_G17_16 I1574_G17_14n VDD VSS AOI21_X1
XI1574_I113_XP I1574_P17_16 I1574_P15_14 I1574_P17_14n VDD VSS NAND2_X1
XI1574_I114_XG I1574_P18_17 I1574_G16_15 I1574_G18_17 I1574_G18_15n VDD VSS AOI21_X1
XI1574_I114_XP I1574_P18_17 I1574_P16_15 I1574_P18_15n VDD VSS NAND2_X1
XI1574_I115_XG I1574_P19_18 I1574_G17_16 I1574_G19_18 I1574_G19_16n VDD VSS AOI21_X1
XI1574_I115_XP I1574_P19_18 I1574_P17_16 I1574_P19_16n VDD VSS NAND2_X1
XI1574_I116_XG I1574_P20_19 I1574_G18_17 I1574_G20_19 I1574_G20_17n VDD VSS AOI21_X1
XI1574_I116_XP I1574_P20_19 I1574_P18_17 I1574_P20_17n VDD VSS NAND2_X1
XI1574_I117_XG I1574_P21_20 I1574_G19_18 I1574_G21_20 I1574_G21_18n VDD VSS AOI21_X1
XI1574_I117_XP I1574_P21_20 I1574_P19_18 I1574_P21_18n VDD VSS NAND2_X1
XI1574_I118_XG I1574_P22_21 I1574_G20_19 I1574_G22_21 I1574_G22_19n VDD VSS AOI21_X1
XI1574_I118_XP I1574_P22_21 I1574_P20_19 I1574_P22_19n VDD VSS NAND2_X1
XI1574_I119_XG I1574_P23_22 I1574_G21_20 I1574_G23_22 I1574_G23_20n VDD VSS AOI21_X1
XI1574_I119_XP I1574_P23_22 I1574_P21_20 I1574_P23_20n VDD VSS NAND2_X1
XI1574_I120_XG I1574_P24_23 I1574_G22_21 I1574_G24_23 I1574_G24_21n VDD VSS AOI21_X1
XI1574_I120_XP I1574_P24_23 I1574_P22_21 I1574_P24_21n VDD VSS NAND2_X1
XI1574_I121_XG I1574_P25_24 I1574_G23_22 I1574_G25_24 I1574_G25_22n VDD VSS AOI21_X1
XI1574_I121_XP I1574_P25_24 I1574_P23_22 I1574_P25_22n VDD VSS NAND2_X1
XI1574_I122_XG I1574_P26_25 I1574_G24_23 I1574_G26_25 I1574_G26_23n VDD VSS AOI21_X1
XI1574_I122_XP I1574_P26_25 I1574_P24_23 I1574_P26_23n VDD VSS NAND2_X1
XI1574_I123_XG I1574_P27_26 I1574_G25_24 I1574_G27_26 I1574_G27_24n VDD VSS AOI21_X1
XI1574_I123_XP I1574_P27_26 I1574_P25_24 I1574_P27_24n VDD VSS NAND2_X1
XI1574_I124_XG I1574_P28_27 I1574_G26_25 I1574_G28_27 I1574_G28_25n VDD VSS AOI21_X1
XI1574_I124_XP I1574_P28_27 I1574_P26_25 I1574_P28_25n VDD VSS NAND2_X1
XI1574_I125_XG I1574_P29_28 I1574_G27_26 I1574_G29_28 I1574_G29_26n VDD VSS AOI21_X1
XI1574_I125_XP I1574_P29_28 I1574_P27_26 I1574_P29_26n VDD VSS NAND2_X1
XI1574_I126_XG I1574_P30_29 I1574_G28_27 I1574_G30_29 I1574_G30_27n VDD VSS AOI21_X1
XI1574_I126_XP I1574_P30_29 I1574_P28_27 I1574_P30_27n VDD VSS NAND2_X1
XI1574_I127_XG I1574_P31_30 I1574_G29_28 I1574_G31_30 I1574_G31_28n VDD VSS AOI21_X1
XI1574_I127_XP I1574_P31_30 I1574_P29_28 I1574_P31_28n VDD VSS NAND2_X1
XI1574_I128_XG I1574_P4_1n I1574_G0_0n I1574_G4_1n I1574_G4_0 VDD VSS OAI21_X1
XI1574_I129 I1574_G1_0 I1574_G1_0n VDD VSS INV_X1
XI1574_I130_XG I1574_P5_2n I1574_G1_0n I1574_G5_2n I1574_G5_0 VDD VSS OAI21_X1
XI1574_I131_XG I1574_P6_3n I1574_G2_0n I1574_G6_3n I1574_G6_0 VDD VSS OAI21_X1
XI1574_I132_XG I1574_P7_4n I1574_G3_0n I1574_G7_4n I1574_G7_0 VDD VSS OAI21_X1
XI1574_I133_XG I1574_P8_5n I1574_G4_1n I1574_G8_5n I1574_G8_1 VDD VSS OAI21_X1
XI1574_I133_XP I1574_P8_5n I1574_P4_1n I1574_P8_1 VDD VSS NOR2_X1
XI1574_I134_XG I1574_P9_6n I1574_G5_2n I1574_G9_6n I1574_G9_2 VDD VSS OAI21_X1
XI1574_I134_XP I1574_P9_6n I1574_P5_2n I1574_P9_2 VDD VSS NOR2_X1
XI1574_I135_XG I1574_P10_7n I1574_G6_3n I1574_G10_7n I1574_G10_3 VDD VSS OAI21_X1
XI1574_I135_XP I1574_P10_7n I1574_P6_3n I1574_P10_3 VDD VSS NOR2_X1
XI1574_I136_XG I1574_P11_8n I1574_G7_4n I1574_G11_8n I1574_G11_4 VDD VSS OAI21_X1
XI1574_I136_XP I1574_P11_8n I1574_P7_4n I1574_P11_4 VDD VSS NOR2_X1
XI1574_I137_XG I1574_P12_9n I1574_G8_5n I1574_G12_9n I1574_G12_5 VDD VSS OAI21_X1
XI1574_I137_XP I1574_P12_9n I1574_P8_5n I1574_P12_5 VDD VSS NOR2_X1
XI1574_I138_XG I1574_P13_10n I1574_G9_6n I1574_G13_10n I1574_G13_6 VDD VSS OAI21_X1
XI1574_I138_XP I1574_P13_10n I1574_P9_6n I1574_P13_6 VDD VSS NOR2_X1
XI1574_I139_XG I1574_P14_11n I1574_G10_7n I1574_G14_11n I1574_G14_7 VDD VSS OAI21_X1
XI1574_I139_XP I1574_P14_11n I1574_P10_7n I1574_P14_7 VDD VSS NOR2_X1
XI1574_I140_XG I1574_P15_12n I1574_G11_8n I1574_G15_12n I1574_G15_8 VDD VSS OAI21_X1
XI1574_I140_XP I1574_P15_12n I1574_P11_8n I1574_P15_8 VDD VSS NOR2_X1
XI1574_I141_XG I1574_P16_13n I1574_G12_9n I1574_G16_13n I1574_G16_9 VDD VSS OAI21_X1
XI1574_I141_XP I1574_P16_13n I1574_P12_9n I1574_P16_9 VDD VSS NOR2_X1
XI1574_I142_XG I1574_P17_14n I1574_G13_10n I1574_G17_14n I1574_G17_10 VDD VSS OAI21_X1
XI1574_I142_XP I1574_P17_14n I1574_P13_10n I1574_P17_10 VDD VSS NOR2_X1
XI1574_I143_XG I1574_P18_15n I1574_G14_11n I1574_G18_15n I1574_G18_11 VDD VSS OAI21_X1
XI1574_I143_XP I1574_P18_15n I1574_P14_11n I1574_P18_11 VDD VSS NOR2_X1
XI1574_I144_XG I1574_P19_16n I1574_G15_12n I1574_G19_16n I1574_G19_12 VDD VSS OAI21_X1
XI1574_I144_XP I1574_P19_16n I1574_P15_12n I1574_P19_12 VDD VSS NOR2_X1
XI1574_I145_XG I1574_P20_17n I1574_G16_13n I1574_G20_17n I1574_G20_13 VDD VSS OAI21_X1
XI1574_I145_XP I1574_P20_17n I1574_P16_13n I1574_P20_13 VDD VSS NOR2_X1
XI1574_I146_XG I1574_P21_18n I1574_G17_14n I1574_G21_18n I1574_G21_14 VDD VSS OAI21_X1
XI1574_I146_XP I1574_P21_18n I1574_P17_14n I1574_P21_14 VDD VSS NOR2_X1
XI1574_I147_XG I1574_P22_19n I1574_G18_15n I1574_G22_19n I1574_G22_15 VDD VSS OAI21_X1
XI1574_I147_XP I1574_P22_19n I1574_P18_15n I1574_P22_15 VDD VSS NOR2_X1
XI1574_I148_XG I1574_P23_20n I1574_G19_16n I1574_G23_20n I1574_G23_16 VDD VSS OAI21_X1
XI1574_I148_XP I1574_P23_20n I1574_P19_16n I1574_P23_16 VDD VSS NOR2_X1
XI1574_I149_XG I1574_P24_21n I1574_G20_17n I1574_G24_21n I1574_G24_17 VDD VSS OAI21_X1
XI1574_I149_XP I1574_P24_21n I1574_P20_17n I1574_P24_17 VDD VSS NOR2_X1
XI1574_I150_XG I1574_P25_22n I1574_G21_18n I1574_G25_22n I1574_G25_18 VDD VSS OAI21_X1
XI1574_I150_XP I1574_P25_22n I1574_P21_18n I1574_P25_18 VDD VSS NOR2_X1
XI1574_I151_XG I1574_P26_23n I1574_G22_19n I1574_G26_23n I1574_G26_19 VDD VSS OAI21_X1
XI1574_I151_XP I1574_P26_23n I1574_P22_19n I1574_P26_19 VDD VSS NOR2_X1
XI1574_I152_XG I1574_P27_24n I1574_G23_20n I1574_G27_24n I1574_G27_20 VDD VSS OAI21_X1
XI1574_I152_XP I1574_P27_24n I1574_P23_20n I1574_P27_20 VDD VSS NOR2_X1
XI1574_I153_XG I1574_P28_25n I1574_G24_21n I1574_G28_25n I1574_G28_21 VDD VSS OAI21_X1
XI1574_I153_XP I1574_P28_25n I1574_P24_21n I1574_P28_21 VDD VSS NOR2_X1
XI1574_I154_XG I1574_P29_26n I1574_G25_22n I1574_G29_26n I1574_G29_22 VDD VSS OAI21_X1
XI1574_I154_XP I1574_P29_26n I1574_P25_22n I1574_P29_22 VDD VSS NOR2_X1
XI1574_I155_XG I1574_P30_27n I1574_G26_23n I1574_G30_27n I1574_G30_23 VDD VSS OAI21_X1
XI1574_I155_XP I1574_P30_27n I1574_P26_23n I1574_P30_23 VDD VSS NOR2_X1
XI1574_I156_XG I1574_P31_28n I1574_G27_24n I1574_G31_28n I1574_G31_24 VDD VSS OAI21_X1
XI1574_I156_XP I1574_P31_28n I1574_P27_24n I1574_P31_24 VDD VSS NOR2_X1
XI1574_I157_XG I1574_P8_1 I1574_G0_0 I1574_G8_1 I1574_G8_0n VDD VSS AOI21_X1
XI1574_I158_XG I1574_P9_2 I1574_G1_0 I1574_G9_2 I1574_G9_0n VDD VSS AOI21_X1
XI1574_I159 I1574_G2_0n I1574_G2_0np VDD VSS INV_X1
XI1574_I160_XG I1574_P10_3 I1574_G2_0np I1574_G10_3 I1574_G10_0n VDD VSS AOI21_X1
XI1574_I161 I1574_G3_0n I1574_G3_0np VDD VSS INV_X1
XI1574_I162_XG I1574_P11_4 I1574_G3_0np I1574_G11_4 I1574_G11_0n VDD VSS AOI21_X1
XI1574_I163_XG I1574_P12_5 I1574_G4_0 I1574_G12_5 I1574_G12_0n VDD VSS AOI21_X1
XI1574_I164_XG I1574_P13_6 I1574_G5_0 I1574_G13_6 I1574_G13_0n VDD VSS AOI21_X1
XI1574_I165_XG I1574_P14_7 I1574_G6_0 I1574_G14_7 I1574_G14_0n VDD VSS AOI21_X1
XI1574_I166_XG I1574_P15_8 I1574_G7_0 I1574_G15_8 I1574_G15_0n VDD VSS AOI21_X1
XI1574_I167_XG I1574_P16_9 I1574_G8_1 I1574_G16_9 I1574_G16_1n VDD VSS AOI21_X1
XI1574_I167_XP I1574_P16_9 I1574_P8_1 I1574_P16_1n VDD VSS NAND2_X1
XI1574_I168_XG I1574_P17_10 I1574_G9_2 I1574_G17_10 I1574_G17_2n VDD VSS AOI21_X1
XI1574_I168_XP I1574_P17_10 I1574_P9_2 I1574_P17_2n VDD VSS NAND2_X1
XI1574_I169_XG I1574_P18_11 I1574_G10_3 I1574_G18_11 I1574_G18_3n VDD VSS AOI21_X1
XI1574_I169_XP I1574_P18_11 I1574_P10_3 I1574_P18_3n VDD VSS NAND2_X1
XI1574_I170_XG I1574_P19_12 I1574_G11_4 I1574_G19_12 I1574_G19_4n VDD VSS AOI21_X1
XI1574_I170_XP I1574_P19_12 I1574_P11_4 I1574_P19_4n VDD VSS NAND2_X1
XI1574_I171_XG I1574_P20_13 I1574_G12_5 I1574_G20_13 I1574_G20_5n VDD VSS AOI21_X1
XI1574_I171_XP I1574_P20_13 I1574_P12_5 I1574_P20_5n VDD VSS NAND2_X1
XI1574_I172_XG I1574_P21_14 I1574_G13_6 I1574_G21_14 I1574_G21_6n VDD VSS AOI21_X1
XI1574_I172_XP I1574_P21_14 I1574_P13_6 I1574_P21_6n VDD VSS NAND2_X1
XI1574_I173_XG I1574_P22_15 I1574_G14_7 I1574_G22_15 I1574_G22_7n VDD VSS AOI21_X1
XI1574_I173_XP I1574_P22_15 I1574_P14_7 I1574_P22_7n VDD VSS NAND2_X1
XI1574_I174_XG I1574_P23_16 I1574_G15_8 I1574_G23_16 I1574_G23_8n VDD VSS AOI21_X1
XI1574_I174_XP I1574_P23_16 I1574_P15_8 I1574_P23_8n VDD VSS NAND2_X1
XI1574_I175_XG I1574_P24_17 I1574_G16_9 I1574_G24_17 I1574_G24_9n VDD VSS AOI21_X1
XI1574_I175_XP I1574_P24_17 I1574_P16_9 I1574_P24_9n VDD VSS NAND2_X1
XI1574_I176_XG I1574_P25_18 I1574_G17_10 I1574_G25_18 I1574_G25_10n VDD VSS AOI21_X1
XI1574_I176_XP I1574_P25_18 I1574_P17_10 I1574_P25_10n VDD VSS NAND2_X1
XI1574_I177_XG I1574_P26_19 I1574_G18_11 I1574_G26_19 I1574_G26_11n VDD VSS AOI21_X1
XI1574_I177_XP I1574_P26_19 I1574_P18_11 I1574_P26_11n VDD VSS NAND2_X1
XI1574_I178_XG I1574_P27_20 I1574_G19_12 I1574_G27_20 I1574_G27_12n VDD VSS AOI21_X1
XI1574_I178_XP I1574_P27_20 I1574_P19_12 I1574_P27_12n VDD VSS NAND2_X1
XI1574_I179_XG I1574_P28_21 I1574_G20_13 I1574_G28_21 I1574_G28_13n VDD VSS AOI21_X1
XI1574_I179_XP I1574_P28_21 I1574_P20_13 I1574_P28_13n VDD VSS NAND2_X1
XI1574_I180_XG I1574_P29_22 I1574_G21_14 I1574_G29_22 I1574_G29_14n VDD VSS AOI21_X1
XI1574_I180_XP I1574_P29_22 I1574_P21_14 I1574_P29_14n VDD VSS NAND2_X1
XI1574_I181_XG I1574_P30_23 I1574_G22_15 I1574_G30_23 I1574_G30_15n VDD VSS AOI21_X1
XI1574_I181_XP I1574_P30_23 I1574_P22_15 I1574_P30_15n VDD VSS NAND2_X1
XI1574_I182_XG I1574_P31_24 I1574_G23_16 I1574_G31_24 I1574_G31_16n VDD VSS AOI21_X1
XI1574_I182_XP I1574_P31_24 I1574_P23_16 I1574_P31_16n VDD VSS NAND2_X1
XI1574_I183_XG I1574_P16_1n I1574_G0_0n I1574_G16_1n I1574_G16_0 VDD VSS OAI21_X1
XI1574_I184_XG I1574_P17_2n I1574_G1_0n I1574_G17_2n I1574_G17_0 VDD VSS OAI21_X1
XI1574_I185_XG I1574_P18_3n I1574_G2_0n I1574_G18_3n I1574_G18_0 VDD VSS OAI21_X1
XI1574_I186_XG I1574_P19_4n I1574_G3_0n I1574_G19_4n I1574_G19_0 VDD VSS OAI21_X1
XI1574_I187 I1574_G4_0 I1574_G4_0n VDD VSS INV_X1
XI1574_I188_XG I1574_P20_5n I1574_G4_0n I1574_G20_5n I1574_G20_0 VDD VSS OAI21_X1
XI1574_I189 I1574_G5_0 I1574_G5_0n VDD VSS INV_X1
XI1574_I190_XG I1574_P21_6n I1574_G5_0n I1574_G21_6n I1574_G21_0 VDD VSS OAI21_X1
XI1574_I191 I1574_G6_0 I1574_G6_0n VDD VSS INV_X1
XI1574_I192_XG I1574_P22_7n I1574_G6_0n I1574_G22_7n I1574_G22_0 VDD VSS OAI21_X1
XI1574_I193 I1574_G7_0 I1574_G7_0n VDD VSS INV_X1
XI1574_I194_XG I1574_P23_8n I1574_G7_0n I1574_G23_8n I1574_G23_0 VDD VSS OAI21_X1
XI1574_I195_XG I1574_P24_9n I1574_G8_0n I1574_G24_9n I1574_G24_0 VDD VSS OAI21_X1
XI1574_I196_XG I1574_P25_10n I1574_G9_0n I1574_G25_10n I1574_G25_0 VDD VSS OAI21_X1
XI1574_I197_XG I1574_P26_11n I1574_G10_0n I1574_G26_11n I1574_G26_0 VDD VSS OAI21_X1
XI1574_I198_XG I1574_P27_12n I1574_G11_0n I1574_G27_12n I1574_G27_0 VDD VSS OAI21_X1
XI1574_I199_XG I1574_P28_13n I1574_G12_0n I1574_G28_13n I1574_G28_0 VDD VSS OAI21_X1
XI1574_I200_XG I1574_P29_14n I1574_G13_0n I1574_G29_14n I1574_G29_0 VDD VSS OAI21_X1
XI1574_I201_XG I1574_P30_15n I1574_G14_0n I1574_G30_15n c22_m VDD VSS OAI21_X1
XI1574_I202_XG I1574_P31_16n I1574_G15_0n I1574_G31_16n c22_o VDD VSS OAI21_X1
XI1574_I203 I1574_pn0 qu10_b3_5 p22_0 VDD VSS XNOR2_X1
XI1574_I204 I1574_pn1 I1574_G0_0 p22_1 VDD VSS XNOR2_X1
XI1574_I205 I1574_pn2 I1574_G1_0 p22_2 VDD VSS XNOR2_X1
XI1574_I206 I1574_pn3 I1574_G2_0n p22_3 VDD VSS XOR2_X1
XI1574_I207 I1574_pn4 I1574_G3_0n p22_4 VDD VSS XOR2_X1
XI1574_I208 I1574_pn5 I1574_G4_0 p22_5 VDD VSS XNOR2_X1
XI1574_I209 I1574_pn6 I1574_G5_0 p22_6 VDD VSS XNOR2_X1
XI1574_I210 I1574_pn7 I1574_G6_0 p22_7 VDD VSS XNOR2_X1
XI1574_I211 I1574_pn8 I1574_G7_0 p22_8 VDD VSS XNOR2_X1
XI1574_I212 I1574_pn9 I1574_G8_0n p22_9 VDD VSS XOR2_X1
XI1574_I213 I1574_pn10 I1574_G9_0n p22_10 VDD VSS XOR2_X1
XI1574_I214 I1574_pn11 I1574_G10_0n p22_11 VDD VSS XOR2_X1
XI1574_I215 I1574_pn12 I1574_G11_0n p22_12 VDD VSS XOR2_X1
XI1574_I216 I1574_pn13 I1574_G12_0n p22_13 VDD VSS XOR2_X1
XI1574_I217 I1574_pn14 I1574_G13_0n p22_14 VDD VSS XOR2_X1
XI1574_I218 I1574_pn15 I1574_G14_0n p22_15 VDD VSS XOR2_X1
XI1574_I219 I1574_pn16 I1574_G15_0n p22_16 VDD VSS XOR2_X1
XI1574_I220 I1574_pn17 I1574_G16_0 p22_17 VDD VSS XNOR2_X1
XI1574_I221 I1574_pn18 I1574_G17_0 p22_18 VDD VSS XNOR2_X1
XI1574_I222 I1574_pn19 I1574_G18_0 p22_19 VDD VSS XNOR2_X1
XI1574_I223 I1574_pn20 I1574_G19_0 p22_20 VDD VSS XNOR2_X1
XI1574_I224 I1574_pn21 I1574_G20_0 p22_21 VDD VSS XNOR2_X1
XI1574_I225 I1574_pn22 I1574_G21_0 p22_22 VDD VSS XNOR2_X1
XI1574_I226 I1574_pn23 I1574_G22_0 p22_23 VDD VSS XNOR2_X1
XI1574_I227 I1574_pn24 I1574_G23_0 p22_24 VDD VSS XNOR2_X1
XI1574_I228 I1574_pn25 I1574_G24_0 p22_25 VDD VSS XNOR2_X1
XI1574_I229 I1574_pn26 I1574_G25_0 p22_26 VDD VSS XNOR2_X1
XI1574_I230 I1574_pn27 I1574_G26_0 p22_27 VDD VSS XNOR2_X1
XI1574_I231 I1574_pn28 I1574_G27_0 p22_28 VDD VSS XNOR2_X1
XI1574_I232 I1574_pn29 I1574_G28_0 p22_29 VDD VSS XNOR2_X1
XI1574_I233 I1574_pn30 I1574_G29_0 p22_30 VDD VSS XNOR2_X1
XI1574_I234 I1574_pn31 c22_m p22_31 VDD VSS XNOR2_X1
XI1575 p21_31 qu10_b3_5 h22 VDD VSS XOR2_X1
XI1576 h22 c22_o p22_32 VDD VSS XOR2_X1
XI1577 p22_32 qu9 VDD VSS INV_X4
XI1578 qu9 qu9_b0 VDD VSS INV_X1
XI1579 qu9_b0 qu9_b1_0 VDD VSS INV_X4
XI1580 qu9_b1_0 qu9_b2_0 VDD VSS INV_X4
XI1581 qu9_b1_0 qu9_b2_1 VDD VSS INV_X4
XI1582 qu9_b2_0 qu9_b3_0 VDD VSS INV_X4
XI1583 qu9_b2_0 qu9_b3_1 VDD VSS INV_X4
XI1584 qu9_b2_0 qu9_b3_2 VDD VSS INV_X4
XI1585 qu9_b2_1 qu9_b3_3 VDD VSS INV_X4
XI1586 qu9_b2_1 qu9_b3_4 VDD VSS INV_X4
XI1587 qu9_b2_1 qu9_b3_5 VDD VSS INV_X4
XI1588 B_0_b3_4 qu9_b3_0 b23_0 VDD VSS XOR2_X1
XI1589 dd1_b3_4 qu9_b3_0 b23_1 VDD VSS XOR2_X1
XI1590 dd2_b3_4 qu9_b3_0 b23_2 VDD VSS XOR2_X1
XI1591 dd3_b3_4 qu9_b3_0 b23_3 VDD VSS XOR2_X1
XI1592 dd4_b3_4 qu9_b3_0 b23_4 VDD VSS XOR2_X1
XI1593 dd5_b3_4 qu9_b3_0 b23_5 VDD VSS XOR2_X1
XI1594 dd6_b3_4 qu9_b3_1 b23_6 VDD VSS XOR2_X1
XI1595 dd7_b3_4 qu9_b3_1 b23_7 VDD VSS XOR2_X1
XI1596 dd8_b3_4 qu9_b3_1 b23_8 VDD VSS XOR2_X1
XI1597 dd9_b3_4 qu9_b3_1 b23_9 VDD VSS XOR2_X1
XI1598 dd10_b3_4 qu9_b3_1 b23_10 VDD VSS XOR2_X1
XI1599 dd11_b3_4 qu9_b3_1 b23_11 VDD VSS XOR2_X1
XI1600 dd12_b3_4 qu9_b3_2 b23_12 VDD VSS XOR2_X1
XI1601 dd13_b3_4 qu9_b3_2 b23_13 VDD VSS XOR2_X1
XI1602 dd14_b3_4 qu9_b3_2 b23_14 VDD VSS XOR2_X1
XI1603 dd15_b3_4 qu9_b3_2 b23_15 VDD VSS XOR2_X1
XI1604 dd16_b3_4 qu9_b3_2 b23_16 VDD VSS XOR2_X1
XI1605 dd17_b3_4 qu9_b3_2 b23_17 VDD VSS XOR2_X1
XI1606 dd18_b3_4 qu9_b3_3 b23_18 VDD VSS XOR2_X1
XI1607 dd19_b3_4 qu9_b3_3 b23_19 VDD VSS XOR2_X1
XI1608 dd20_b3_4 qu9_b3_3 b23_20 VDD VSS XOR2_X1
XI1609 dd21_b3_4 qu9_b3_3 b23_21 VDD VSS XOR2_X1
XI1610 dd22_b3_4 qu9_b3_3 b23_22 VDD VSS XOR2_X1
XI1611 dd23_b3_4 qu9_b3_3 b23_23 VDD VSS XOR2_X1
XI1612 dd24_b3_4 qu9_b3_4 b23_24 VDD VSS XOR2_X1
XI1613 dd25_b3_4 qu9_b3_4 b23_25 VDD VSS XOR2_X1
XI1614 dd26_b3_4 qu9_b3_4 b23_26 VDD VSS XOR2_X1
XI1615 dd27_b3_4 qu9_b3_4 b23_27 VDD VSS XOR2_X1
XI1616 dd28_b3_4 qu9_b3_4 b23_28 VDD VSS XOR2_X1
XI1617 dd29_b3_4 qu9_b3_4 b23_29 VDD VSS XOR2_X1
XI1618 dd30_b3_4 qu9_b3_5 b23_30 VDD VSS XOR2_X1
XI1619 dd31_b3_4 qu9_b3_5 b23_31 VDD VSS XOR2_X1
XI1620_I0 aa8 b23_0 I1620_gn0 VDD VSS NAND2_X1
XI1620_I1 p22_0 b23_1 I1620_gn1 VDD VSS NAND2_X1
XI1620_I2 p22_1 b23_2 I1620_gn2 VDD VSS NAND2_X1
XI1620_I3 p22_2 b23_3 I1620_gn3 VDD VSS NAND2_X1
XI1620_I4 p22_3 b23_4 I1620_gn4 VDD VSS NAND2_X1
XI1620_I5 p22_4 b23_5 I1620_gn5 VDD VSS NAND2_X1
XI1620_I6 p22_5 b23_6 I1620_gn6 VDD VSS NAND2_X1
XI1620_I7 p22_6 b23_7 I1620_gn7 VDD VSS NAND2_X1
XI1620_I8 p22_7 b23_8 I1620_gn8 VDD VSS NAND2_X1
XI1620_I9 p22_8 b23_9 I1620_gn9 VDD VSS NAND2_X1
XI1620_I10 p22_9 b23_10 I1620_gn10 VDD VSS NAND2_X1
XI1620_I11 p22_10 b23_11 I1620_gn11 VDD VSS NAND2_X1
XI1620_I12 p22_11 b23_12 I1620_gn12 VDD VSS NAND2_X1
XI1620_I13 p22_12 b23_13 I1620_gn13 VDD VSS NAND2_X1
XI1620_I14 p22_13 b23_14 I1620_gn14 VDD VSS NAND2_X1
XI1620_I15 p22_14 b23_15 I1620_gn15 VDD VSS NAND2_X1
XI1620_I16 p22_15 b23_16 I1620_gn16 VDD VSS NAND2_X1
XI1620_I17 p22_16 b23_17 I1620_gn17 VDD VSS NAND2_X1
XI1620_I18 p22_17 b23_18 I1620_gn18 VDD VSS NAND2_X1
XI1620_I19 p22_18 b23_19 I1620_gn19 VDD VSS NAND2_X1
XI1620_I20 p22_19 b23_20 I1620_gn20 VDD VSS NAND2_X1
XI1620_I21 p22_20 b23_21 I1620_gn21 VDD VSS NAND2_X1
XI1620_I22 p22_21 b23_22 I1620_gn22 VDD VSS NAND2_X1
XI1620_I23 p22_22 b23_23 I1620_gn23 VDD VSS NAND2_X1
XI1620_I24 p22_23 b23_24 I1620_gn24 VDD VSS NAND2_X1
XI1620_I25 p22_24 b23_25 I1620_gn25 VDD VSS NAND2_X1
XI1620_I26 p22_25 b23_26 I1620_gn26 VDD VSS NAND2_X1
XI1620_I27 p22_26 b23_27 I1620_gn27 VDD VSS NAND2_X1
XI1620_I28 p22_27 b23_28 I1620_gn28 VDD VSS NAND2_X1
XI1620_I29 p22_28 b23_29 I1620_gn29 VDD VSS NAND2_X1
XI1620_I30 p22_29 b23_30 I1620_gn30 VDD VSS NAND2_X1
XI1620_I31 p22_30 b23_31 I1620_gn31 VDD VSS NAND2_X1
XI1620_I32 aa8 b23_0 I1620_pn0 VDD VSS XNOR2_X1
XI1620_I33 p22_0 b23_1 I1620_pn1 VDD VSS XNOR2_X1
XI1620_I34 p22_1 b23_2 I1620_pn2 VDD VSS XNOR2_X1
XI1620_I35 p22_2 b23_3 I1620_pn3 VDD VSS XNOR2_X1
XI1620_I36 p22_3 b23_4 I1620_pn4 VDD VSS XNOR2_X1
XI1620_I37 p22_4 b23_5 I1620_pn5 VDD VSS XNOR2_X1
XI1620_I38 p22_5 b23_6 I1620_pn6 VDD VSS XNOR2_X1
XI1620_I39 p22_6 b23_7 I1620_pn7 VDD VSS XNOR2_X1
XI1620_I40 p22_7 b23_8 I1620_pn8 VDD VSS XNOR2_X1
XI1620_I41 p22_8 b23_9 I1620_pn9 VDD VSS XNOR2_X1
XI1620_I42 p22_9 b23_10 I1620_pn10 VDD VSS XNOR2_X1
XI1620_I43 p22_10 b23_11 I1620_pn11 VDD VSS XNOR2_X1
XI1620_I44 p22_11 b23_12 I1620_pn12 VDD VSS XNOR2_X1
XI1620_I45 p22_12 b23_13 I1620_pn13 VDD VSS XNOR2_X1
XI1620_I46 p22_13 b23_14 I1620_pn14 VDD VSS XNOR2_X1
XI1620_I47 p22_14 b23_15 I1620_pn15 VDD VSS XNOR2_X1
XI1620_I48 p22_15 b23_16 I1620_pn16 VDD VSS XNOR2_X1
XI1620_I49 p22_16 b23_17 I1620_pn17 VDD VSS XNOR2_X1
XI1620_I50 p22_17 b23_18 I1620_pn18 VDD VSS XNOR2_X1
XI1620_I51 p22_18 b23_19 I1620_pn19 VDD VSS XNOR2_X1
XI1620_I52 p22_19 b23_20 I1620_pn20 VDD VSS XNOR2_X1
XI1620_I53 p22_20 b23_21 I1620_pn21 VDD VSS XNOR2_X1
XI1620_I54 p22_21 b23_22 I1620_pn22 VDD VSS XNOR2_X1
XI1620_I55 p22_22 b23_23 I1620_pn23 VDD VSS XNOR2_X1
XI1620_I56 p22_23 b23_24 I1620_pn24 VDD VSS XNOR2_X1
XI1620_I57 p22_24 b23_25 I1620_pn25 VDD VSS XNOR2_X1
XI1620_I58 p22_25 b23_26 I1620_pn26 VDD VSS XNOR2_X1
XI1620_I59 p22_26 b23_27 I1620_pn27 VDD VSS XNOR2_X1
XI1620_I60 p22_27 b23_28 I1620_pn28 VDD VSS XNOR2_X1
XI1620_I61 p22_28 b23_29 I1620_pn29 VDD VSS XNOR2_X1
XI1620_I62 p22_29 b23_30 I1620_pn30 VDD VSS XNOR2_X1
XI1620_I63 p22_30 b23_31 I1620_pn31 VDD VSS XNOR2_X1
XI1620_I64 qu9_b3_5 I1620_cinn VDD VSS INV_X1
XI1620_I65_XG I1620_pn0 I1620_cinn I1620_gn0 I1620_G0_0 VDD VSS OAI21_X1
XI1620_I66 I1620_G0_0 I1620_G0_0n VDD VSS INV_X1
XI1620_I67_XG I1620_pn1 I1620_G0_0n I1620_gn1 I1620_G1_0 VDD VSS OAI21_X1
XI1620_I68_XG I1620_pn2 I1620_gn1 I1620_gn2 I1620_G2_1 VDD VSS OAI21_X1
XI1620_I68_XP I1620_pn2 I1620_pn1 I1620_P2_1 VDD VSS NOR2_X1
XI1620_I69_XG I1620_pn3 I1620_gn2 I1620_gn3 I1620_G3_2 VDD VSS OAI21_X1
XI1620_I69_XP I1620_pn3 I1620_pn2 I1620_P3_2 VDD VSS NOR2_X1
XI1620_I70_XG I1620_pn4 I1620_gn3 I1620_gn4 I1620_G4_3 VDD VSS OAI21_X1
XI1620_I70_XP I1620_pn4 I1620_pn3 I1620_P4_3 VDD VSS NOR2_X1
XI1620_I71_XG I1620_pn5 I1620_gn4 I1620_gn5 I1620_G5_4 VDD VSS OAI21_X1
XI1620_I71_XP I1620_pn5 I1620_pn4 I1620_P5_4 VDD VSS NOR2_X1
XI1620_I72_XG I1620_pn6 I1620_gn5 I1620_gn6 I1620_G6_5 VDD VSS OAI21_X1
XI1620_I72_XP I1620_pn6 I1620_pn5 I1620_P6_5 VDD VSS NOR2_X1
XI1620_I73_XG I1620_pn7 I1620_gn6 I1620_gn7 I1620_G7_6 VDD VSS OAI21_X1
XI1620_I73_XP I1620_pn7 I1620_pn6 I1620_P7_6 VDD VSS NOR2_X1
XI1620_I74_XG I1620_pn8 I1620_gn7 I1620_gn8 I1620_G8_7 VDD VSS OAI21_X1
XI1620_I74_XP I1620_pn8 I1620_pn7 I1620_P8_7 VDD VSS NOR2_X1
XI1620_I75_XG I1620_pn9 I1620_gn8 I1620_gn9 I1620_G9_8 VDD VSS OAI21_X1
XI1620_I75_XP I1620_pn9 I1620_pn8 I1620_P9_8 VDD VSS NOR2_X1
XI1620_I76_XG I1620_pn10 I1620_gn9 I1620_gn10 I1620_G10_9 VDD VSS OAI21_X1
XI1620_I76_XP I1620_pn10 I1620_pn9 I1620_P10_9 VDD VSS NOR2_X1
XI1620_I77_XG I1620_pn11 I1620_gn10 I1620_gn11 I1620_G11_10 VDD VSS OAI21_X1
XI1620_I77_XP I1620_pn11 I1620_pn10 I1620_P11_10 VDD VSS NOR2_X1
XI1620_I78_XG I1620_pn12 I1620_gn11 I1620_gn12 I1620_G12_11 VDD VSS OAI21_X1
XI1620_I78_XP I1620_pn12 I1620_pn11 I1620_P12_11 VDD VSS NOR2_X1
XI1620_I79_XG I1620_pn13 I1620_gn12 I1620_gn13 I1620_G13_12 VDD VSS OAI21_X1
XI1620_I79_XP I1620_pn13 I1620_pn12 I1620_P13_12 VDD VSS NOR2_X1
XI1620_I80_XG I1620_pn14 I1620_gn13 I1620_gn14 I1620_G14_13 VDD VSS OAI21_X1
XI1620_I80_XP I1620_pn14 I1620_pn13 I1620_P14_13 VDD VSS NOR2_X1
XI1620_I81_XG I1620_pn15 I1620_gn14 I1620_gn15 I1620_G15_14 VDD VSS OAI21_X1
XI1620_I81_XP I1620_pn15 I1620_pn14 I1620_P15_14 VDD VSS NOR2_X1
XI1620_I82_XG I1620_pn16 I1620_gn15 I1620_gn16 I1620_G16_15 VDD VSS OAI21_X1
XI1620_I82_XP I1620_pn16 I1620_pn15 I1620_P16_15 VDD VSS NOR2_X1
XI1620_I83_XG I1620_pn17 I1620_gn16 I1620_gn17 I1620_G17_16 VDD VSS OAI21_X1
XI1620_I83_XP I1620_pn17 I1620_pn16 I1620_P17_16 VDD VSS NOR2_X1
XI1620_I84_XG I1620_pn18 I1620_gn17 I1620_gn18 I1620_G18_17 VDD VSS OAI21_X1
XI1620_I84_XP I1620_pn18 I1620_pn17 I1620_P18_17 VDD VSS NOR2_X1
XI1620_I85_XG I1620_pn19 I1620_gn18 I1620_gn19 I1620_G19_18 VDD VSS OAI21_X1
XI1620_I85_XP I1620_pn19 I1620_pn18 I1620_P19_18 VDD VSS NOR2_X1
XI1620_I86_XG I1620_pn20 I1620_gn19 I1620_gn20 I1620_G20_19 VDD VSS OAI21_X1
XI1620_I86_XP I1620_pn20 I1620_pn19 I1620_P20_19 VDD VSS NOR2_X1
XI1620_I87_XG I1620_pn21 I1620_gn20 I1620_gn21 I1620_G21_20 VDD VSS OAI21_X1
XI1620_I87_XP I1620_pn21 I1620_pn20 I1620_P21_20 VDD VSS NOR2_X1
XI1620_I88_XG I1620_pn22 I1620_gn21 I1620_gn22 I1620_G22_21 VDD VSS OAI21_X1
XI1620_I88_XP I1620_pn22 I1620_pn21 I1620_P22_21 VDD VSS NOR2_X1
XI1620_I89_XG I1620_pn23 I1620_gn22 I1620_gn23 I1620_G23_22 VDD VSS OAI21_X1
XI1620_I89_XP I1620_pn23 I1620_pn22 I1620_P23_22 VDD VSS NOR2_X1
XI1620_I90_XG I1620_pn24 I1620_gn23 I1620_gn24 I1620_G24_23 VDD VSS OAI21_X1
XI1620_I90_XP I1620_pn24 I1620_pn23 I1620_P24_23 VDD VSS NOR2_X1
XI1620_I91_XG I1620_pn25 I1620_gn24 I1620_gn25 I1620_G25_24 VDD VSS OAI21_X1
XI1620_I91_XP I1620_pn25 I1620_pn24 I1620_P25_24 VDD VSS NOR2_X1
XI1620_I92_XG I1620_pn26 I1620_gn25 I1620_gn26 I1620_G26_25 VDD VSS OAI21_X1
XI1620_I92_XP I1620_pn26 I1620_pn25 I1620_P26_25 VDD VSS NOR2_X1
XI1620_I93_XG I1620_pn27 I1620_gn26 I1620_gn27 I1620_G27_26 VDD VSS OAI21_X1
XI1620_I93_XP I1620_pn27 I1620_pn26 I1620_P27_26 VDD VSS NOR2_X1
XI1620_I94_XG I1620_pn28 I1620_gn27 I1620_gn28 I1620_G28_27 VDD VSS OAI21_X1
XI1620_I94_XP I1620_pn28 I1620_pn27 I1620_P28_27 VDD VSS NOR2_X1
XI1620_I95_XG I1620_pn29 I1620_gn28 I1620_gn29 I1620_G29_28 VDD VSS OAI21_X1
XI1620_I95_XP I1620_pn29 I1620_pn28 I1620_P29_28 VDD VSS NOR2_X1
XI1620_I96_XG I1620_pn30 I1620_gn29 I1620_gn30 I1620_G30_29 VDD VSS OAI21_X1
XI1620_I96_XP I1620_pn30 I1620_pn29 I1620_P30_29 VDD VSS NOR2_X1
XI1620_I97_XG I1620_pn31 I1620_gn30 I1620_gn31 I1620_G31_30 VDD VSS OAI21_X1
XI1620_I97_XP I1620_pn31 I1620_pn30 I1620_P31_30 VDD VSS NOR2_X1
XI1620_I98_XG I1620_P2_1 I1620_G0_0 I1620_G2_1 I1620_G2_0n VDD VSS AOI21_X1
XI1620_I99_XG I1620_P3_2 I1620_G1_0 I1620_G3_2 I1620_G3_0n VDD VSS AOI21_X1
XI1620_I100_XG I1620_P4_3 I1620_G2_1 I1620_G4_3 I1620_G4_1n VDD VSS AOI21_X1
XI1620_I100_XP I1620_P4_3 I1620_P2_1 I1620_P4_1n VDD VSS NAND2_X1
XI1620_I101_XG I1620_P5_4 I1620_G3_2 I1620_G5_4 I1620_G5_2n VDD VSS AOI21_X1
XI1620_I101_XP I1620_P5_4 I1620_P3_2 I1620_P5_2n VDD VSS NAND2_X1
XI1620_I102_XG I1620_P6_5 I1620_G4_3 I1620_G6_5 I1620_G6_3n VDD VSS AOI21_X1
XI1620_I102_XP I1620_P6_5 I1620_P4_3 I1620_P6_3n VDD VSS NAND2_X1
XI1620_I103_XG I1620_P7_6 I1620_G5_4 I1620_G7_6 I1620_G7_4n VDD VSS AOI21_X1
XI1620_I103_XP I1620_P7_6 I1620_P5_4 I1620_P7_4n VDD VSS NAND2_X1
XI1620_I104_XG I1620_P8_7 I1620_G6_5 I1620_G8_7 I1620_G8_5n VDD VSS AOI21_X1
XI1620_I104_XP I1620_P8_7 I1620_P6_5 I1620_P8_5n VDD VSS NAND2_X1
XI1620_I105_XG I1620_P9_8 I1620_G7_6 I1620_G9_8 I1620_G9_6n VDD VSS AOI21_X1
XI1620_I105_XP I1620_P9_8 I1620_P7_6 I1620_P9_6n VDD VSS NAND2_X1
XI1620_I106_XG I1620_P10_9 I1620_G8_7 I1620_G10_9 I1620_G10_7n VDD VSS AOI21_X1
XI1620_I106_XP I1620_P10_9 I1620_P8_7 I1620_P10_7n VDD VSS NAND2_X1
XI1620_I107_XG I1620_P11_10 I1620_G9_8 I1620_G11_10 I1620_G11_8n VDD VSS AOI21_X1
XI1620_I107_XP I1620_P11_10 I1620_P9_8 I1620_P11_8n VDD VSS NAND2_X1
XI1620_I108_XG I1620_P12_11 I1620_G10_9 I1620_G12_11 I1620_G12_9n VDD VSS AOI21_X1
XI1620_I108_XP I1620_P12_11 I1620_P10_9 I1620_P12_9n VDD VSS NAND2_X1
XI1620_I109_XG I1620_P13_12 I1620_G11_10 I1620_G13_12 I1620_G13_10n VDD VSS AOI21_X1
XI1620_I109_XP I1620_P13_12 I1620_P11_10 I1620_P13_10n VDD VSS NAND2_X1
XI1620_I110_XG I1620_P14_13 I1620_G12_11 I1620_G14_13 I1620_G14_11n VDD VSS AOI21_X1
XI1620_I110_XP I1620_P14_13 I1620_P12_11 I1620_P14_11n VDD VSS NAND2_X1
XI1620_I111_XG I1620_P15_14 I1620_G13_12 I1620_G15_14 I1620_G15_12n VDD VSS AOI21_X1
XI1620_I111_XP I1620_P15_14 I1620_P13_12 I1620_P15_12n VDD VSS NAND2_X1
XI1620_I112_XG I1620_P16_15 I1620_G14_13 I1620_G16_15 I1620_G16_13n VDD VSS AOI21_X1
XI1620_I112_XP I1620_P16_15 I1620_P14_13 I1620_P16_13n VDD VSS NAND2_X1
XI1620_I113_XG I1620_P17_16 I1620_G15_14 I1620_G17_16 I1620_G17_14n VDD VSS AOI21_X1
XI1620_I113_XP I1620_P17_16 I1620_P15_14 I1620_P17_14n VDD VSS NAND2_X1
XI1620_I114_XG I1620_P18_17 I1620_G16_15 I1620_G18_17 I1620_G18_15n VDD VSS AOI21_X1
XI1620_I114_XP I1620_P18_17 I1620_P16_15 I1620_P18_15n VDD VSS NAND2_X1
XI1620_I115_XG I1620_P19_18 I1620_G17_16 I1620_G19_18 I1620_G19_16n VDD VSS AOI21_X1
XI1620_I115_XP I1620_P19_18 I1620_P17_16 I1620_P19_16n VDD VSS NAND2_X1
XI1620_I116_XG I1620_P20_19 I1620_G18_17 I1620_G20_19 I1620_G20_17n VDD VSS AOI21_X1
XI1620_I116_XP I1620_P20_19 I1620_P18_17 I1620_P20_17n VDD VSS NAND2_X1
XI1620_I117_XG I1620_P21_20 I1620_G19_18 I1620_G21_20 I1620_G21_18n VDD VSS AOI21_X1
XI1620_I117_XP I1620_P21_20 I1620_P19_18 I1620_P21_18n VDD VSS NAND2_X1
XI1620_I118_XG I1620_P22_21 I1620_G20_19 I1620_G22_21 I1620_G22_19n VDD VSS AOI21_X1
XI1620_I118_XP I1620_P22_21 I1620_P20_19 I1620_P22_19n VDD VSS NAND2_X1
XI1620_I119_XG I1620_P23_22 I1620_G21_20 I1620_G23_22 I1620_G23_20n VDD VSS AOI21_X1
XI1620_I119_XP I1620_P23_22 I1620_P21_20 I1620_P23_20n VDD VSS NAND2_X1
XI1620_I120_XG I1620_P24_23 I1620_G22_21 I1620_G24_23 I1620_G24_21n VDD VSS AOI21_X1
XI1620_I120_XP I1620_P24_23 I1620_P22_21 I1620_P24_21n VDD VSS NAND2_X1
XI1620_I121_XG I1620_P25_24 I1620_G23_22 I1620_G25_24 I1620_G25_22n VDD VSS AOI21_X1
XI1620_I121_XP I1620_P25_24 I1620_P23_22 I1620_P25_22n VDD VSS NAND2_X1
XI1620_I122_XG I1620_P26_25 I1620_G24_23 I1620_G26_25 I1620_G26_23n VDD VSS AOI21_X1
XI1620_I122_XP I1620_P26_25 I1620_P24_23 I1620_P26_23n VDD VSS NAND2_X1
XI1620_I123_XG I1620_P27_26 I1620_G25_24 I1620_G27_26 I1620_G27_24n VDD VSS AOI21_X1
XI1620_I123_XP I1620_P27_26 I1620_P25_24 I1620_P27_24n VDD VSS NAND2_X1
XI1620_I124_XG I1620_P28_27 I1620_G26_25 I1620_G28_27 I1620_G28_25n VDD VSS AOI21_X1
XI1620_I124_XP I1620_P28_27 I1620_P26_25 I1620_P28_25n VDD VSS NAND2_X1
XI1620_I125_XG I1620_P29_28 I1620_G27_26 I1620_G29_28 I1620_G29_26n VDD VSS AOI21_X1
XI1620_I125_XP I1620_P29_28 I1620_P27_26 I1620_P29_26n VDD VSS NAND2_X1
XI1620_I126_XG I1620_P30_29 I1620_G28_27 I1620_G30_29 I1620_G30_27n VDD VSS AOI21_X1
XI1620_I126_XP I1620_P30_29 I1620_P28_27 I1620_P30_27n VDD VSS NAND2_X1
XI1620_I127_XG I1620_P31_30 I1620_G29_28 I1620_G31_30 I1620_G31_28n VDD VSS AOI21_X1
XI1620_I127_XP I1620_P31_30 I1620_P29_28 I1620_P31_28n VDD VSS NAND2_X1
XI1620_I128_XG I1620_P4_1n I1620_G0_0n I1620_G4_1n I1620_G4_0 VDD VSS OAI21_X1
XI1620_I129 I1620_G1_0 I1620_G1_0n VDD VSS INV_X1
XI1620_I130_XG I1620_P5_2n I1620_G1_0n I1620_G5_2n I1620_G5_0 VDD VSS OAI21_X1
XI1620_I131_XG I1620_P6_3n I1620_G2_0n I1620_G6_3n I1620_G6_0 VDD VSS OAI21_X1
XI1620_I132_XG I1620_P7_4n I1620_G3_0n I1620_G7_4n I1620_G7_0 VDD VSS OAI21_X1
XI1620_I133_XG I1620_P8_5n I1620_G4_1n I1620_G8_5n I1620_G8_1 VDD VSS OAI21_X1
XI1620_I133_XP I1620_P8_5n I1620_P4_1n I1620_P8_1 VDD VSS NOR2_X1
XI1620_I134_XG I1620_P9_6n I1620_G5_2n I1620_G9_6n I1620_G9_2 VDD VSS OAI21_X1
XI1620_I134_XP I1620_P9_6n I1620_P5_2n I1620_P9_2 VDD VSS NOR2_X1
XI1620_I135_XG I1620_P10_7n I1620_G6_3n I1620_G10_7n I1620_G10_3 VDD VSS OAI21_X1
XI1620_I135_XP I1620_P10_7n I1620_P6_3n I1620_P10_3 VDD VSS NOR2_X1
XI1620_I136_XG I1620_P11_8n I1620_G7_4n I1620_G11_8n I1620_G11_4 VDD VSS OAI21_X1
XI1620_I136_XP I1620_P11_8n I1620_P7_4n I1620_P11_4 VDD VSS NOR2_X1
XI1620_I137_XG I1620_P12_9n I1620_G8_5n I1620_G12_9n I1620_G12_5 VDD VSS OAI21_X1
XI1620_I137_XP I1620_P12_9n I1620_P8_5n I1620_P12_5 VDD VSS NOR2_X1
XI1620_I138_XG I1620_P13_10n I1620_G9_6n I1620_G13_10n I1620_G13_6 VDD VSS OAI21_X1
XI1620_I138_XP I1620_P13_10n I1620_P9_6n I1620_P13_6 VDD VSS NOR2_X1
XI1620_I139_XG I1620_P14_11n I1620_G10_7n I1620_G14_11n I1620_G14_7 VDD VSS OAI21_X1
XI1620_I139_XP I1620_P14_11n I1620_P10_7n I1620_P14_7 VDD VSS NOR2_X1
XI1620_I140_XG I1620_P15_12n I1620_G11_8n I1620_G15_12n I1620_G15_8 VDD VSS OAI21_X1
XI1620_I140_XP I1620_P15_12n I1620_P11_8n I1620_P15_8 VDD VSS NOR2_X1
XI1620_I141_XG I1620_P16_13n I1620_G12_9n I1620_G16_13n I1620_G16_9 VDD VSS OAI21_X1
XI1620_I141_XP I1620_P16_13n I1620_P12_9n I1620_P16_9 VDD VSS NOR2_X1
XI1620_I142_XG I1620_P17_14n I1620_G13_10n I1620_G17_14n I1620_G17_10 VDD VSS OAI21_X1
XI1620_I142_XP I1620_P17_14n I1620_P13_10n I1620_P17_10 VDD VSS NOR2_X1
XI1620_I143_XG I1620_P18_15n I1620_G14_11n I1620_G18_15n I1620_G18_11 VDD VSS OAI21_X1
XI1620_I143_XP I1620_P18_15n I1620_P14_11n I1620_P18_11 VDD VSS NOR2_X1
XI1620_I144_XG I1620_P19_16n I1620_G15_12n I1620_G19_16n I1620_G19_12 VDD VSS OAI21_X1
XI1620_I144_XP I1620_P19_16n I1620_P15_12n I1620_P19_12 VDD VSS NOR2_X1
XI1620_I145_XG I1620_P20_17n I1620_G16_13n I1620_G20_17n I1620_G20_13 VDD VSS OAI21_X1
XI1620_I145_XP I1620_P20_17n I1620_P16_13n I1620_P20_13 VDD VSS NOR2_X1
XI1620_I146_XG I1620_P21_18n I1620_G17_14n I1620_G21_18n I1620_G21_14 VDD VSS OAI21_X1
XI1620_I146_XP I1620_P21_18n I1620_P17_14n I1620_P21_14 VDD VSS NOR2_X1
XI1620_I147_XG I1620_P22_19n I1620_G18_15n I1620_G22_19n I1620_G22_15 VDD VSS OAI21_X1
XI1620_I147_XP I1620_P22_19n I1620_P18_15n I1620_P22_15 VDD VSS NOR2_X1
XI1620_I148_XG I1620_P23_20n I1620_G19_16n I1620_G23_20n I1620_G23_16 VDD VSS OAI21_X1
XI1620_I148_XP I1620_P23_20n I1620_P19_16n I1620_P23_16 VDD VSS NOR2_X1
XI1620_I149_XG I1620_P24_21n I1620_G20_17n I1620_G24_21n I1620_G24_17 VDD VSS OAI21_X1
XI1620_I149_XP I1620_P24_21n I1620_P20_17n I1620_P24_17 VDD VSS NOR2_X1
XI1620_I150_XG I1620_P25_22n I1620_G21_18n I1620_G25_22n I1620_G25_18 VDD VSS OAI21_X1
XI1620_I150_XP I1620_P25_22n I1620_P21_18n I1620_P25_18 VDD VSS NOR2_X1
XI1620_I151_XG I1620_P26_23n I1620_G22_19n I1620_G26_23n I1620_G26_19 VDD VSS OAI21_X1
XI1620_I151_XP I1620_P26_23n I1620_P22_19n I1620_P26_19 VDD VSS NOR2_X1
XI1620_I152_XG I1620_P27_24n I1620_G23_20n I1620_G27_24n I1620_G27_20 VDD VSS OAI21_X1
XI1620_I152_XP I1620_P27_24n I1620_P23_20n I1620_P27_20 VDD VSS NOR2_X1
XI1620_I153_XG I1620_P28_25n I1620_G24_21n I1620_G28_25n I1620_G28_21 VDD VSS OAI21_X1
XI1620_I153_XP I1620_P28_25n I1620_P24_21n I1620_P28_21 VDD VSS NOR2_X1
XI1620_I154_XG I1620_P29_26n I1620_G25_22n I1620_G29_26n I1620_G29_22 VDD VSS OAI21_X1
XI1620_I154_XP I1620_P29_26n I1620_P25_22n I1620_P29_22 VDD VSS NOR2_X1
XI1620_I155_XG I1620_P30_27n I1620_G26_23n I1620_G30_27n I1620_G30_23 VDD VSS OAI21_X1
XI1620_I155_XP I1620_P30_27n I1620_P26_23n I1620_P30_23 VDD VSS NOR2_X1
XI1620_I156_XG I1620_P31_28n I1620_G27_24n I1620_G31_28n I1620_G31_24 VDD VSS OAI21_X1
XI1620_I156_XP I1620_P31_28n I1620_P27_24n I1620_P31_24 VDD VSS NOR2_X1
XI1620_I157_XG I1620_P8_1 I1620_G0_0 I1620_G8_1 I1620_G8_0n VDD VSS AOI21_X1
XI1620_I158_XG I1620_P9_2 I1620_G1_0 I1620_G9_2 I1620_G9_0n VDD VSS AOI21_X1
XI1620_I159 I1620_G2_0n I1620_G2_0np VDD VSS INV_X1
XI1620_I160_XG I1620_P10_3 I1620_G2_0np I1620_G10_3 I1620_G10_0n VDD VSS AOI21_X1
XI1620_I161 I1620_G3_0n I1620_G3_0np VDD VSS INV_X1
XI1620_I162_XG I1620_P11_4 I1620_G3_0np I1620_G11_4 I1620_G11_0n VDD VSS AOI21_X1
XI1620_I163_XG I1620_P12_5 I1620_G4_0 I1620_G12_5 I1620_G12_0n VDD VSS AOI21_X1
XI1620_I164_XG I1620_P13_6 I1620_G5_0 I1620_G13_6 I1620_G13_0n VDD VSS AOI21_X1
XI1620_I165_XG I1620_P14_7 I1620_G6_0 I1620_G14_7 I1620_G14_0n VDD VSS AOI21_X1
XI1620_I166_XG I1620_P15_8 I1620_G7_0 I1620_G15_8 I1620_G15_0n VDD VSS AOI21_X1
XI1620_I167_XG I1620_P16_9 I1620_G8_1 I1620_G16_9 I1620_G16_1n VDD VSS AOI21_X1
XI1620_I167_XP I1620_P16_9 I1620_P8_1 I1620_P16_1n VDD VSS NAND2_X1
XI1620_I168_XG I1620_P17_10 I1620_G9_2 I1620_G17_10 I1620_G17_2n VDD VSS AOI21_X1
XI1620_I168_XP I1620_P17_10 I1620_P9_2 I1620_P17_2n VDD VSS NAND2_X1
XI1620_I169_XG I1620_P18_11 I1620_G10_3 I1620_G18_11 I1620_G18_3n VDD VSS AOI21_X1
XI1620_I169_XP I1620_P18_11 I1620_P10_3 I1620_P18_3n VDD VSS NAND2_X1
XI1620_I170_XG I1620_P19_12 I1620_G11_4 I1620_G19_12 I1620_G19_4n VDD VSS AOI21_X1
XI1620_I170_XP I1620_P19_12 I1620_P11_4 I1620_P19_4n VDD VSS NAND2_X1
XI1620_I171_XG I1620_P20_13 I1620_G12_5 I1620_G20_13 I1620_G20_5n VDD VSS AOI21_X1
XI1620_I171_XP I1620_P20_13 I1620_P12_5 I1620_P20_5n VDD VSS NAND2_X1
XI1620_I172_XG I1620_P21_14 I1620_G13_6 I1620_G21_14 I1620_G21_6n VDD VSS AOI21_X1
XI1620_I172_XP I1620_P21_14 I1620_P13_6 I1620_P21_6n VDD VSS NAND2_X1
XI1620_I173_XG I1620_P22_15 I1620_G14_7 I1620_G22_15 I1620_G22_7n VDD VSS AOI21_X1
XI1620_I173_XP I1620_P22_15 I1620_P14_7 I1620_P22_7n VDD VSS NAND2_X1
XI1620_I174_XG I1620_P23_16 I1620_G15_8 I1620_G23_16 I1620_G23_8n VDD VSS AOI21_X1
XI1620_I174_XP I1620_P23_16 I1620_P15_8 I1620_P23_8n VDD VSS NAND2_X1
XI1620_I175_XG I1620_P24_17 I1620_G16_9 I1620_G24_17 I1620_G24_9n VDD VSS AOI21_X1
XI1620_I175_XP I1620_P24_17 I1620_P16_9 I1620_P24_9n VDD VSS NAND2_X1
XI1620_I176_XG I1620_P25_18 I1620_G17_10 I1620_G25_18 I1620_G25_10n VDD VSS AOI21_X1
XI1620_I176_XP I1620_P25_18 I1620_P17_10 I1620_P25_10n VDD VSS NAND2_X1
XI1620_I177_XG I1620_P26_19 I1620_G18_11 I1620_G26_19 I1620_G26_11n VDD VSS AOI21_X1
XI1620_I177_XP I1620_P26_19 I1620_P18_11 I1620_P26_11n VDD VSS NAND2_X1
XI1620_I178_XG I1620_P27_20 I1620_G19_12 I1620_G27_20 I1620_G27_12n VDD VSS AOI21_X1
XI1620_I178_XP I1620_P27_20 I1620_P19_12 I1620_P27_12n VDD VSS NAND2_X1
XI1620_I179_XG I1620_P28_21 I1620_G20_13 I1620_G28_21 I1620_G28_13n VDD VSS AOI21_X1
XI1620_I179_XP I1620_P28_21 I1620_P20_13 I1620_P28_13n VDD VSS NAND2_X1
XI1620_I180_XG I1620_P29_22 I1620_G21_14 I1620_G29_22 I1620_G29_14n VDD VSS AOI21_X1
XI1620_I180_XP I1620_P29_22 I1620_P21_14 I1620_P29_14n VDD VSS NAND2_X1
XI1620_I181_XG I1620_P30_23 I1620_G22_15 I1620_G30_23 I1620_G30_15n VDD VSS AOI21_X1
XI1620_I181_XP I1620_P30_23 I1620_P22_15 I1620_P30_15n VDD VSS NAND2_X1
XI1620_I182_XG I1620_P31_24 I1620_G23_16 I1620_G31_24 I1620_G31_16n VDD VSS AOI21_X1
XI1620_I182_XP I1620_P31_24 I1620_P23_16 I1620_P31_16n VDD VSS NAND2_X1
XI1620_I183_XG I1620_P16_1n I1620_G0_0n I1620_G16_1n I1620_G16_0 VDD VSS OAI21_X1
XI1620_I184_XG I1620_P17_2n I1620_G1_0n I1620_G17_2n I1620_G17_0 VDD VSS OAI21_X1
XI1620_I185_XG I1620_P18_3n I1620_G2_0n I1620_G18_3n I1620_G18_0 VDD VSS OAI21_X1
XI1620_I186_XG I1620_P19_4n I1620_G3_0n I1620_G19_4n I1620_G19_0 VDD VSS OAI21_X1
XI1620_I187 I1620_G4_0 I1620_G4_0n VDD VSS INV_X1
XI1620_I188_XG I1620_P20_5n I1620_G4_0n I1620_G20_5n I1620_G20_0 VDD VSS OAI21_X1
XI1620_I189 I1620_G5_0 I1620_G5_0n VDD VSS INV_X1
XI1620_I190_XG I1620_P21_6n I1620_G5_0n I1620_G21_6n I1620_G21_0 VDD VSS OAI21_X1
XI1620_I191 I1620_G6_0 I1620_G6_0n VDD VSS INV_X1
XI1620_I192_XG I1620_P22_7n I1620_G6_0n I1620_G22_7n I1620_G22_0 VDD VSS OAI21_X1
XI1620_I193 I1620_G7_0 I1620_G7_0n VDD VSS INV_X1
XI1620_I194_XG I1620_P23_8n I1620_G7_0n I1620_G23_8n I1620_G23_0 VDD VSS OAI21_X1
XI1620_I195_XG I1620_P24_9n I1620_G8_0n I1620_G24_9n I1620_G24_0 VDD VSS OAI21_X1
XI1620_I196_XG I1620_P25_10n I1620_G9_0n I1620_G25_10n I1620_G25_0 VDD VSS OAI21_X1
XI1620_I197_XG I1620_P26_11n I1620_G10_0n I1620_G26_11n I1620_G26_0 VDD VSS OAI21_X1
XI1620_I198_XG I1620_P27_12n I1620_G11_0n I1620_G27_12n I1620_G27_0 VDD VSS OAI21_X1
XI1620_I199_XG I1620_P28_13n I1620_G12_0n I1620_G28_13n I1620_G28_0 VDD VSS OAI21_X1
XI1620_I200_XG I1620_P29_14n I1620_G13_0n I1620_G29_14n I1620_G29_0 VDD VSS OAI21_X1
XI1620_I201_XG I1620_P30_15n I1620_G14_0n I1620_G30_15n c23_m VDD VSS OAI21_X1
XI1620_I202_XG I1620_P31_16n I1620_G15_0n I1620_G31_16n c23_o VDD VSS OAI21_X1
XI1620_I203 I1620_pn0 qu9_b3_5 p23_0 VDD VSS XNOR2_X1
XI1620_I204 I1620_pn1 I1620_G0_0 p23_1 VDD VSS XNOR2_X1
XI1620_I205 I1620_pn2 I1620_G1_0 p23_2 VDD VSS XNOR2_X1
XI1620_I206 I1620_pn3 I1620_G2_0n p23_3 VDD VSS XOR2_X1
XI1620_I207 I1620_pn4 I1620_G3_0n p23_4 VDD VSS XOR2_X1
XI1620_I208 I1620_pn5 I1620_G4_0 p23_5 VDD VSS XNOR2_X1
XI1620_I209 I1620_pn6 I1620_G5_0 p23_6 VDD VSS XNOR2_X1
XI1620_I210 I1620_pn7 I1620_G6_0 p23_7 VDD VSS XNOR2_X1
XI1620_I211 I1620_pn8 I1620_G7_0 p23_8 VDD VSS XNOR2_X1
XI1620_I212 I1620_pn9 I1620_G8_0n p23_9 VDD VSS XOR2_X1
XI1620_I213 I1620_pn10 I1620_G9_0n p23_10 VDD VSS XOR2_X1
XI1620_I214 I1620_pn11 I1620_G10_0n p23_11 VDD VSS XOR2_X1
XI1620_I215 I1620_pn12 I1620_G11_0n p23_12 VDD VSS XOR2_X1
XI1620_I216 I1620_pn13 I1620_G12_0n p23_13 VDD VSS XOR2_X1
XI1620_I217 I1620_pn14 I1620_G13_0n p23_14 VDD VSS XOR2_X1
XI1620_I218 I1620_pn15 I1620_G14_0n p23_15 VDD VSS XOR2_X1
XI1620_I219 I1620_pn16 I1620_G15_0n p23_16 VDD VSS XOR2_X1
XI1620_I220 I1620_pn17 I1620_G16_0 p23_17 VDD VSS XNOR2_X1
XI1620_I221 I1620_pn18 I1620_G17_0 p23_18 VDD VSS XNOR2_X1
XI1620_I222 I1620_pn19 I1620_G18_0 p23_19 VDD VSS XNOR2_X1
XI1620_I223 I1620_pn20 I1620_G19_0 p23_20 VDD VSS XNOR2_X1
XI1620_I224 I1620_pn21 I1620_G20_0 p23_21 VDD VSS XNOR2_X1
XI1620_I225 I1620_pn22 I1620_G21_0 p23_22 VDD VSS XNOR2_X1
XI1620_I226 I1620_pn23 I1620_G22_0 p23_23 VDD VSS XNOR2_X1
XI1620_I227 I1620_pn24 I1620_G23_0 p23_24 VDD VSS XNOR2_X1
XI1620_I228 I1620_pn25 I1620_G24_0 p23_25 VDD VSS XNOR2_X1
XI1620_I229 I1620_pn26 I1620_G25_0 p23_26 VDD VSS XNOR2_X1
XI1620_I230 I1620_pn27 I1620_G26_0 p23_27 VDD VSS XNOR2_X1
XI1620_I231 I1620_pn28 I1620_G27_0 p23_28 VDD VSS XNOR2_X1
XI1620_I232 I1620_pn29 I1620_G28_0 p23_29 VDD VSS XNOR2_X1
XI1620_I233 I1620_pn30 I1620_G29_0 p23_30 VDD VSS XNOR2_X1
XI1620_I234 I1620_pn31 c23_m p23_31 VDD VSS XNOR2_X1
XI1621 p22_31 qu9_b3_5 h23 VDD VSS XOR2_X1
XI1622 h23 c23_o p23_32 VDD VSS XOR2_X1
XI1623 p23_32 qu8 VDD VSS INV_X4
XI1624 qu8 qu8_b0 VDD VSS INV_X1
XI1625 qu8_b0 qu8_b1_0 VDD VSS INV_X4
XI1626 qu8_b1_0 qu8_b2_0 VDD VSS INV_X4
XI1627 qu8_b1_0 qu8_b2_1 VDD VSS INV_X4
XI1628 qu8_b2_0 qu8_b3_0 VDD VSS INV_X4
XI1629 qu8_b2_0 qu8_b3_1 VDD VSS INV_X4
XI1630 qu8_b2_0 qu8_b3_2 VDD VSS INV_X4
XI1631 qu8_b2_1 qu8_b3_3 VDD VSS INV_X4
XI1632 qu8_b2_1 qu8_b3_4 VDD VSS INV_X4
XI1633 qu8_b2_1 qu8_b3_5 VDD VSS INV_X4
XI1634 B_0_b3_4 qu8_b3_0 b24_0 VDD VSS XOR2_X1
XI1635 dd1_b3_4 qu8_b3_0 b24_1 VDD VSS XOR2_X1
XI1636 dd2_b3_4 qu8_b3_0 b24_2 VDD VSS XOR2_X1
XI1637 dd3_b3_4 qu8_b3_0 b24_3 VDD VSS XOR2_X1
XI1638 dd4_b3_4 qu8_b3_0 b24_4 VDD VSS XOR2_X1
XI1639 dd5_b3_4 qu8_b3_0 b24_5 VDD VSS XOR2_X1
XI1640 dd6_b3_4 qu8_b3_1 b24_6 VDD VSS XOR2_X1
XI1641 dd7_b3_4 qu8_b3_1 b24_7 VDD VSS XOR2_X1
XI1642 dd8_b3_4 qu8_b3_1 b24_8 VDD VSS XOR2_X1
XI1643 dd9_b3_4 qu8_b3_1 b24_9 VDD VSS XOR2_X1
XI1644 dd10_b3_4 qu8_b3_1 b24_10 VDD VSS XOR2_X1
XI1645 dd11_b3_4 qu8_b3_1 b24_11 VDD VSS XOR2_X1
XI1646 dd12_b3_4 qu8_b3_2 b24_12 VDD VSS XOR2_X1
XI1647 dd13_b3_4 qu8_b3_2 b24_13 VDD VSS XOR2_X1
XI1648 dd14_b3_4 qu8_b3_2 b24_14 VDD VSS XOR2_X1
XI1649 dd15_b3_4 qu8_b3_2 b24_15 VDD VSS XOR2_X1
XI1650 dd16_b3_4 qu8_b3_2 b24_16 VDD VSS XOR2_X1
XI1651 dd17_b3_4 qu8_b3_2 b24_17 VDD VSS XOR2_X1
XI1652 dd18_b3_4 qu8_b3_3 b24_18 VDD VSS XOR2_X1
XI1653 dd19_b3_4 qu8_b3_3 b24_19 VDD VSS XOR2_X1
XI1654 dd20_b3_4 qu8_b3_3 b24_20 VDD VSS XOR2_X1
XI1655 dd21_b3_4 qu8_b3_3 b24_21 VDD VSS XOR2_X1
XI1656 dd22_b3_4 qu8_b3_3 b24_22 VDD VSS XOR2_X1
XI1657 dd23_b3_4 qu8_b3_3 b24_23 VDD VSS XOR2_X1
XI1658 dd24_b3_4 qu8_b3_4 b24_24 VDD VSS XOR2_X1
XI1659 dd25_b3_4 qu8_b3_4 b24_25 VDD VSS XOR2_X1
XI1660 dd26_b3_4 qu8_b3_4 b24_26 VDD VSS XOR2_X1
XI1661 dd27_b3_4 qu8_b3_4 b24_27 VDD VSS XOR2_X1
XI1662 dd28_b3_4 qu8_b3_4 b24_28 VDD VSS XOR2_X1
XI1663 dd29_b3_4 qu8_b3_4 b24_29 VDD VSS XOR2_X1
XI1664 dd30_b3_4 qu8_b3_5 b24_30 VDD VSS XOR2_X1
XI1665 dd31_b3_4 qu8_b3_5 b24_31 VDD VSS XOR2_X1
XI1666_I0 aa7 b24_0 I1666_gn0 VDD VSS NAND2_X1
XI1666_I1 p23_0 b24_1 I1666_gn1 VDD VSS NAND2_X1
XI1666_I2 p23_1 b24_2 I1666_gn2 VDD VSS NAND2_X1
XI1666_I3 p23_2 b24_3 I1666_gn3 VDD VSS NAND2_X1
XI1666_I4 p23_3 b24_4 I1666_gn4 VDD VSS NAND2_X1
XI1666_I5 p23_4 b24_5 I1666_gn5 VDD VSS NAND2_X1
XI1666_I6 p23_5 b24_6 I1666_gn6 VDD VSS NAND2_X1
XI1666_I7 p23_6 b24_7 I1666_gn7 VDD VSS NAND2_X1
XI1666_I8 p23_7 b24_8 I1666_gn8 VDD VSS NAND2_X1
XI1666_I9 p23_8 b24_9 I1666_gn9 VDD VSS NAND2_X1
XI1666_I10 p23_9 b24_10 I1666_gn10 VDD VSS NAND2_X1
XI1666_I11 p23_10 b24_11 I1666_gn11 VDD VSS NAND2_X1
XI1666_I12 p23_11 b24_12 I1666_gn12 VDD VSS NAND2_X1
XI1666_I13 p23_12 b24_13 I1666_gn13 VDD VSS NAND2_X1
XI1666_I14 p23_13 b24_14 I1666_gn14 VDD VSS NAND2_X1
XI1666_I15 p23_14 b24_15 I1666_gn15 VDD VSS NAND2_X1
XI1666_I16 p23_15 b24_16 I1666_gn16 VDD VSS NAND2_X1
XI1666_I17 p23_16 b24_17 I1666_gn17 VDD VSS NAND2_X1
XI1666_I18 p23_17 b24_18 I1666_gn18 VDD VSS NAND2_X1
XI1666_I19 p23_18 b24_19 I1666_gn19 VDD VSS NAND2_X1
XI1666_I20 p23_19 b24_20 I1666_gn20 VDD VSS NAND2_X1
XI1666_I21 p23_20 b24_21 I1666_gn21 VDD VSS NAND2_X1
XI1666_I22 p23_21 b24_22 I1666_gn22 VDD VSS NAND2_X1
XI1666_I23 p23_22 b24_23 I1666_gn23 VDD VSS NAND2_X1
XI1666_I24 p23_23 b24_24 I1666_gn24 VDD VSS NAND2_X1
XI1666_I25 p23_24 b24_25 I1666_gn25 VDD VSS NAND2_X1
XI1666_I26 p23_25 b24_26 I1666_gn26 VDD VSS NAND2_X1
XI1666_I27 p23_26 b24_27 I1666_gn27 VDD VSS NAND2_X1
XI1666_I28 p23_27 b24_28 I1666_gn28 VDD VSS NAND2_X1
XI1666_I29 p23_28 b24_29 I1666_gn29 VDD VSS NAND2_X1
XI1666_I30 p23_29 b24_30 I1666_gn30 VDD VSS NAND2_X1
XI1666_I31 p23_30 b24_31 I1666_gn31 VDD VSS NAND2_X1
XI1666_I32 aa7 b24_0 I1666_pn0 VDD VSS XNOR2_X1
XI1666_I33 p23_0 b24_1 I1666_pn1 VDD VSS XNOR2_X1
XI1666_I34 p23_1 b24_2 I1666_pn2 VDD VSS XNOR2_X1
XI1666_I35 p23_2 b24_3 I1666_pn3 VDD VSS XNOR2_X1
XI1666_I36 p23_3 b24_4 I1666_pn4 VDD VSS XNOR2_X1
XI1666_I37 p23_4 b24_5 I1666_pn5 VDD VSS XNOR2_X1
XI1666_I38 p23_5 b24_6 I1666_pn6 VDD VSS XNOR2_X1
XI1666_I39 p23_6 b24_7 I1666_pn7 VDD VSS XNOR2_X1
XI1666_I40 p23_7 b24_8 I1666_pn8 VDD VSS XNOR2_X1
XI1666_I41 p23_8 b24_9 I1666_pn9 VDD VSS XNOR2_X1
XI1666_I42 p23_9 b24_10 I1666_pn10 VDD VSS XNOR2_X1
XI1666_I43 p23_10 b24_11 I1666_pn11 VDD VSS XNOR2_X1
XI1666_I44 p23_11 b24_12 I1666_pn12 VDD VSS XNOR2_X1
XI1666_I45 p23_12 b24_13 I1666_pn13 VDD VSS XNOR2_X1
XI1666_I46 p23_13 b24_14 I1666_pn14 VDD VSS XNOR2_X1
XI1666_I47 p23_14 b24_15 I1666_pn15 VDD VSS XNOR2_X1
XI1666_I48 p23_15 b24_16 I1666_pn16 VDD VSS XNOR2_X1
XI1666_I49 p23_16 b24_17 I1666_pn17 VDD VSS XNOR2_X1
XI1666_I50 p23_17 b24_18 I1666_pn18 VDD VSS XNOR2_X1
XI1666_I51 p23_18 b24_19 I1666_pn19 VDD VSS XNOR2_X1
XI1666_I52 p23_19 b24_20 I1666_pn20 VDD VSS XNOR2_X1
XI1666_I53 p23_20 b24_21 I1666_pn21 VDD VSS XNOR2_X1
XI1666_I54 p23_21 b24_22 I1666_pn22 VDD VSS XNOR2_X1
XI1666_I55 p23_22 b24_23 I1666_pn23 VDD VSS XNOR2_X1
XI1666_I56 p23_23 b24_24 I1666_pn24 VDD VSS XNOR2_X1
XI1666_I57 p23_24 b24_25 I1666_pn25 VDD VSS XNOR2_X1
XI1666_I58 p23_25 b24_26 I1666_pn26 VDD VSS XNOR2_X1
XI1666_I59 p23_26 b24_27 I1666_pn27 VDD VSS XNOR2_X1
XI1666_I60 p23_27 b24_28 I1666_pn28 VDD VSS XNOR2_X1
XI1666_I61 p23_28 b24_29 I1666_pn29 VDD VSS XNOR2_X1
XI1666_I62 p23_29 b24_30 I1666_pn30 VDD VSS XNOR2_X1
XI1666_I63 p23_30 b24_31 I1666_pn31 VDD VSS XNOR2_X1
XI1666_I64 qu8_b3_5 I1666_cinn VDD VSS INV_X1
XI1666_I65_XG I1666_pn0 I1666_cinn I1666_gn0 I1666_G0_0 VDD VSS OAI21_X1
XI1666_I66 I1666_G0_0 I1666_G0_0n VDD VSS INV_X1
XI1666_I67_XG I1666_pn1 I1666_G0_0n I1666_gn1 I1666_G1_0 VDD VSS OAI21_X1
XI1666_I68_XG I1666_pn2 I1666_gn1 I1666_gn2 I1666_G2_1 VDD VSS OAI21_X1
XI1666_I68_XP I1666_pn2 I1666_pn1 I1666_P2_1 VDD VSS NOR2_X1
XI1666_I69_XG I1666_pn3 I1666_gn2 I1666_gn3 I1666_G3_2 VDD VSS OAI21_X1
XI1666_I69_XP I1666_pn3 I1666_pn2 I1666_P3_2 VDD VSS NOR2_X1
XI1666_I70_XG I1666_pn4 I1666_gn3 I1666_gn4 I1666_G4_3 VDD VSS OAI21_X1
XI1666_I70_XP I1666_pn4 I1666_pn3 I1666_P4_3 VDD VSS NOR2_X1
XI1666_I71_XG I1666_pn5 I1666_gn4 I1666_gn5 I1666_G5_4 VDD VSS OAI21_X1
XI1666_I71_XP I1666_pn5 I1666_pn4 I1666_P5_4 VDD VSS NOR2_X1
XI1666_I72_XG I1666_pn6 I1666_gn5 I1666_gn6 I1666_G6_5 VDD VSS OAI21_X1
XI1666_I72_XP I1666_pn6 I1666_pn5 I1666_P6_5 VDD VSS NOR2_X1
XI1666_I73_XG I1666_pn7 I1666_gn6 I1666_gn7 I1666_G7_6 VDD VSS OAI21_X1
XI1666_I73_XP I1666_pn7 I1666_pn6 I1666_P7_6 VDD VSS NOR2_X1
XI1666_I74_XG I1666_pn8 I1666_gn7 I1666_gn8 I1666_G8_7 VDD VSS OAI21_X1
XI1666_I74_XP I1666_pn8 I1666_pn7 I1666_P8_7 VDD VSS NOR2_X1
XI1666_I75_XG I1666_pn9 I1666_gn8 I1666_gn9 I1666_G9_8 VDD VSS OAI21_X1
XI1666_I75_XP I1666_pn9 I1666_pn8 I1666_P9_8 VDD VSS NOR2_X1
XI1666_I76_XG I1666_pn10 I1666_gn9 I1666_gn10 I1666_G10_9 VDD VSS OAI21_X1
XI1666_I76_XP I1666_pn10 I1666_pn9 I1666_P10_9 VDD VSS NOR2_X1
XI1666_I77_XG I1666_pn11 I1666_gn10 I1666_gn11 I1666_G11_10 VDD VSS OAI21_X1
XI1666_I77_XP I1666_pn11 I1666_pn10 I1666_P11_10 VDD VSS NOR2_X1
XI1666_I78_XG I1666_pn12 I1666_gn11 I1666_gn12 I1666_G12_11 VDD VSS OAI21_X1
XI1666_I78_XP I1666_pn12 I1666_pn11 I1666_P12_11 VDD VSS NOR2_X1
XI1666_I79_XG I1666_pn13 I1666_gn12 I1666_gn13 I1666_G13_12 VDD VSS OAI21_X1
XI1666_I79_XP I1666_pn13 I1666_pn12 I1666_P13_12 VDD VSS NOR2_X1
XI1666_I80_XG I1666_pn14 I1666_gn13 I1666_gn14 I1666_G14_13 VDD VSS OAI21_X1
XI1666_I80_XP I1666_pn14 I1666_pn13 I1666_P14_13 VDD VSS NOR2_X1
XI1666_I81_XG I1666_pn15 I1666_gn14 I1666_gn15 I1666_G15_14 VDD VSS OAI21_X1
XI1666_I81_XP I1666_pn15 I1666_pn14 I1666_P15_14 VDD VSS NOR2_X1
XI1666_I82_XG I1666_pn16 I1666_gn15 I1666_gn16 I1666_G16_15 VDD VSS OAI21_X1
XI1666_I82_XP I1666_pn16 I1666_pn15 I1666_P16_15 VDD VSS NOR2_X1
XI1666_I83_XG I1666_pn17 I1666_gn16 I1666_gn17 I1666_G17_16 VDD VSS OAI21_X1
XI1666_I83_XP I1666_pn17 I1666_pn16 I1666_P17_16 VDD VSS NOR2_X1
XI1666_I84_XG I1666_pn18 I1666_gn17 I1666_gn18 I1666_G18_17 VDD VSS OAI21_X1
XI1666_I84_XP I1666_pn18 I1666_pn17 I1666_P18_17 VDD VSS NOR2_X1
XI1666_I85_XG I1666_pn19 I1666_gn18 I1666_gn19 I1666_G19_18 VDD VSS OAI21_X1
XI1666_I85_XP I1666_pn19 I1666_pn18 I1666_P19_18 VDD VSS NOR2_X1
XI1666_I86_XG I1666_pn20 I1666_gn19 I1666_gn20 I1666_G20_19 VDD VSS OAI21_X1
XI1666_I86_XP I1666_pn20 I1666_pn19 I1666_P20_19 VDD VSS NOR2_X1
XI1666_I87_XG I1666_pn21 I1666_gn20 I1666_gn21 I1666_G21_20 VDD VSS OAI21_X1
XI1666_I87_XP I1666_pn21 I1666_pn20 I1666_P21_20 VDD VSS NOR2_X1
XI1666_I88_XG I1666_pn22 I1666_gn21 I1666_gn22 I1666_G22_21 VDD VSS OAI21_X1
XI1666_I88_XP I1666_pn22 I1666_pn21 I1666_P22_21 VDD VSS NOR2_X1
XI1666_I89_XG I1666_pn23 I1666_gn22 I1666_gn23 I1666_G23_22 VDD VSS OAI21_X1
XI1666_I89_XP I1666_pn23 I1666_pn22 I1666_P23_22 VDD VSS NOR2_X1
XI1666_I90_XG I1666_pn24 I1666_gn23 I1666_gn24 I1666_G24_23 VDD VSS OAI21_X1
XI1666_I90_XP I1666_pn24 I1666_pn23 I1666_P24_23 VDD VSS NOR2_X1
XI1666_I91_XG I1666_pn25 I1666_gn24 I1666_gn25 I1666_G25_24 VDD VSS OAI21_X1
XI1666_I91_XP I1666_pn25 I1666_pn24 I1666_P25_24 VDD VSS NOR2_X1
XI1666_I92_XG I1666_pn26 I1666_gn25 I1666_gn26 I1666_G26_25 VDD VSS OAI21_X1
XI1666_I92_XP I1666_pn26 I1666_pn25 I1666_P26_25 VDD VSS NOR2_X1
XI1666_I93_XG I1666_pn27 I1666_gn26 I1666_gn27 I1666_G27_26 VDD VSS OAI21_X1
XI1666_I93_XP I1666_pn27 I1666_pn26 I1666_P27_26 VDD VSS NOR2_X1
XI1666_I94_XG I1666_pn28 I1666_gn27 I1666_gn28 I1666_G28_27 VDD VSS OAI21_X1
XI1666_I94_XP I1666_pn28 I1666_pn27 I1666_P28_27 VDD VSS NOR2_X1
XI1666_I95_XG I1666_pn29 I1666_gn28 I1666_gn29 I1666_G29_28 VDD VSS OAI21_X1
XI1666_I95_XP I1666_pn29 I1666_pn28 I1666_P29_28 VDD VSS NOR2_X1
XI1666_I96_XG I1666_pn30 I1666_gn29 I1666_gn30 I1666_G30_29 VDD VSS OAI21_X1
XI1666_I96_XP I1666_pn30 I1666_pn29 I1666_P30_29 VDD VSS NOR2_X1
XI1666_I97_XG I1666_pn31 I1666_gn30 I1666_gn31 I1666_G31_30 VDD VSS OAI21_X1
XI1666_I97_XP I1666_pn31 I1666_pn30 I1666_P31_30 VDD VSS NOR2_X1
XI1666_I98_XG I1666_P2_1 I1666_G0_0 I1666_G2_1 I1666_G2_0n VDD VSS AOI21_X1
XI1666_I99_XG I1666_P3_2 I1666_G1_0 I1666_G3_2 I1666_G3_0n VDD VSS AOI21_X1
XI1666_I100_XG I1666_P4_3 I1666_G2_1 I1666_G4_3 I1666_G4_1n VDD VSS AOI21_X1
XI1666_I100_XP I1666_P4_3 I1666_P2_1 I1666_P4_1n VDD VSS NAND2_X1
XI1666_I101_XG I1666_P5_4 I1666_G3_2 I1666_G5_4 I1666_G5_2n VDD VSS AOI21_X1
XI1666_I101_XP I1666_P5_4 I1666_P3_2 I1666_P5_2n VDD VSS NAND2_X1
XI1666_I102_XG I1666_P6_5 I1666_G4_3 I1666_G6_5 I1666_G6_3n VDD VSS AOI21_X1
XI1666_I102_XP I1666_P6_5 I1666_P4_3 I1666_P6_3n VDD VSS NAND2_X1
XI1666_I103_XG I1666_P7_6 I1666_G5_4 I1666_G7_6 I1666_G7_4n VDD VSS AOI21_X1
XI1666_I103_XP I1666_P7_6 I1666_P5_4 I1666_P7_4n VDD VSS NAND2_X1
XI1666_I104_XG I1666_P8_7 I1666_G6_5 I1666_G8_7 I1666_G8_5n VDD VSS AOI21_X1
XI1666_I104_XP I1666_P8_7 I1666_P6_5 I1666_P8_5n VDD VSS NAND2_X1
XI1666_I105_XG I1666_P9_8 I1666_G7_6 I1666_G9_8 I1666_G9_6n VDD VSS AOI21_X1
XI1666_I105_XP I1666_P9_8 I1666_P7_6 I1666_P9_6n VDD VSS NAND2_X1
XI1666_I106_XG I1666_P10_9 I1666_G8_7 I1666_G10_9 I1666_G10_7n VDD VSS AOI21_X1
XI1666_I106_XP I1666_P10_9 I1666_P8_7 I1666_P10_7n VDD VSS NAND2_X1
XI1666_I107_XG I1666_P11_10 I1666_G9_8 I1666_G11_10 I1666_G11_8n VDD VSS AOI21_X1
XI1666_I107_XP I1666_P11_10 I1666_P9_8 I1666_P11_8n VDD VSS NAND2_X1
XI1666_I108_XG I1666_P12_11 I1666_G10_9 I1666_G12_11 I1666_G12_9n VDD VSS AOI21_X1
XI1666_I108_XP I1666_P12_11 I1666_P10_9 I1666_P12_9n VDD VSS NAND2_X1
XI1666_I109_XG I1666_P13_12 I1666_G11_10 I1666_G13_12 I1666_G13_10n VDD VSS AOI21_X1
XI1666_I109_XP I1666_P13_12 I1666_P11_10 I1666_P13_10n VDD VSS NAND2_X1
XI1666_I110_XG I1666_P14_13 I1666_G12_11 I1666_G14_13 I1666_G14_11n VDD VSS AOI21_X1
XI1666_I110_XP I1666_P14_13 I1666_P12_11 I1666_P14_11n VDD VSS NAND2_X1
XI1666_I111_XG I1666_P15_14 I1666_G13_12 I1666_G15_14 I1666_G15_12n VDD VSS AOI21_X1
XI1666_I111_XP I1666_P15_14 I1666_P13_12 I1666_P15_12n VDD VSS NAND2_X1
XI1666_I112_XG I1666_P16_15 I1666_G14_13 I1666_G16_15 I1666_G16_13n VDD VSS AOI21_X1
XI1666_I112_XP I1666_P16_15 I1666_P14_13 I1666_P16_13n VDD VSS NAND2_X1
XI1666_I113_XG I1666_P17_16 I1666_G15_14 I1666_G17_16 I1666_G17_14n VDD VSS AOI21_X1
XI1666_I113_XP I1666_P17_16 I1666_P15_14 I1666_P17_14n VDD VSS NAND2_X1
XI1666_I114_XG I1666_P18_17 I1666_G16_15 I1666_G18_17 I1666_G18_15n VDD VSS AOI21_X1
XI1666_I114_XP I1666_P18_17 I1666_P16_15 I1666_P18_15n VDD VSS NAND2_X1
XI1666_I115_XG I1666_P19_18 I1666_G17_16 I1666_G19_18 I1666_G19_16n VDD VSS AOI21_X1
XI1666_I115_XP I1666_P19_18 I1666_P17_16 I1666_P19_16n VDD VSS NAND2_X1
XI1666_I116_XG I1666_P20_19 I1666_G18_17 I1666_G20_19 I1666_G20_17n VDD VSS AOI21_X1
XI1666_I116_XP I1666_P20_19 I1666_P18_17 I1666_P20_17n VDD VSS NAND2_X1
XI1666_I117_XG I1666_P21_20 I1666_G19_18 I1666_G21_20 I1666_G21_18n VDD VSS AOI21_X1
XI1666_I117_XP I1666_P21_20 I1666_P19_18 I1666_P21_18n VDD VSS NAND2_X1
XI1666_I118_XG I1666_P22_21 I1666_G20_19 I1666_G22_21 I1666_G22_19n VDD VSS AOI21_X1
XI1666_I118_XP I1666_P22_21 I1666_P20_19 I1666_P22_19n VDD VSS NAND2_X1
XI1666_I119_XG I1666_P23_22 I1666_G21_20 I1666_G23_22 I1666_G23_20n VDD VSS AOI21_X1
XI1666_I119_XP I1666_P23_22 I1666_P21_20 I1666_P23_20n VDD VSS NAND2_X1
XI1666_I120_XG I1666_P24_23 I1666_G22_21 I1666_G24_23 I1666_G24_21n VDD VSS AOI21_X1
XI1666_I120_XP I1666_P24_23 I1666_P22_21 I1666_P24_21n VDD VSS NAND2_X1
XI1666_I121_XG I1666_P25_24 I1666_G23_22 I1666_G25_24 I1666_G25_22n VDD VSS AOI21_X1
XI1666_I121_XP I1666_P25_24 I1666_P23_22 I1666_P25_22n VDD VSS NAND2_X1
XI1666_I122_XG I1666_P26_25 I1666_G24_23 I1666_G26_25 I1666_G26_23n VDD VSS AOI21_X1
XI1666_I122_XP I1666_P26_25 I1666_P24_23 I1666_P26_23n VDD VSS NAND2_X1
XI1666_I123_XG I1666_P27_26 I1666_G25_24 I1666_G27_26 I1666_G27_24n VDD VSS AOI21_X1
XI1666_I123_XP I1666_P27_26 I1666_P25_24 I1666_P27_24n VDD VSS NAND2_X1
XI1666_I124_XG I1666_P28_27 I1666_G26_25 I1666_G28_27 I1666_G28_25n VDD VSS AOI21_X1
XI1666_I124_XP I1666_P28_27 I1666_P26_25 I1666_P28_25n VDD VSS NAND2_X1
XI1666_I125_XG I1666_P29_28 I1666_G27_26 I1666_G29_28 I1666_G29_26n VDD VSS AOI21_X1
XI1666_I125_XP I1666_P29_28 I1666_P27_26 I1666_P29_26n VDD VSS NAND2_X1
XI1666_I126_XG I1666_P30_29 I1666_G28_27 I1666_G30_29 I1666_G30_27n VDD VSS AOI21_X1
XI1666_I126_XP I1666_P30_29 I1666_P28_27 I1666_P30_27n VDD VSS NAND2_X1
XI1666_I127_XG I1666_P31_30 I1666_G29_28 I1666_G31_30 I1666_G31_28n VDD VSS AOI21_X1
XI1666_I127_XP I1666_P31_30 I1666_P29_28 I1666_P31_28n VDD VSS NAND2_X1
XI1666_I128_XG I1666_P4_1n I1666_G0_0n I1666_G4_1n I1666_G4_0 VDD VSS OAI21_X1
XI1666_I129 I1666_G1_0 I1666_G1_0n VDD VSS INV_X1
XI1666_I130_XG I1666_P5_2n I1666_G1_0n I1666_G5_2n I1666_G5_0 VDD VSS OAI21_X1
XI1666_I131_XG I1666_P6_3n I1666_G2_0n I1666_G6_3n I1666_G6_0 VDD VSS OAI21_X1
XI1666_I132_XG I1666_P7_4n I1666_G3_0n I1666_G7_4n I1666_G7_0 VDD VSS OAI21_X1
XI1666_I133_XG I1666_P8_5n I1666_G4_1n I1666_G8_5n I1666_G8_1 VDD VSS OAI21_X1
XI1666_I133_XP I1666_P8_5n I1666_P4_1n I1666_P8_1 VDD VSS NOR2_X1
XI1666_I134_XG I1666_P9_6n I1666_G5_2n I1666_G9_6n I1666_G9_2 VDD VSS OAI21_X1
XI1666_I134_XP I1666_P9_6n I1666_P5_2n I1666_P9_2 VDD VSS NOR2_X1
XI1666_I135_XG I1666_P10_7n I1666_G6_3n I1666_G10_7n I1666_G10_3 VDD VSS OAI21_X1
XI1666_I135_XP I1666_P10_7n I1666_P6_3n I1666_P10_3 VDD VSS NOR2_X1
XI1666_I136_XG I1666_P11_8n I1666_G7_4n I1666_G11_8n I1666_G11_4 VDD VSS OAI21_X1
XI1666_I136_XP I1666_P11_8n I1666_P7_4n I1666_P11_4 VDD VSS NOR2_X1
XI1666_I137_XG I1666_P12_9n I1666_G8_5n I1666_G12_9n I1666_G12_5 VDD VSS OAI21_X1
XI1666_I137_XP I1666_P12_9n I1666_P8_5n I1666_P12_5 VDD VSS NOR2_X1
XI1666_I138_XG I1666_P13_10n I1666_G9_6n I1666_G13_10n I1666_G13_6 VDD VSS OAI21_X1
XI1666_I138_XP I1666_P13_10n I1666_P9_6n I1666_P13_6 VDD VSS NOR2_X1
XI1666_I139_XG I1666_P14_11n I1666_G10_7n I1666_G14_11n I1666_G14_7 VDD VSS OAI21_X1
XI1666_I139_XP I1666_P14_11n I1666_P10_7n I1666_P14_7 VDD VSS NOR2_X1
XI1666_I140_XG I1666_P15_12n I1666_G11_8n I1666_G15_12n I1666_G15_8 VDD VSS OAI21_X1
XI1666_I140_XP I1666_P15_12n I1666_P11_8n I1666_P15_8 VDD VSS NOR2_X1
XI1666_I141_XG I1666_P16_13n I1666_G12_9n I1666_G16_13n I1666_G16_9 VDD VSS OAI21_X1
XI1666_I141_XP I1666_P16_13n I1666_P12_9n I1666_P16_9 VDD VSS NOR2_X1
XI1666_I142_XG I1666_P17_14n I1666_G13_10n I1666_G17_14n I1666_G17_10 VDD VSS OAI21_X1
XI1666_I142_XP I1666_P17_14n I1666_P13_10n I1666_P17_10 VDD VSS NOR2_X1
XI1666_I143_XG I1666_P18_15n I1666_G14_11n I1666_G18_15n I1666_G18_11 VDD VSS OAI21_X1
XI1666_I143_XP I1666_P18_15n I1666_P14_11n I1666_P18_11 VDD VSS NOR2_X1
XI1666_I144_XG I1666_P19_16n I1666_G15_12n I1666_G19_16n I1666_G19_12 VDD VSS OAI21_X1
XI1666_I144_XP I1666_P19_16n I1666_P15_12n I1666_P19_12 VDD VSS NOR2_X1
XI1666_I145_XG I1666_P20_17n I1666_G16_13n I1666_G20_17n I1666_G20_13 VDD VSS OAI21_X1
XI1666_I145_XP I1666_P20_17n I1666_P16_13n I1666_P20_13 VDD VSS NOR2_X1
XI1666_I146_XG I1666_P21_18n I1666_G17_14n I1666_G21_18n I1666_G21_14 VDD VSS OAI21_X1
XI1666_I146_XP I1666_P21_18n I1666_P17_14n I1666_P21_14 VDD VSS NOR2_X1
XI1666_I147_XG I1666_P22_19n I1666_G18_15n I1666_G22_19n I1666_G22_15 VDD VSS OAI21_X1
XI1666_I147_XP I1666_P22_19n I1666_P18_15n I1666_P22_15 VDD VSS NOR2_X1
XI1666_I148_XG I1666_P23_20n I1666_G19_16n I1666_G23_20n I1666_G23_16 VDD VSS OAI21_X1
XI1666_I148_XP I1666_P23_20n I1666_P19_16n I1666_P23_16 VDD VSS NOR2_X1
XI1666_I149_XG I1666_P24_21n I1666_G20_17n I1666_G24_21n I1666_G24_17 VDD VSS OAI21_X1
XI1666_I149_XP I1666_P24_21n I1666_P20_17n I1666_P24_17 VDD VSS NOR2_X1
XI1666_I150_XG I1666_P25_22n I1666_G21_18n I1666_G25_22n I1666_G25_18 VDD VSS OAI21_X1
XI1666_I150_XP I1666_P25_22n I1666_P21_18n I1666_P25_18 VDD VSS NOR2_X1
XI1666_I151_XG I1666_P26_23n I1666_G22_19n I1666_G26_23n I1666_G26_19 VDD VSS OAI21_X1
XI1666_I151_XP I1666_P26_23n I1666_P22_19n I1666_P26_19 VDD VSS NOR2_X1
XI1666_I152_XG I1666_P27_24n I1666_G23_20n I1666_G27_24n I1666_G27_20 VDD VSS OAI21_X1
XI1666_I152_XP I1666_P27_24n I1666_P23_20n I1666_P27_20 VDD VSS NOR2_X1
XI1666_I153_XG I1666_P28_25n I1666_G24_21n I1666_G28_25n I1666_G28_21 VDD VSS OAI21_X1
XI1666_I153_XP I1666_P28_25n I1666_P24_21n I1666_P28_21 VDD VSS NOR2_X1
XI1666_I154_XG I1666_P29_26n I1666_G25_22n I1666_G29_26n I1666_G29_22 VDD VSS OAI21_X1
XI1666_I154_XP I1666_P29_26n I1666_P25_22n I1666_P29_22 VDD VSS NOR2_X1
XI1666_I155_XG I1666_P30_27n I1666_G26_23n I1666_G30_27n I1666_G30_23 VDD VSS OAI21_X1
XI1666_I155_XP I1666_P30_27n I1666_P26_23n I1666_P30_23 VDD VSS NOR2_X1
XI1666_I156_XG I1666_P31_28n I1666_G27_24n I1666_G31_28n I1666_G31_24 VDD VSS OAI21_X1
XI1666_I156_XP I1666_P31_28n I1666_P27_24n I1666_P31_24 VDD VSS NOR2_X1
XI1666_I157_XG I1666_P8_1 I1666_G0_0 I1666_G8_1 I1666_G8_0n VDD VSS AOI21_X1
XI1666_I158_XG I1666_P9_2 I1666_G1_0 I1666_G9_2 I1666_G9_0n VDD VSS AOI21_X1
XI1666_I159 I1666_G2_0n I1666_G2_0np VDD VSS INV_X1
XI1666_I160_XG I1666_P10_3 I1666_G2_0np I1666_G10_3 I1666_G10_0n VDD VSS AOI21_X1
XI1666_I161 I1666_G3_0n I1666_G3_0np VDD VSS INV_X1
XI1666_I162_XG I1666_P11_4 I1666_G3_0np I1666_G11_4 I1666_G11_0n VDD VSS AOI21_X1
XI1666_I163_XG I1666_P12_5 I1666_G4_0 I1666_G12_5 I1666_G12_0n VDD VSS AOI21_X1
XI1666_I164_XG I1666_P13_6 I1666_G5_0 I1666_G13_6 I1666_G13_0n VDD VSS AOI21_X1
XI1666_I165_XG I1666_P14_7 I1666_G6_0 I1666_G14_7 I1666_G14_0n VDD VSS AOI21_X1
XI1666_I166_XG I1666_P15_8 I1666_G7_0 I1666_G15_8 I1666_G15_0n VDD VSS AOI21_X1
XI1666_I167_XG I1666_P16_9 I1666_G8_1 I1666_G16_9 I1666_G16_1n VDD VSS AOI21_X1
XI1666_I167_XP I1666_P16_9 I1666_P8_1 I1666_P16_1n VDD VSS NAND2_X1
XI1666_I168_XG I1666_P17_10 I1666_G9_2 I1666_G17_10 I1666_G17_2n VDD VSS AOI21_X1
XI1666_I168_XP I1666_P17_10 I1666_P9_2 I1666_P17_2n VDD VSS NAND2_X1
XI1666_I169_XG I1666_P18_11 I1666_G10_3 I1666_G18_11 I1666_G18_3n VDD VSS AOI21_X1
XI1666_I169_XP I1666_P18_11 I1666_P10_3 I1666_P18_3n VDD VSS NAND2_X1
XI1666_I170_XG I1666_P19_12 I1666_G11_4 I1666_G19_12 I1666_G19_4n VDD VSS AOI21_X1
XI1666_I170_XP I1666_P19_12 I1666_P11_4 I1666_P19_4n VDD VSS NAND2_X1
XI1666_I171_XG I1666_P20_13 I1666_G12_5 I1666_G20_13 I1666_G20_5n VDD VSS AOI21_X1
XI1666_I171_XP I1666_P20_13 I1666_P12_5 I1666_P20_5n VDD VSS NAND2_X1
XI1666_I172_XG I1666_P21_14 I1666_G13_6 I1666_G21_14 I1666_G21_6n VDD VSS AOI21_X1
XI1666_I172_XP I1666_P21_14 I1666_P13_6 I1666_P21_6n VDD VSS NAND2_X1
XI1666_I173_XG I1666_P22_15 I1666_G14_7 I1666_G22_15 I1666_G22_7n VDD VSS AOI21_X1
XI1666_I173_XP I1666_P22_15 I1666_P14_7 I1666_P22_7n VDD VSS NAND2_X1
XI1666_I174_XG I1666_P23_16 I1666_G15_8 I1666_G23_16 I1666_G23_8n VDD VSS AOI21_X1
XI1666_I174_XP I1666_P23_16 I1666_P15_8 I1666_P23_8n VDD VSS NAND2_X1
XI1666_I175_XG I1666_P24_17 I1666_G16_9 I1666_G24_17 I1666_G24_9n VDD VSS AOI21_X1
XI1666_I175_XP I1666_P24_17 I1666_P16_9 I1666_P24_9n VDD VSS NAND2_X1
XI1666_I176_XG I1666_P25_18 I1666_G17_10 I1666_G25_18 I1666_G25_10n VDD VSS AOI21_X1
XI1666_I176_XP I1666_P25_18 I1666_P17_10 I1666_P25_10n VDD VSS NAND2_X1
XI1666_I177_XG I1666_P26_19 I1666_G18_11 I1666_G26_19 I1666_G26_11n VDD VSS AOI21_X1
XI1666_I177_XP I1666_P26_19 I1666_P18_11 I1666_P26_11n VDD VSS NAND2_X1
XI1666_I178_XG I1666_P27_20 I1666_G19_12 I1666_G27_20 I1666_G27_12n VDD VSS AOI21_X1
XI1666_I178_XP I1666_P27_20 I1666_P19_12 I1666_P27_12n VDD VSS NAND2_X1
XI1666_I179_XG I1666_P28_21 I1666_G20_13 I1666_G28_21 I1666_G28_13n VDD VSS AOI21_X1
XI1666_I179_XP I1666_P28_21 I1666_P20_13 I1666_P28_13n VDD VSS NAND2_X1
XI1666_I180_XG I1666_P29_22 I1666_G21_14 I1666_G29_22 I1666_G29_14n VDD VSS AOI21_X1
XI1666_I180_XP I1666_P29_22 I1666_P21_14 I1666_P29_14n VDD VSS NAND2_X1
XI1666_I181_XG I1666_P30_23 I1666_G22_15 I1666_G30_23 I1666_G30_15n VDD VSS AOI21_X1
XI1666_I181_XP I1666_P30_23 I1666_P22_15 I1666_P30_15n VDD VSS NAND2_X1
XI1666_I182_XG I1666_P31_24 I1666_G23_16 I1666_G31_24 I1666_G31_16n VDD VSS AOI21_X1
XI1666_I182_XP I1666_P31_24 I1666_P23_16 I1666_P31_16n VDD VSS NAND2_X1
XI1666_I183_XG I1666_P16_1n I1666_G0_0n I1666_G16_1n I1666_G16_0 VDD VSS OAI21_X1
XI1666_I184_XG I1666_P17_2n I1666_G1_0n I1666_G17_2n I1666_G17_0 VDD VSS OAI21_X1
XI1666_I185_XG I1666_P18_3n I1666_G2_0n I1666_G18_3n I1666_G18_0 VDD VSS OAI21_X1
XI1666_I186_XG I1666_P19_4n I1666_G3_0n I1666_G19_4n I1666_G19_0 VDD VSS OAI21_X1
XI1666_I187 I1666_G4_0 I1666_G4_0n VDD VSS INV_X1
XI1666_I188_XG I1666_P20_5n I1666_G4_0n I1666_G20_5n I1666_G20_0 VDD VSS OAI21_X1
XI1666_I189 I1666_G5_0 I1666_G5_0n VDD VSS INV_X1
XI1666_I190_XG I1666_P21_6n I1666_G5_0n I1666_G21_6n I1666_G21_0 VDD VSS OAI21_X1
XI1666_I191 I1666_G6_0 I1666_G6_0n VDD VSS INV_X1
XI1666_I192_XG I1666_P22_7n I1666_G6_0n I1666_G22_7n I1666_G22_0 VDD VSS OAI21_X1
XI1666_I193 I1666_G7_0 I1666_G7_0n VDD VSS INV_X1
XI1666_I194_XG I1666_P23_8n I1666_G7_0n I1666_G23_8n I1666_G23_0 VDD VSS OAI21_X1
XI1666_I195_XG I1666_P24_9n I1666_G8_0n I1666_G24_9n I1666_G24_0 VDD VSS OAI21_X1
XI1666_I196_XG I1666_P25_10n I1666_G9_0n I1666_G25_10n I1666_G25_0 VDD VSS OAI21_X1
XI1666_I197_XG I1666_P26_11n I1666_G10_0n I1666_G26_11n I1666_G26_0 VDD VSS OAI21_X1
XI1666_I198_XG I1666_P27_12n I1666_G11_0n I1666_G27_12n I1666_G27_0 VDD VSS OAI21_X1
XI1666_I199_XG I1666_P28_13n I1666_G12_0n I1666_G28_13n I1666_G28_0 VDD VSS OAI21_X1
XI1666_I200_XG I1666_P29_14n I1666_G13_0n I1666_G29_14n I1666_G29_0 VDD VSS OAI21_X1
XI1666_I201_XG I1666_P30_15n I1666_G14_0n I1666_G30_15n c24_m VDD VSS OAI21_X1
XI1666_I202_XG I1666_P31_16n I1666_G15_0n I1666_G31_16n c24_o VDD VSS OAI21_X1
XI1666_I203 I1666_pn0 qu8_b3_5 p24_0 VDD VSS XNOR2_X1
XI1666_I204 I1666_pn1 I1666_G0_0 p24_1 VDD VSS XNOR2_X1
XI1666_I205 I1666_pn2 I1666_G1_0 p24_2 VDD VSS XNOR2_X1
XI1666_I206 I1666_pn3 I1666_G2_0n p24_3 VDD VSS XOR2_X1
XI1666_I207 I1666_pn4 I1666_G3_0n p24_4 VDD VSS XOR2_X1
XI1666_I208 I1666_pn5 I1666_G4_0 p24_5 VDD VSS XNOR2_X1
XI1666_I209 I1666_pn6 I1666_G5_0 p24_6 VDD VSS XNOR2_X1
XI1666_I210 I1666_pn7 I1666_G6_0 p24_7 VDD VSS XNOR2_X1
XI1666_I211 I1666_pn8 I1666_G7_0 p24_8 VDD VSS XNOR2_X1
XI1666_I212 I1666_pn9 I1666_G8_0n p24_9 VDD VSS XOR2_X1
XI1666_I213 I1666_pn10 I1666_G9_0n p24_10 VDD VSS XOR2_X1
XI1666_I214 I1666_pn11 I1666_G10_0n p24_11 VDD VSS XOR2_X1
XI1666_I215 I1666_pn12 I1666_G11_0n p24_12 VDD VSS XOR2_X1
XI1666_I216 I1666_pn13 I1666_G12_0n p24_13 VDD VSS XOR2_X1
XI1666_I217 I1666_pn14 I1666_G13_0n p24_14 VDD VSS XOR2_X1
XI1666_I218 I1666_pn15 I1666_G14_0n p24_15 VDD VSS XOR2_X1
XI1666_I219 I1666_pn16 I1666_G15_0n p24_16 VDD VSS XOR2_X1
XI1666_I220 I1666_pn17 I1666_G16_0 p24_17 VDD VSS XNOR2_X1
XI1666_I221 I1666_pn18 I1666_G17_0 p24_18 VDD VSS XNOR2_X1
XI1666_I222 I1666_pn19 I1666_G18_0 p24_19 VDD VSS XNOR2_X1
XI1666_I223 I1666_pn20 I1666_G19_0 p24_20 VDD VSS XNOR2_X1
XI1666_I224 I1666_pn21 I1666_G20_0 p24_21 VDD VSS XNOR2_X1
XI1666_I225 I1666_pn22 I1666_G21_0 p24_22 VDD VSS XNOR2_X1
XI1666_I226 I1666_pn23 I1666_G22_0 p24_23 VDD VSS XNOR2_X1
XI1666_I227 I1666_pn24 I1666_G23_0 p24_24 VDD VSS XNOR2_X1
XI1666_I228 I1666_pn25 I1666_G24_0 p24_25 VDD VSS XNOR2_X1
XI1666_I229 I1666_pn26 I1666_G25_0 p24_26 VDD VSS XNOR2_X1
XI1666_I230 I1666_pn27 I1666_G26_0 p24_27 VDD VSS XNOR2_X1
XI1666_I231 I1666_pn28 I1666_G27_0 p24_28 VDD VSS XNOR2_X1
XI1666_I232 I1666_pn29 I1666_G28_0 p24_29 VDD VSS XNOR2_X1
XI1666_I233 I1666_pn30 I1666_G29_0 p24_30 VDD VSS XNOR2_X1
XI1666_I234 I1666_pn31 c24_m p24_31 VDD VSS XNOR2_X1
XI1667 p23_31 qu8_b3_5 h24 VDD VSS XOR2_X1
XI1668 h24 c24_o p24_32 VDD VSS XOR2_X1
XI1669 p24_32 qu7 VDD VSS INV_X4
XI1670 qu7 qu7_b0 VDD VSS INV_X1
XI1671 qu7_b0 qu7_b1_0 VDD VSS INV_X4
XI1672 qu7_b1_0 qu7_b2_0 VDD VSS INV_X4
XI1673 qu7_b1_0 qu7_b2_1 VDD VSS INV_X4
XI1674 qu7_b2_0 qu7_b3_0 VDD VSS INV_X4
XI1675 qu7_b2_0 qu7_b3_1 VDD VSS INV_X4
XI1676 qu7_b2_0 qu7_b3_2 VDD VSS INV_X4
XI1677 qu7_b2_1 qu7_b3_3 VDD VSS INV_X4
XI1678 qu7_b2_1 qu7_b3_4 VDD VSS INV_X4
XI1679 qu7_b2_1 qu7_b3_5 VDD VSS INV_X4
XI1680 B_0_b3_4 qu7_b3_0 b25_0 VDD VSS XOR2_X1
XI1681 dd1_b3_4 qu7_b3_0 b25_1 VDD VSS XOR2_X1
XI1682 dd2_b3_4 qu7_b3_0 b25_2 VDD VSS XOR2_X1
XI1683 dd3_b3_4 qu7_b3_0 b25_3 VDD VSS XOR2_X1
XI1684 dd4_b3_4 qu7_b3_0 b25_4 VDD VSS XOR2_X1
XI1685 dd5_b3_4 qu7_b3_0 b25_5 VDD VSS XOR2_X1
XI1686 dd6_b3_4 qu7_b3_1 b25_6 VDD VSS XOR2_X1
XI1687 dd7_b3_4 qu7_b3_1 b25_7 VDD VSS XOR2_X1
XI1688 dd8_b3_4 qu7_b3_1 b25_8 VDD VSS XOR2_X1
XI1689 dd9_b3_4 qu7_b3_1 b25_9 VDD VSS XOR2_X1
XI1690 dd10_b3_4 qu7_b3_1 b25_10 VDD VSS XOR2_X1
XI1691 dd11_b3_4 qu7_b3_1 b25_11 VDD VSS XOR2_X1
XI1692 dd12_b3_4 qu7_b3_2 b25_12 VDD VSS XOR2_X1
XI1693 dd13_b3_4 qu7_b3_2 b25_13 VDD VSS XOR2_X1
XI1694 dd14_b3_4 qu7_b3_2 b25_14 VDD VSS XOR2_X1
XI1695 dd15_b3_4 qu7_b3_2 b25_15 VDD VSS XOR2_X1
XI1696 dd16_b3_4 qu7_b3_2 b25_16 VDD VSS XOR2_X1
XI1697 dd17_b3_4 qu7_b3_2 b25_17 VDD VSS XOR2_X1
XI1698 dd18_b3_4 qu7_b3_3 b25_18 VDD VSS XOR2_X1
XI1699 dd19_b3_4 qu7_b3_3 b25_19 VDD VSS XOR2_X1
XI1700 dd20_b3_4 qu7_b3_3 b25_20 VDD VSS XOR2_X1
XI1701 dd21_b3_4 qu7_b3_3 b25_21 VDD VSS XOR2_X1
XI1702 dd22_b3_4 qu7_b3_3 b25_22 VDD VSS XOR2_X1
XI1703 dd23_b3_4 qu7_b3_3 b25_23 VDD VSS XOR2_X1
XI1704 dd24_b3_4 qu7_b3_4 b25_24 VDD VSS XOR2_X1
XI1705 dd25_b3_4 qu7_b3_4 b25_25 VDD VSS XOR2_X1
XI1706 dd26_b3_4 qu7_b3_4 b25_26 VDD VSS XOR2_X1
XI1707 dd27_b3_4 qu7_b3_4 b25_27 VDD VSS XOR2_X1
XI1708 dd28_b3_4 qu7_b3_4 b25_28 VDD VSS XOR2_X1
XI1709 dd29_b3_4 qu7_b3_4 b25_29 VDD VSS XOR2_X1
XI1710 dd30_b3_4 qu7_b3_5 b25_30 VDD VSS XOR2_X1
XI1711 dd31_b3_4 qu7_b3_5 b25_31 VDD VSS XOR2_X1
XI1712_I0 aa6 b25_0 I1712_gn0 VDD VSS NAND2_X1
XI1712_I1 p24_0 b25_1 I1712_gn1 VDD VSS NAND2_X1
XI1712_I2 p24_1 b25_2 I1712_gn2 VDD VSS NAND2_X1
XI1712_I3 p24_2 b25_3 I1712_gn3 VDD VSS NAND2_X1
XI1712_I4 p24_3 b25_4 I1712_gn4 VDD VSS NAND2_X1
XI1712_I5 p24_4 b25_5 I1712_gn5 VDD VSS NAND2_X1
XI1712_I6 p24_5 b25_6 I1712_gn6 VDD VSS NAND2_X1
XI1712_I7 p24_6 b25_7 I1712_gn7 VDD VSS NAND2_X1
XI1712_I8 p24_7 b25_8 I1712_gn8 VDD VSS NAND2_X1
XI1712_I9 p24_8 b25_9 I1712_gn9 VDD VSS NAND2_X1
XI1712_I10 p24_9 b25_10 I1712_gn10 VDD VSS NAND2_X1
XI1712_I11 p24_10 b25_11 I1712_gn11 VDD VSS NAND2_X1
XI1712_I12 p24_11 b25_12 I1712_gn12 VDD VSS NAND2_X1
XI1712_I13 p24_12 b25_13 I1712_gn13 VDD VSS NAND2_X1
XI1712_I14 p24_13 b25_14 I1712_gn14 VDD VSS NAND2_X1
XI1712_I15 p24_14 b25_15 I1712_gn15 VDD VSS NAND2_X1
XI1712_I16 p24_15 b25_16 I1712_gn16 VDD VSS NAND2_X1
XI1712_I17 p24_16 b25_17 I1712_gn17 VDD VSS NAND2_X1
XI1712_I18 p24_17 b25_18 I1712_gn18 VDD VSS NAND2_X1
XI1712_I19 p24_18 b25_19 I1712_gn19 VDD VSS NAND2_X1
XI1712_I20 p24_19 b25_20 I1712_gn20 VDD VSS NAND2_X1
XI1712_I21 p24_20 b25_21 I1712_gn21 VDD VSS NAND2_X1
XI1712_I22 p24_21 b25_22 I1712_gn22 VDD VSS NAND2_X1
XI1712_I23 p24_22 b25_23 I1712_gn23 VDD VSS NAND2_X1
XI1712_I24 p24_23 b25_24 I1712_gn24 VDD VSS NAND2_X1
XI1712_I25 p24_24 b25_25 I1712_gn25 VDD VSS NAND2_X1
XI1712_I26 p24_25 b25_26 I1712_gn26 VDD VSS NAND2_X1
XI1712_I27 p24_26 b25_27 I1712_gn27 VDD VSS NAND2_X1
XI1712_I28 p24_27 b25_28 I1712_gn28 VDD VSS NAND2_X1
XI1712_I29 p24_28 b25_29 I1712_gn29 VDD VSS NAND2_X1
XI1712_I30 p24_29 b25_30 I1712_gn30 VDD VSS NAND2_X1
XI1712_I31 p24_30 b25_31 I1712_gn31 VDD VSS NAND2_X1
XI1712_I32 aa6 b25_0 I1712_pn0 VDD VSS XNOR2_X1
XI1712_I33 p24_0 b25_1 I1712_pn1 VDD VSS XNOR2_X1
XI1712_I34 p24_1 b25_2 I1712_pn2 VDD VSS XNOR2_X1
XI1712_I35 p24_2 b25_3 I1712_pn3 VDD VSS XNOR2_X1
XI1712_I36 p24_3 b25_4 I1712_pn4 VDD VSS XNOR2_X1
XI1712_I37 p24_4 b25_5 I1712_pn5 VDD VSS XNOR2_X1
XI1712_I38 p24_5 b25_6 I1712_pn6 VDD VSS XNOR2_X1
XI1712_I39 p24_6 b25_7 I1712_pn7 VDD VSS XNOR2_X1
XI1712_I40 p24_7 b25_8 I1712_pn8 VDD VSS XNOR2_X1
XI1712_I41 p24_8 b25_9 I1712_pn9 VDD VSS XNOR2_X1
XI1712_I42 p24_9 b25_10 I1712_pn10 VDD VSS XNOR2_X1
XI1712_I43 p24_10 b25_11 I1712_pn11 VDD VSS XNOR2_X1
XI1712_I44 p24_11 b25_12 I1712_pn12 VDD VSS XNOR2_X1
XI1712_I45 p24_12 b25_13 I1712_pn13 VDD VSS XNOR2_X1
XI1712_I46 p24_13 b25_14 I1712_pn14 VDD VSS XNOR2_X1
XI1712_I47 p24_14 b25_15 I1712_pn15 VDD VSS XNOR2_X1
XI1712_I48 p24_15 b25_16 I1712_pn16 VDD VSS XNOR2_X1
XI1712_I49 p24_16 b25_17 I1712_pn17 VDD VSS XNOR2_X1
XI1712_I50 p24_17 b25_18 I1712_pn18 VDD VSS XNOR2_X1
XI1712_I51 p24_18 b25_19 I1712_pn19 VDD VSS XNOR2_X1
XI1712_I52 p24_19 b25_20 I1712_pn20 VDD VSS XNOR2_X1
XI1712_I53 p24_20 b25_21 I1712_pn21 VDD VSS XNOR2_X1
XI1712_I54 p24_21 b25_22 I1712_pn22 VDD VSS XNOR2_X1
XI1712_I55 p24_22 b25_23 I1712_pn23 VDD VSS XNOR2_X1
XI1712_I56 p24_23 b25_24 I1712_pn24 VDD VSS XNOR2_X1
XI1712_I57 p24_24 b25_25 I1712_pn25 VDD VSS XNOR2_X1
XI1712_I58 p24_25 b25_26 I1712_pn26 VDD VSS XNOR2_X1
XI1712_I59 p24_26 b25_27 I1712_pn27 VDD VSS XNOR2_X1
XI1712_I60 p24_27 b25_28 I1712_pn28 VDD VSS XNOR2_X1
XI1712_I61 p24_28 b25_29 I1712_pn29 VDD VSS XNOR2_X1
XI1712_I62 p24_29 b25_30 I1712_pn30 VDD VSS XNOR2_X1
XI1712_I63 p24_30 b25_31 I1712_pn31 VDD VSS XNOR2_X1
XI1712_I64 qu7_b3_5 I1712_cinn VDD VSS INV_X1
XI1712_I65_XG I1712_pn0 I1712_cinn I1712_gn0 I1712_G0_0 VDD VSS OAI21_X1
XI1712_I66 I1712_G0_0 I1712_G0_0n VDD VSS INV_X1
XI1712_I67_XG I1712_pn1 I1712_G0_0n I1712_gn1 I1712_G1_0 VDD VSS OAI21_X1
XI1712_I68_XG I1712_pn2 I1712_gn1 I1712_gn2 I1712_G2_1 VDD VSS OAI21_X1
XI1712_I68_XP I1712_pn2 I1712_pn1 I1712_P2_1 VDD VSS NOR2_X1
XI1712_I69_XG I1712_pn3 I1712_gn2 I1712_gn3 I1712_G3_2 VDD VSS OAI21_X1
XI1712_I69_XP I1712_pn3 I1712_pn2 I1712_P3_2 VDD VSS NOR2_X1
XI1712_I70_XG I1712_pn4 I1712_gn3 I1712_gn4 I1712_G4_3 VDD VSS OAI21_X1
XI1712_I70_XP I1712_pn4 I1712_pn3 I1712_P4_3 VDD VSS NOR2_X1
XI1712_I71_XG I1712_pn5 I1712_gn4 I1712_gn5 I1712_G5_4 VDD VSS OAI21_X1
XI1712_I71_XP I1712_pn5 I1712_pn4 I1712_P5_4 VDD VSS NOR2_X1
XI1712_I72_XG I1712_pn6 I1712_gn5 I1712_gn6 I1712_G6_5 VDD VSS OAI21_X1
XI1712_I72_XP I1712_pn6 I1712_pn5 I1712_P6_5 VDD VSS NOR2_X1
XI1712_I73_XG I1712_pn7 I1712_gn6 I1712_gn7 I1712_G7_6 VDD VSS OAI21_X1
XI1712_I73_XP I1712_pn7 I1712_pn6 I1712_P7_6 VDD VSS NOR2_X1
XI1712_I74_XG I1712_pn8 I1712_gn7 I1712_gn8 I1712_G8_7 VDD VSS OAI21_X1
XI1712_I74_XP I1712_pn8 I1712_pn7 I1712_P8_7 VDD VSS NOR2_X1
XI1712_I75_XG I1712_pn9 I1712_gn8 I1712_gn9 I1712_G9_8 VDD VSS OAI21_X1
XI1712_I75_XP I1712_pn9 I1712_pn8 I1712_P9_8 VDD VSS NOR2_X1
XI1712_I76_XG I1712_pn10 I1712_gn9 I1712_gn10 I1712_G10_9 VDD VSS OAI21_X1
XI1712_I76_XP I1712_pn10 I1712_pn9 I1712_P10_9 VDD VSS NOR2_X1
XI1712_I77_XG I1712_pn11 I1712_gn10 I1712_gn11 I1712_G11_10 VDD VSS OAI21_X1
XI1712_I77_XP I1712_pn11 I1712_pn10 I1712_P11_10 VDD VSS NOR2_X1
XI1712_I78_XG I1712_pn12 I1712_gn11 I1712_gn12 I1712_G12_11 VDD VSS OAI21_X1
XI1712_I78_XP I1712_pn12 I1712_pn11 I1712_P12_11 VDD VSS NOR2_X1
XI1712_I79_XG I1712_pn13 I1712_gn12 I1712_gn13 I1712_G13_12 VDD VSS OAI21_X1
XI1712_I79_XP I1712_pn13 I1712_pn12 I1712_P13_12 VDD VSS NOR2_X1
XI1712_I80_XG I1712_pn14 I1712_gn13 I1712_gn14 I1712_G14_13 VDD VSS OAI21_X1
XI1712_I80_XP I1712_pn14 I1712_pn13 I1712_P14_13 VDD VSS NOR2_X1
XI1712_I81_XG I1712_pn15 I1712_gn14 I1712_gn15 I1712_G15_14 VDD VSS OAI21_X1
XI1712_I81_XP I1712_pn15 I1712_pn14 I1712_P15_14 VDD VSS NOR2_X1
XI1712_I82_XG I1712_pn16 I1712_gn15 I1712_gn16 I1712_G16_15 VDD VSS OAI21_X1
XI1712_I82_XP I1712_pn16 I1712_pn15 I1712_P16_15 VDD VSS NOR2_X1
XI1712_I83_XG I1712_pn17 I1712_gn16 I1712_gn17 I1712_G17_16 VDD VSS OAI21_X1
XI1712_I83_XP I1712_pn17 I1712_pn16 I1712_P17_16 VDD VSS NOR2_X1
XI1712_I84_XG I1712_pn18 I1712_gn17 I1712_gn18 I1712_G18_17 VDD VSS OAI21_X1
XI1712_I84_XP I1712_pn18 I1712_pn17 I1712_P18_17 VDD VSS NOR2_X1
XI1712_I85_XG I1712_pn19 I1712_gn18 I1712_gn19 I1712_G19_18 VDD VSS OAI21_X1
XI1712_I85_XP I1712_pn19 I1712_pn18 I1712_P19_18 VDD VSS NOR2_X1
XI1712_I86_XG I1712_pn20 I1712_gn19 I1712_gn20 I1712_G20_19 VDD VSS OAI21_X1
XI1712_I86_XP I1712_pn20 I1712_pn19 I1712_P20_19 VDD VSS NOR2_X1
XI1712_I87_XG I1712_pn21 I1712_gn20 I1712_gn21 I1712_G21_20 VDD VSS OAI21_X1
XI1712_I87_XP I1712_pn21 I1712_pn20 I1712_P21_20 VDD VSS NOR2_X1
XI1712_I88_XG I1712_pn22 I1712_gn21 I1712_gn22 I1712_G22_21 VDD VSS OAI21_X1
XI1712_I88_XP I1712_pn22 I1712_pn21 I1712_P22_21 VDD VSS NOR2_X1
XI1712_I89_XG I1712_pn23 I1712_gn22 I1712_gn23 I1712_G23_22 VDD VSS OAI21_X1
XI1712_I89_XP I1712_pn23 I1712_pn22 I1712_P23_22 VDD VSS NOR2_X1
XI1712_I90_XG I1712_pn24 I1712_gn23 I1712_gn24 I1712_G24_23 VDD VSS OAI21_X1
XI1712_I90_XP I1712_pn24 I1712_pn23 I1712_P24_23 VDD VSS NOR2_X1
XI1712_I91_XG I1712_pn25 I1712_gn24 I1712_gn25 I1712_G25_24 VDD VSS OAI21_X1
XI1712_I91_XP I1712_pn25 I1712_pn24 I1712_P25_24 VDD VSS NOR2_X1
XI1712_I92_XG I1712_pn26 I1712_gn25 I1712_gn26 I1712_G26_25 VDD VSS OAI21_X1
XI1712_I92_XP I1712_pn26 I1712_pn25 I1712_P26_25 VDD VSS NOR2_X1
XI1712_I93_XG I1712_pn27 I1712_gn26 I1712_gn27 I1712_G27_26 VDD VSS OAI21_X1
XI1712_I93_XP I1712_pn27 I1712_pn26 I1712_P27_26 VDD VSS NOR2_X1
XI1712_I94_XG I1712_pn28 I1712_gn27 I1712_gn28 I1712_G28_27 VDD VSS OAI21_X1
XI1712_I94_XP I1712_pn28 I1712_pn27 I1712_P28_27 VDD VSS NOR2_X1
XI1712_I95_XG I1712_pn29 I1712_gn28 I1712_gn29 I1712_G29_28 VDD VSS OAI21_X1
XI1712_I95_XP I1712_pn29 I1712_pn28 I1712_P29_28 VDD VSS NOR2_X1
XI1712_I96_XG I1712_pn30 I1712_gn29 I1712_gn30 I1712_G30_29 VDD VSS OAI21_X1
XI1712_I96_XP I1712_pn30 I1712_pn29 I1712_P30_29 VDD VSS NOR2_X1
XI1712_I97_XG I1712_pn31 I1712_gn30 I1712_gn31 I1712_G31_30 VDD VSS OAI21_X1
XI1712_I97_XP I1712_pn31 I1712_pn30 I1712_P31_30 VDD VSS NOR2_X1
XI1712_I98_XG I1712_P2_1 I1712_G0_0 I1712_G2_1 I1712_G2_0n VDD VSS AOI21_X1
XI1712_I99_XG I1712_P3_2 I1712_G1_0 I1712_G3_2 I1712_G3_0n VDD VSS AOI21_X1
XI1712_I100_XG I1712_P4_3 I1712_G2_1 I1712_G4_3 I1712_G4_1n VDD VSS AOI21_X1
XI1712_I100_XP I1712_P4_3 I1712_P2_1 I1712_P4_1n VDD VSS NAND2_X1
XI1712_I101_XG I1712_P5_4 I1712_G3_2 I1712_G5_4 I1712_G5_2n VDD VSS AOI21_X1
XI1712_I101_XP I1712_P5_4 I1712_P3_2 I1712_P5_2n VDD VSS NAND2_X1
XI1712_I102_XG I1712_P6_5 I1712_G4_3 I1712_G6_5 I1712_G6_3n VDD VSS AOI21_X1
XI1712_I102_XP I1712_P6_5 I1712_P4_3 I1712_P6_3n VDD VSS NAND2_X1
XI1712_I103_XG I1712_P7_6 I1712_G5_4 I1712_G7_6 I1712_G7_4n VDD VSS AOI21_X1
XI1712_I103_XP I1712_P7_6 I1712_P5_4 I1712_P7_4n VDD VSS NAND2_X1
XI1712_I104_XG I1712_P8_7 I1712_G6_5 I1712_G8_7 I1712_G8_5n VDD VSS AOI21_X1
XI1712_I104_XP I1712_P8_7 I1712_P6_5 I1712_P8_5n VDD VSS NAND2_X1
XI1712_I105_XG I1712_P9_8 I1712_G7_6 I1712_G9_8 I1712_G9_6n VDD VSS AOI21_X1
XI1712_I105_XP I1712_P9_8 I1712_P7_6 I1712_P9_6n VDD VSS NAND2_X1
XI1712_I106_XG I1712_P10_9 I1712_G8_7 I1712_G10_9 I1712_G10_7n VDD VSS AOI21_X1
XI1712_I106_XP I1712_P10_9 I1712_P8_7 I1712_P10_7n VDD VSS NAND2_X1
XI1712_I107_XG I1712_P11_10 I1712_G9_8 I1712_G11_10 I1712_G11_8n VDD VSS AOI21_X1
XI1712_I107_XP I1712_P11_10 I1712_P9_8 I1712_P11_8n VDD VSS NAND2_X1
XI1712_I108_XG I1712_P12_11 I1712_G10_9 I1712_G12_11 I1712_G12_9n VDD VSS AOI21_X1
XI1712_I108_XP I1712_P12_11 I1712_P10_9 I1712_P12_9n VDD VSS NAND2_X1
XI1712_I109_XG I1712_P13_12 I1712_G11_10 I1712_G13_12 I1712_G13_10n VDD VSS AOI21_X1
XI1712_I109_XP I1712_P13_12 I1712_P11_10 I1712_P13_10n VDD VSS NAND2_X1
XI1712_I110_XG I1712_P14_13 I1712_G12_11 I1712_G14_13 I1712_G14_11n VDD VSS AOI21_X1
XI1712_I110_XP I1712_P14_13 I1712_P12_11 I1712_P14_11n VDD VSS NAND2_X1
XI1712_I111_XG I1712_P15_14 I1712_G13_12 I1712_G15_14 I1712_G15_12n VDD VSS AOI21_X1
XI1712_I111_XP I1712_P15_14 I1712_P13_12 I1712_P15_12n VDD VSS NAND2_X1
XI1712_I112_XG I1712_P16_15 I1712_G14_13 I1712_G16_15 I1712_G16_13n VDD VSS AOI21_X1
XI1712_I112_XP I1712_P16_15 I1712_P14_13 I1712_P16_13n VDD VSS NAND2_X1
XI1712_I113_XG I1712_P17_16 I1712_G15_14 I1712_G17_16 I1712_G17_14n VDD VSS AOI21_X1
XI1712_I113_XP I1712_P17_16 I1712_P15_14 I1712_P17_14n VDD VSS NAND2_X1
XI1712_I114_XG I1712_P18_17 I1712_G16_15 I1712_G18_17 I1712_G18_15n VDD VSS AOI21_X1
XI1712_I114_XP I1712_P18_17 I1712_P16_15 I1712_P18_15n VDD VSS NAND2_X1
XI1712_I115_XG I1712_P19_18 I1712_G17_16 I1712_G19_18 I1712_G19_16n VDD VSS AOI21_X1
XI1712_I115_XP I1712_P19_18 I1712_P17_16 I1712_P19_16n VDD VSS NAND2_X1
XI1712_I116_XG I1712_P20_19 I1712_G18_17 I1712_G20_19 I1712_G20_17n VDD VSS AOI21_X1
XI1712_I116_XP I1712_P20_19 I1712_P18_17 I1712_P20_17n VDD VSS NAND2_X1
XI1712_I117_XG I1712_P21_20 I1712_G19_18 I1712_G21_20 I1712_G21_18n VDD VSS AOI21_X1
XI1712_I117_XP I1712_P21_20 I1712_P19_18 I1712_P21_18n VDD VSS NAND2_X1
XI1712_I118_XG I1712_P22_21 I1712_G20_19 I1712_G22_21 I1712_G22_19n VDD VSS AOI21_X1
XI1712_I118_XP I1712_P22_21 I1712_P20_19 I1712_P22_19n VDD VSS NAND2_X1
XI1712_I119_XG I1712_P23_22 I1712_G21_20 I1712_G23_22 I1712_G23_20n VDD VSS AOI21_X1
XI1712_I119_XP I1712_P23_22 I1712_P21_20 I1712_P23_20n VDD VSS NAND2_X1
XI1712_I120_XG I1712_P24_23 I1712_G22_21 I1712_G24_23 I1712_G24_21n VDD VSS AOI21_X1
XI1712_I120_XP I1712_P24_23 I1712_P22_21 I1712_P24_21n VDD VSS NAND2_X1
XI1712_I121_XG I1712_P25_24 I1712_G23_22 I1712_G25_24 I1712_G25_22n VDD VSS AOI21_X1
XI1712_I121_XP I1712_P25_24 I1712_P23_22 I1712_P25_22n VDD VSS NAND2_X1
XI1712_I122_XG I1712_P26_25 I1712_G24_23 I1712_G26_25 I1712_G26_23n VDD VSS AOI21_X1
XI1712_I122_XP I1712_P26_25 I1712_P24_23 I1712_P26_23n VDD VSS NAND2_X1
XI1712_I123_XG I1712_P27_26 I1712_G25_24 I1712_G27_26 I1712_G27_24n VDD VSS AOI21_X1
XI1712_I123_XP I1712_P27_26 I1712_P25_24 I1712_P27_24n VDD VSS NAND2_X1
XI1712_I124_XG I1712_P28_27 I1712_G26_25 I1712_G28_27 I1712_G28_25n VDD VSS AOI21_X1
XI1712_I124_XP I1712_P28_27 I1712_P26_25 I1712_P28_25n VDD VSS NAND2_X1
XI1712_I125_XG I1712_P29_28 I1712_G27_26 I1712_G29_28 I1712_G29_26n VDD VSS AOI21_X1
XI1712_I125_XP I1712_P29_28 I1712_P27_26 I1712_P29_26n VDD VSS NAND2_X1
XI1712_I126_XG I1712_P30_29 I1712_G28_27 I1712_G30_29 I1712_G30_27n VDD VSS AOI21_X1
XI1712_I126_XP I1712_P30_29 I1712_P28_27 I1712_P30_27n VDD VSS NAND2_X1
XI1712_I127_XG I1712_P31_30 I1712_G29_28 I1712_G31_30 I1712_G31_28n VDD VSS AOI21_X1
XI1712_I127_XP I1712_P31_30 I1712_P29_28 I1712_P31_28n VDD VSS NAND2_X1
XI1712_I128_XG I1712_P4_1n I1712_G0_0n I1712_G4_1n I1712_G4_0 VDD VSS OAI21_X1
XI1712_I129 I1712_G1_0 I1712_G1_0n VDD VSS INV_X1
XI1712_I130_XG I1712_P5_2n I1712_G1_0n I1712_G5_2n I1712_G5_0 VDD VSS OAI21_X1
XI1712_I131_XG I1712_P6_3n I1712_G2_0n I1712_G6_3n I1712_G6_0 VDD VSS OAI21_X1
XI1712_I132_XG I1712_P7_4n I1712_G3_0n I1712_G7_4n I1712_G7_0 VDD VSS OAI21_X1
XI1712_I133_XG I1712_P8_5n I1712_G4_1n I1712_G8_5n I1712_G8_1 VDD VSS OAI21_X1
XI1712_I133_XP I1712_P8_5n I1712_P4_1n I1712_P8_1 VDD VSS NOR2_X1
XI1712_I134_XG I1712_P9_6n I1712_G5_2n I1712_G9_6n I1712_G9_2 VDD VSS OAI21_X1
XI1712_I134_XP I1712_P9_6n I1712_P5_2n I1712_P9_2 VDD VSS NOR2_X1
XI1712_I135_XG I1712_P10_7n I1712_G6_3n I1712_G10_7n I1712_G10_3 VDD VSS OAI21_X1
XI1712_I135_XP I1712_P10_7n I1712_P6_3n I1712_P10_3 VDD VSS NOR2_X1
XI1712_I136_XG I1712_P11_8n I1712_G7_4n I1712_G11_8n I1712_G11_4 VDD VSS OAI21_X1
XI1712_I136_XP I1712_P11_8n I1712_P7_4n I1712_P11_4 VDD VSS NOR2_X1
XI1712_I137_XG I1712_P12_9n I1712_G8_5n I1712_G12_9n I1712_G12_5 VDD VSS OAI21_X1
XI1712_I137_XP I1712_P12_9n I1712_P8_5n I1712_P12_5 VDD VSS NOR2_X1
XI1712_I138_XG I1712_P13_10n I1712_G9_6n I1712_G13_10n I1712_G13_6 VDD VSS OAI21_X1
XI1712_I138_XP I1712_P13_10n I1712_P9_6n I1712_P13_6 VDD VSS NOR2_X1
XI1712_I139_XG I1712_P14_11n I1712_G10_7n I1712_G14_11n I1712_G14_7 VDD VSS OAI21_X1
XI1712_I139_XP I1712_P14_11n I1712_P10_7n I1712_P14_7 VDD VSS NOR2_X1
XI1712_I140_XG I1712_P15_12n I1712_G11_8n I1712_G15_12n I1712_G15_8 VDD VSS OAI21_X1
XI1712_I140_XP I1712_P15_12n I1712_P11_8n I1712_P15_8 VDD VSS NOR2_X1
XI1712_I141_XG I1712_P16_13n I1712_G12_9n I1712_G16_13n I1712_G16_9 VDD VSS OAI21_X1
XI1712_I141_XP I1712_P16_13n I1712_P12_9n I1712_P16_9 VDD VSS NOR2_X1
XI1712_I142_XG I1712_P17_14n I1712_G13_10n I1712_G17_14n I1712_G17_10 VDD VSS OAI21_X1
XI1712_I142_XP I1712_P17_14n I1712_P13_10n I1712_P17_10 VDD VSS NOR2_X1
XI1712_I143_XG I1712_P18_15n I1712_G14_11n I1712_G18_15n I1712_G18_11 VDD VSS OAI21_X1
XI1712_I143_XP I1712_P18_15n I1712_P14_11n I1712_P18_11 VDD VSS NOR2_X1
XI1712_I144_XG I1712_P19_16n I1712_G15_12n I1712_G19_16n I1712_G19_12 VDD VSS OAI21_X1
XI1712_I144_XP I1712_P19_16n I1712_P15_12n I1712_P19_12 VDD VSS NOR2_X1
XI1712_I145_XG I1712_P20_17n I1712_G16_13n I1712_G20_17n I1712_G20_13 VDD VSS OAI21_X1
XI1712_I145_XP I1712_P20_17n I1712_P16_13n I1712_P20_13 VDD VSS NOR2_X1
XI1712_I146_XG I1712_P21_18n I1712_G17_14n I1712_G21_18n I1712_G21_14 VDD VSS OAI21_X1
XI1712_I146_XP I1712_P21_18n I1712_P17_14n I1712_P21_14 VDD VSS NOR2_X1
XI1712_I147_XG I1712_P22_19n I1712_G18_15n I1712_G22_19n I1712_G22_15 VDD VSS OAI21_X1
XI1712_I147_XP I1712_P22_19n I1712_P18_15n I1712_P22_15 VDD VSS NOR2_X1
XI1712_I148_XG I1712_P23_20n I1712_G19_16n I1712_G23_20n I1712_G23_16 VDD VSS OAI21_X1
XI1712_I148_XP I1712_P23_20n I1712_P19_16n I1712_P23_16 VDD VSS NOR2_X1
XI1712_I149_XG I1712_P24_21n I1712_G20_17n I1712_G24_21n I1712_G24_17 VDD VSS OAI21_X1
XI1712_I149_XP I1712_P24_21n I1712_P20_17n I1712_P24_17 VDD VSS NOR2_X1
XI1712_I150_XG I1712_P25_22n I1712_G21_18n I1712_G25_22n I1712_G25_18 VDD VSS OAI21_X1
XI1712_I150_XP I1712_P25_22n I1712_P21_18n I1712_P25_18 VDD VSS NOR2_X1
XI1712_I151_XG I1712_P26_23n I1712_G22_19n I1712_G26_23n I1712_G26_19 VDD VSS OAI21_X1
XI1712_I151_XP I1712_P26_23n I1712_P22_19n I1712_P26_19 VDD VSS NOR2_X1
XI1712_I152_XG I1712_P27_24n I1712_G23_20n I1712_G27_24n I1712_G27_20 VDD VSS OAI21_X1
XI1712_I152_XP I1712_P27_24n I1712_P23_20n I1712_P27_20 VDD VSS NOR2_X1
XI1712_I153_XG I1712_P28_25n I1712_G24_21n I1712_G28_25n I1712_G28_21 VDD VSS OAI21_X1
XI1712_I153_XP I1712_P28_25n I1712_P24_21n I1712_P28_21 VDD VSS NOR2_X1
XI1712_I154_XG I1712_P29_26n I1712_G25_22n I1712_G29_26n I1712_G29_22 VDD VSS OAI21_X1
XI1712_I154_XP I1712_P29_26n I1712_P25_22n I1712_P29_22 VDD VSS NOR2_X1
XI1712_I155_XG I1712_P30_27n I1712_G26_23n I1712_G30_27n I1712_G30_23 VDD VSS OAI21_X1
XI1712_I155_XP I1712_P30_27n I1712_P26_23n I1712_P30_23 VDD VSS NOR2_X1
XI1712_I156_XG I1712_P31_28n I1712_G27_24n I1712_G31_28n I1712_G31_24 VDD VSS OAI21_X1
XI1712_I156_XP I1712_P31_28n I1712_P27_24n I1712_P31_24 VDD VSS NOR2_X1
XI1712_I157_XG I1712_P8_1 I1712_G0_0 I1712_G8_1 I1712_G8_0n VDD VSS AOI21_X1
XI1712_I158_XG I1712_P9_2 I1712_G1_0 I1712_G9_2 I1712_G9_0n VDD VSS AOI21_X1
XI1712_I159 I1712_G2_0n I1712_G2_0np VDD VSS INV_X1
XI1712_I160_XG I1712_P10_3 I1712_G2_0np I1712_G10_3 I1712_G10_0n VDD VSS AOI21_X1
XI1712_I161 I1712_G3_0n I1712_G3_0np VDD VSS INV_X1
XI1712_I162_XG I1712_P11_4 I1712_G3_0np I1712_G11_4 I1712_G11_0n VDD VSS AOI21_X1
XI1712_I163_XG I1712_P12_5 I1712_G4_0 I1712_G12_5 I1712_G12_0n VDD VSS AOI21_X1
XI1712_I164_XG I1712_P13_6 I1712_G5_0 I1712_G13_6 I1712_G13_0n VDD VSS AOI21_X1
XI1712_I165_XG I1712_P14_7 I1712_G6_0 I1712_G14_7 I1712_G14_0n VDD VSS AOI21_X1
XI1712_I166_XG I1712_P15_8 I1712_G7_0 I1712_G15_8 I1712_G15_0n VDD VSS AOI21_X1
XI1712_I167_XG I1712_P16_9 I1712_G8_1 I1712_G16_9 I1712_G16_1n VDD VSS AOI21_X1
XI1712_I167_XP I1712_P16_9 I1712_P8_1 I1712_P16_1n VDD VSS NAND2_X1
XI1712_I168_XG I1712_P17_10 I1712_G9_2 I1712_G17_10 I1712_G17_2n VDD VSS AOI21_X1
XI1712_I168_XP I1712_P17_10 I1712_P9_2 I1712_P17_2n VDD VSS NAND2_X1
XI1712_I169_XG I1712_P18_11 I1712_G10_3 I1712_G18_11 I1712_G18_3n VDD VSS AOI21_X1
XI1712_I169_XP I1712_P18_11 I1712_P10_3 I1712_P18_3n VDD VSS NAND2_X1
XI1712_I170_XG I1712_P19_12 I1712_G11_4 I1712_G19_12 I1712_G19_4n VDD VSS AOI21_X1
XI1712_I170_XP I1712_P19_12 I1712_P11_4 I1712_P19_4n VDD VSS NAND2_X1
XI1712_I171_XG I1712_P20_13 I1712_G12_5 I1712_G20_13 I1712_G20_5n VDD VSS AOI21_X1
XI1712_I171_XP I1712_P20_13 I1712_P12_5 I1712_P20_5n VDD VSS NAND2_X1
XI1712_I172_XG I1712_P21_14 I1712_G13_6 I1712_G21_14 I1712_G21_6n VDD VSS AOI21_X1
XI1712_I172_XP I1712_P21_14 I1712_P13_6 I1712_P21_6n VDD VSS NAND2_X1
XI1712_I173_XG I1712_P22_15 I1712_G14_7 I1712_G22_15 I1712_G22_7n VDD VSS AOI21_X1
XI1712_I173_XP I1712_P22_15 I1712_P14_7 I1712_P22_7n VDD VSS NAND2_X1
XI1712_I174_XG I1712_P23_16 I1712_G15_8 I1712_G23_16 I1712_G23_8n VDD VSS AOI21_X1
XI1712_I174_XP I1712_P23_16 I1712_P15_8 I1712_P23_8n VDD VSS NAND2_X1
XI1712_I175_XG I1712_P24_17 I1712_G16_9 I1712_G24_17 I1712_G24_9n VDD VSS AOI21_X1
XI1712_I175_XP I1712_P24_17 I1712_P16_9 I1712_P24_9n VDD VSS NAND2_X1
XI1712_I176_XG I1712_P25_18 I1712_G17_10 I1712_G25_18 I1712_G25_10n VDD VSS AOI21_X1
XI1712_I176_XP I1712_P25_18 I1712_P17_10 I1712_P25_10n VDD VSS NAND2_X1
XI1712_I177_XG I1712_P26_19 I1712_G18_11 I1712_G26_19 I1712_G26_11n VDD VSS AOI21_X1
XI1712_I177_XP I1712_P26_19 I1712_P18_11 I1712_P26_11n VDD VSS NAND2_X1
XI1712_I178_XG I1712_P27_20 I1712_G19_12 I1712_G27_20 I1712_G27_12n VDD VSS AOI21_X1
XI1712_I178_XP I1712_P27_20 I1712_P19_12 I1712_P27_12n VDD VSS NAND2_X1
XI1712_I179_XG I1712_P28_21 I1712_G20_13 I1712_G28_21 I1712_G28_13n VDD VSS AOI21_X1
XI1712_I179_XP I1712_P28_21 I1712_P20_13 I1712_P28_13n VDD VSS NAND2_X1
XI1712_I180_XG I1712_P29_22 I1712_G21_14 I1712_G29_22 I1712_G29_14n VDD VSS AOI21_X1
XI1712_I180_XP I1712_P29_22 I1712_P21_14 I1712_P29_14n VDD VSS NAND2_X1
XI1712_I181_XG I1712_P30_23 I1712_G22_15 I1712_G30_23 I1712_G30_15n VDD VSS AOI21_X1
XI1712_I181_XP I1712_P30_23 I1712_P22_15 I1712_P30_15n VDD VSS NAND2_X1
XI1712_I182_XG I1712_P31_24 I1712_G23_16 I1712_G31_24 I1712_G31_16n VDD VSS AOI21_X1
XI1712_I182_XP I1712_P31_24 I1712_P23_16 I1712_P31_16n VDD VSS NAND2_X1
XI1712_I183_XG I1712_P16_1n I1712_G0_0n I1712_G16_1n I1712_G16_0 VDD VSS OAI21_X1
XI1712_I184_XG I1712_P17_2n I1712_G1_0n I1712_G17_2n I1712_G17_0 VDD VSS OAI21_X1
XI1712_I185_XG I1712_P18_3n I1712_G2_0n I1712_G18_3n I1712_G18_0 VDD VSS OAI21_X1
XI1712_I186_XG I1712_P19_4n I1712_G3_0n I1712_G19_4n I1712_G19_0 VDD VSS OAI21_X1
XI1712_I187 I1712_G4_0 I1712_G4_0n VDD VSS INV_X1
XI1712_I188_XG I1712_P20_5n I1712_G4_0n I1712_G20_5n I1712_G20_0 VDD VSS OAI21_X1
XI1712_I189 I1712_G5_0 I1712_G5_0n VDD VSS INV_X1
XI1712_I190_XG I1712_P21_6n I1712_G5_0n I1712_G21_6n I1712_G21_0 VDD VSS OAI21_X1
XI1712_I191 I1712_G6_0 I1712_G6_0n VDD VSS INV_X1
XI1712_I192_XG I1712_P22_7n I1712_G6_0n I1712_G22_7n I1712_G22_0 VDD VSS OAI21_X1
XI1712_I193 I1712_G7_0 I1712_G7_0n VDD VSS INV_X1
XI1712_I194_XG I1712_P23_8n I1712_G7_0n I1712_G23_8n I1712_G23_0 VDD VSS OAI21_X1
XI1712_I195_XG I1712_P24_9n I1712_G8_0n I1712_G24_9n I1712_G24_0 VDD VSS OAI21_X1
XI1712_I196_XG I1712_P25_10n I1712_G9_0n I1712_G25_10n I1712_G25_0 VDD VSS OAI21_X1
XI1712_I197_XG I1712_P26_11n I1712_G10_0n I1712_G26_11n I1712_G26_0 VDD VSS OAI21_X1
XI1712_I198_XG I1712_P27_12n I1712_G11_0n I1712_G27_12n I1712_G27_0 VDD VSS OAI21_X1
XI1712_I199_XG I1712_P28_13n I1712_G12_0n I1712_G28_13n I1712_G28_0 VDD VSS OAI21_X1
XI1712_I200_XG I1712_P29_14n I1712_G13_0n I1712_G29_14n I1712_G29_0 VDD VSS OAI21_X1
XI1712_I201_XG I1712_P30_15n I1712_G14_0n I1712_G30_15n c25_m VDD VSS OAI21_X1
XI1712_I202_XG I1712_P31_16n I1712_G15_0n I1712_G31_16n c25_o VDD VSS OAI21_X1
XI1712_I203 I1712_pn0 qu7_b3_5 p25_0 VDD VSS XNOR2_X1
XI1712_I204 I1712_pn1 I1712_G0_0 p25_1 VDD VSS XNOR2_X1
XI1712_I205 I1712_pn2 I1712_G1_0 p25_2 VDD VSS XNOR2_X1
XI1712_I206 I1712_pn3 I1712_G2_0n p25_3 VDD VSS XOR2_X1
XI1712_I207 I1712_pn4 I1712_G3_0n p25_4 VDD VSS XOR2_X1
XI1712_I208 I1712_pn5 I1712_G4_0 p25_5 VDD VSS XNOR2_X1
XI1712_I209 I1712_pn6 I1712_G5_0 p25_6 VDD VSS XNOR2_X1
XI1712_I210 I1712_pn7 I1712_G6_0 p25_7 VDD VSS XNOR2_X1
XI1712_I211 I1712_pn8 I1712_G7_0 p25_8 VDD VSS XNOR2_X1
XI1712_I212 I1712_pn9 I1712_G8_0n p25_9 VDD VSS XOR2_X1
XI1712_I213 I1712_pn10 I1712_G9_0n p25_10 VDD VSS XOR2_X1
XI1712_I214 I1712_pn11 I1712_G10_0n p25_11 VDD VSS XOR2_X1
XI1712_I215 I1712_pn12 I1712_G11_0n p25_12 VDD VSS XOR2_X1
XI1712_I216 I1712_pn13 I1712_G12_0n p25_13 VDD VSS XOR2_X1
XI1712_I217 I1712_pn14 I1712_G13_0n p25_14 VDD VSS XOR2_X1
XI1712_I218 I1712_pn15 I1712_G14_0n p25_15 VDD VSS XOR2_X1
XI1712_I219 I1712_pn16 I1712_G15_0n p25_16 VDD VSS XOR2_X1
XI1712_I220 I1712_pn17 I1712_G16_0 p25_17 VDD VSS XNOR2_X1
XI1712_I221 I1712_pn18 I1712_G17_0 p25_18 VDD VSS XNOR2_X1
XI1712_I222 I1712_pn19 I1712_G18_0 p25_19 VDD VSS XNOR2_X1
XI1712_I223 I1712_pn20 I1712_G19_0 p25_20 VDD VSS XNOR2_X1
XI1712_I224 I1712_pn21 I1712_G20_0 p25_21 VDD VSS XNOR2_X1
XI1712_I225 I1712_pn22 I1712_G21_0 p25_22 VDD VSS XNOR2_X1
XI1712_I226 I1712_pn23 I1712_G22_0 p25_23 VDD VSS XNOR2_X1
XI1712_I227 I1712_pn24 I1712_G23_0 p25_24 VDD VSS XNOR2_X1
XI1712_I228 I1712_pn25 I1712_G24_0 p25_25 VDD VSS XNOR2_X1
XI1712_I229 I1712_pn26 I1712_G25_0 p25_26 VDD VSS XNOR2_X1
XI1712_I230 I1712_pn27 I1712_G26_0 p25_27 VDD VSS XNOR2_X1
XI1712_I231 I1712_pn28 I1712_G27_0 p25_28 VDD VSS XNOR2_X1
XI1712_I232 I1712_pn29 I1712_G28_0 p25_29 VDD VSS XNOR2_X1
XI1712_I233 I1712_pn30 I1712_G29_0 p25_30 VDD VSS XNOR2_X1
XI1712_I234 I1712_pn31 c25_m p25_31 VDD VSS XNOR2_X1
XI1713 p24_31 qu7_b3_5 h25 VDD VSS XOR2_X1
XI1714 h25 c25_o p25_32 VDD VSS XOR2_X1
XI1715 p25_32 qu6 VDD VSS INV_X4
XI1716 qu6 qu6_b0 VDD VSS INV_X1
XI1717 qu6_b0 qu6_b1_0 VDD VSS INV_X4
XI1718 qu6_b1_0 qu6_b2_0 VDD VSS INV_X4
XI1719 qu6_b1_0 qu6_b2_1 VDD VSS INV_X4
XI1720 qu6_b2_0 qu6_b3_0 VDD VSS INV_X4
XI1721 qu6_b2_0 qu6_b3_1 VDD VSS INV_X4
XI1722 qu6_b2_0 qu6_b3_2 VDD VSS INV_X4
XI1723 qu6_b2_1 qu6_b3_3 VDD VSS INV_X4
XI1724 qu6_b2_1 qu6_b3_4 VDD VSS INV_X4
XI1725 qu6_b2_1 qu6_b3_5 VDD VSS INV_X4
XI1726 B_0_b3_4 qu6_b3_0 b26_0 VDD VSS XOR2_X1
XI1727 dd1_b3_4 qu6_b3_0 b26_1 VDD VSS XOR2_X1
XI1728 dd2_b3_4 qu6_b3_0 b26_2 VDD VSS XOR2_X1
XI1729 dd3_b3_4 qu6_b3_0 b26_3 VDD VSS XOR2_X1
XI1730 dd4_b3_4 qu6_b3_0 b26_4 VDD VSS XOR2_X1
XI1731 dd5_b3_4 qu6_b3_0 b26_5 VDD VSS XOR2_X1
XI1732 dd6_b3_4 qu6_b3_1 b26_6 VDD VSS XOR2_X1
XI1733 dd7_b3_4 qu6_b3_1 b26_7 VDD VSS XOR2_X1
XI1734 dd8_b3_4 qu6_b3_1 b26_8 VDD VSS XOR2_X1
XI1735 dd9_b3_4 qu6_b3_1 b26_9 VDD VSS XOR2_X1
XI1736 dd10_b3_4 qu6_b3_1 b26_10 VDD VSS XOR2_X1
XI1737 dd11_b3_4 qu6_b3_1 b26_11 VDD VSS XOR2_X1
XI1738 dd12_b3_4 qu6_b3_2 b26_12 VDD VSS XOR2_X1
XI1739 dd13_b3_4 qu6_b3_2 b26_13 VDD VSS XOR2_X1
XI1740 dd14_b3_4 qu6_b3_2 b26_14 VDD VSS XOR2_X1
XI1741 dd15_b3_4 qu6_b3_2 b26_15 VDD VSS XOR2_X1
XI1742 dd16_b3_4 qu6_b3_2 b26_16 VDD VSS XOR2_X1
XI1743 dd17_b3_4 qu6_b3_2 b26_17 VDD VSS XOR2_X1
XI1744 dd18_b3_4 qu6_b3_3 b26_18 VDD VSS XOR2_X1
XI1745 dd19_b3_4 qu6_b3_3 b26_19 VDD VSS XOR2_X1
XI1746 dd20_b3_4 qu6_b3_3 b26_20 VDD VSS XOR2_X1
XI1747 dd21_b3_4 qu6_b3_3 b26_21 VDD VSS XOR2_X1
XI1748 dd22_b3_4 qu6_b3_3 b26_22 VDD VSS XOR2_X1
XI1749 dd23_b3_4 qu6_b3_3 b26_23 VDD VSS XOR2_X1
XI1750 dd24_b3_4 qu6_b3_4 b26_24 VDD VSS XOR2_X1
XI1751 dd25_b3_4 qu6_b3_4 b26_25 VDD VSS XOR2_X1
XI1752 dd26_b3_4 qu6_b3_4 b26_26 VDD VSS XOR2_X1
XI1753 dd27_b3_4 qu6_b3_4 b26_27 VDD VSS XOR2_X1
XI1754 dd28_b3_4 qu6_b3_4 b26_28 VDD VSS XOR2_X1
XI1755 dd29_b3_4 qu6_b3_4 b26_29 VDD VSS XOR2_X1
XI1756 dd30_b3_4 qu6_b3_5 b26_30 VDD VSS XOR2_X1
XI1757 dd31_b3_4 qu6_b3_5 b26_31 VDD VSS XOR2_X1
XI1758_I0 aa5 b26_0 I1758_gn0 VDD VSS NAND2_X1
XI1758_I1 p25_0 b26_1 I1758_gn1 VDD VSS NAND2_X1
XI1758_I2 p25_1 b26_2 I1758_gn2 VDD VSS NAND2_X1
XI1758_I3 p25_2 b26_3 I1758_gn3 VDD VSS NAND2_X1
XI1758_I4 p25_3 b26_4 I1758_gn4 VDD VSS NAND2_X1
XI1758_I5 p25_4 b26_5 I1758_gn5 VDD VSS NAND2_X1
XI1758_I6 p25_5 b26_6 I1758_gn6 VDD VSS NAND2_X1
XI1758_I7 p25_6 b26_7 I1758_gn7 VDD VSS NAND2_X1
XI1758_I8 p25_7 b26_8 I1758_gn8 VDD VSS NAND2_X1
XI1758_I9 p25_8 b26_9 I1758_gn9 VDD VSS NAND2_X1
XI1758_I10 p25_9 b26_10 I1758_gn10 VDD VSS NAND2_X1
XI1758_I11 p25_10 b26_11 I1758_gn11 VDD VSS NAND2_X1
XI1758_I12 p25_11 b26_12 I1758_gn12 VDD VSS NAND2_X1
XI1758_I13 p25_12 b26_13 I1758_gn13 VDD VSS NAND2_X1
XI1758_I14 p25_13 b26_14 I1758_gn14 VDD VSS NAND2_X1
XI1758_I15 p25_14 b26_15 I1758_gn15 VDD VSS NAND2_X1
XI1758_I16 p25_15 b26_16 I1758_gn16 VDD VSS NAND2_X1
XI1758_I17 p25_16 b26_17 I1758_gn17 VDD VSS NAND2_X1
XI1758_I18 p25_17 b26_18 I1758_gn18 VDD VSS NAND2_X1
XI1758_I19 p25_18 b26_19 I1758_gn19 VDD VSS NAND2_X1
XI1758_I20 p25_19 b26_20 I1758_gn20 VDD VSS NAND2_X1
XI1758_I21 p25_20 b26_21 I1758_gn21 VDD VSS NAND2_X1
XI1758_I22 p25_21 b26_22 I1758_gn22 VDD VSS NAND2_X1
XI1758_I23 p25_22 b26_23 I1758_gn23 VDD VSS NAND2_X1
XI1758_I24 p25_23 b26_24 I1758_gn24 VDD VSS NAND2_X1
XI1758_I25 p25_24 b26_25 I1758_gn25 VDD VSS NAND2_X1
XI1758_I26 p25_25 b26_26 I1758_gn26 VDD VSS NAND2_X1
XI1758_I27 p25_26 b26_27 I1758_gn27 VDD VSS NAND2_X1
XI1758_I28 p25_27 b26_28 I1758_gn28 VDD VSS NAND2_X1
XI1758_I29 p25_28 b26_29 I1758_gn29 VDD VSS NAND2_X1
XI1758_I30 p25_29 b26_30 I1758_gn30 VDD VSS NAND2_X1
XI1758_I31 p25_30 b26_31 I1758_gn31 VDD VSS NAND2_X1
XI1758_I32 aa5 b26_0 I1758_pn0 VDD VSS XNOR2_X1
XI1758_I33 p25_0 b26_1 I1758_pn1 VDD VSS XNOR2_X1
XI1758_I34 p25_1 b26_2 I1758_pn2 VDD VSS XNOR2_X1
XI1758_I35 p25_2 b26_3 I1758_pn3 VDD VSS XNOR2_X1
XI1758_I36 p25_3 b26_4 I1758_pn4 VDD VSS XNOR2_X1
XI1758_I37 p25_4 b26_5 I1758_pn5 VDD VSS XNOR2_X1
XI1758_I38 p25_5 b26_6 I1758_pn6 VDD VSS XNOR2_X1
XI1758_I39 p25_6 b26_7 I1758_pn7 VDD VSS XNOR2_X1
XI1758_I40 p25_7 b26_8 I1758_pn8 VDD VSS XNOR2_X1
XI1758_I41 p25_8 b26_9 I1758_pn9 VDD VSS XNOR2_X1
XI1758_I42 p25_9 b26_10 I1758_pn10 VDD VSS XNOR2_X1
XI1758_I43 p25_10 b26_11 I1758_pn11 VDD VSS XNOR2_X1
XI1758_I44 p25_11 b26_12 I1758_pn12 VDD VSS XNOR2_X1
XI1758_I45 p25_12 b26_13 I1758_pn13 VDD VSS XNOR2_X1
XI1758_I46 p25_13 b26_14 I1758_pn14 VDD VSS XNOR2_X1
XI1758_I47 p25_14 b26_15 I1758_pn15 VDD VSS XNOR2_X1
XI1758_I48 p25_15 b26_16 I1758_pn16 VDD VSS XNOR2_X1
XI1758_I49 p25_16 b26_17 I1758_pn17 VDD VSS XNOR2_X1
XI1758_I50 p25_17 b26_18 I1758_pn18 VDD VSS XNOR2_X1
XI1758_I51 p25_18 b26_19 I1758_pn19 VDD VSS XNOR2_X1
XI1758_I52 p25_19 b26_20 I1758_pn20 VDD VSS XNOR2_X1
XI1758_I53 p25_20 b26_21 I1758_pn21 VDD VSS XNOR2_X1
XI1758_I54 p25_21 b26_22 I1758_pn22 VDD VSS XNOR2_X1
XI1758_I55 p25_22 b26_23 I1758_pn23 VDD VSS XNOR2_X1
XI1758_I56 p25_23 b26_24 I1758_pn24 VDD VSS XNOR2_X1
XI1758_I57 p25_24 b26_25 I1758_pn25 VDD VSS XNOR2_X1
XI1758_I58 p25_25 b26_26 I1758_pn26 VDD VSS XNOR2_X1
XI1758_I59 p25_26 b26_27 I1758_pn27 VDD VSS XNOR2_X1
XI1758_I60 p25_27 b26_28 I1758_pn28 VDD VSS XNOR2_X1
XI1758_I61 p25_28 b26_29 I1758_pn29 VDD VSS XNOR2_X1
XI1758_I62 p25_29 b26_30 I1758_pn30 VDD VSS XNOR2_X1
XI1758_I63 p25_30 b26_31 I1758_pn31 VDD VSS XNOR2_X1
XI1758_I64 qu6_b3_5 I1758_cinn VDD VSS INV_X1
XI1758_I65_XG I1758_pn0 I1758_cinn I1758_gn0 I1758_G0_0 VDD VSS OAI21_X1
XI1758_I66 I1758_G0_0 I1758_G0_0n VDD VSS INV_X1
XI1758_I67_XG I1758_pn1 I1758_G0_0n I1758_gn1 I1758_G1_0 VDD VSS OAI21_X1
XI1758_I68_XG I1758_pn2 I1758_gn1 I1758_gn2 I1758_G2_1 VDD VSS OAI21_X1
XI1758_I68_XP I1758_pn2 I1758_pn1 I1758_P2_1 VDD VSS NOR2_X1
XI1758_I69_XG I1758_pn3 I1758_gn2 I1758_gn3 I1758_G3_2 VDD VSS OAI21_X1
XI1758_I69_XP I1758_pn3 I1758_pn2 I1758_P3_2 VDD VSS NOR2_X1
XI1758_I70_XG I1758_pn4 I1758_gn3 I1758_gn4 I1758_G4_3 VDD VSS OAI21_X1
XI1758_I70_XP I1758_pn4 I1758_pn3 I1758_P4_3 VDD VSS NOR2_X1
XI1758_I71_XG I1758_pn5 I1758_gn4 I1758_gn5 I1758_G5_4 VDD VSS OAI21_X1
XI1758_I71_XP I1758_pn5 I1758_pn4 I1758_P5_4 VDD VSS NOR2_X1
XI1758_I72_XG I1758_pn6 I1758_gn5 I1758_gn6 I1758_G6_5 VDD VSS OAI21_X1
XI1758_I72_XP I1758_pn6 I1758_pn5 I1758_P6_5 VDD VSS NOR2_X1
XI1758_I73_XG I1758_pn7 I1758_gn6 I1758_gn7 I1758_G7_6 VDD VSS OAI21_X1
XI1758_I73_XP I1758_pn7 I1758_pn6 I1758_P7_6 VDD VSS NOR2_X1
XI1758_I74_XG I1758_pn8 I1758_gn7 I1758_gn8 I1758_G8_7 VDD VSS OAI21_X1
XI1758_I74_XP I1758_pn8 I1758_pn7 I1758_P8_7 VDD VSS NOR2_X1
XI1758_I75_XG I1758_pn9 I1758_gn8 I1758_gn9 I1758_G9_8 VDD VSS OAI21_X1
XI1758_I75_XP I1758_pn9 I1758_pn8 I1758_P9_8 VDD VSS NOR2_X1
XI1758_I76_XG I1758_pn10 I1758_gn9 I1758_gn10 I1758_G10_9 VDD VSS OAI21_X1
XI1758_I76_XP I1758_pn10 I1758_pn9 I1758_P10_9 VDD VSS NOR2_X1
XI1758_I77_XG I1758_pn11 I1758_gn10 I1758_gn11 I1758_G11_10 VDD VSS OAI21_X1
XI1758_I77_XP I1758_pn11 I1758_pn10 I1758_P11_10 VDD VSS NOR2_X1
XI1758_I78_XG I1758_pn12 I1758_gn11 I1758_gn12 I1758_G12_11 VDD VSS OAI21_X1
XI1758_I78_XP I1758_pn12 I1758_pn11 I1758_P12_11 VDD VSS NOR2_X1
XI1758_I79_XG I1758_pn13 I1758_gn12 I1758_gn13 I1758_G13_12 VDD VSS OAI21_X1
XI1758_I79_XP I1758_pn13 I1758_pn12 I1758_P13_12 VDD VSS NOR2_X1
XI1758_I80_XG I1758_pn14 I1758_gn13 I1758_gn14 I1758_G14_13 VDD VSS OAI21_X1
XI1758_I80_XP I1758_pn14 I1758_pn13 I1758_P14_13 VDD VSS NOR2_X1
XI1758_I81_XG I1758_pn15 I1758_gn14 I1758_gn15 I1758_G15_14 VDD VSS OAI21_X1
XI1758_I81_XP I1758_pn15 I1758_pn14 I1758_P15_14 VDD VSS NOR2_X1
XI1758_I82_XG I1758_pn16 I1758_gn15 I1758_gn16 I1758_G16_15 VDD VSS OAI21_X1
XI1758_I82_XP I1758_pn16 I1758_pn15 I1758_P16_15 VDD VSS NOR2_X1
XI1758_I83_XG I1758_pn17 I1758_gn16 I1758_gn17 I1758_G17_16 VDD VSS OAI21_X1
XI1758_I83_XP I1758_pn17 I1758_pn16 I1758_P17_16 VDD VSS NOR2_X1
XI1758_I84_XG I1758_pn18 I1758_gn17 I1758_gn18 I1758_G18_17 VDD VSS OAI21_X1
XI1758_I84_XP I1758_pn18 I1758_pn17 I1758_P18_17 VDD VSS NOR2_X1
XI1758_I85_XG I1758_pn19 I1758_gn18 I1758_gn19 I1758_G19_18 VDD VSS OAI21_X1
XI1758_I85_XP I1758_pn19 I1758_pn18 I1758_P19_18 VDD VSS NOR2_X1
XI1758_I86_XG I1758_pn20 I1758_gn19 I1758_gn20 I1758_G20_19 VDD VSS OAI21_X1
XI1758_I86_XP I1758_pn20 I1758_pn19 I1758_P20_19 VDD VSS NOR2_X1
XI1758_I87_XG I1758_pn21 I1758_gn20 I1758_gn21 I1758_G21_20 VDD VSS OAI21_X1
XI1758_I87_XP I1758_pn21 I1758_pn20 I1758_P21_20 VDD VSS NOR2_X1
XI1758_I88_XG I1758_pn22 I1758_gn21 I1758_gn22 I1758_G22_21 VDD VSS OAI21_X1
XI1758_I88_XP I1758_pn22 I1758_pn21 I1758_P22_21 VDD VSS NOR2_X1
XI1758_I89_XG I1758_pn23 I1758_gn22 I1758_gn23 I1758_G23_22 VDD VSS OAI21_X1
XI1758_I89_XP I1758_pn23 I1758_pn22 I1758_P23_22 VDD VSS NOR2_X1
XI1758_I90_XG I1758_pn24 I1758_gn23 I1758_gn24 I1758_G24_23 VDD VSS OAI21_X1
XI1758_I90_XP I1758_pn24 I1758_pn23 I1758_P24_23 VDD VSS NOR2_X1
XI1758_I91_XG I1758_pn25 I1758_gn24 I1758_gn25 I1758_G25_24 VDD VSS OAI21_X1
XI1758_I91_XP I1758_pn25 I1758_pn24 I1758_P25_24 VDD VSS NOR2_X1
XI1758_I92_XG I1758_pn26 I1758_gn25 I1758_gn26 I1758_G26_25 VDD VSS OAI21_X1
XI1758_I92_XP I1758_pn26 I1758_pn25 I1758_P26_25 VDD VSS NOR2_X1
XI1758_I93_XG I1758_pn27 I1758_gn26 I1758_gn27 I1758_G27_26 VDD VSS OAI21_X1
XI1758_I93_XP I1758_pn27 I1758_pn26 I1758_P27_26 VDD VSS NOR2_X1
XI1758_I94_XG I1758_pn28 I1758_gn27 I1758_gn28 I1758_G28_27 VDD VSS OAI21_X1
XI1758_I94_XP I1758_pn28 I1758_pn27 I1758_P28_27 VDD VSS NOR2_X1
XI1758_I95_XG I1758_pn29 I1758_gn28 I1758_gn29 I1758_G29_28 VDD VSS OAI21_X1
XI1758_I95_XP I1758_pn29 I1758_pn28 I1758_P29_28 VDD VSS NOR2_X1
XI1758_I96_XG I1758_pn30 I1758_gn29 I1758_gn30 I1758_G30_29 VDD VSS OAI21_X1
XI1758_I96_XP I1758_pn30 I1758_pn29 I1758_P30_29 VDD VSS NOR2_X1
XI1758_I97_XG I1758_pn31 I1758_gn30 I1758_gn31 I1758_G31_30 VDD VSS OAI21_X1
XI1758_I97_XP I1758_pn31 I1758_pn30 I1758_P31_30 VDD VSS NOR2_X1
XI1758_I98_XG I1758_P2_1 I1758_G0_0 I1758_G2_1 I1758_G2_0n VDD VSS AOI21_X1
XI1758_I99_XG I1758_P3_2 I1758_G1_0 I1758_G3_2 I1758_G3_0n VDD VSS AOI21_X1
XI1758_I100_XG I1758_P4_3 I1758_G2_1 I1758_G4_3 I1758_G4_1n VDD VSS AOI21_X1
XI1758_I100_XP I1758_P4_3 I1758_P2_1 I1758_P4_1n VDD VSS NAND2_X1
XI1758_I101_XG I1758_P5_4 I1758_G3_2 I1758_G5_4 I1758_G5_2n VDD VSS AOI21_X1
XI1758_I101_XP I1758_P5_4 I1758_P3_2 I1758_P5_2n VDD VSS NAND2_X1
XI1758_I102_XG I1758_P6_5 I1758_G4_3 I1758_G6_5 I1758_G6_3n VDD VSS AOI21_X1
XI1758_I102_XP I1758_P6_5 I1758_P4_3 I1758_P6_3n VDD VSS NAND2_X1
XI1758_I103_XG I1758_P7_6 I1758_G5_4 I1758_G7_6 I1758_G7_4n VDD VSS AOI21_X1
XI1758_I103_XP I1758_P7_6 I1758_P5_4 I1758_P7_4n VDD VSS NAND2_X1
XI1758_I104_XG I1758_P8_7 I1758_G6_5 I1758_G8_7 I1758_G8_5n VDD VSS AOI21_X1
XI1758_I104_XP I1758_P8_7 I1758_P6_5 I1758_P8_5n VDD VSS NAND2_X1
XI1758_I105_XG I1758_P9_8 I1758_G7_6 I1758_G9_8 I1758_G9_6n VDD VSS AOI21_X1
XI1758_I105_XP I1758_P9_8 I1758_P7_6 I1758_P9_6n VDD VSS NAND2_X1
XI1758_I106_XG I1758_P10_9 I1758_G8_7 I1758_G10_9 I1758_G10_7n VDD VSS AOI21_X1
XI1758_I106_XP I1758_P10_9 I1758_P8_7 I1758_P10_7n VDD VSS NAND2_X1
XI1758_I107_XG I1758_P11_10 I1758_G9_8 I1758_G11_10 I1758_G11_8n VDD VSS AOI21_X1
XI1758_I107_XP I1758_P11_10 I1758_P9_8 I1758_P11_8n VDD VSS NAND2_X1
XI1758_I108_XG I1758_P12_11 I1758_G10_9 I1758_G12_11 I1758_G12_9n VDD VSS AOI21_X1
XI1758_I108_XP I1758_P12_11 I1758_P10_9 I1758_P12_9n VDD VSS NAND2_X1
XI1758_I109_XG I1758_P13_12 I1758_G11_10 I1758_G13_12 I1758_G13_10n VDD VSS AOI21_X1
XI1758_I109_XP I1758_P13_12 I1758_P11_10 I1758_P13_10n VDD VSS NAND2_X1
XI1758_I110_XG I1758_P14_13 I1758_G12_11 I1758_G14_13 I1758_G14_11n VDD VSS AOI21_X1
XI1758_I110_XP I1758_P14_13 I1758_P12_11 I1758_P14_11n VDD VSS NAND2_X1
XI1758_I111_XG I1758_P15_14 I1758_G13_12 I1758_G15_14 I1758_G15_12n VDD VSS AOI21_X1
XI1758_I111_XP I1758_P15_14 I1758_P13_12 I1758_P15_12n VDD VSS NAND2_X1
XI1758_I112_XG I1758_P16_15 I1758_G14_13 I1758_G16_15 I1758_G16_13n VDD VSS AOI21_X1
XI1758_I112_XP I1758_P16_15 I1758_P14_13 I1758_P16_13n VDD VSS NAND2_X1
XI1758_I113_XG I1758_P17_16 I1758_G15_14 I1758_G17_16 I1758_G17_14n VDD VSS AOI21_X1
XI1758_I113_XP I1758_P17_16 I1758_P15_14 I1758_P17_14n VDD VSS NAND2_X1
XI1758_I114_XG I1758_P18_17 I1758_G16_15 I1758_G18_17 I1758_G18_15n VDD VSS AOI21_X1
XI1758_I114_XP I1758_P18_17 I1758_P16_15 I1758_P18_15n VDD VSS NAND2_X1
XI1758_I115_XG I1758_P19_18 I1758_G17_16 I1758_G19_18 I1758_G19_16n VDD VSS AOI21_X1
XI1758_I115_XP I1758_P19_18 I1758_P17_16 I1758_P19_16n VDD VSS NAND2_X1
XI1758_I116_XG I1758_P20_19 I1758_G18_17 I1758_G20_19 I1758_G20_17n VDD VSS AOI21_X1
XI1758_I116_XP I1758_P20_19 I1758_P18_17 I1758_P20_17n VDD VSS NAND2_X1
XI1758_I117_XG I1758_P21_20 I1758_G19_18 I1758_G21_20 I1758_G21_18n VDD VSS AOI21_X1
XI1758_I117_XP I1758_P21_20 I1758_P19_18 I1758_P21_18n VDD VSS NAND2_X1
XI1758_I118_XG I1758_P22_21 I1758_G20_19 I1758_G22_21 I1758_G22_19n VDD VSS AOI21_X1
XI1758_I118_XP I1758_P22_21 I1758_P20_19 I1758_P22_19n VDD VSS NAND2_X1
XI1758_I119_XG I1758_P23_22 I1758_G21_20 I1758_G23_22 I1758_G23_20n VDD VSS AOI21_X1
XI1758_I119_XP I1758_P23_22 I1758_P21_20 I1758_P23_20n VDD VSS NAND2_X1
XI1758_I120_XG I1758_P24_23 I1758_G22_21 I1758_G24_23 I1758_G24_21n VDD VSS AOI21_X1
XI1758_I120_XP I1758_P24_23 I1758_P22_21 I1758_P24_21n VDD VSS NAND2_X1
XI1758_I121_XG I1758_P25_24 I1758_G23_22 I1758_G25_24 I1758_G25_22n VDD VSS AOI21_X1
XI1758_I121_XP I1758_P25_24 I1758_P23_22 I1758_P25_22n VDD VSS NAND2_X1
XI1758_I122_XG I1758_P26_25 I1758_G24_23 I1758_G26_25 I1758_G26_23n VDD VSS AOI21_X1
XI1758_I122_XP I1758_P26_25 I1758_P24_23 I1758_P26_23n VDD VSS NAND2_X1
XI1758_I123_XG I1758_P27_26 I1758_G25_24 I1758_G27_26 I1758_G27_24n VDD VSS AOI21_X1
XI1758_I123_XP I1758_P27_26 I1758_P25_24 I1758_P27_24n VDD VSS NAND2_X1
XI1758_I124_XG I1758_P28_27 I1758_G26_25 I1758_G28_27 I1758_G28_25n VDD VSS AOI21_X1
XI1758_I124_XP I1758_P28_27 I1758_P26_25 I1758_P28_25n VDD VSS NAND2_X1
XI1758_I125_XG I1758_P29_28 I1758_G27_26 I1758_G29_28 I1758_G29_26n VDD VSS AOI21_X1
XI1758_I125_XP I1758_P29_28 I1758_P27_26 I1758_P29_26n VDD VSS NAND2_X1
XI1758_I126_XG I1758_P30_29 I1758_G28_27 I1758_G30_29 I1758_G30_27n VDD VSS AOI21_X1
XI1758_I126_XP I1758_P30_29 I1758_P28_27 I1758_P30_27n VDD VSS NAND2_X1
XI1758_I127_XG I1758_P31_30 I1758_G29_28 I1758_G31_30 I1758_G31_28n VDD VSS AOI21_X1
XI1758_I127_XP I1758_P31_30 I1758_P29_28 I1758_P31_28n VDD VSS NAND2_X1
XI1758_I128_XG I1758_P4_1n I1758_G0_0n I1758_G4_1n I1758_G4_0 VDD VSS OAI21_X1
XI1758_I129 I1758_G1_0 I1758_G1_0n VDD VSS INV_X1
XI1758_I130_XG I1758_P5_2n I1758_G1_0n I1758_G5_2n I1758_G5_0 VDD VSS OAI21_X1
XI1758_I131_XG I1758_P6_3n I1758_G2_0n I1758_G6_3n I1758_G6_0 VDD VSS OAI21_X1
XI1758_I132_XG I1758_P7_4n I1758_G3_0n I1758_G7_4n I1758_G7_0 VDD VSS OAI21_X1
XI1758_I133_XG I1758_P8_5n I1758_G4_1n I1758_G8_5n I1758_G8_1 VDD VSS OAI21_X1
XI1758_I133_XP I1758_P8_5n I1758_P4_1n I1758_P8_1 VDD VSS NOR2_X1
XI1758_I134_XG I1758_P9_6n I1758_G5_2n I1758_G9_6n I1758_G9_2 VDD VSS OAI21_X1
XI1758_I134_XP I1758_P9_6n I1758_P5_2n I1758_P9_2 VDD VSS NOR2_X1
XI1758_I135_XG I1758_P10_7n I1758_G6_3n I1758_G10_7n I1758_G10_3 VDD VSS OAI21_X1
XI1758_I135_XP I1758_P10_7n I1758_P6_3n I1758_P10_3 VDD VSS NOR2_X1
XI1758_I136_XG I1758_P11_8n I1758_G7_4n I1758_G11_8n I1758_G11_4 VDD VSS OAI21_X1
XI1758_I136_XP I1758_P11_8n I1758_P7_4n I1758_P11_4 VDD VSS NOR2_X1
XI1758_I137_XG I1758_P12_9n I1758_G8_5n I1758_G12_9n I1758_G12_5 VDD VSS OAI21_X1
XI1758_I137_XP I1758_P12_9n I1758_P8_5n I1758_P12_5 VDD VSS NOR2_X1
XI1758_I138_XG I1758_P13_10n I1758_G9_6n I1758_G13_10n I1758_G13_6 VDD VSS OAI21_X1
XI1758_I138_XP I1758_P13_10n I1758_P9_6n I1758_P13_6 VDD VSS NOR2_X1
XI1758_I139_XG I1758_P14_11n I1758_G10_7n I1758_G14_11n I1758_G14_7 VDD VSS OAI21_X1
XI1758_I139_XP I1758_P14_11n I1758_P10_7n I1758_P14_7 VDD VSS NOR2_X1
XI1758_I140_XG I1758_P15_12n I1758_G11_8n I1758_G15_12n I1758_G15_8 VDD VSS OAI21_X1
XI1758_I140_XP I1758_P15_12n I1758_P11_8n I1758_P15_8 VDD VSS NOR2_X1
XI1758_I141_XG I1758_P16_13n I1758_G12_9n I1758_G16_13n I1758_G16_9 VDD VSS OAI21_X1
XI1758_I141_XP I1758_P16_13n I1758_P12_9n I1758_P16_9 VDD VSS NOR2_X1
XI1758_I142_XG I1758_P17_14n I1758_G13_10n I1758_G17_14n I1758_G17_10 VDD VSS OAI21_X1
XI1758_I142_XP I1758_P17_14n I1758_P13_10n I1758_P17_10 VDD VSS NOR2_X1
XI1758_I143_XG I1758_P18_15n I1758_G14_11n I1758_G18_15n I1758_G18_11 VDD VSS OAI21_X1
XI1758_I143_XP I1758_P18_15n I1758_P14_11n I1758_P18_11 VDD VSS NOR2_X1
XI1758_I144_XG I1758_P19_16n I1758_G15_12n I1758_G19_16n I1758_G19_12 VDD VSS OAI21_X1
XI1758_I144_XP I1758_P19_16n I1758_P15_12n I1758_P19_12 VDD VSS NOR2_X1
XI1758_I145_XG I1758_P20_17n I1758_G16_13n I1758_G20_17n I1758_G20_13 VDD VSS OAI21_X1
XI1758_I145_XP I1758_P20_17n I1758_P16_13n I1758_P20_13 VDD VSS NOR2_X1
XI1758_I146_XG I1758_P21_18n I1758_G17_14n I1758_G21_18n I1758_G21_14 VDD VSS OAI21_X1
XI1758_I146_XP I1758_P21_18n I1758_P17_14n I1758_P21_14 VDD VSS NOR2_X1
XI1758_I147_XG I1758_P22_19n I1758_G18_15n I1758_G22_19n I1758_G22_15 VDD VSS OAI21_X1
XI1758_I147_XP I1758_P22_19n I1758_P18_15n I1758_P22_15 VDD VSS NOR2_X1
XI1758_I148_XG I1758_P23_20n I1758_G19_16n I1758_G23_20n I1758_G23_16 VDD VSS OAI21_X1
XI1758_I148_XP I1758_P23_20n I1758_P19_16n I1758_P23_16 VDD VSS NOR2_X1
XI1758_I149_XG I1758_P24_21n I1758_G20_17n I1758_G24_21n I1758_G24_17 VDD VSS OAI21_X1
XI1758_I149_XP I1758_P24_21n I1758_P20_17n I1758_P24_17 VDD VSS NOR2_X1
XI1758_I150_XG I1758_P25_22n I1758_G21_18n I1758_G25_22n I1758_G25_18 VDD VSS OAI21_X1
XI1758_I150_XP I1758_P25_22n I1758_P21_18n I1758_P25_18 VDD VSS NOR2_X1
XI1758_I151_XG I1758_P26_23n I1758_G22_19n I1758_G26_23n I1758_G26_19 VDD VSS OAI21_X1
XI1758_I151_XP I1758_P26_23n I1758_P22_19n I1758_P26_19 VDD VSS NOR2_X1
XI1758_I152_XG I1758_P27_24n I1758_G23_20n I1758_G27_24n I1758_G27_20 VDD VSS OAI21_X1
XI1758_I152_XP I1758_P27_24n I1758_P23_20n I1758_P27_20 VDD VSS NOR2_X1
XI1758_I153_XG I1758_P28_25n I1758_G24_21n I1758_G28_25n I1758_G28_21 VDD VSS OAI21_X1
XI1758_I153_XP I1758_P28_25n I1758_P24_21n I1758_P28_21 VDD VSS NOR2_X1
XI1758_I154_XG I1758_P29_26n I1758_G25_22n I1758_G29_26n I1758_G29_22 VDD VSS OAI21_X1
XI1758_I154_XP I1758_P29_26n I1758_P25_22n I1758_P29_22 VDD VSS NOR2_X1
XI1758_I155_XG I1758_P30_27n I1758_G26_23n I1758_G30_27n I1758_G30_23 VDD VSS OAI21_X1
XI1758_I155_XP I1758_P30_27n I1758_P26_23n I1758_P30_23 VDD VSS NOR2_X1
XI1758_I156_XG I1758_P31_28n I1758_G27_24n I1758_G31_28n I1758_G31_24 VDD VSS OAI21_X1
XI1758_I156_XP I1758_P31_28n I1758_P27_24n I1758_P31_24 VDD VSS NOR2_X1
XI1758_I157_XG I1758_P8_1 I1758_G0_0 I1758_G8_1 I1758_G8_0n VDD VSS AOI21_X1
XI1758_I158_XG I1758_P9_2 I1758_G1_0 I1758_G9_2 I1758_G9_0n VDD VSS AOI21_X1
XI1758_I159 I1758_G2_0n I1758_G2_0np VDD VSS INV_X1
XI1758_I160_XG I1758_P10_3 I1758_G2_0np I1758_G10_3 I1758_G10_0n VDD VSS AOI21_X1
XI1758_I161 I1758_G3_0n I1758_G3_0np VDD VSS INV_X1
XI1758_I162_XG I1758_P11_4 I1758_G3_0np I1758_G11_4 I1758_G11_0n VDD VSS AOI21_X1
XI1758_I163_XG I1758_P12_5 I1758_G4_0 I1758_G12_5 I1758_G12_0n VDD VSS AOI21_X1
XI1758_I164_XG I1758_P13_6 I1758_G5_0 I1758_G13_6 I1758_G13_0n VDD VSS AOI21_X1
XI1758_I165_XG I1758_P14_7 I1758_G6_0 I1758_G14_7 I1758_G14_0n VDD VSS AOI21_X1
XI1758_I166_XG I1758_P15_8 I1758_G7_0 I1758_G15_8 I1758_G15_0n VDD VSS AOI21_X1
XI1758_I167_XG I1758_P16_9 I1758_G8_1 I1758_G16_9 I1758_G16_1n VDD VSS AOI21_X1
XI1758_I167_XP I1758_P16_9 I1758_P8_1 I1758_P16_1n VDD VSS NAND2_X1
XI1758_I168_XG I1758_P17_10 I1758_G9_2 I1758_G17_10 I1758_G17_2n VDD VSS AOI21_X1
XI1758_I168_XP I1758_P17_10 I1758_P9_2 I1758_P17_2n VDD VSS NAND2_X1
XI1758_I169_XG I1758_P18_11 I1758_G10_3 I1758_G18_11 I1758_G18_3n VDD VSS AOI21_X1
XI1758_I169_XP I1758_P18_11 I1758_P10_3 I1758_P18_3n VDD VSS NAND2_X1
XI1758_I170_XG I1758_P19_12 I1758_G11_4 I1758_G19_12 I1758_G19_4n VDD VSS AOI21_X1
XI1758_I170_XP I1758_P19_12 I1758_P11_4 I1758_P19_4n VDD VSS NAND2_X1
XI1758_I171_XG I1758_P20_13 I1758_G12_5 I1758_G20_13 I1758_G20_5n VDD VSS AOI21_X1
XI1758_I171_XP I1758_P20_13 I1758_P12_5 I1758_P20_5n VDD VSS NAND2_X1
XI1758_I172_XG I1758_P21_14 I1758_G13_6 I1758_G21_14 I1758_G21_6n VDD VSS AOI21_X1
XI1758_I172_XP I1758_P21_14 I1758_P13_6 I1758_P21_6n VDD VSS NAND2_X1
XI1758_I173_XG I1758_P22_15 I1758_G14_7 I1758_G22_15 I1758_G22_7n VDD VSS AOI21_X1
XI1758_I173_XP I1758_P22_15 I1758_P14_7 I1758_P22_7n VDD VSS NAND2_X1
XI1758_I174_XG I1758_P23_16 I1758_G15_8 I1758_G23_16 I1758_G23_8n VDD VSS AOI21_X1
XI1758_I174_XP I1758_P23_16 I1758_P15_8 I1758_P23_8n VDD VSS NAND2_X1
XI1758_I175_XG I1758_P24_17 I1758_G16_9 I1758_G24_17 I1758_G24_9n VDD VSS AOI21_X1
XI1758_I175_XP I1758_P24_17 I1758_P16_9 I1758_P24_9n VDD VSS NAND2_X1
XI1758_I176_XG I1758_P25_18 I1758_G17_10 I1758_G25_18 I1758_G25_10n VDD VSS AOI21_X1
XI1758_I176_XP I1758_P25_18 I1758_P17_10 I1758_P25_10n VDD VSS NAND2_X1
XI1758_I177_XG I1758_P26_19 I1758_G18_11 I1758_G26_19 I1758_G26_11n VDD VSS AOI21_X1
XI1758_I177_XP I1758_P26_19 I1758_P18_11 I1758_P26_11n VDD VSS NAND2_X1
XI1758_I178_XG I1758_P27_20 I1758_G19_12 I1758_G27_20 I1758_G27_12n VDD VSS AOI21_X1
XI1758_I178_XP I1758_P27_20 I1758_P19_12 I1758_P27_12n VDD VSS NAND2_X1
XI1758_I179_XG I1758_P28_21 I1758_G20_13 I1758_G28_21 I1758_G28_13n VDD VSS AOI21_X1
XI1758_I179_XP I1758_P28_21 I1758_P20_13 I1758_P28_13n VDD VSS NAND2_X1
XI1758_I180_XG I1758_P29_22 I1758_G21_14 I1758_G29_22 I1758_G29_14n VDD VSS AOI21_X1
XI1758_I180_XP I1758_P29_22 I1758_P21_14 I1758_P29_14n VDD VSS NAND2_X1
XI1758_I181_XG I1758_P30_23 I1758_G22_15 I1758_G30_23 I1758_G30_15n VDD VSS AOI21_X1
XI1758_I181_XP I1758_P30_23 I1758_P22_15 I1758_P30_15n VDD VSS NAND2_X1
XI1758_I182_XG I1758_P31_24 I1758_G23_16 I1758_G31_24 I1758_G31_16n VDD VSS AOI21_X1
XI1758_I182_XP I1758_P31_24 I1758_P23_16 I1758_P31_16n VDD VSS NAND2_X1
XI1758_I183_XG I1758_P16_1n I1758_G0_0n I1758_G16_1n I1758_G16_0 VDD VSS OAI21_X1
XI1758_I184_XG I1758_P17_2n I1758_G1_0n I1758_G17_2n I1758_G17_0 VDD VSS OAI21_X1
XI1758_I185_XG I1758_P18_3n I1758_G2_0n I1758_G18_3n I1758_G18_0 VDD VSS OAI21_X1
XI1758_I186_XG I1758_P19_4n I1758_G3_0n I1758_G19_4n I1758_G19_0 VDD VSS OAI21_X1
XI1758_I187 I1758_G4_0 I1758_G4_0n VDD VSS INV_X1
XI1758_I188_XG I1758_P20_5n I1758_G4_0n I1758_G20_5n I1758_G20_0 VDD VSS OAI21_X1
XI1758_I189 I1758_G5_0 I1758_G5_0n VDD VSS INV_X1
XI1758_I190_XG I1758_P21_6n I1758_G5_0n I1758_G21_6n I1758_G21_0 VDD VSS OAI21_X1
XI1758_I191 I1758_G6_0 I1758_G6_0n VDD VSS INV_X1
XI1758_I192_XG I1758_P22_7n I1758_G6_0n I1758_G22_7n I1758_G22_0 VDD VSS OAI21_X1
XI1758_I193 I1758_G7_0 I1758_G7_0n VDD VSS INV_X1
XI1758_I194_XG I1758_P23_8n I1758_G7_0n I1758_G23_8n I1758_G23_0 VDD VSS OAI21_X1
XI1758_I195_XG I1758_P24_9n I1758_G8_0n I1758_G24_9n I1758_G24_0 VDD VSS OAI21_X1
XI1758_I196_XG I1758_P25_10n I1758_G9_0n I1758_G25_10n I1758_G25_0 VDD VSS OAI21_X1
XI1758_I197_XG I1758_P26_11n I1758_G10_0n I1758_G26_11n I1758_G26_0 VDD VSS OAI21_X1
XI1758_I198_XG I1758_P27_12n I1758_G11_0n I1758_G27_12n I1758_G27_0 VDD VSS OAI21_X1
XI1758_I199_XG I1758_P28_13n I1758_G12_0n I1758_G28_13n I1758_G28_0 VDD VSS OAI21_X1
XI1758_I200_XG I1758_P29_14n I1758_G13_0n I1758_G29_14n I1758_G29_0 VDD VSS OAI21_X1
XI1758_I201_XG I1758_P30_15n I1758_G14_0n I1758_G30_15n c26_m VDD VSS OAI21_X1
XI1758_I202_XG I1758_P31_16n I1758_G15_0n I1758_G31_16n c26_o VDD VSS OAI21_X1
XI1758_I203 I1758_pn0 qu6_b3_5 p26_0 VDD VSS XNOR2_X1
XI1758_I204 I1758_pn1 I1758_G0_0 p26_1 VDD VSS XNOR2_X1
XI1758_I205 I1758_pn2 I1758_G1_0 p26_2 VDD VSS XNOR2_X1
XI1758_I206 I1758_pn3 I1758_G2_0n p26_3 VDD VSS XOR2_X1
XI1758_I207 I1758_pn4 I1758_G3_0n p26_4 VDD VSS XOR2_X1
XI1758_I208 I1758_pn5 I1758_G4_0 p26_5 VDD VSS XNOR2_X1
XI1758_I209 I1758_pn6 I1758_G5_0 p26_6 VDD VSS XNOR2_X1
XI1758_I210 I1758_pn7 I1758_G6_0 p26_7 VDD VSS XNOR2_X1
XI1758_I211 I1758_pn8 I1758_G7_0 p26_8 VDD VSS XNOR2_X1
XI1758_I212 I1758_pn9 I1758_G8_0n p26_9 VDD VSS XOR2_X1
XI1758_I213 I1758_pn10 I1758_G9_0n p26_10 VDD VSS XOR2_X1
XI1758_I214 I1758_pn11 I1758_G10_0n p26_11 VDD VSS XOR2_X1
XI1758_I215 I1758_pn12 I1758_G11_0n p26_12 VDD VSS XOR2_X1
XI1758_I216 I1758_pn13 I1758_G12_0n p26_13 VDD VSS XOR2_X1
XI1758_I217 I1758_pn14 I1758_G13_0n p26_14 VDD VSS XOR2_X1
XI1758_I218 I1758_pn15 I1758_G14_0n p26_15 VDD VSS XOR2_X1
XI1758_I219 I1758_pn16 I1758_G15_0n p26_16 VDD VSS XOR2_X1
XI1758_I220 I1758_pn17 I1758_G16_0 p26_17 VDD VSS XNOR2_X1
XI1758_I221 I1758_pn18 I1758_G17_0 p26_18 VDD VSS XNOR2_X1
XI1758_I222 I1758_pn19 I1758_G18_0 p26_19 VDD VSS XNOR2_X1
XI1758_I223 I1758_pn20 I1758_G19_0 p26_20 VDD VSS XNOR2_X1
XI1758_I224 I1758_pn21 I1758_G20_0 p26_21 VDD VSS XNOR2_X1
XI1758_I225 I1758_pn22 I1758_G21_0 p26_22 VDD VSS XNOR2_X1
XI1758_I226 I1758_pn23 I1758_G22_0 p26_23 VDD VSS XNOR2_X1
XI1758_I227 I1758_pn24 I1758_G23_0 p26_24 VDD VSS XNOR2_X1
XI1758_I228 I1758_pn25 I1758_G24_0 p26_25 VDD VSS XNOR2_X1
XI1758_I229 I1758_pn26 I1758_G25_0 p26_26 VDD VSS XNOR2_X1
XI1758_I230 I1758_pn27 I1758_G26_0 p26_27 VDD VSS XNOR2_X1
XI1758_I231 I1758_pn28 I1758_G27_0 p26_28 VDD VSS XNOR2_X1
XI1758_I232 I1758_pn29 I1758_G28_0 p26_29 VDD VSS XNOR2_X1
XI1758_I233 I1758_pn30 I1758_G29_0 p26_30 VDD VSS XNOR2_X1
XI1758_I234 I1758_pn31 c26_m p26_31 VDD VSS XNOR2_X1
XI1759 p25_31 qu6_b3_5 h26 VDD VSS XOR2_X1
XI1760 h26 c26_o p26_32 VDD VSS XOR2_X1
XI1761 p26_32 qu5 VDD VSS INV_X4
XI1762 qu5 qu5_b0 VDD VSS INV_X1
XI1763 qu5_b0 qu5_b1_0 VDD VSS INV_X4
XI1764 qu5_b1_0 qu5_b2_0 VDD VSS INV_X4
XI1765 qu5_b1_0 qu5_b2_1 VDD VSS INV_X4
XI1766 qu5_b2_0 qu5_b3_0 VDD VSS INV_X4
XI1767 qu5_b2_0 qu5_b3_1 VDD VSS INV_X4
XI1768 qu5_b2_0 qu5_b3_2 VDD VSS INV_X4
XI1769 qu5_b2_1 qu5_b3_3 VDD VSS INV_X4
XI1770 qu5_b2_1 qu5_b3_4 VDD VSS INV_X4
XI1771 qu5_b2_1 qu5_b3_5 VDD VSS INV_X4
XI1772 B_0_b3_4 qu5_b3_0 b27_0 VDD VSS XOR2_X1
XI1773 dd1_b3_4 qu5_b3_0 b27_1 VDD VSS XOR2_X1
XI1774 dd2_b3_4 qu5_b3_0 b27_2 VDD VSS XOR2_X1
XI1775 dd3_b3_4 qu5_b3_0 b27_3 VDD VSS XOR2_X1
XI1776 dd4_b3_4 qu5_b3_0 b27_4 VDD VSS XOR2_X1
XI1777 dd5_b3_4 qu5_b3_0 b27_5 VDD VSS XOR2_X1
XI1778 dd6_b3_4 qu5_b3_1 b27_6 VDD VSS XOR2_X1
XI1779 dd7_b3_4 qu5_b3_1 b27_7 VDD VSS XOR2_X1
XI1780 dd8_b3_4 qu5_b3_1 b27_8 VDD VSS XOR2_X1
XI1781 dd9_b3_4 qu5_b3_1 b27_9 VDD VSS XOR2_X1
XI1782 dd10_b3_4 qu5_b3_1 b27_10 VDD VSS XOR2_X1
XI1783 dd11_b3_4 qu5_b3_1 b27_11 VDD VSS XOR2_X1
XI1784 dd12_b3_4 qu5_b3_2 b27_12 VDD VSS XOR2_X1
XI1785 dd13_b3_4 qu5_b3_2 b27_13 VDD VSS XOR2_X1
XI1786 dd14_b3_4 qu5_b3_2 b27_14 VDD VSS XOR2_X1
XI1787 dd15_b3_4 qu5_b3_2 b27_15 VDD VSS XOR2_X1
XI1788 dd16_b3_4 qu5_b3_2 b27_16 VDD VSS XOR2_X1
XI1789 dd17_b3_4 qu5_b3_2 b27_17 VDD VSS XOR2_X1
XI1790 dd18_b3_4 qu5_b3_3 b27_18 VDD VSS XOR2_X1
XI1791 dd19_b3_4 qu5_b3_3 b27_19 VDD VSS XOR2_X1
XI1792 dd20_b3_4 qu5_b3_3 b27_20 VDD VSS XOR2_X1
XI1793 dd21_b3_4 qu5_b3_3 b27_21 VDD VSS XOR2_X1
XI1794 dd22_b3_4 qu5_b3_3 b27_22 VDD VSS XOR2_X1
XI1795 dd23_b3_4 qu5_b3_3 b27_23 VDD VSS XOR2_X1
XI1796 dd24_b3_4 qu5_b3_4 b27_24 VDD VSS XOR2_X1
XI1797 dd25_b3_4 qu5_b3_4 b27_25 VDD VSS XOR2_X1
XI1798 dd26_b3_4 qu5_b3_4 b27_26 VDD VSS XOR2_X1
XI1799 dd27_b3_4 qu5_b3_4 b27_27 VDD VSS XOR2_X1
XI1800 dd28_b3_4 qu5_b3_4 b27_28 VDD VSS XOR2_X1
XI1801 dd29_b3_4 qu5_b3_4 b27_29 VDD VSS XOR2_X1
XI1802 dd30_b3_4 qu5_b3_5 b27_30 VDD VSS XOR2_X1
XI1803 dd31_b3_4 qu5_b3_5 b27_31 VDD VSS XOR2_X1
XI1804_I0 aa4 b27_0 I1804_gn0 VDD VSS NAND2_X1
XI1804_I1 p26_0 b27_1 I1804_gn1 VDD VSS NAND2_X1
XI1804_I2 p26_1 b27_2 I1804_gn2 VDD VSS NAND2_X1
XI1804_I3 p26_2 b27_3 I1804_gn3 VDD VSS NAND2_X1
XI1804_I4 p26_3 b27_4 I1804_gn4 VDD VSS NAND2_X1
XI1804_I5 p26_4 b27_5 I1804_gn5 VDD VSS NAND2_X1
XI1804_I6 p26_5 b27_6 I1804_gn6 VDD VSS NAND2_X1
XI1804_I7 p26_6 b27_7 I1804_gn7 VDD VSS NAND2_X1
XI1804_I8 p26_7 b27_8 I1804_gn8 VDD VSS NAND2_X1
XI1804_I9 p26_8 b27_9 I1804_gn9 VDD VSS NAND2_X1
XI1804_I10 p26_9 b27_10 I1804_gn10 VDD VSS NAND2_X1
XI1804_I11 p26_10 b27_11 I1804_gn11 VDD VSS NAND2_X1
XI1804_I12 p26_11 b27_12 I1804_gn12 VDD VSS NAND2_X1
XI1804_I13 p26_12 b27_13 I1804_gn13 VDD VSS NAND2_X1
XI1804_I14 p26_13 b27_14 I1804_gn14 VDD VSS NAND2_X1
XI1804_I15 p26_14 b27_15 I1804_gn15 VDD VSS NAND2_X1
XI1804_I16 p26_15 b27_16 I1804_gn16 VDD VSS NAND2_X1
XI1804_I17 p26_16 b27_17 I1804_gn17 VDD VSS NAND2_X1
XI1804_I18 p26_17 b27_18 I1804_gn18 VDD VSS NAND2_X1
XI1804_I19 p26_18 b27_19 I1804_gn19 VDD VSS NAND2_X1
XI1804_I20 p26_19 b27_20 I1804_gn20 VDD VSS NAND2_X1
XI1804_I21 p26_20 b27_21 I1804_gn21 VDD VSS NAND2_X1
XI1804_I22 p26_21 b27_22 I1804_gn22 VDD VSS NAND2_X1
XI1804_I23 p26_22 b27_23 I1804_gn23 VDD VSS NAND2_X1
XI1804_I24 p26_23 b27_24 I1804_gn24 VDD VSS NAND2_X1
XI1804_I25 p26_24 b27_25 I1804_gn25 VDD VSS NAND2_X1
XI1804_I26 p26_25 b27_26 I1804_gn26 VDD VSS NAND2_X1
XI1804_I27 p26_26 b27_27 I1804_gn27 VDD VSS NAND2_X1
XI1804_I28 p26_27 b27_28 I1804_gn28 VDD VSS NAND2_X1
XI1804_I29 p26_28 b27_29 I1804_gn29 VDD VSS NAND2_X1
XI1804_I30 p26_29 b27_30 I1804_gn30 VDD VSS NAND2_X1
XI1804_I31 p26_30 b27_31 I1804_gn31 VDD VSS NAND2_X1
XI1804_I32 aa4 b27_0 I1804_pn0 VDD VSS XNOR2_X1
XI1804_I33 p26_0 b27_1 I1804_pn1 VDD VSS XNOR2_X1
XI1804_I34 p26_1 b27_2 I1804_pn2 VDD VSS XNOR2_X1
XI1804_I35 p26_2 b27_3 I1804_pn3 VDD VSS XNOR2_X1
XI1804_I36 p26_3 b27_4 I1804_pn4 VDD VSS XNOR2_X1
XI1804_I37 p26_4 b27_5 I1804_pn5 VDD VSS XNOR2_X1
XI1804_I38 p26_5 b27_6 I1804_pn6 VDD VSS XNOR2_X1
XI1804_I39 p26_6 b27_7 I1804_pn7 VDD VSS XNOR2_X1
XI1804_I40 p26_7 b27_8 I1804_pn8 VDD VSS XNOR2_X1
XI1804_I41 p26_8 b27_9 I1804_pn9 VDD VSS XNOR2_X1
XI1804_I42 p26_9 b27_10 I1804_pn10 VDD VSS XNOR2_X1
XI1804_I43 p26_10 b27_11 I1804_pn11 VDD VSS XNOR2_X1
XI1804_I44 p26_11 b27_12 I1804_pn12 VDD VSS XNOR2_X1
XI1804_I45 p26_12 b27_13 I1804_pn13 VDD VSS XNOR2_X1
XI1804_I46 p26_13 b27_14 I1804_pn14 VDD VSS XNOR2_X1
XI1804_I47 p26_14 b27_15 I1804_pn15 VDD VSS XNOR2_X1
XI1804_I48 p26_15 b27_16 I1804_pn16 VDD VSS XNOR2_X1
XI1804_I49 p26_16 b27_17 I1804_pn17 VDD VSS XNOR2_X1
XI1804_I50 p26_17 b27_18 I1804_pn18 VDD VSS XNOR2_X1
XI1804_I51 p26_18 b27_19 I1804_pn19 VDD VSS XNOR2_X1
XI1804_I52 p26_19 b27_20 I1804_pn20 VDD VSS XNOR2_X1
XI1804_I53 p26_20 b27_21 I1804_pn21 VDD VSS XNOR2_X1
XI1804_I54 p26_21 b27_22 I1804_pn22 VDD VSS XNOR2_X1
XI1804_I55 p26_22 b27_23 I1804_pn23 VDD VSS XNOR2_X1
XI1804_I56 p26_23 b27_24 I1804_pn24 VDD VSS XNOR2_X1
XI1804_I57 p26_24 b27_25 I1804_pn25 VDD VSS XNOR2_X1
XI1804_I58 p26_25 b27_26 I1804_pn26 VDD VSS XNOR2_X1
XI1804_I59 p26_26 b27_27 I1804_pn27 VDD VSS XNOR2_X1
XI1804_I60 p26_27 b27_28 I1804_pn28 VDD VSS XNOR2_X1
XI1804_I61 p26_28 b27_29 I1804_pn29 VDD VSS XNOR2_X1
XI1804_I62 p26_29 b27_30 I1804_pn30 VDD VSS XNOR2_X1
XI1804_I63 p26_30 b27_31 I1804_pn31 VDD VSS XNOR2_X1
XI1804_I64 qu5_b3_5 I1804_cinn VDD VSS INV_X1
XI1804_I65_XG I1804_pn0 I1804_cinn I1804_gn0 I1804_G0_0 VDD VSS OAI21_X1
XI1804_I66 I1804_G0_0 I1804_G0_0n VDD VSS INV_X1
XI1804_I67_XG I1804_pn1 I1804_G0_0n I1804_gn1 I1804_G1_0 VDD VSS OAI21_X1
XI1804_I68_XG I1804_pn2 I1804_gn1 I1804_gn2 I1804_G2_1 VDD VSS OAI21_X1
XI1804_I68_XP I1804_pn2 I1804_pn1 I1804_P2_1 VDD VSS NOR2_X1
XI1804_I69_XG I1804_pn3 I1804_gn2 I1804_gn3 I1804_G3_2 VDD VSS OAI21_X1
XI1804_I69_XP I1804_pn3 I1804_pn2 I1804_P3_2 VDD VSS NOR2_X1
XI1804_I70_XG I1804_pn4 I1804_gn3 I1804_gn4 I1804_G4_3 VDD VSS OAI21_X1
XI1804_I70_XP I1804_pn4 I1804_pn3 I1804_P4_3 VDD VSS NOR2_X1
XI1804_I71_XG I1804_pn5 I1804_gn4 I1804_gn5 I1804_G5_4 VDD VSS OAI21_X1
XI1804_I71_XP I1804_pn5 I1804_pn4 I1804_P5_4 VDD VSS NOR2_X1
XI1804_I72_XG I1804_pn6 I1804_gn5 I1804_gn6 I1804_G6_5 VDD VSS OAI21_X1
XI1804_I72_XP I1804_pn6 I1804_pn5 I1804_P6_5 VDD VSS NOR2_X1
XI1804_I73_XG I1804_pn7 I1804_gn6 I1804_gn7 I1804_G7_6 VDD VSS OAI21_X1
XI1804_I73_XP I1804_pn7 I1804_pn6 I1804_P7_6 VDD VSS NOR2_X1
XI1804_I74_XG I1804_pn8 I1804_gn7 I1804_gn8 I1804_G8_7 VDD VSS OAI21_X1
XI1804_I74_XP I1804_pn8 I1804_pn7 I1804_P8_7 VDD VSS NOR2_X1
XI1804_I75_XG I1804_pn9 I1804_gn8 I1804_gn9 I1804_G9_8 VDD VSS OAI21_X1
XI1804_I75_XP I1804_pn9 I1804_pn8 I1804_P9_8 VDD VSS NOR2_X1
XI1804_I76_XG I1804_pn10 I1804_gn9 I1804_gn10 I1804_G10_9 VDD VSS OAI21_X1
XI1804_I76_XP I1804_pn10 I1804_pn9 I1804_P10_9 VDD VSS NOR2_X1
XI1804_I77_XG I1804_pn11 I1804_gn10 I1804_gn11 I1804_G11_10 VDD VSS OAI21_X1
XI1804_I77_XP I1804_pn11 I1804_pn10 I1804_P11_10 VDD VSS NOR2_X1
XI1804_I78_XG I1804_pn12 I1804_gn11 I1804_gn12 I1804_G12_11 VDD VSS OAI21_X1
XI1804_I78_XP I1804_pn12 I1804_pn11 I1804_P12_11 VDD VSS NOR2_X1
XI1804_I79_XG I1804_pn13 I1804_gn12 I1804_gn13 I1804_G13_12 VDD VSS OAI21_X1
XI1804_I79_XP I1804_pn13 I1804_pn12 I1804_P13_12 VDD VSS NOR2_X1
XI1804_I80_XG I1804_pn14 I1804_gn13 I1804_gn14 I1804_G14_13 VDD VSS OAI21_X1
XI1804_I80_XP I1804_pn14 I1804_pn13 I1804_P14_13 VDD VSS NOR2_X1
XI1804_I81_XG I1804_pn15 I1804_gn14 I1804_gn15 I1804_G15_14 VDD VSS OAI21_X1
XI1804_I81_XP I1804_pn15 I1804_pn14 I1804_P15_14 VDD VSS NOR2_X1
XI1804_I82_XG I1804_pn16 I1804_gn15 I1804_gn16 I1804_G16_15 VDD VSS OAI21_X1
XI1804_I82_XP I1804_pn16 I1804_pn15 I1804_P16_15 VDD VSS NOR2_X1
XI1804_I83_XG I1804_pn17 I1804_gn16 I1804_gn17 I1804_G17_16 VDD VSS OAI21_X1
XI1804_I83_XP I1804_pn17 I1804_pn16 I1804_P17_16 VDD VSS NOR2_X1
XI1804_I84_XG I1804_pn18 I1804_gn17 I1804_gn18 I1804_G18_17 VDD VSS OAI21_X1
XI1804_I84_XP I1804_pn18 I1804_pn17 I1804_P18_17 VDD VSS NOR2_X1
XI1804_I85_XG I1804_pn19 I1804_gn18 I1804_gn19 I1804_G19_18 VDD VSS OAI21_X1
XI1804_I85_XP I1804_pn19 I1804_pn18 I1804_P19_18 VDD VSS NOR2_X1
XI1804_I86_XG I1804_pn20 I1804_gn19 I1804_gn20 I1804_G20_19 VDD VSS OAI21_X1
XI1804_I86_XP I1804_pn20 I1804_pn19 I1804_P20_19 VDD VSS NOR2_X1
XI1804_I87_XG I1804_pn21 I1804_gn20 I1804_gn21 I1804_G21_20 VDD VSS OAI21_X1
XI1804_I87_XP I1804_pn21 I1804_pn20 I1804_P21_20 VDD VSS NOR2_X1
XI1804_I88_XG I1804_pn22 I1804_gn21 I1804_gn22 I1804_G22_21 VDD VSS OAI21_X1
XI1804_I88_XP I1804_pn22 I1804_pn21 I1804_P22_21 VDD VSS NOR2_X1
XI1804_I89_XG I1804_pn23 I1804_gn22 I1804_gn23 I1804_G23_22 VDD VSS OAI21_X1
XI1804_I89_XP I1804_pn23 I1804_pn22 I1804_P23_22 VDD VSS NOR2_X1
XI1804_I90_XG I1804_pn24 I1804_gn23 I1804_gn24 I1804_G24_23 VDD VSS OAI21_X1
XI1804_I90_XP I1804_pn24 I1804_pn23 I1804_P24_23 VDD VSS NOR2_X1
XI1804_I91_XG I1804_pn25 I1804_gn24 I1804_gn25 I1804_G25_24 VDD VSS OAI21_X1
XI1804_I91_XP I1804_pn25 I1804_pn24 I1804_P25_24 VDD VSS NOR2_X1
XI1804_I92_XG I1804_pn26 I1804_gn25 I1804_gn26 I1804_G26_25 VDD VSS OAI21_X1
XI1804_I92_XP I1804_pn26 I1804_pn25 I1804_P26_25 VDD VSS NOR2_X1
XI1804_I93_XG I1804_pn27 I1804_gn26 I1804_gn27 I1804_G27_26 VDD VSS OAI21_X1
XI1804_I93_XP I1804_pn27 I1804_pn26 I1804_P27_26 VDD VSS NOR2_X1
XI1804_I94_XG I1804_pn28 I1804_gn27 I1804_gn28 I1804_G28_27 VDD VSS OAI21_X1
XI1804_I94_XP I1804_pn28 I1804_pn27 I1804_P28_27 VDD VSS NOR2_X1
XI1804_I95_XG I1804_pn29 I1804_gn28 I1804_gn29 I1804_G29_28 VDD VSS OAI21_X1
XI1804_I95_XP I1804_pn29 I1804_pn28 I1804_P29_28 VDD VSS NOR2_X1
XI1804_I96_XG I1804_pn30 I1804_gn29 I1804_gn30 I1804_G30_29 VDD VSS OAI21_X1
XI1804_I96_XP I1804_pn30 I1804_pn29 I1804_P30_29 VDD VSS NOR2_X1
XI1804_I97_XG I1804_pn31 I1804_gn30 I1804_gn31 I1804_G31_30 VDD VSS OAI21_X1
XI1804_I97_XP I1804_pn31 I1804_pn30 I1804_P31_30 VDD VSS NOR2_X1
XI1804_I98_XG I1804_P2_1 I1804_G0_0 I1804_G2_1 I1804_G2_0n VDD VSS AOI21_X1
XI1804_I99_XG I1804_P3_2 I1804_G1_0 I1804_G3_2 I1804_G3_0n VDD VSS AOI21_X1
XI1804_I100_XG I1804_P4_3 I1804_G2_1 I1804_G4_3 I1804_G4_1n VDD VSS AOI21_X1
XI1804_I100_XP I1804_P4_3 I1804_P2_1 I1804_P4_1n VDD VSS NAND2_X1
XI1804_I101_XG I1804_P5_4 I1804_G3_2 I1804_G5_4 I1804_G5_2n VDD VSS AOI21_X1
XI1804_I101_XP I1804_P5_4 I1804_P3_2 I1804_P5_2n VDD VSS NAND2_X1
XI1804_I102_XG I1804_P6_5 I1804_G4_3 I1804_G6_5 I1804_G6_3n VDD VSS AOI21_X1
XI1804_I102_XP I1804_P6_5 I1804_P4_3 I1804_P6_3n VDD VSS NAND2_X1
XI1804_I103_XG I1804_P7_6 I1804_G5_4 I1804_G7_6 I1804_G7_4n VDD VSS AOI21_X1
XI1804_I103_XP I1804_P7_6 I1804_P5_4 I1804_P7_4n VDD VSS NAND2_X1
XI1804_I104_XG I1804_P8_7 I1804_G6_5 I1804_G8_7 I1804_G8_5n VDD VSS AOI21_X1
XI1804_I104_XP I1804_P8_7 I1804_P6_5 I1804_P8_5n VDD VSS NAND2_X1
XI1804_I105_XG I1804_P9_8 I1804_G7_6 I1804_G9_8 I1804_G9_6n VDD VSS AOI21_X1
XI1804_I105_XP I1804_P9_8 I1804_P7_6 I1804_P9_6n VDD VSS NAND2_X1
XI1804_I106_XG I1804_P10_9 I1804_G8_7 I1804_G10_9 I1804_G10_7n VDD VSS AOI21_X1
XI1804_I106_XP I1804_P10_9 I1804_P8_7 I1804_P10_7n VDD VSS NAND2_X1
XI1804_I107_XG I1804_P11_10 I1804_G9_8 I1804_G11_10 I1804_G11_8n VDD VSS AOI21_X1
XI1804_I107_XP I1804_P11_10 I1804_P9_8 I1804_P11_8n VDD VSS NAND2_X1
XI1804_I108_XG I1804_P12_11 I1804_G10_9 I1804_G12_11 I1804_G12_9n VDD VSS AOI21_X1
XI1804_I108_XP I1804_P12_11 I1804_P10_9 I1804_P12_9n VDD VSS NAND2_X1
XI1804_I109_XG I1804_P13_12 I1804_G11_10 I1804_G13_12 I1804_G13_10n VDD VSS AOI21_X1
XI1804_I109_XP I1804_P13_12 I1804_P11_10 I1804_P13_10n VDD VSS NAND2_X1
XI1804_I110_XG I1804_P14_13 I1804_G12_11 I1804_G14_13 I1804_G14_11n VDD VSS AOI21_X1
XI1804_I110_XP I1804_P14_13 I1804_P12_11 I1804_P14_11n VDD VSS NAND2_X1
XI1804_I111_XG I1804_P15_14 I1804_G13_12 I1804_G15_14 I1804_G15_12n VDD VSS AOI21_X1
XI1804_I111_XP I1804_P15_14 I1804_P13_12 I1804_P15_12n VDD VSS NAND2_X1
XI1804_I112_XG I1804_P16_15 I1804_G14_13 I1804_G16_15 I1804_G16_13n VDD VSS AOI21_X1
XI1804_I112_XP I1804_P16_15 I1804_P14_13 I1804_P16_13n VDD VSS NAND2_X1
XI1804_I113_XG I1804_P17_16 I1804_G15_14 I1804_G17_16 I1804_G17_14n VDD VSS AOI21_X1
XI1804_I113_XP I1804_P17_16 I1804_P15_14 I1804_P17_14n VDD VSS NAND2_X1
XI1804_I114_XG I1804_P18_17 I1804_G16_15 I1804_G18_17 I1804_G18_15n VDD VSS AOI21_X1
XI1804_I114_XP I1804_P18_17 I1804_P16_15 I1804_P18_15n VDD VSS NAND2_X1
XI1804_I115_XG I1804_P19_18 I1804_G17_16 I1804_G19_18 I1804_G19_16n VDD VSS AOI21_X1
XI1804_I115_XP I1804_P19_18 I1804_P17_16 I1804_P19_16n VDD VSS NAND2_X1
XI1804_I116_XG I1804_P20_19 I1804_G18_17 I1804_G20_19 I1804_G20_17n VDD VSS AOI21_X1
XI1804_I116_XP I1804_P20_19 I1804_P18_17 I1804_P20_17n VDD VSS NAND2_X1
XI1804_I117_XG I1804_P21_20 I1804_G19_18 I1804_G21_20 I1804_G21_18n VDD VSS AOI21_X1
XI1804_I117_XP I1804_P21_20 I1804_P19_18 I1804_P21_18n VDD VSS NAND2_X1
XI1804_I118_XG I1804_P22_21 I1804_G20_19 I1804_G22_21 I1804_G22_19n VDD VSS AOI21_X1
XI1804_I118_XP I1804_P22_21 I1804_P20_19 I1804_P22_19n VDD VSS NAND2_X1
XI1804_I119_XG I1804_P23_22 I1804_G21_20 I1804_G23_22 I1804_G23_20n VDD VSS AOI21_X1
XI1804_I119_XP I1804_P23_22 I1804_P21_20 I1804_P23_20n VDD VSS NAND2_X1
XI1804_I120_XG I1804_P24_23 I1804_G22_21 I1804_G24_23 I1804_G24_21n VDD VSS AOI21_X1
XI1804_I120_XP I1804_P24_23 I1804_P22_21 I1804_P24_21n VDD VSS NAND2_X1
XI1804_I121_XG I1804_P25_24 I1804_G23_22 I1804_G25_24 I1804_G25_22n VDD VSS AOI21_X1
XI1804_I121_XP I1804_P25_24 I1804_P23_22 I1804_P25_22n VDD VSS NAND2_X1
XI1804_I122_XG I1804_P26_25 I1804_G24_23 I1804_G26_25 I1804_G26_23n VDD VSS AOI21_X1
XI1804_I122_XP I1804_P26_25 I1804_P24_23 I1804_P26_23n VDD VSS NAND2_X1
XI1804_I123_XG I1804_P27_26 I1804_G25_24 I1804_G27_26 I1804_G27_24n VDD VSS AOI21_X1
XI1804_I123_XP I1804_P27_26 I1804_P25_24 I1804_P27_24n VDD VSS NAND2_X1
XI1804_I124_XG I1804_P28_27 I1804_G26_25 I1804_G28_27 I1804_G28_25n VDD VSS AOI21_X1
XI1804_I124_XP I1804_P28_27 I1804_P26_25 I1804_P28_25n VDD VSS NAND2_X1
XI1804_I125_XG I1804_P29_28 I1804_G27_26 I1804_G29_28 I1804_G29_26n VDD VSS AOI21_X1
XI1804_I125_XP I1804_P29_28 I1804_P27_26 I1804_P29_26n VDD VSS NAND2_X1
XI1804_I126_XG I1804_P30_29 I1804_G28_27 I1804_G30_29 I1804_G30_27n VDD VSS AOI21_X1
XI1804_I126_XP I1804_P30_29 I1804_P28_27 I1804_P30_27n VDD VSS NAND2_X1
XI1804_I127_XG I1804_P31_30 I1804_G29_28 I1804_G31_30 I1804_G31_28n VDD VSS AOI21_X1
XI1804_I127_XP I1804_P31_30 I1804_P29_28 I1804_P31_28n VDD VSS NAND2_X1
XI1804_I128_XG I1804_P4_1n I1804_G0_0n I1804_G4_1n I1804_G4_0 VDD VSS OAI21_X1
XI1804_I129 I1804_G1_0 I1804_G1_0n VDD VSS INV_X1
XI1804_I130_XG I1804_P5_2n I1804_G1_0n I1804_G5_2n I1804_G5_0 VDD VSS OAI21_X1
XI1804_I131_XG I1804_P6_3n I1804_G2_0n I1804_G6_3n I1804_G6_0 VDD VSS OAI21_X1
XI1804_I132_XG I1804_P7_4n I1804_G3_0n I1804_G7_4n I1804_G7_0 VDD VSS OAI21_X1
XI1804_I133_XG I1804_P8_5n I1804_G4_1n I1804_G8_5n I1804_G8_1 VDD VSS OAI21_X1
XI1804_I133_XP I1804_P8_5n I1804_P4_1n I1804_P8_1 VDD VSS NOR2_X1
XI1804_I134_XG I1804_P9_6n I1804_G5_2n I1804_G9_6n I1804_G9_2 VDD VSS OAI21_X1
XI1804_I134_XP I1804_P9_6n I1804_P5_2n I1804_P9_2 VDD VSS NOR2_X1
XI1804_I135_XG I1804_P10_7n I1804_G6_3n I1804_G10_7n I1804_G10_3 VDD VSS OAI21_X1
XI1804_I135_XP I1804_P10_7n I1804_P6_3n I1804_P10_3 VDD VSS NOR2_X1
XI1804_I136_XG I1804_P11_8n I1804_G7_4n I1804_G11_8n I1804_G11_4 VDD VSS OAI21_X1
XI1804_I136_XP I1804_P11_8n I1804_P7_4n I1804_P11_4 VDD VSS NOR2_X1
XI1804_I137_XG I1804_P12_9n I1804_G8_5n I1804_G12_9n I1804_G12_5 VDD VSS OAI21_X1
XI1804_I137_XP I1804_P12_9n I1804_P8_5n I1804_P12_5 VDD VSS NOR2_X1
XI1804_I138_XG I1804_P13_10n I1804_G9_6n I1804_G13_10n I1804_G13_6 VDD VSS OAI21_X1
XI1804_I138_XP I1804_P13_10n I1804_P9_6n I1804_P13_6 VDD VSS NOR2_X1
XI1804_I139_XG I1804_P14_11n I1804_G10_7n I1804_G14_11n I1804_G14_7 VDD VSS OAI21_X1
XI1804_I139_XP I1804_P14_11n I1804_P10_7n I1804_P14_7 VDD VSS NOR2_X1
XI1804_I140_XG I1804_P15_12n I1804_G11_8n I1804_G15_12n I1804_G15_8 VDD VSS OAI21_X1
XI1804_I140_XP I1804_P15_12n I1804_P11_8n I1804_P15_8 VDD VSS NOR2_X1
XI1804_I141_XG I1804_P16_13n I1804_G12_9n I1804_G16_13n I1804_G16_9 VDD VSS OAI21_X1
XI1804_I141_XP I1804_P16_13n I1804_P12_9n I1804_P16_9 VDD VSS NOR2_X1
XI1804_I142_XG I1804_P17_14n I1804_G13_10n I1804_G17_14n I1804_G17_10 VDD VSS OAI21_X1
XI1804_I142_XP I1804_P17_14n I1804_P13_10n I1804_P17_10 VDD VSS NOR2_X1
XI1804_I143_XG I1804_P18_15n I1804_G14_11n I1804_G18_15n I1804_G18_11 VDD VSS OAI21_X1
XI1804_I143_XP I1804_P18_15n I1804_P14_11n I1804_P18_11 VDD VSS NOR2_X1
XI1804_I144_XG I1804_P19_16n I1804_G15_12n I1804_G19_16n I1804_G19_12 VDD VSS OAI21_X1
XI1804_I144_XP I1804_P19_16n I1804_P15_12n I1804_P19_12 VDD VSS NOR2_X1
XI1804_I145_XG I1804_P20_17n I1804_G16_13n I1804_G20_17n I1804_G20_13 VDD VSS OAI21_X1
XI1804_I145_XP I1804_P20_17n I1804_P16_13n I1804_P20_13 VDD VSS NOR2_X1
XI1804_I146_XG I1804_P21_18n I1804_G17_14n I1804_G21_18n I1804_G21_14 VDD VSS OAI21_X1
XI1804_I146_XP I1804_P21_18n I1804_P17_14n I1804_P21_14 VDD VSS NOR2_X1
XI1804_I147_XG I1804_P22_19n I1804_G18_15n I1804_G22_19n I1804_G22_15 VDD VSS OAI21_X1
XI1804_I147_XP I1804_P22_19n I1804_P18_15n I1804_P22_15 VDD VSS NOR2_X1
XI1804_I148_XG I1804_P23_20n I1804_G19_16n I1804_G23_20n I1804_G23_16 VDD VSS OAI21_X1
XI1804_I148_XP I1804_P23_20n I1804_P19_16n I1804_P23_16 VDD VSS NOR2_X1
XI1804_I149_XG I1804_P24_21n I1804_G20_17n I1804_G24_21n I1804_G24_17 VDD VSS OAI21_X1
XI1804_I149_XP I1804_P24_21n I1804_P20_17n I1804_P24_17 VDD VSS NOR2_X1
XI1804_I150_XG I1804_P25_22n I1804_G21_18n I1804_G25_22n I1804_G25_18 VDD VSS OAI21_X1
XI1804_I150_XP I1804_P25_22n I1804_P21_18n I1804_P25_18 VDD VSS NOR2_X1
XI1804_I151_XG I1804_P26_23n I1804_G22_19n I1804_G26_23n I1804_G26_19 VDD VSS OAI21_X1
XI1804_I151_XP I1804_P26_23n I1804_P22_19n I1804_P26_19 VDD VSS NOR2_X1
XI1804_I152_XG I1804_P27_24n I1804_G23_20n I1804_G27_24n I1804_G27_20 VDD VSS OAI21_X1
XI1804_I152_XP I1804_P27_24n I1804_P23_20n I1804_P27_20 VDD VSS NOR2_X1
XI1804_I153_XG I1804_P28_25n I1804_G24_21n I1804_G28_25n I1804_G28_21 VDD VSS OAI21_X1
XI1804_I153_XP I1804_P28_25n I1804_P24_21n I1804_P28_21 VDD VSS NOR2_X1
XI1804_I154_XG I1804_P29_26n I1804_G25_22n I1804_G29_26n I1804_G29_22 VDD VSS OAI21_X1
XI1804_I154_XP I1804_P29_26n I1804_P25_22n I1804_P29_22 VDD VSS NOR2_X1
XI1804_I155_XG I1804_P30_27n I1804_G26_23n I1804_G30_27n I1804_G30_23 VDD VSS OAI21_X1
XI1804_I155_XP I1804_P30_27n I1804_P26_23n I1804_P30_23 VDD VSS NOR2_X1
XI1804_I156_XG I1804_P31_28n I1804_G27_24n I1804_G31_28n I1804_G31_24 VDD VSS OAI21_X1
XI1804_I156_XP I1804_P31_28n I1804_P27_24n I1804_P31_24 VDD VSS NOR2_X1
XI1804_I157_XG I1804_P8_1 I1804_G0_0 I1804_G8_1 I1804_G8_0n VDD VSS AOI21_X1
XI1804_I158_XG I1804_P9_2 I1804_G1_0 I1804_G9_2 I1804_G9_0n VDD VSS AOI21_X1
XI1804_I159 I1804_G2_0n I1804_G2_0np VDD VSS INV_X1
XI1804_I160_XG I1804_P10_3 I1804_G2_0np I1804_G10_3 I1804_G10_0n VDD VSS AOI21_X1
XI1804_I161 I1804_G3_0n I1804_G3_0np VDD VSS INV_X1
XI1804_I162_XG I1804_P11_4 I1804_G3_0np I1804_G11_4 I1804_G11_0n VDD VSS AOI21_X1
XI1804_I163_XG I1804_P12_5 I1804_G4_0 I1804_G12_5 I1804_G12_0n VDD VSS AOI21_X1
XI1804_I164_XG I1804_P13_6 I1804_G5_0 I1804_G13_6 I1804_G13_0n VDD VSS AOI21_X1
XI1804_I165_XG I1804_P14_7 I1804_G6_0 I1804_G14_7 I1804_G14_0n VDD VSS AOI21_X1
XI1804_I166_XG I1804_P15_8 I1804_G7_0 I1804_G15_8 I1804_G15_0n VDD VSS AOI21_X1
XI1804_I167_XG I1804_P16_9 I1804_G8_1 I1804_G16_9 I1804_G16_1n VDD VSS AOI21_X1
XI1804_I167_XP I1804_P16_9 I1804_P8_1 I1804_P16_1n VDD VSS NAND2_X1
XI1804_I168_XG I1804_P17_10 I1804_G9_2 I1804_G17_10 I1804_G17_2n VDD VSS AOI21_X1
XI1804_I168_XP I1804_P17_10 I1804_P9_2 I1804_P17_2n VDD VSS NAND2_X1
XI1804_I169_XG I1804_P18_11 I1804_G10_3 I1804_G18_11 I1804_G18_3n VDD VSS AOI21_X1
XI1804_I169_XP I1804_P18_11 I1804_P10_3 I1804_P18_3n VDD VSS NAND2_X1
XI1804_I170_XG I1804_P19_12 I1804_G11_4 I1804_G19_12 I1804_G19_4n VDD VSS AOI21_X1
XI1804_I170_XP I1804_P19_12 I1804_P11_4 I1804_P19_4n VDD VSS NAND2_X1
XI1804_I171_XG I1804_P20_13 I1804_G12_5 I1804_G20_13 I1804_G20_5n VDD VSS AOI21_X1
XI1804_I171_XP I1804_P20_13 I1804_P12_5 I1804_P20_5n VDD VSS NAND2_X1
XI1804_I172_XG I1804_P21_14 I1804_G13_6 I1804_G21_14 I1804_G21_6n VDD VSS AOI21_X1
XI1804_I172_XP I1804_P21_14 I1804_P13_6 I1804_P21_6n VDD VSS NAND2_X1
XI1804_I173_XG I1804_P22_15 I1804_G14_7 I1804_G22_15 I1804_G22_7n VDD VSS AOI21_X1
XI1804_I173_XP I1804_P22_15 I1804_P14_7 I1804_P22_7n VDD VSS NAND2_X1
XI1804_I174_XG I1804_P23_16 I1804_G15_8 I1804_G23_16 I1804_G23_8n VDD VSS AOI21_X1
XI1804_I174_XP I1804_P23_16 I1804_P15_8 I1804_P23_8n VDD VSS NAND2_X1
XI1804_I175_XG I1804_P24_17 I1804_G16_9 I1804_G24_17 I1804_G24_9n VDD VSS AOI21_X1
XI1804_I175_XP I1804_P24_17 I1804_P16_9 I1804_P24_9n VDD VSS NAND2_X1
XI1804_I176_XG I1804_P25_18 I1804_G17_10 I1804_G25_18 I1804_G25_10n VDD VSS AOI21_X1
XI1804_I176_XP I1804_P25_18 I1804_P17_10 I1804_P25_10n VDD VSS NAND2_X1
XI1804_I177_XG I1804_P26_19 I1804_G18_11 I1804_G26_19 I1804_G26_11n VDD VSS AOI21_X1
XI1804_I177_XP I1804_P26_19 I1804_P18_11 I1804_P26_11n VDD VSS NAND2_X1
XI1804_I178_XG I1804_P27_20 I1804_G19_12 I1804_G27_20 I1804_G27_12n VDD VSS AOI21_X1
XI1804_I178_XP I1804_P27_20 I1804_P19_12 I1804_P27_12n VDD VSS NAND2_X1
XI1804_I179_XG I1804_P28_21 I1804_G20_13 I1804_G28_21 I1804_G28_13n VDD VSS AOI21_X1
XI1804_I179_XP I1804_P28_21 I1804_P20_13 I1804_P28_13n VDD VSS NAND2_X1
XI1804_I180_XG I1804_P29_22 I1804_G21_14 I1804_G29_22 I1804_G29_14n VDD VSS AOI21_X1
XI1804_I180_XP I1804_P29_22 I1804_P21_14 I1804_P29_14n VDD VSS NAND2_X1
XI1804_I181_XG I1804_P30_23 I1804_G22_15 I1804_G30_23 I1804_G30_15n VDD VSS AOI21_X1
XI1804_I181_XP I1804_P30_23 I1804_P22_15 I1804_P30_15n VDD VSS NAND2_X1
XI1804_I182_XG I1804_P31_24 I1804_G23_16 I1804_G31_24 I1804_G31_16n VDD VSS AOI21_X1
XI1804_I182_XP I1804_P31_24 I1804_P23_16 I1804_P31_16n VDD VSS NAND2_X1
XI1804_I183_XG I1804_P16_1n I1804_G0_0n I1804_G16_1n I1804_G16_0 VDD VSS OAI21_X1
XI1804_I184_XG I1804_P17_2n I1804_G1_0n I1804_G17_2n I1804_G17_0 VDD VSS OAI21_X1
XI1804_I185_XG I1804_P18_3n I1804_G2_0n I1804_G18_3n I1804_G18_0 VDD VSS OAI21_X1
XI1804_I186_XG I1804_P19_4n I1804_G3_0n I1804_G19_4n I1804_G19_0 VDD VSS OAI21_X1
XI1804_I187 I1804_G4_0 I1804_G4_0n VDD VSS INV_X1
XI1804_I188_XG I1804_P20_5n I1804_G4_0n I1804_G20_5n I1804_G20_0 VDD VSS OAI21_X1
XI1804_I189 I1804_G5_0 I1804_G5_0n VDD VSS INV_X1
XI1804_I190_XG I1804_P21_6n I1804_G5_0n I1804_G21_6n I1804_G21_0 VDD VSS OAI21_X1
XI1804_I191 I1804_G6_0 I1804_G6_0n VDD VSS INV_X1
XI1804_I192_XG I1804_P22_7n I1804_G6_0n I1804_G22_7n I1804_G22_0 VDD VSS OAI21_X1
XI1804_I193 I1804_G7_0 I1804_G7_0n VDD VSS INV_X1
XI1804_I194_XG I1804_P23_8n I1804_G7_0n I1804_G23_8n I1804_G23_0 VDD VSS OAI21_X1
XI1804_I195_XG I1804_P24_9n I1804_G8_0n I1804_G24_9n I1804_G24_0 VDD VSS OAI21_X1
XI1804_I196_XG I1804_P25_10n I1804_G9_0n I1804_G25_10n I1804_G25_0 VDD VSS OAI21_X1
XI1804_I197_XG I1804_P26_11n I1804_G10_0n I1804_G26_11n I1804_G26_0 VDD VSS OAI21_X1
XI1804_I198_XG I1804_P27_12n I1804_G11_0n I1804_G27_12n I1804_G27_0 VDD VSS OAI21_X1
XI1804_I199_XG I1804_P28_13n I1804_G12_0n I1804_G28_13n I1804_G28_0 VDD VSS OAI21_X1
XI1804_I200_XG I1804_P29_14n I1804_G13_0n I1804_G29_14n I1804_G29_0 VDD VSS OAI21_X1
XI1804_I201_XG I1804_P30_15n I1804_G14_0n I1804_G30_15n c27_m VDD VSS OAI21_X1
XI1804_I202_XG I1804_P31_16n I1804_G15_0n I1804_G31_16n c27_o VDD VSS OAI21_X1
XI1804_I203 I1804_pn0 qu5_b3_5 p27_0 VDD VSS XNOR2_X1
XI1804_I204 I1804_pn1 I1804_G0_0 p27_1 VDD VSS XNOR2_X1
XI1804_I205 I1804_pn2 I1804_G1_0 p27_2 VDD VSS XNOR2_X1
XI1804_I206 I1804_pn3 I1804_G2_0n p27_3 VDD VSS XOR2_X1
XI1804_I207 I1804_pn4 I1804_G3_0n p27_4 VDD VSS XOR2_X1
XI1804_I208 I1804_pn5 I1804_G4_0 p27_5 VDD VSS XNOR2_X1
XI1804_I209 I1804_pn6 I1804_G5_0 p27_6 VDD VSS XNOR2_X1
XI1804_I210 I1804_pn7 I1804_G6_0 p27_7 VDD VSS XNOR2_X1
XI1804_I211 I1804_pn8 I1804_G7_0 p27_8 VDD VSS XNOR2_X1
XI1804_I212 I1804_pn9 I1804_G8_0n p27_9 VDD VSS XOR2_X1
XI1804_I213 I1804_pn10 I1804_G9_0n p27_10 VDD VSS XOR2_X1
XI1804_I214 I1804_pn11 I1804_G10_0n p27_11 VDD VSS XOR2_X1
XI1804_I215 I1804_pn12 I1804_G11_0n p27_12 VDD VSS XOR2_X1
XI1804_I216 I1804_pn13 I1804_G12_0n p27_13 VDD VSS XOR2_X1
XI1804_I217 I1804_pn14 I1804_G13_0n p27_14 VDD VSS XOR2_X1
XI1804_I218 I1804_pn15 I1804_G14_0n p27_15 VDD VSS XOR2_X1
XI1804_I219 I1804_pn16 I1804_G15_0n p27_16 VDD VSS XOR2_X1
XI1804_I220 I1804_pn17 I1804_G16_0 p27_17 VDD VSS XNOR2_X1
XI1804_I221 I1804_pn18 I1804_G17_0 p27_18 VDD VSS XNOR2_X1
XI1804_I222 I1804_pn19 I1804_G18_0 p27_19 VDD VSS XNOR2_X1
XI1804_I223 I1804_pn20 I1804_G19_0 p27_20 VDD VSS XNOR2_X1
XI1804_I224 I1804_pn21 I1804_G20_0 p27_21 VDD VSS XNOR2_X1
XI1804_I225 I1804_pn22 I1804_G21_0 p27_22 VDD VSS XNOR2_X1
XI1804_I226 I1804_pn23 I1804_G22_0 p27_23 VDD VSS XNOR2_X1
XI1804_I227 I1804_pn24 I1804_G23_0 p27_24 VDD VSS XNOR2_X1
XI1804_I228 I1804_pn25 I1804_G24_0 p27_25 VDD VSS XNOR2_X1
XI1804_I229 I1804_pn26 I1804_G25_0 p27_26 VDD VSS XNOR2_X1
XI1804_I230 I1804_pn27 I1804_G26_0 p27_27 VDD VSS XNOR2_X1
XI1804_I231 I1804_pn28 I1804_G27_0 p27_28 VDD VSS XNOR2_X1
XI1804_I232 I1804_pn29 I1804_G28_0 p27_29 VDD VSS XNOR2_X1
XI1804_I233 I1804_pn30 I1804_G29_0 p27_30 VDD VSS XNOR2_X1
XI1804_I234 I1804_pn31 c27_m p27_31 VDD VSS XNOR2_X1
XI1805 p26_31 qu5_b3_5 h27 VDD VSS XOR2_X1
XI1806 h27 c27_o p27_32 VDD VSS XOR2_X1
XI1807 p27_32 qu4 VDD VSS INV_X4
XI1808 qu4 qu4_b0 VDD VSS INV_X1
XI1809 qu4_b0 qu4_b1_0 VDD VSS INV_X4
XI1810 qu4_b1_0 qu4_b2_0 VDD VSS INV_X4
XI1811 qu4_b1_0 qu4_b2_1 VDD VSS INV_X4
XI1812 qu4_b2_0 qu4_b3_0 VDD VSS INV_X4
XI1813 qu4_b2_0 qu4_b3_1 VDD VSS INV_X4
XI1814 qu4_b2_0 qu4_b3_2 VDD VSS INV_X4
XI1815 qu4_b2_1 qu4_b3_3 VDD VSS INV_X4
XI1816 qu4_b2_1 qu4_b3_4 VDD VSS INV_X4
XI1817 qu4_b2_1 qu4_b3_5 VDD VSS INV_X4
XI1818 B_0_b3_4 qu4_b3_0 b28_0 VDD VSS XOR2_X1
XI1819 dd1_b3_5 qu4_b3_0 b28_1 VDD VSS XOR2_X1
XI1820 dd2_b3_5 qu4_b3_0 b28_2 VDD VSS XOR2_X1
XI1821 dd3_b3_5 qu4_b3_0 b28_3 VDD VSS XOR2_X1
XI1822 dd4_b3_5 qu4_b3_0 b28_4 VDD VSS XOR2_X1
XI1823 dd5_b3_5 qu4_b3_0 b28_5 VDD VSS XOR2_X1
XI1824 dd6_b3_5 qu4_b3_1 b28_6 VDD VSS XOR2_X1
XI1825 dd7_b3_5 qu4_b3_1 b28_7 VDD VSS XOR2_X1
XI1826 dd8_b3_5 qu4_b3_1 b28_8 VDD VSS XOR2_X1
XI1827 dd9_b3_5 qu4_b3_1 b28_9 VDD VSS XOR2_X1
XI1828 dd10_b3_5 qu4_b3_1 b28_10 VDD VSS XOR2_X1
XI1829 dd11_b3_5 qu4_b3_1 b28_11 VDD VSS XOR2_X1
XI1830 dd12_b3_5 qu4_b3_2 b28_12 VDD VSS XOR2_X1
XI1831 dd13_b3_5 qu4_b3_2 b28_13 VDD VSS XOR2_X1
XI1832 dd14_b3_5 qu4_b3_2 b28_14 VDD VSS XOR2_X1
XI1833 dd15_b3_5 qu4_b3_2 b28_15 VDD VSS XOR2_X1
XI1834 dd16_b3_5 qu4_b3_2 b28_16 VDD VSS XOR2_X1
XI1835 dd17_b3_5 qu4_b3_2 b28_17 VDD VSS XOR2_X1
XI1836 dd18_b3_5 qu4_b3_3 b28_18 VDD VSS XOR2_X1
XI1837 dd19_b3_5 qu4_b3_3 b28_19 VDD VSS XOR2_X1
XI1838 dd20_b3_5 qu4_b3_3 b28_20 VDD VSS XOR2_X1
XI1839 dd21_b3_5 qu4_b3_3 b28_21 VDD VSS XOR2_X1
XI1840 dd22_b3_5 qu4_b3_3 b28_22 VDD VSS XOR2_X1
XI1841 dd23_b3_5 qu4_b3_3 b28_23 VDD VSS XOR2_X1
XI1842 dd24_b3_5 qu4_b3_4 b28_24 VDD VSS XOR2_X1
XI1843 dd25_b3_5 qu4_b3_4 b28_25 VDD VSS XOR2_X1
XI1844 dd26_b3_5 qu4_b3_4 b28_26 VDD VSS XOR2_X1
XI1845 dd27_b3_5 qu4_b3_4 b28_27 VDD VSS XOR2_X1
XI1846 dd28_b3_5 qu4_b3_4 b28_28 VDD VSS XOR2_X1
XI1847 dd29_b3_5 qu4_b3_4 b28_29 VDD VSS XOR2_X1
XI1848 dd30_b3_5 qu4_b3_5 b28_30 VDD VSS XOR2_X1
XI1849 dd31_b3_5 qu4_b3_5 b28_31 VDD VSS XOR2_X1
XI1850_I0 aa3 b28_0 I1850_gn0 VDD VSS NAND2_X1
XI1850_I1 p27_0 b28_1 I1850_gn1 VDD VSS NAND2_X1
XI1850_I2 p27_1 b28_2 I1850_gn2 VDD VSS NAND2_X1
XI1850_I3 p27_2 b28_3 I1850_gn3 VDD VSS NAND2_X1
XI1850_I4 p27_3 b28_4 I1850_gn4 VDD VSS NAND2_X1
XI1850_I5 p27_4 b28_5 I1850_gn5 VDD VSS NAND2_X1
XI1850_I6 p27_5 b28_6 I1850_gn6 VDD VSS NAND2_X1
XI1850_I7 p27_6 b28_7 I1850_gn7 VDD VSS NAND2_X1
XI1850_I8 p27_7 b28_8 I1850_gn8 VDD VSS NAND2_X1
XI1850_I9 p27_8 b28_9 I1850_gn9 VDD VSS NAND2_X1
XI1850_I10 p27_9 b28_10 I1850_gn10 VDD VSS NAND2_X1
XI1850_I11 p27_10 b28_11 I1850_gn11 VDD VSS NAND2_X1
XI1850_I12 p27_11 b28_12 I1850_gn12 VDD VSS NAND2_X1
XI1850_I13 p27_12 b28_13 I1850_gn13 VDD VSS NAND2_X1
XI1850_I14 p27_13 b28_14 I1850_gn14 VDD VSS NAND2_X1
XI1850_I15 p27_14 b28_15 I1850_gn15 VDD VSS NAND2_X1
XI1850_I16 p27_15 b28_16 I1850_gn16 VDD VSS NAND2_X1
XI1850_I17 p27_16 b28_17 I1850_gn17 VDD VSS NAND2_X1
XI1850_I18 p27_17 b28_18 I1850_gn18 VDD VSS NAND2_X1
XI1850_I19 p27_18 b28_19 I1850_gn19 VDD VSS NAND2_X1
XI1850_I20 p27_19 b28_20 I1850_gn20 VDD VSS NAND2_X1
XI1850_I21 p27_20 b28_21 I1850_gn21 VDD VSS NAND2_X1
XI1850_I22 p27_21 b28_22 I1850_gn22 VDD VSS NAND2_X1
XI1850_I23 p27_22 b28_23 I1850_gn23 VDD VSS NAND2_X1
XI1850_I24 p27_23 b28_24 I1850_gn24 VDD VSS NAND2_X1
XI1850_I25 p27_24 b28_25 I1850_gn25 VDD VSS NAND2_X1
XI1850_I26 p27_25 b28_26 I1850_gn26 VDD VSS NAND2_X1
XI1850_I27 p27_26 b28_27 I1850_gn27 VDD VSS NAND2_X1
XI1850_I28 p27_27 b28_28 I1850_gn28 VDD VSS NAND2_X1
XI1850_I29 p27_28 b28_29 I1850_gn29 VDD VSS NAND2_X1
XI1850_I30 p27_29 b28_30 I1850_gn30 VDD VSS NAND2_X1
XI1850_I31 p27_30 b28_31 I1850_gn31 VDD VSS NAND2_X1
XI1850_I32 aa3 b28_0 I1850_pn0 VDD VSS XNOR2_X1
XI1850_I33 p27_0 b28_1 I1850_pn1 VDD VSS XNOR2_X1
XI1850_I34 p27_1 b28_2 I1850_pn2 VDD VSS XNOR2_X1
XI1850_I35 p27_2 b28_3 I1850_pn3 VDD VSS XNOR2_X1
XI1850_I36 p27_3 b28_4 I1850_pn4 VDD VSS XNOR2_X1
XI1850_I37 p27_4 b28_5 I1850_pn5 VDD VSS XNOR2_X1
XI1850_I38 p27_5 b28_6 I1850_pn6 VDD VSS XNOR2_X1
XI1850_I39 p27_6 b28_7 I1850_pn7 VDD VSS XNOR2_X1
XI1850_I40 p27_7 b28_8 I1850_pn8 VDD VSS XNOR2_X1
XI1850_I41 p27_8 b28_9 I1850_pn9 VDD VSS XNOR2_X1
XI1850_I42 p27_9 b28_10 I1850_pn10 VDD VSS XNOR2_X1
XI1850_I43 p27_10 b28_11 I1850_pn11 VDD VSS XNOR2_X1
XI1850_I44 p27_11 b28_12 I1850_pn12 VDD VSS XNOR2_X1
XI1850_I45 p27_12 b28_13 I1850_pn13 VDD VSS XNOR2_X1
XI1850_I46 p27_13 b28_14 I1850_pn14 VDD VSS XNOR2_X1
XI1850_I47 p27_14 b28_15 I1850_pn15 VDD VSS XNOR2_X1
XI1850_I48 p27_15 b28_16 I1850_pn16 VDD VSS XNOR2_X1
XI1850_I49 p27_16 b28_17 I1850_pn17 VDD VSS XNOR2_X1
XI1850_I50 p27_17 b28_18 I1850_pn18 VDD VSS XNOR2_X1
XI1850_I51 p27_18 b28_19 I1850_pn19 VDD VSS XNOR2_X1
XI1850_I52 p27_19 b28_20 I1850_pn20 VDD VSS XNOR2_X1
XI1850_I53 p27_20 b28_21 I1850_pn21 VDD VSS XNOR2_X1
XI1850_I54 p27_21 b28_22 I1850_pn22 VDD VSS XNOR2_X1
XI1850_I55 p27_22 b28_23 I1850_pn23 VDD VSS XNOR2_X1
XI1850_I56 p27_23 b28_24 I1850_pn24 VDD VSS XNOR2_X1
XI1850_I57 p27_24 b28_25 I1850_pn25 VDD VSS XNOR2_X1
XI1850_I58 p27_25 b28_26 I1850_pn26 VDD VSS XNOR2_X1
XI1850_I59 p27_26 b28_27 I1850_pn27 VDD VSS XNOR2_X1
XI1850_I60 p27_27 b28_28 I1850_pn28 VDD VSS XNOR2_X1
XI1850_I61 p27_28 b28_29 I1850_pn29 VDD VSS XNOR2_X1
XI1850_I62 p27_29 b28_30 I1850_pn30 VDD VSS XNOR2_X1
XI1850_I63 p27_30 b28_31 I1850_pn31 VDD VSS XNOR2_X1
XI1850_I64 qu4_b3_5 I1850_cinn VDD VSS INV_X1
XI1850_I65_XG I1850_pn0 I1850_cinn I1850_gn0 I1850_G0_0 VDD VSS OAI21_X1
XI1850_I66 I1850_G0_0 I1850_G0_0n VDD VSS INV_X1
XI1850_I67_XG I1850_pn1 I1850_G0_0n I1850_gn1 I1850_G1_0 VDD VSS OAI21_X1
XI1850_I68_XG I1850_pn2 I1850_gn1 I1850_gn2 I1850_G2_1 VDD VSS OAI21_X1
XI1850_I68_XP I1850_pn2 I1850_pn1 I1850_P2_1 VDD VSS NOR2_X1
XI1850_I69_XG I1850_pn3 I1850_gn2 I1850_gn3 I1850_G3_2 VDD VSS OAI21_X1
XI1850_I69_XP I1850_pn3 I1850_pn2 I1850_P3_2 VDD VSS NOR2_X1
XI1850_I70_XG I1850_pn4 I1850_gn3 I1850_gn4 I1850_G4_3 VDD VSS OAI21_X1
XI1850_I70_XP I1850_pn4 I1850_pn3 I1850_P4_3 VDD VSS NOR2_X1
XI1850_I71_XG I1850_pn5 I1850_gn4 I1850_gn5 I1850_G5_4 VDD VSS OAI21_X1
XI1850_I71_XP I1850_pn5 I1850_pn4 I1850_P5_4 VDD VSS NOR2_X1
XI1850_I72_XG I1850_pn6 I1850_gn5 I1850_gn6 I1850_G6_5 VDD VSS OAI21_X1
XI1850_I72_XP I1850_pn6 I1850_pn5 I1850_P6_5 VDD VSS NOR2_X1
XI1850_I73_XG I1850_pn7 I1850_gn6 I1850_gn7 I1850_G7_6 VDD VSS OAI21_X1
XI1850_I73_XP I1850_pn7 I1850_pn6 I1850_P7_6 VDD VSS NOR2_X1
XI1850_I74_XG I1850_pn8 I1850_gn7 I1850_gn8 I1850_G8_7 VDD VSS OAI21_X1
XI1850_I74_XP I1850_pn8 I1850_pn7 I1850_P8_7 VDD VSS NOR2_X1
XI1850_I75_XG I1850_pn9 I1850_gn8 I1850_gn9 I1850_G9_8 VDD VSS OAI21_X1
XI1850_I75_XP I1850_pn9 I1850_pn8 I1850_P9_8 VDD VSS NOR2_X1
XI1850_I76_XG I1850_pn10 I1850_gn9 I1850_gn10 I1850_G10_9 VDD VSS OAI21_X1
XI1850_I76_XP I1850_pn10 I1850_pn9 I1850_P10_9 VDD VSS NOR2_X1
XI1850_I77_XG I1850_pn11 I1850_gn10 I1850_gn11 I1850_G11_10 VDD VSS OAI21_X1
XI1850_I77_XP I1850_pn11 I1850_pn10 I1850_P11_10 VDD VSS NOR2_X1
XI1850_I78_XG I1850_pn12 I1850_gn11 I1850_gn12 I1850_G12_11 VDD VSS OAI21_X1
XI1850_I78_XP I1850_pn12 I1850_pn11 I1850_P12_11 VDD VSS NOR2_X1
XI1850_I79_XG I1850_pn13 I1850_gn12 I1850_gn13 I1850_G13_12 VDD VSS OAI21_X1
XI1850_I79_XP I1850_pn13 I1850_pn12 I1850_P13_12 VDD VSS NOR2_X1
XI1850_I80_XG I1850_pn14 I1850_gn13 I1850_gn14 I1850_G14_13 VDD VSS OAI21_X1
XI1850_I80_XP I1850_pn14 I1850_pn13 I1850_P14_13 VDD VSS NOR2_X1
XI1850_I81_XG I1850_pn15 I1850_gn14 I1850_gn15 I1850_G15_14 VDD VSS OAI21_X1
XI1850_I81_XP I1850_pn15 I1850_pn14 I1850_P15_14 VDD VSS NOR2_X1
XI1850_I82_XG I1850_pn16 I1850_gn15 I1850_gn16 I1850_G16_15 VDD VSS OAI21_X1
XI1850_I82_XP I1850_pn16 I1850_pn15 I1850_P16_15 VDD VSS NOR2_X1
XI1850_I83_XG I1850_pn17 I1850_gn16 I1850_gn17 I1850_G17_16 VDD VSS OAI21_X1
XI1850_I83_XP I1850_pn17 I1850_pn16 I1850_P17_16 VDD VSS NOR2_X1
XI1850_I84_XG I1850_pn18 I1850_gn17 I1850_gn18 I1850_G18_17 VDD VSS OAI21_X1
XI1850_I84_XP I1850_pn18 I1850_pn17 I1850_P18_17 VDD VSS NOR2_X1
XI1850_I85_XG I1850_pn19 I1850_gn18 I1850_gn19 I1850_G19_18 VDD VSS OAI21_X1
XI1850_I85_XP I1850_pn19 I1850_pn18 I1850_P19_18 VDD VSS NOR2_X1
XI1850_I86_XG I1850_pn20 I1850_gn19 I1850_gn20 I1850_G20_19 VDD VSS OAI21_X1
XI1850_I86_XP I1850_pn20 I1850_pn19 I1850_P20_19 VDD VSS NOR2_X1
XI1850_I87_XG I1850_pn21 I1850_gn20 I1850_gn21 I1850_G21_20 VDD VSS OAI21_X1
XI1850_I87_XP I1850_pn21 I1850_pn20 I1850_P21_20 VDD VSS NOR2_X1
XI1850_I88_XG I1850_pn22 I1850_gn21 I1850_gn22 I1850_G22_21 VDD VSS OAI21_X1
XI1850_I88_XP I1850_pn22 I1850_pn21 I1850_P22_21 VDD VSS NOR2_X1
XI1850_I89_XG I1850_pn23 I1850_gn22 I1850_gn23 I1850_G23_22 VDD VSS OAI21_X1
XI1850_I89_XP I1850_pn23 I1850_pn22 I1850_P23_22 VDD VSS NOR2_X1
XI1850_I90_XG I1850_pn24 I1850_gn23 I1850_gn24 I1850_G24_23 VDD VSS OAI21_X1
XI1850_I90_XP I1850_pn24 I1850_pn23 I1850_P24_23 VDD VSS NOR2_X1
XI1850_I91_XG I1850_pn25 I1850_gn24 I1850_gn25 I1850_G25_24 VDD VSS OAI21_X1
XI1850_I91_XP I1850_pn25 I1850_pn24 I1850_P25_24 VDD VSS NOR2_X1
XI1850_I92_XG I1850_pn26 I1850_gn25 I1850_gn26 I1850_G26_25 VDD VSS OAI21_X1
XI1850_I92_XP I1850_pn26 I1850_pn25 I1850_P26_25 VDD VSS NOR2_X1
XI1850_I93_XG I1850_pn27 I1850_gn26 I1850_gn27 I1850_G27_26 VDD VSS OAI21_X1
XI1850_I93_XP I1850_pn27 I1850_pn26 I1850_P27_26 VDD VSS NOR2_X1
XI1850_I94_XG I1850_pn28 I1850_gn27 I1850_gn28 I1850_G28_27 VDD VSS OAI21_X1
XI1850_I94_XP I1850_pn28 I1850_pn27 I1850_P28_27 VDD VSS NOR2_X1
XI1850_I95_XG I1850_pn29 I1850_gn28 I1850_gn29 I1850_G29_28 VDD VSS OAI21_X1
XI1850_I95_XP I1850_pn29 I1850_pn28 I1850_P29_28 VDD VSS NOR2_X1
XI1850_I96_XG I1850_pn30 I1850_gn29 I1850_gn30 I1850_G30_29 VDD VSS OAI21_X1
XI1850_I96_XP I1850_pn30 I1850_pn29 I1850_P30_29 VDD VSS NOR2_X1
XI1850_I97_XG I1850_pn31 I1850_gn30 I1850_gn31 I1850_G31_30 VDD VSS OAI21_X1
XI1850_I97_XP I1850_pn31 I1850_pn30 I1850_P31_30 VDD VSS NOR2_X1
XI1850_I98_XG I1850_P2_1 I1850_G0_0 I1850_G2_1 I1850_G2_0n VDD VSS AOI21_X1
XI1850_I99_XG I1850_P3_2 I1850_G1_0 I1850_G3_2 I1850_G3_0n VDD VSS AOI21_X1
XI1850_I100_XG I1850_P4_3 I1850_G2_1 I1850_G4_3 I1850_G4_1n VDD VSS AOI21_X1
XI1850_I100_XP I1850_P4_3 I1850_P2_1 I1850_P4_1n VDD VSS NAND2_X1
XI1850_I101_XG I1850_P5_4 I1850_G3_2 I1850_G5_4 I1850_G5_2n VDD VSS AOI21_X1
XI1850_I101_XP I1850_P5_4 I1850_P3_2 I1850_P5_2n VDD VSS NAND2_X1
XI1850_I102_XG I1850_P6_5 I1850_G4_3 I1850_G6_5 I1850_G6_3n VDD VSS AOI21_X1
XI1850_I102_XP I1850_P6_5 I1850_P4_3 I1850_P6_3n VDD VSS NAND2_X1
XI1850_I103_XG I1850_P7_6 I1850_G5_4 I1850_G7_6 I1850_G7_4n VDD VSS AOI21_X1
XI1850_I103_XP I1850_P7_6 I1850_P5_4 I1850_P7_4n VDD VSS NAND2_X1
XI1850_I104_XG I1850_P8_7 I1850_G6_5 I1850_G8_7 I1850_G8_5n VDD VSS AOI21_X1
XI1850_I104_XP I1850_P8_7 I1850_P6_5 I1850_P8_5n VDD VSS NAND2_X1
XI1850_I105_XG I1850_P9_8 I1850_G7_6 I1850_G9_8 I1850_G9_6n VDD VSS AOI21_X1
XI1850_I105_XP I1850_P9_8 I1850_P7_6 I1850_P9_6n VDD VSS NAND2_X1
XI1850_I106_XG I1850_P10_9 I1850_G8_7 I1850_G10_9 I1850_G10_7n VDD VSS AOI21_X1
XI1850_I106_XP I1850_P10_9 I1850_P8_7 I1850_P10_7n VDD VSS NAND2_X1
XI1850_I107_XG I1850_P11_10 I1850_G9_8 I1850_G11_10 I1850_G11_8n VDD VSS AOI21_X1
XI1850_I107_XP I1850_P11_10 I1850_P9_8 I1850_P11_8n VDD VSS NAND2_X1
XI1850_I108_XG I1850_P12_11 I1850_G10_9 I1850_G12_11 I1850_G12_9n VDD VSS AOI21_X1
XI1850_I108_XP I1850_P12_11 I1850_P10_9 I1850_P12_9n VDD VSS NAND2_X1
XI1850_I109_XG I1850_P13_12 I1850_G11_10 I1850_G13_12 I1850_G13_10n VDD VSS AOI21_X1
XI1850_I109_XP I1850_P13_12 I1850_P11_10 I1850_P13_10n VDD VSS NAND2_X1
XI1850_I110_XG I1850_P14_13 I1850_G12_11 I1850_G14_13 I1850_G14_11n VDD VSS AOI21_X1
XI1850_I110_XP I1850_P14_13 I1850_P12_11 I1850_P14_11n VDD VSS NAND2_X1
XI1850_I111_XG I1850_P15_14 I1850_G13_12 I1850_G15_14 I1850_G15_12n VDD VSS AOI21_X1
XI1850_I111_XP I1850_P15_14 I1850_P13_12 I1850_P15_12n VDD VSS NAND2_X1
XI1850_I112_XG I1850_P16_15 I1850_G14_13 I1850_G16_15 I1850_G16_13n VDD VSS AOI21_X1
XI1850_I112_XP I1850_P16_15 I1850_P14_13 I1850_P16_13n VDD VSS NAND2_X1
XI1850_I113_XG I1850_P17_16 I1850_G15_14 I1850_G17_16 I1850_G17_14n VDD VSS AOI21_X1
XI1850_I113_XP I1850_P17_16 I1850_P15_14 I1850_P17_14n VDD VSS NAND2_X1
XI1850_I114_XG I1850_P18_17 I1850_G16_15 I1850_G18_17 I1850_G18_15n VDD VSS AOI21_X1
XI1850_I114_XP I1850_P18_17 I1850_P16_15 I1850_P18_15n VDD VSS NAND2_X1
XI1850_I115_XG I1850_P19_18 I1850_G17_16 I1850_G19_18 I1850_G19_16n VDD VSS AOI21_X1
XI1850_I115_XP I1850_P19_18 I1850_P17_16 I1850_P19_16n VDD VSS NAND2_X1
XI1850_I116_XG I1850_P20_19 I1850_G18_17 I1850_G20_19 I1850_G20_17n VDD VSS AOI21_X1
XI1850_I116_XP I1850_P20_19 I1850_P18_17 I1850_P20_17n VDD VSS NAND2_X1
XI1850_I117_XG I1850_P21_20 I1850_G19_18 I1850_G21_20 I1850_G21_18n VDD VSS AOI21_X1
XI1850_I117_XP I1850_P21_20 I1850_P19_18 I1850_P21_18n VDD VSS NAND2_X1
XI1850_I118_XG I1850_P22_21 I1850_G20_19 I1850_G22_21 I1850_G22_19n VDD VSS AOI21_X1
XI1850_I118_XP I1850_P22_21 I1850_P20_19 I1850_P22_19n VDD VSS NAND2_X1
XI1850_I119_XG I1850_P23_22 I1850_G21_20 I1850_G23_22 I1850_G23_20n VDD VSS AOI21_X1
XI1850_I119_XP I1850_P23_22 I1850_P21_20 I1850_P23_20n VDD VSS NAND2_X1
XI1850_I120_XG I1850_P24_23 I1850_G22_21 I1850_G24_23 I1850_G24_21n VDD VSS AOI21_X1
XI1850_I120_XP I1850_P24_23 I1850_P22_21 I1850_P24_21n VDD VSS NAND2_X1
XI1850_I121_XG I1850_P25_24 I1850_G23_22 I1850_G25_24 I1850_G25_22n VDD VSS AOI21_X1
XI1850_I121_XP I1850_P25_24 I1850_P23_22 I1850_P25_22n VDD VSS NAND2_X1
XI1850_I122_XG I1850_P26_25 I1850_G24_23 I1850_G26_25 I1850_G26_23n VDD VSS AOI21_X1
XI1850_I122_XP I1850_P26_25 I1850_P24_23 I1850_P26_23n VDD VSS NAND2_X1
XI1850_I123_XG I1850_P27_26 I1850_G25_24 I1850_G27_26 I1850_G27_24n VDD VSS AOI21_X1
XI1850_I123_XP I1850_P27_26 I1850_P25_24 I1850_P27_24n VDD VSS NAND2_X1
XI1850_I124_XG I1850_P28_27 I1850_G26_25 I1850_G28_27 I1850_G28_25n VDD VSS AOI21_X1
XI1850_I124_XP I1850_P28_27 I1850_P26_25 I1850_P28_25n VDD VSS NAND2_X1
XI1850_I125_XG I1850_P29_28 I1850_G27_26 I1850_G29_28 I1850_G29_26n VDD VSS AOI21_X1
XI1850_I125_XP I1850_P29_28 I1850_P27_26 I1850_P29_26n VDD VSS NAND2_X1
XI1850_I126_XG I1850_P30_29 I1850_G28_27 I1850_G30_29 I1850_G30_27n VDD VSS AOI21_X1
XI1850_I126_XP I1850_P30_29 I1850_P28_27 I1850_P30_27n VDD VSS NAND2_X1
XI1850_I127_XG I1850_P31_30 I1850_G29_28 I1850_G31_30 I1850_G31_28n VDD VSS AOI21_X1
XI1850_I127_XP I1850_P31_30 I1850_P29_28 I1850_P31_28n VDD VSS NAND2_X1
XI1850_I128_XG I1850_P4_1n I1850_G0_0n I1850_G4_1n I1850_G4_0 VDD VSS OAI21_X1
XI1850_I129 I1850_G1_0 I1850_G1_0n VDD VSS INV_X1
XI1850_I130_XG I1850_P5_2n I1850_G1_0n I1850_G5_2n I1850_G5_0 VDD VSS OAI21_X1
XI1850_I131_XG I1850_P6_3n I1850_G2_0n I1850_G6_3n I1850_G6_0 VDD VSS OAI21_X1
XI1850_I132_XG I1850_P7_4n I1850_G3_0n I1850_G7_4n I1850_G7_0 VDD VSS OAI21_X1
XI1850_I133_XG I1850_P8_5n I1850_G4_1n I1850_G8_5n I1850_G8_1 VDD VSS OAI21_X1
XI1850_I133_XP I1850_P8_5n I1850_P4_1n I1850_P8_1 VDD VSS NOR2_X1
XI1850_I134_XG I1850_P9_6n I1850_G5_2n I1850_G9_6n I1850_G9_2 VDD VSS OAI21_X1
XI1850_I134_XP I1850_P9_6n I1850_P5_2n I1850_P9_2 VDD VSS NOR2_X1
XI1850_I135_XG I1850_P10_7n I1850_G6_3n I1850_G10_7n I1850_G10_3 VDD VSS OAI21_X1
XI1850_I135_XP I1850_P10_7n I1850_P6_3n I1850_P10_3 VDD VSS NOR2_X1
XI1850_I136_XG I1850_P11_8n I1850_G7_4n I1850_G11_8n I1850_G11_4 VDD VSS OAI21_X1
XI1850_I136_XP I1850_P11_8n I1850_P7_4n I1850_P11_4 VDD VSS NOR2_X1
XI1850_I137_XG I1850_P12_9n I1850_G8_5n I1850_G12_9n I1850_G12_5 VDD VSS OAI21_X1
XI1850_I137_XP I1850_P12_9n I1850_P8_5n I1850_P12_5 VDD VSS NOR2_X1
XI1850_I138_XG I1850_P13_10n I1850_G9_6n I1850_G13_10n I1850_G13_6 VDD VSS OAI21_X1
XI1850_I138_XP I1850_P13_10n I1850_P9_6n I1850_P13_6 VDD VSS NOR2_X1
XI1850_I139_XG I1850_P14_11n I1850_G10_7n I1850_G14_11n I1850_G14_7 VDD VSS OAI21_X1
XI1850_I139_XP I1850_P14_11n I1850_P10_7n I1850_P14_7 VDD VSS NOR2_X1
XI1850_I140_XG I1850_P15_12n I1850_G11_8n I1850_G15_12n I1850_G15_8 VDD VSS OAI21_X1
XI1850_I140_XP I1850_P15_12n I1850_P11_8n I1850_P15_8 VDD VSS NOR2_X1
XI1850_I141_XG I1850_P16_13n I1850_G12_9n I1850_G16_13n I1850_G16_9 VDD VSS OAI21_X1
XI1850_I141_XP I1850_P16_13n I1850_P12_9n I1850_P16_9 VDD VSS NOR2_X1
XI1850_I142_XG I1850_P17_14n I1850_G13_10n I1850_G17_14n I1850_G17_10 VDD VSS OAI21_X1
XI1850_I142_XP I1850_P17_14n I1850_P13_10n I1850_P17_10 VDD VSS NOR2_X1
XI1850_I143_XG I1850_P18_15n I1850_G14_11n I1850_G18_15n I1850_G18_11 VDD VSS OAI21_X1
XI1850_I143_XP I1850_P18_15n I1850_P14_11n I1850_P18_11 VDD VSS NOR2_X1
XI1850_I144_XG I1850_P19_16n I1850_G15_12n I1850_G19_16n I1850_G19_12 VDD VSS OAI21_X1
XI1850_I144_XP I1850_P19_16n I1850_P15_12n I1850_P19_12 VDD VSS NOR2_X1
XI1850_I145_XG I1850_P20_17n I1850_G16_13n I1850_G20_17n I1850_G20_13 VDD VSS OAI21_X1
XI1850_I145_XP I1850_P20_17n I1850_P16_13n I1850_P20_13 VDD VSS NOR2_X1
XI1850_I146_XG I1850_P21_18n I1850_G17_14n I1850_G21_18n I1850_G21_14 VDD VSS OAI21_X1
XI1850_I146_XP I1850_P21_18n I1850_P17_14n I1850_P21_14 VDD VSS NOR2_X1
XI1850_I147_XG I1850_P22_19n I1850_G18_15n I1850_G22_19n I1850_G22_15 VDD VSS OAI21_X1
XI1850_I147_XP I1850_P22_19n I1850_P18_15n I1850_P22_15 VDD VSS NOR2_X1
XI1850_I148_XG I1850_P23_20n I1850_G19_16n I1850_G23_20n I1850_G23_16 VDD VSS OAI21_X1
XI1850_I148_XP I1850_P23_20n I1850_P19_16n I1850_P23_16 VDD VSS NOR2_X1
XI1850_I149_XG I1850_P24_21n I1850_G20_17n I1850_G24_21n I1850_G24_17 VDD VSS OAI21_X1
XI1850_I149_XP I1850_P24_21n I1850_P20_17n I1850_P24_17 VDD VSS NOR2_X1
XI1850_I150_XG I1850_P25_22n I1850_G21_18n I1850_G25_22n I1850_G25_18 VDD VSS OAI21_X1
XI1850_I150_XP I1850_P25_22n I1850_P21_18n I1850_P25_18 VDD VSS NOR2_X1
XI1850_I151_XG I1850_P26_23n I1850_G22_19n I1850_G26_23n I1850_G26_19 VDD VSS OAI21_X1
XI1850_I151_XP I1850_P26_23n I1850_P22_19n I1850_P26_19 VDD VSS NOR2_X1
XI1850_I152_XG I1850_P27_24n I1850_G23_20n I1850_G27_24n I1850_G27_20 VDD VSS OAI21_X1
XI1850_I152_XP I1850_P27_24n I1850_P23_20n I1850_P27_20 VDD VSS NOR2_X1
XI1850_I153_XG I1850_P28_25n I1850_G24_21n I1850_G28_25n I1850_G28_21 VDD VSS OAI21_X1
XI1850_I153_XP I1850_P28_25n I1850_P24_21n I1850_P28_21 VDD VSS NOR2_X1
XI1850_I154_XG I1850_P29_26n I1850_G25_22n I1850_G29_26n I1850_G29_22 VDD VSS OAI21_X1
XI1850_I154_XP I1850_P29_26n I1850_P25_22n I1850_P29_22 VDD VSS NOR2_X1
XI1850_I155_XG I1850_P30_27n I1850_G26_23n I1850_G30_27n I1850_G30_23 VDD VSS OAI21_X1
XI1850_I155_XP I1850_P30_27n I1850_P26_23n I1850_P30_23 VDD VSS NOR2_X1
XI1850_I156_XG I1850_P31_28n I1850_G27_24n I1850_G31_28n I1850_G31_24 VDD VSS OAI21_X1
XI1850_I156_XP I1850_P31_28n I1850_P27_24n I1850_P31_24 VDD VSS NOR2_X1
XI1850_I157_XG I1850_P8_1 I1850_G0_0 I1850_G8_1 I1850_G8_0n VDD VSS AOI21_X1
XI1850_I158_XG I1850_P9_2 I1850_G1_0 I1850_G9_2 I1850_G9_0n VDD VSS AOI21_X1
XI1850_I159 I1850_G2_0n I1850_G2_0np VDD VSS INV_X1
XI1850_I160_XG I1850_P10_3 I1850_G2_0np I1850_G10_3 I1850_G10_0n VDD VSS AOI21_X1
XI1850_I161 I1850_G3_0n I1850_G3_0np VDD VSS INV_X1
XI1850_I162_XG I1850_P11_4 I1850_G3_0np I1850_G11_4 I1850_G11_0n VDD VSS AOI21_X1
XI1850_I163_XG I1850_P12_5 I1850_G4_0 I1850_G12_5 I1850_G12_0n VDD VSS AOI21_X1
XI1850_I164_XG I1850_P13_6 I1850_G5_0 I1850_G13_6 I1850_G13_0n VDD VSS AOI21_X1
XI1850_I165_XG I1850_P14_7 I1850_G6_0 I1850_G14_7 I1850_G14_0n VDD VSS AOI21_X1
XI1850_I166_XG I1850_P15_8 I1850_G7_0 I1850_G15_8 I1850_G15_0n VDD VSS AOI21_X1
XI1850_I167_XG I1850_P16_9 I1850_G8_1 I1850_G16_9 I1850_G16_1n VDD VSS AOI21_X1
XI1850_I167_XP I1850_P16_9 I1850_P8_1 I1850_P16_1n VDD VSS NAND2_X1
XI1850_I168_XG I1850_P17_10 I1850_G9_2 I1850_G17_10 I1850_G17_2n VDD VSS AOI21_X1
XI1850_I168_XP I1850_P17_10 I1850_P9_2 I1850_P17_2n VDD VSS NAND2_X1
XI1850_I169_XG I1850_P18_11 I1850_G10_3 I1850_G18_11 I1850_G18_3n VDD VSS AOI21_X1
XI1850_I169_XP I1850_P18_11 I1850_P10_3 I1850_P18_3n VDD VSS NAND2_X1
XI1850_I170_XG I1850_P19_12 I1850_G11_4 I1850_G19_12 I1850_G19_4n VDD VSS AOI21_X1
XI1850_I170_XP I1850_P19_12 I1850_P11_4 I1850_P19_4n VDD VSS NAND2_X1
XI1850_I171_XG I1850_P20_13 I1850_G12_5 I1850_G20_13 I1850_G20_5n VDD VSS AOI21_X1
XI1850_I171_XP I1850_P20_13 I1850_P12_5 I1850_P20_5n VDD VSS NAND2_X1
XI1850_I172_XG I1850_P21_14 I1850_G13_6 I1850_G21_14 I1850_G21_6n VDD VSS AOI21_X1
XI1850_I172_XP I1850_P21_14 I1850_P13_6 I1850_P21_6n VDD VSS NAND2_X1
XI1850_I173_XG I1850_P22_15 I1850_G14_7 I1850_G22_15 I1850_G22_7n VDD VSS AOI21_X1
XI1850_I173_XP I1850_P22_15 I1850_P14_7 I1850_P22_7n VDD VSS NAND2_X1
XI1850_I174_XG I1850_P23_16 I1850_G15_8 I1850_G23_16 I1850_G23_8n VDD VSS AOI21_X1
XI1850_I174_XP I1850_P23_16 I1850_P15_8 I1850_P23_8n VDD VSS NAND2_X1
XI1850_I175_XG I1850_P24_17 I1850_G16_9 I1850_G24_17 I1850_G24_9n VDD VSS AOI21_X1
XI1850_I175_XP I1850_P24_17 I1850_P16_9 I1850_P24_9n VDD VSS NAND2_X1
XI1850_I176_XG I1850_P25_18 I1850_G17_10 I1850_G25_18 I1850_G25_10n VDD VSS AOI21_X1
XI1850_I176_XP I1850_P25_18 I1850_P17_10 I1850_P25_10n VDD VSS NAND2_X1
XI1850_I177_XG I1850_P26_19 I1850_G18_11 I1850_G26_19 I1850_G26_11n VDD VSS AOI21_X1
XI1850_I177_XP I1850_P26_19 I1850_P18_11 I1850_P26_11n VDD VSS NAND2_X1
XI1850_I178_XG I1850_P27_20 I1850_G19_12 I1850_G27_20 I1850_G27_12n VDD VSS AOI21_X1
XI1850_I178_XP I1850_P27_20 I1850_P19_12 I1850_P27_12n VDD VSS NAND2_X1
XI1850_I179_XG I1850_P28_21 I1850_G20_13 I1850_G28_21 I1850_G28_13n VDD VSS AOI21_X1
XI1850_I179_XP I1850_P28_21 I1850_P20_13 I1850_P28_13n VDD VSS NAND2_X1
XI1850_I180_XG I1850_P29_22 I1850_G21_14 I1850_G29_22 I1850_G29_14n VDD VSS AOI21_X1
XI1850_I180_XP I1850_P29_22 I1850_P21_14 I1850_P29_14n VDD VSS NAND2_X1
XI1850_I181_XG I1850_P30_23 I1850_G22_15 I1850_G30_23 I1850_G30_15n VDD VSS AOI21_X1
XI1850_I181_XP I1850_P30_23 I1850_P22_15 I1850_P30_15n VDD VSS NAND2_X1
XI1850_I182_XG I1850_P31_24 I1850_G23_16 I1850_G31_24 I1850_G31_16n VDD VSS AOI21_X1
XI1850_I182_XP I1850_P31_24 I1850_P23_16 I1850_P31_16n VDD VSS NAND2_X1
XI1850_I183_XG I1850_P16_1n I1850_G0_0n I1850_G16_1n I1850_G16_0 VDD VSS OAI21_X1
XI1850_I184_XG I1850_P17_2n I1850_G1_0n I1850_G17_2n I1850_G17_0 VDD VSS OAI21_X1
XI1850_I185_XG I1850_P18_3n I1850_G2_0n I1850_G18_3n I1850_G18_0 VDD VSS OAI21_X1
XI1850_I186_XG I1850_P19_4n I1850_G3_0n I1850_G19_4n I1850_G19_0 VDD VSS OAI21_X1
XI1850_I187 I1850_G4_0 I1850_G4_0n VDD VSS INV_X1
XI1850_I188_XG I1850_P20_5n I1850_G4_0n I1850_G20_5n I1850_G20_0 VDD VSS OAI21_X1
XI1850_I189 I1850_G5_0 I1850_G5_0n VDD VSS INV_X1
XI1850_I190_XG I1850_P21_6n I1850_G5_0n I1850_G21_6n I1850_G21_0 VDD VSS OAI21_X1
XI1850_I191 I1850_G6_0 I1850_G6_0n VDD VSS INV_X1
XI1850_I192_XG I1850_P22_7n I1850_G6_0n I1850_G22_7n I1850_G22_0 VDD VSS OAI21_X1
XI1850_I193 I1850_G7_0 I1850_G7_0n VDD VSS INV_X1
XI1850_I194_XG I1850_P23_8n I1850_G7_0n I1850_G23_8n I1850_G23_0 VDD VSS OAI21_X1
XI1850_I195_XG I1850_P24_9n I1850_G8_0n I1850_G24_9n I1850_G24_0 VDD VSS OAI21_X1
XI1850_I196_XG I1850_P25_10n I1850_G9_0n I1850_G25_10n I1850_G25_0 VDD VSS OAI21_X1
XI1850_I197_XG I1850_P26_11n I1850_G10_0n I1850_G26_11n I1850_G26_0 VDD VSS OAI21_X1
XI1850_I198_XG I1850_P27_12n I1850_G11_0n I1850_G27_12n I1850_G27_0 VDD VSS OAI21_X1
XI1850_I199_XG I1850_P28_13n I1850_G12_0n I1850_G28_13n I1850_G28_0 VDD VSS OAI21_X1
XI1850_I200_XG I1850_P29_14n I1850_G13_0n I1850_G29_14n I1850_G29_0 VDD VSS OAI21_X1
XI1850_I201_XG I1850_P30_15n I1850_G14_0n I1850_G30_15n c28_m VDD VSS OAI21_X1
XI1850_I202_XG I1850_P31_16n I1850_G15_0n I1850_G31_16n c28_o VDD VSS OAI21_X1
XI1850_I203 I1850_pn0 qu4_b3_5 p28_0 VDD VSS XNOR2_X1
XI1850_I204 I1850_pn1 I1850_G0_0 p28_1 VDD VSS XNOR2_X1
XI1850_I205 I1850_pn2 I1850_G1_0 p28_2 VDD VSS XNOR2_X1
XI1850_I206 I1850_pn3 I1850_G2_0n p28_3 VDD VSS XOR2_X1
XI1850_I207 I1850_pn4 I1850_G3_0n p28_4 VDD VSS XOR2_X1
XI1850_I208 I1850_pn5 I1850_G4_0 p28_5 VDD VSS XNOR2_X1
XI1850_I209 I1850_pn6 I1850_G5_0 p28_6 VDD VSS XNOR2_X1
XI1850_I210 I1850_pn7 I1850_G6_0 p28_7 VDD VSS XNOR2_X1
XI1850_I211 I1850_pn8 I1850_G7_0 p28_8 VDD VSS XNOR2_X1
XI1850_I212 I1850_pn9 I1850_G8_0n p28_9 VDD VSS XOR2_X1
XI1850_I213 I1850_pn10 I1850_G9_0n p28_10 VDD VSS XOR2_X1
XI1850_I214 I1850_pn11 I1850_G10_0n p28_11 VDD VSS XOR2_X1
XI1850_I215 I1850_pn12 I1850_G11_0n p28_12 VDD VSS XOR2_X1
XI1850_I216 I1850_pn13 I1850_G12_0n p28_13 VDD VSS XOR2_X1
XI1850_I217 I1850_pn14 I1850_G13_0n p28_14 VDD VSS XOR2_X1
XI1850_I218 I1850_pn15 I1850_G14_0n p28_15 VDD VSS XOR2_X1
XI1850_I219 I1850_pn16 I1850_G15_0n p28_16 VDD VSS XOR2_X1
XI1850_I220 I1850_pn17 I1850_G16_0 p28_17 VDD VSS XNOR2_X1
XI1850_I221 I1850_pn18 I1850_G17_0 p28_18 VDD VSS XNOR2_X1
XI1850_I222 I1850_pn19 I1850_G18_0 p28_19 VDD VSS XNOR2_X1
XI1850_I223 I1850_pn20 I1850_G19_0 p28_20 VDD VSS XNOR2_X1
XI1850_I224 I1850_pn21 I1850_G20_0 p28_21 VDD VSS XNOR2_X1
XI1850_I225 I1850_pn22 I1850_G21_0 p28_22 VDD VSS XNOR2_X1
XI1850_I226 I1850_pn23 I1850_G22_0 p28_23 VDD VSS XNOR2_X1
XI1850_I227 I1850_pn24 I1850_G23_0 p28_24 VDD VSS XNOR2_X1
XI1850_I228 I1850_pn25 I1850_G24_0 p28_25 VDD VSS XNOR2_X1
XI1850_I229 I1850_pn26 I1850_G25_0 p28_26 VDD VSS XNOR2_X1
XI1850_I230 I1850_pn27 I1850_G26_0 p28_27 VDD VSS XNOR2_X1
XI1850_I231 I1850_pn28 I1850_G27_0 p28_28 VDD VSS XNOR2_X1
XI1850_I232 I1850_pn29 I1850_G28_0 p28_29 VDD VSS XNOR2_X1
XI1850_I233 I1850_pn30 I1850_G29_0 p28_30 VDD VSS XNOR2_X1
XI1850_I234 I1850_pn31 c28_m p28_31 VDD VSS XNOR2_X1
XI1851 p27_31 qu4_b3_5 h28 VDD VSS XOR2_X1
XI1852 h28 c28_o p28_32 VDD VSS XOR2_X1
XI1853 p28_32 qu3 VDD VSS INV_X4
XI1854 qu3 qu3_b0 VDD VSS INV_X1
XI1855 qu3_b0 qu3_b1_0 VDD VSS INV_X4
XI1856 qu3_b1_0 qu3_b2_0 VDD VSS INV_X4
XI1857 qu3_b1_0 qu3_b2_1 VDD VSS INV_X4
XI1858 qu3_b2_0 qu3_b3_0 VDD VSS INV_X4
XI1859 qu3_b2_0 qu3_b3_1 VDD VSS INV_X4
XI1860 qu3_b2_0 qu3_b3_2 VDD VSS INV_X4
XI1861 qu3_b2_1 qu3_b3_3 VDD VSS INV_X4
XI1862 qu3_b2_1 qu3_b3_4 VDD VSS INV_X4
XI1863 qu3_b2_1 qu3_b3_5 VDD VSS INV_X4
XI1864 B_0_b3_5 qu3_b3_0 b29_0 VDD VSS XOR2_X1
XI1865 dd1_b3_5 qu3_b3_0 b29_1 VDD VSS XOR2_X1
XI1866 dd2_b3_5 qu3_b3_0 b29_2 VDD VSS XOR2_X1
XI1867 dd3_b3_5 qu3_b3_0 b29_3 VDD VSS XOR2_X1
XI1868 dd4_b3_5 qu3_b3_0 b29_4 VDD VSS XOR2_X1
XI1869 dd5_b3_5 qu3_b3_0 b29_5 VDD VSS XOR2_X1
XI1870 dd6_b3_5 qu3_b3_1 b29_6 VDD VSS XOR2_X1
XI1871 dd7_b3_5 qu3_b3_1 b29_7 VDD VSS XOR2_X1
XI1872 dd8_b3_5 qu3_b3_1 b29_8 VDD VSS XOR2_X1
XI1873 dd9_b3_5 qu3_b3_1 b29_9 VDD VSS XOR2_X1
XI1874 dd10_b3_5 qu3_b3_1 b29_10 VDD VSS XOR2_X1
XI1875 dd11_b3_5 qu3_b3_1 b29_11 VDD VSS XOR2_X1
XI1876 dd12_b3_5 qu3_b3_2 b29_12 VDD VSS XOR2_X1
XI1877 dd13_b3_5 qu3_b3_2 b29_13 VDD VSS XOR2_X1
XI1878 dd14_b3_5 qu3_b3_2 b29_14 VDD VSS XOR2_X1
XI1879 dd15_b3_5 qu3_b3_2 b29_15 VDD VSS XOR2_X1
XI1880 dd16_b3_5 qu3_b3_2 b29_16 VDD VSS XOR2_X1
XI1881 dd17_b3_5 qu3_b3_2 b29_17 VDD VSS XOR2_X1
XI1882 dd18_b3_5 qu3_b3_3 b29_18 VDD VSS XOR2_X1
XI1883 dd19_b3_5 qu3_b3_3 b29_19 VDD VSS XOR2_X1
XI1884 dd20_b3_5 qu3_b3_3 b29_20 VDD VSS XOR2_X1
XI1885 dd21_b3_5 qu3_b3_3 b29_21 VDD VSS XOR2_X1
XI1886 dd22_b3_5 qu3_b3_3 b29_22 VDD VSS XOR2_X1
XI1887 dd23_b3_5 qu3_b3_3 b29_23 VDD VSS XOR2_X1
XI1888 dd24_b3_5 qu3_b3_4 b29_24 VDD VSS XOR2_X1
XI1889 dd25_b3_5 qu3_b3_4 b29_25 VDD VSS XOR2_X1
XI1890 dd26_b3_5 qu3_b3_4 b29_26 VDD VSS XOR2_X1
XI1891 dd27_b3_5 qu3_b3_4 b29_27 VDD VSS XOR2_X1
XI1892 dd28_b3_5 qu3_b3_4 b29_28 VDD VSS XOR2_X1
XI1893 dd29_b3_5 qu3_b3_4 b29_29 VDD VSS XOR2_X1
XI1894 dd30_b3_5 qu3_b3_5 b29_30 VDD VSS XOR2_X1
XI1895 dd31_b3_5 qu3_b3_5 b29_31 VDD VSS XOR2_X1
XI1896_I0 aa2 b29_0 I1896_gn0 VDD VSS NAND2_X1
XI1896_I1 p28_0 b29_1 I1896_gn1 VDD VSS NAND2_X1
XI1896_I2 p28_1 b29_2 I1896_gn2 VDD VSS NAND2_X1
XI1896_I3 p28_2 b29_3 I1896_gn3 VDD VSS NAND2_X1
XI1896_I4 p28_3 b29_4 I1896_gn4 VDD VSS NAND2_X1
XI1896_I5 p28_4 b29_5 I1896_gn5 VDD VSS NAND2_X1
XI1896_I6 p28_5 b29_6 I1896_gn6 VDD VSS NAND2_X1
XI1896_I7 p28_6 b29_7 I1896_gn7 VDD VSS NAND2_X1
XI1896_I8 p28_7 b29_8 I1896_gn8 VDD VSS NAND2_X1
XI1896_I9 p28_8 b29_9 I1896_gn9 VDD VSS NAND2_X1
XI1896_I10 p28_9 b29_10 I1896_gn10 VDD VSS NAND2_X1
XI1896_I11 p28_10 b29_11 I1896_gn11 VDD VSS NAND2_X1
XI1896_I12 p28_11 b29_12 I1896_gn12 VDD VSS NAND2_X1
XI1896_I13 p28_12 b29_13 I1896_gn13 VDD VSS NAND2_X1
XI1896_I14 p28_13 b29_14 I1896_gn14 VDD VSS NAND2_X1
XI1896_I15 p28_14 b29_15 I1896_gn15 VDD VSS NAND2_X1
XI1896_I16 p28_15 b29_16 I1896_gn16 VDD VSS NAND2_X1
XI1896_I17 p28_16 b29_17 I1896_gn17 VDD VSS NAND2_X1
XI1896_I18 p28_17 b29_18 I1896_gn18 VDD VSS NAND2_X1
XI1896_I19 p28_18 b29_19 I1896_gn19 VDD VSS NAND2_X1
XI1896_I20 p28_19 b29_20 I1896_gn20 VDD VSS NAND2_X1
XI1896_I21 p28_20 b29_21 I1896_gn21 VDD VSS NAND2_X1
XI1896_I22 p28_21 b29_22 I1896_gn22 VDD VSS NAND2_X1
XI1896_I23 p28_22 b29_23 I1896_gn23 VDD VSS NAND2_X1
XI1896_I24 p28_23 b29_24 I1896_gn24 VDD VSS NAND2_X1
XI1896_I25 p28_24 b29_25 I1896_gn25 VDD VSS NAND2_X1
XI1896_I26 p28_25 b29_26 I1896_gn26 VDD VSS NAND2_X1
XI1896_I27 p28_26 b29_27 I1896_gn27 VDD VSS NAND2_X1
XI1896_I28 p28_27 b29_28 I1896_gn28 VDD VSS NAND2_X1
XI1896_I29 p28_28 b29_29 I1896_gn29 VDD VSS NAND2_X1
XI1896_I30 p28_29 b29_30 I1896_gn30 VDD VSS NAND2_X1
XI1896_I31 p28_30 b29_31 I1896_gn31 VDD VSS NAND2_X1
XI1896_I32 aa2 b29_0 I1896_pn0 VDD VSS XNOR2_X1
XI1896_I33 p28_0 b29_1 I1896_pn1 VDD VSS XNOR2_X1
XI1896_I34 p28_1 b29_2 I1896_pn2 VDD VSS XNOR2_X1
XI1896_I35 p28_2 b29_3 I1896_pn3 VDD VSS XNOR2_X1
XI1896_I36 p28_3 b29_4 I1896_pn4 VDD VSS XNOR2_X1
XI1896_I37 p28_4 b29_5 I1896_pn5 VDD VSS XNOR2_X1
XI1896_I38 p28_5 b29_6 I1896_pn6 VDD VSS XNOR2_X1
XI1896_I39 p28_6 b29_7 I1896_pn7 VDD VSS XNOR2_X1
XI1896_I40 p28_7 b29_8 I1896_pn8 VDD VSS XNOR2_X1
XI1896_I41 p28_8 b29_9 I1896_pn9 VDD VSS XNOR2_X1
XI1896_I42 p28_9 b29_10 I1896_pn10 VDD VSS XNOR2_X1
XI1896_I43 p28_10 b29_11 I1896_pn11 VDD VSS XNOR2_X1
XI1896_I44 p28_11 b29_12 I1896_pn12 VDD VSS XNOR2_X1
XI1896_I45 p28_12 b29_13 I1896_pn13 VDD VSS XNOR2_X1
XI1896_I46 p28_13 b29_14 I1896_pn14 VDD VSS XNOR2_X1
XI1896_I47 p28_14 b29_15 I1896_pn15 VDD VSS XNOR2_X1
XI1896_I48 p28_15 b29_16 I1896_pn16 VDD VSS XNOR2_X1
XI1896_I49 p28_16 b29_17 I1896_pn17 VDD VSS XNOR2_X1
XI1896_I50 p28_17 b29_18 I1896_pn18 VDD VSS XNOR2_X1
XI1896_I51 p28_18 b29_19 I1896_pn19 VDD VSS XNOR2_X1
XI1896_I52 p28_19 b29_20 I1896_pn20 VDD VSS XNOR2_X1
XI1896_I53 p28_20 b29_21 I1896_pn21 VDD VSS XNOR2_X1
XI1896_I54 p28_21 b29_22 I1896_pn22 VDD VSS XNOR2_X1
XI1896_I55 p28_22 b29_23 I1896_pn23 VDD VSS XNOR2_X1
XI1896_I56 p28_23 b29_24 I1896_pn24 VDD VSS XNOR2_X1
XI1896_I57 p28_24 b29_25 I1896_pn25 VDD VSS XNOR2_X1
XI1896_I58 p28_25 b29_26 I1896_pn26 VDD VSS XNOR2_X1
XI1896_I59 p28_26 b29_27 I1896_pn27 VDD VSS XNOR2_X1
XI1896_I60 p28_27 b29_28 I1896_pn28 VDD VSS XNOR2_X1
XI1896_I61 p28_28 b29_29 I1896_pn29 VDD VSS XNOR2_X1
XI1896_I62 p28_29 b29_30 I1896_pn30 VDD VSS XNOR2_X1
XI1896_I63 p28_30 b29_31 I1896_pn31 VDD VSS XNOR2_X1
XI1896_I64 qu3_b3_5 I1896_cinn VDD VSS INV_X1
XI1896_I65_XG I1896_pn0 I1896_cinn I1896_gn0 I1896_G0_0 VDD VSS OAI21_X1
XI1896_I66 I1896_G0_0 I1896_G0_0n VDD VSS INV_X1
XI1896_I67_XG I1896_pn1 I1896_G0_0n I1896_gn1 I1896_G1_0 VDD VSS OAI21_X1
XI1896_I68_XG I1896_pn2 I1896_gn1 I1896_gn2 I1896_G2_1 VDD VSS OAI21_X1
XI1896_I68_XP I1896_pn2 I1896_pn1 I1896_P2_1 VDD VSS NOR2_X1
XI1896_I69_XG I1896_pn3 I1896_gn2 I1896_gn3 I1896_G3_2 VDD VSS OAI21_X1
XI1896_I69_XP I1896_pn3 I1896_pn2 I1896_P3_2 VDD VSS NOR2_X1
XI1896_I70_XG I1896_pn4 I1896_gn3 I1896_gn4 I1896_G4_3 VDD VSS OAI21_X1
XI1896_I70_XP I1896_pn4 I1896_pn3 I1896_P4_3 VDD VSS NOR2_X1
XI1896_I71_XG I1896_pn5 I1896_gn4 I1896_gn5 I1896_G5_4 VDD VSS OAI21_X1
XI1896_I71_XP I1896_pn5 I1896_pn4 I1896_P5_4 VDD VSS NOR2_X1
XI1896_I72_XG I1896_pn6 I1896_gn5 I1896_gn6 I1896_G6_5 VDD VSS OAI21_X1
XI1896_I72_XP I1896_pn6 I1896_pn5 I1896_P6_5 VDD VSS NOR2_X1
XI1896_I73_XG I1896_pn7 I1896_gn6 I1896_gn7 I1896_G7_6 VDD VSS OAI21_X1
XI1896_I73_XP I1896_pn7 I1896_pn6 I1896_P7_6 VDD VSS NOR2_X1
XI1896_I74_XG I1896_pn8 I1896_gn7 I1896_gn8 I1896_G8_7 VDD VSS OAI21_X1
XI1896_I74_XP I1896_pn8 I1896_pn7 I1896_P8_7 VDD VSS NOR2_X1
XI1896_I75_XG I1896_pn9 I1896_gn8 I1896_gn9 I1896_G9_8 VDD VSS OAI21_X1
XI1896_I75_XP I1896_pn9 I1896_pn8 I1896_P9_8 VDD VSS NOR2_X1
XI1896_I76_XG I1896_pn10 I1896_gn9 I1896_gn10 I1896_G10_9 VDD VSS OAI21_X1
XI1896_I76_XP I1896_pn10 I1896_pn9 I1896_P10_9 VDD VSS NOR2_X1
XI1896_I77_XG I1896_pn11 I1896_gn10 I1896_gn11 I1896_G11_10 VDD VSS OAI21_X1
XI1896_I77_XP I1896_pn11 I1896_pn10 I1896_P11_10 VDD VSS NOR2_X1
XI1896_I78_XG I1896_pn12 I1896_gn11 I1896_gn12 I1896_G12_11 VDD VSS OAI21_X1
XI1896_I78_XP I1896_pn12 I1896_pn11 I1896_P12_11 VDD VSS NOR2_X1
XI1896_I79_XG I1896_pn13 I1896_gn12 I1896_gn13 I1896_G13_12 VDD VSS OAI21_X1
XI1896_I79_XP I1896_pn13 I1896_pn12 I1896_P13_12 VDD VSS NOR2_X1
XI1896_I80_XG I1896_pn14 I1896_gn13 I1896_gn14 I1896_G14_13 VDD VSS OAI21_X1
XI1896_I80_XP I1896_pn14 I1896_pn13 I1896_P14_13 VDD VSS NOR2_X1
XI1896_I81_XG I1896_pn15 I1896_gn14 I1896_gn15 I1896_G15_14 VDD VSS OAI21_X1
XI1896_I81_XP I1896_pn15 I1896_pn14 I1896_P15_14 VDD VSS NOR2_X1
XI1896_I82_XG I1896_pn16 I1896_gn15 I1896_gn16 I1896_G16_15 VDD VSS OAI21_X1
XI1896_I82_XP I1896_pn16 I1896_pn15 I1896_P16_15 VDD VSS NOR2_X1
XI1896_I83_XG I1896_pn17 I1896_gn16 I1896_gn17 I1896_G17_16 VDD VSS OAI21_X1
XI1896_I83_XP I1896_pn17 I1896_pn16 I1896_P17_16 VDD VSS NOR2_X1
XI1896_I84_XG I1896_pn18 I1896_gn17 I1896_gn18 I1896_G18_17 VDD VSS OAI21_X1
XI1896_I84_XP I1896_pn18 I1896_pn17 I1896_P18_17 VDD VSS NOR2_X1
XI1896_I85_XG I1896_pn19 I1896_gn18 I1896_gn19 I1896_G19_18 VDD VSS OAI21_X1
XI1896_I85_XP I1896_pn19 I1896_pn18 I1896_P19_18 VDD VSS NOR2_X1
XI1896_I86_XG I1896_pn20 I1896_gn19 I1896_gn20 I1896_G20_19 VDD VSS OAI21_X1
XI1896_I86_XP I1896_pn20 I1896_pn19 I1896_P20_19 VDD VSS NOR2_X1
XI1896_I87_XG I1896_pn21 I1896_gn20 I1896_gn21 I1896_G21_20 VDD VSS OAI21_X1
XI1896_I87_XP I1896_pn21 I1896_pn20 I1896_P21_20 VDD VSS NOR2_X1
XI1896_I88_XG I1896_pn22 I1896_gn21 I1896_gn22 I1896_G22_21 VDD VSS OAI21_X1
XI1896_I88_XP I1896_pn22 I1896_pn21 I1896_P22_21 VDD VSS NOR2_X1
XI1896_I89_XG I1896_pn23 I1896_gn22 I1896_gn23 I1896_G23_22 VDD VSS OAI21_X1
XI1896_I89_XP I1896_pn23 I1896_pn22 I1896_P23_22 VDD VSS NOR2_X1
XI1896_I90_XG I1896_pn24 I1896_gn23 I1896_gn24 I1896_G24_23 VDD VSS OAI21_X1
XI1896_I90_XP I1896_pn24 I1896_pn23 I1896_P24_23 VDD VSS NOR2_X1
XI1896_I91_XG I1896_pn25 I1896_gn24 I1896_gn25 I1896_G25_24 VDD VSS OAI21_X1
XI1896_I91_XP I1896_pn25 I1896_pn24 I1896_P25_24 VDD VSS NOR2_X1
XI1896_I92_XG I1896_pn26 I1896_gn25 I1896_gn26 I1896_G26_25 VDD VSS OAI21_X1
XI1896_I92_XP I1896_pn26 I1896_pn25 I1896_P26_25 VDD VSS NOR2_X1
XI1896_I93_XG I1896_pn27 I1896_gn26 I1896_gn27 I1896_G27_26 VDD VSS OAI21_X1
XI1896_I93_XP I1896_pn27 I1896_pn26 I1896_P27_26 VDD VSS NOR2_X1
XI1896_I94_XG I1896_pn28 I1896_gn27 I1896_gn28 I1896_G28_27 VDD VSS OAI21_X1
XI1896_I94_XP I1896_pn28 I1896_pn27 I1896_P28_27 VDD VSS NOR2_X1
XI1896_I95_XG I1896_pn29 I1896_gn28 I1896_gn29 I1896_G29_28 VDD VSS OAI21_X1
XI1896_I95_XP I1896_pn29 I1896_pn28 I1896_P29_28 VDD VSS NOR2_X1
XI1896_I96_XG I1896_pn30 I1896_gn29 I1896_gn30 I1896_G30_29 VDD VSS OAI21_X1
XI1896_I96_XP I1896_pn30 I1896_pn29 I1896_P30_29 VDD VSS NOR2_X1
XI1896_I97_XG I1896_pn31 I1896_gn30 I1896_gn31 I1896_G31_30 VDD VSS OAI21_X1
XI1896_I97_XP I1896_pn31 I1896_pn30 I1896_P31_30 VDD VSS NOR2_X1
XI1896_I98_XG I1896_P2_1 I1896_G0_0 I1896_G2_1 I1896_G2_0n VDD VSS AOI21_X1
XI1896_I99_XG I1896_P3_2 I1896_G1_0 I1896_G3_2 I1896_G3_0n VDD VSS AOI21_X1
XI1896_I100_XG I1896_P4_3 I1896_G2_1 I1896_G4_3 I1896_G4_1n VDD VSS AOI21_X1
XI1896_I100_XP I1896_P4_3 I1896_P2_1 I1896_P4_1n VDD VSS NAND2_X1
XI1896_I101_XG I1896_P5_4 I1896_G3_2 I1896_G5_4 I1896_G5_2n VDD VSS AOI21_X1
XI1896_I101_XP I1896_P5_4 I1896_P3_2 I1896_P5_2n VDD VSS NAND2_X1
XI1896_I102_XG I1896_P6_5 I1896_G4_3 I1896_G6_5 I1896_G6_3n VDD VSS AOI21_X1
XI1896_I102_XP I1896_P6_5 I1896_P4_3 I1896_P6_3n VDD VSS NAND2_X1
XI1896_I103_XG I1896_P7_6 I1896_G5_4 I1896_G7_6 I1896_G7_4n VDD VSS AOI21_X1
XI1896_I103_XP I1896_P7_6 I1896_P5_4 I1896_P7_4n VDD VSS NAND2_X1
XI1896_I104_XG I1896_P8_7 I1896_G6_5 I1896_G8_7 I1896_G8_5n VDD VSS AOI21_X1
XI1896_I104_XP I1896_P8_7 I1896_P6_5 I1896_P8_5n VDD VSS NAND2_X1
XI1896_I105_XG I1896_P9_8 I1896_G7_6 I1896_G9_8 I1896_G9_6n VDD VSS AOI21_X1
XI1896_I105_XP I1896_P9_8 I1896_P7_6 I1896_P9_6n VDD VSS NAND2_X1
XI1896_I106_XG I1896_P10_9 I1896_G8_7 I1896_G10_9 I1896_G10_7n VDD VSS AOI21_X1
XI1896_I106_XP I1896_P10_9 I1896_P8_7 I1896_P10_7n VDD VSS NAND2_X1
XI1896_I107_XG I1896_P11_10 I1896_G9_8 I1896_G11_10 I1896_G11_8n VDD VSS AOI21_X1
XI1896_I107_XP I1896_P11_10 I1896_P9_8 I1896_P11_8n VDD VSS NAND2_X1
XI1896_I108_XG I1896_P12_11 I1896_G10_9 I1896_G12_11 I1896_G12_9n VDD VSS AOI21_X1
XI1896_I108_XP I1896_P12_11 I1896_P10_9 I1896_P12_9n VDD VSS NAND2_X1
XI1896_I109_XG I1896_P13_12 I1896_G11_10 I1896_G13_12 I1896_G13_10n VDD VSS AOI21_X1
XI1896_I109_XP I1896_P13_12 I1896_P11_10 I1896_P13_10n VDD VSS NAND2_X1
XI1896_I110_XG I1896_P14_13 I1896_G12_11 I1896_G14_13 I1896_G14_11n VDD VSS AOI21_X1
XI1896_I110_XP I1896_P14_13 I1896_P12_11 I1896_P14_11n VDD VSS NAND2_X1
XI1896_I111_XG I1896_P15_14 I1896_G13_12 I1896_G15_14 I1896_G15_12n VDD VSS AOI21_X1
XI1896_I111_XP I1896_P15_14 I1896_P13_12 I1896_P15_12n VDD VSS NAND2_X1
XI1896_I112_XG I1896_P16_15 I1896_G14_13 I1896_G16_15 I1896_G16_13n VDD VSS AOI21_X1
XI1896_I112_XP I1896_P16_15 I1896_P14_13 I1896_P16_13n VDD VSS NAND2_X1
XI1896_I113_XG I1896_P17_16 I1896_G15_14 I1896_G17_16 I1896_G17_14n VDD VSS AOI21_X1
XI1896_I113_XP I1896_P17_16 I1896_P15_14 I1896_P17_14n VDD VSS NAND2_X1
XI1896_I114_XG I1896_P18_17 I1896_G16_15 I1896_G18_17 I1896_G18_15n VDD VSS AOI21_X1
XI1896_I114_XP I1896_P18_17 I1896_P16_15 I1896_P18_15n VDD VSS NAND2_X1
XI1896_I115_XG I1896_P19_18 I1896_G17_16 I1896_G19_18 I1896_G19_16n VDD VSS AOI21_X1
XI1896_I115_XP I1896_P19_18 I1896_P17_16 I1896_P19_16n VDD VSS NAND2_X1
XI1896_I116_XG I1896_P20_19 I1896_G18_17 I1896_G20_19 I1896_G20_17n VDD VSS AOI21_X1
XI1896_I116_XP I1896_P20_19 I1896_P18_17 I1896_P20_17n VDD VSS NAND2_X1
XI1896_I117_XG I1896_P21_20 I1896_G19_18 I1896_G21_20 I1896_G21_18n VDD VSS AOI21_X1
XI1896_I117_XP I1896_P21_20 I1896_P19_18 I1896_P21_18n VDD VSS NAND2_X1
XI1896_I118_XG I1896_P22_21 I1896_G20_19 I1896_G22_21 I1896_G22_19n VDD VSS AOI21_X1
XI1896_I118_XP I1896_P22_21 I1896_P20_19 I1896_P22_19n VDD VSS NAND2_X1
XI1896_I119_XG I1896_P23_22 I1896_G21_20 I1896_G23_22 I1896_G23_20n VDD VSS AOI21_X1
XI1896_I119_XP I1896_P23_22 I1896_P21_20 I1896_P23_20n VDD VSS NAND2_X1
XI1896_I120_XG I1896_P24_23 I1896_G22_21 I1896_G24_23 I1896_G24_21n VDD VSS AOI21_X1
XI1896_I120_XP I1896_P24_23 I1896_P22_21 I1896_P24_21n VDD VSS NAND2_X1
XI1896_I121_XG I1896_P25_24 I1896_G23_22 I1896_G25_24 I1896_G25_22n VDD VSS AOI21_X1
XI1896_I121_XP I1896_P25_24 I1896_P23_22 I1896_P25_22n VDD VSS NAND2_X1
XI1896_I122_XG I1896_P26_25 I1896_G24_23 I1896_G26_25 I1896_G26_23n VDD VSS AOI21_X1
XI1896_I122_XP I1896_P26_25 I1896_P24_23 I1896_P26_23n VDD VSS NAND2_X1
XI1896_I123_XG I1896_P27_26 I1896_G25_24 I1896_G27_26 I1896_G27_24n VDD VSS AOI21_X1
XI1896_I123_XP I1896_P27_26 I1896_P25_24 I1896_P27_24n VDD VSS NAND2_X1
XI1896_I124_XG I1896_P28_27 I1896_G26_25 I1896_G28_27 I1896_G28_25n VDD VSS AOI21_X1
XI1896_I124_XP I1896_P28_27 I1896_P26_25 I1896_P28_25n VDD VSS NAND2_X1
XI1896_I125_XG I1896_P29_28 I1896_G27_26 I1896_G29_28 I1896_G29_26n VDD VSS AOI21_X1
XI1896_I125_XP I1896_P29_28 I1896_P27_26 I1896_P29_26n VDD VSS NAND2_X1
XI1896_I126_XG I1896_P30_29 I1896_G28_27 I1896_G30_29 I1896_G30_27n VDD VSS AOI21_X1
XI1896_I126_XP I1896_P30_29 I1896_P28_27 I1896_P30_27n VDD VSS NAND2_X1
XI1896_I127_XG I1896_P31_30 I1896_G29_28 I1896_G31_30 I1896_G31_28n VDD VSS AOI21_X1
XI1896_I127_XP I1896_P31_30 I1896_P29_28 I1896_P31_28n VDD VSS NAND2_X1
XI1896_I128_XG I1896_P4_1n I1896_G0_0n I1896_G4_1n I1896_G4_0 VDD VSS OAI21_X1
XI1896_I129 I1896_G1_0 I1896_G1_0n VDD VSS INV_X1
XI1896_I130_XG I1896_P5_2n I1896_G1_0n I1896_G5_2n I1896_G5_0 VDD VSS OAI21_X1
XI1896_I131_XG I1896_P6_3n I1896_G2_0n I1896_G6_3n I1896_G6_0 VDD VSS OAI21_X1
XI1896_I132_XG I1896_P7_4n I1896_G3_0n I1896_G7_4n I1896_G7_0 VDD VSS OAI21_X1
XI1896_I133_XG I1896_P8_5n I1896_G4_1n I1896_G8_5n I1896_G8_1 VDD VSS OAI21_X1
XI1896_I133_XP I1896_P8_5n I1896_P4_1n I1896_P8_1 VDD VSS NOR2_X1
XI1896_I134_XG I1896_P9_6n I1896_G5_2n I1896_G9_6n I1896_G9_2 VDD VSS OAI21_X1
XI1896_I134_XP I1896_P9_6n I1896_P5_2n I1896_P9_2 VDD VSS NOR2_X1
XI1896_I135_XG I1896_P10_7n I1896_G6_3n I1896_G10_7n I1896_G10_3 VDD VSS OAI21_X1
XI1896_I135_XP I1896_P10_7n I1896_P6_3n I1896_P10_3 VDD VSS NOR2_X1
XI1896_I136_XG I1896_P11_8n I1896_G7_4n I1896_G11_8n I1896_G11_4 VDD VSS OAI21_X1
XI1896_I136_XP I1896_P11_8n I1896_P7_4n I1896_P11_4 VDD VSS NOR2_X1
XI1896_I137_XG I1896_P12_9n I1896_G8_5n I1896_G12_9n I1896_G12_5 VDD VSS OAI21_X1
XI1896_I137_XP I1896_P12_9n I1896_P8_5n I1896_P12_5 VDD VSS NOR2_X1
XI1896_I138_XG I1896_P13_10n I1896_G9_6n I1896_G13_10n I1896_G13_6 VDD VSS OAI21_X1
XI1896_I138_XP I1896_P13_10n I1896_P9_6n I1896_P13_6 VDD VSS NOR2_X1
XI1896_I139_XG I1896_P14_11n I1896_G10_7n I1896_G14_11n I1896_G14_7 VDD VSS OAI21_X1
XI1896_I139_XP I1896_P14_11n I1896_P10_7n I1896_P14_7 VDD VSS NOR2_X1
XI1896_I140_XG I1896_P15_12n I1896_G11_8n I1896_G15_12n I1896_G15_8 VDD VSS OAI21_X1
XI1896_I140_XP I1896_P15_12n I1896_P11_8n I1896_P15_8 VDD VSS NOR2_X1
XI1896_I141_XG I1896_P16_13n I1896_G12_9n I1896_G16_13n I1896_G16_9 VDD VSS OAI21_X1
XI1896_I141_XP I1896_P16_13n I1896_P12_9n I1896_P16_9 VDD VSS NOR2_X1
XI1896_I142_XG I1896_P17_14n I1896_G13_10n I1896_G17_14n I1896_G17_10 VDD VSS OAI21_X1
XI1896_I142_XP I1896_P17_14n I1896_P13_10n I1896_P17_10 VDD VSS NOR2_X1
XI1896_I143_XG I1896_P18_15n I1896_G14_11n I1896_G18_15n I1896_G18_11 VDD VSS OAI21_X1
XI1896_I143_XP I1896_P18_15n I1896_P14_11n I1896_P18_11 VDD VSS NOR2_X1
XI1896_I144_XG I1896_P19_16n I1896_G15_12n I1896_G19_16n I1896_G19_12 VDD VSS OAI21_X1
XI1896_I144_XP I1896_P19_16n I1896_P15_12n I1896_P19_12 VDD VSS NOR2_X1
XI1896_I145_XG I1896_P20_17n I1896_G16_13n I1896_G20_17n I1896_G20_13 VDD VSS OAI21_X1
XI1896_I145_XP I1896_P20_17n I1896_P16_13n I1896_P20_13 VDD VSS NOR2_X1
XI1896_I146_XG I1896_P21_18n I1896_G17_14n I1896_G21_18n I1896_G21_14 VDD VSS OAI21_X1
XI1896_I146_XP I1896_P21_18n I1896_P17_14n I1896_P21_14 VDD VSS NOR2_X1
XI1896_I147_XG I1896_P22_19n I1896_G18_15n I1896_G22_19n I1896_G22_15 VDD VSS OAI21_X1
XI1896_I147_XP I1896_P22_19n I1896_P18_15n I1896_P22_15 VDD VSS NOR2_X1
XI1896_I148_XG I1896_P23_20n I1896_G19_16n I1896_G23_20n I1896_G23_16 VDD VSS OAI21_X1
XI1896_I148_XP I1896_P23_20n I1896_P19_16n I1896_P23_16 VDD VSS NOR2_X1
XI1896_I149_XG I1896_P24_21n I1896_G20_17n I1896_G24_21n I1896_G24_17 VDD VSS OAI21_X1
XI1896_I149_XP I1896_P24_21n I1896_P20_17n I1896_P24_17 VDD VSS NOR2_X1
XI1896_I150_XG I1896_P25_22n I1896_G21_18n I1896_G25_22n I1896_G25_18 VDD VSS OAI21_X1
XI1896_I150_XP I1896_P25_22n I1896_P21_18n I1896_P25_18 VDD VSS NOR2_X1
XI1896_I151_XG I1896_P26_23n I1896_G22_19n I1896_G26_23n I1896_G26_19 VDD VSS OAI21_X1
XI1896_I151_XP I1896_P26_23n I1896_P22_19n I1896_P26_19 VDD VSS NOR2_X1
XI1896_I152_XG I1896_P27_24n I1896_G23_20n I1896_G27_24n I1896_G27_20 VDD VSS OAI21_X1
XI1896_I152_XP I1896_P27_24n I1896_P23_20n I1896_P27_20 VDD VSS NOR2_X1
XI1896_I153_XG I1896_P28_25n I1896_G24_21n I1896_G28_25n I1896_G28_21 VDD VSS OAI21_X1
XI1896_I153_XP I1896_P28_25n I1896_P24_21n I1896_P28_21 VDD VSS NOR2_X1
XI1896_I154_XG I1896_P29_26n I1896_G25_22n I1896_G29_26n I1896_G29_22 VDD VSS OAI21_X1
XI1896_I154_XP I1896_P29_26n I1896_P25_22n I1896_P29_22 VDD VSS NOR2_X1
XI1896_I155_XG I1896_P30_27n I1896_G26_23n I1896_G30_27n I1896_G30_23 VDD VSS OAI21_X1
XI1896_I155_XP I1896_P30_27n I1896_P26_23n I1896_P30_23 VDD VSS NOR2_X1
XI1896_I156_XG I1896_P31_28n I1896_G27_24n I1896_G31_28n I1896_G31_24 VDD VSS OAI21_X1
XI1896_I156_XP I1896_P31_28n I1896_P27_24n I1896_P31_24 VDD VSS NOR2_X1
XI1896_I157_XG I1896_P8_1 I1896_G0_0 I1896_G8_1 I1896_G8_0n VDD VSS AOI21_X1
XI1896_I158_XG I1896_P9_2 I1896_G1_0 I1896_G9_2 I1896_G9_0n VDD VSS AOI21_X1
XI1896_I159 I1896_G2_0n I1896_G2_0np VDD VSS INV_X1
XI1896_I160_XG I1896_P10_3 I1896_G2_0np I1896_G10_3 I1896_G10_0n VDD VSS AOI21_X1
XI1896_I161 I1896_G3_0n I1896_G3_0np VDD VSS INV_X1
XI1896_I162_XG I1896_P11_4 I1896_G3_0np I1896_G11_4 I1896_G11_0n VDD VSS AOI21_X1
XI1896_I163_XG I1896_P12_5 I1896_G4_0 I1896_G12_5 I1896_G12_0n VDD VSS AOI21_X1
XI1896_I164_XG I1896_P13_6 I1896_G5_0 I1896_G13_6 I1896_G13_0n VDD VSS AOI21_X1
XI1896_I165_XG I1896_P14_7 I1896_G6_0 I1896_G14_7 I1896_G14_0n VDD VSS AOI21_X1
XI1896_I166_XG I1896_P15_8 I1896_G7_0 I1896_G15_8 I1896_G15_0n VDD VSS AOI21_X1
XI1896_I167_XG I1896_P16_9 I1896_G8_1 I1896_G16_9 I1896_G16_1n VDD VSS AOI21_X1
XI1896_I167_XP I1896_P16_9 I1896_P8_1 I1896_P16_1n VDD VSS NAND2_X1
XI1896_I168_XG I1896_P17_10 I1896_G9_2 I1896_G17_10 I1896_G17_2n VDD VSS AOI21_X1
XI1896_I168_XP I1896_P17_10 I1896_P9_2 I1896_P17_2n VDD VSS NAND2_X1
XI1896_I169_XG I1896_P18_11 I1896_G10_3 I1896_G18_11 I1896_G18_3n VDD VSS AOI21_X1
XI1896_I169_XP I1896_P18_11 I1896_P10_3 I1896_P18_3n VDD VSS NAND2_X1
XI1896_I170_XG I1896_P19_12 I1896_G11_4 I1896_G19_12 I1896_G19_4n VDD VSS AOI21_X1
XI1896_I170_XP I1896_P19_12 I1896_P11_4 I1896_P19_4n VDD VSS NAND2_X1
XI1896_I171_XG I1896_P20_13 I1896_G12_5 I1896_G20_13 I1896_G20_5n VDD VSS AOI21_X1
XI1896_I171_XP I1896_P20_13 I1896_P12_5 I1896_P20_5n VDD VSS NAND2_X1
XI1896_I172_XG I1896_P21_14 I1896_G13_6 I1896_G21_14 I1896_G21_6n VDD VSS AOI21_X1
XI1896_I172_XP I1896_P21_14 I1896_P13_6 I1896_P21_6n VDD VSS NAND2_X1
XI1896_I173_XG I1896_P22_15 I1896_G14_7 I1896_G22_15 I1896_G22_7n VDD VSS AOI21_X1
XI1896_I173_XP I1896_P22_15 I1896_P14_7 I1896_P22_7n VDD VSS NAND2_X1
XI1896_I174_XG I1896_P23_16 I1896_G15_8 I1896_G23_16 I1896_G23_8n VDD VSS AOI21_X1
XI1896_I174_XP I1896_P23_16 I1896_P15_8 I1896_P23_8n VDD VSS NAND2_X1
XI1896_I175_XG I1896_P24_17 I1896_G16_9 I1896_G24_17 I1896_G24_9n VDD VSS AOI21_X1
XI1896_I175_XP I1896_P24_17 I1896_P16_9 I1896_P24_9n VDD VSS NAND2_X1
XI1896_I176_XG I1896_P25_18 I1896_G17_10 I1896_G25_18 I1896_G25_10n VDD VSS AOI21_X1
XI1896_I176_XP I1896_P25_18 I1896_P17_10 I1896_P25_10n VDD VSS NAND2_X1
XI1896_I177_XG I1896_P26_19 I1896_G18_11 I1896_G26_19 I1896_G26_11n VDD VSS AOI21_X1
XI1896_I177_XP I1896_P26_19 I1896_P18_11 I1896_P26_11n VDD VSS NAND2_X1
XI1896_I178_XG I1896_P27_20 I1896_G19_12 I1896_G27_20 I1896_G27_12n VDD VSS AOI21_X1
XI1896_I178_XP I1896_P27_20 I1896_P19_12 I1896_P27_12n VDD VSS NAND2_X1
XI1896_I179_XG I1896_P28_21 I1896_G20_13 I1896_G28_21 I1896_G28_13n VDD VSS AOI21_X1
XI1896_I179_XP I1896_P28_21 I1896_P20_13 I1896_P28_13n VDD VSS NAND2_X1
XI1896_I180_XG I1896_P29_22 I1896_G21_14 I1896_G29_22 I1896_G29_14n VDD VSS AOI21_X1
XI1896_I180_XP I1896_P29_22 I1896_P21_14 I1896_P29_14n VDD VSS NAND2_X1
XI1896_I181_XG I1896_P30_23 I1896_G22_15 I1896_G30_23 I1896_G30_15n VDD VSS AOI21_X1
XI1896_I181_XP I1896_P30_23 I1896_P22_15 I1896_P30_15n VDD VSS NAND2_X1
XI1896_I182_XG I1896_P31_24 I1896_G23_16 I1896_G31_24 I1896_G31_16n VDD VSS AOI21_X1
XI1896_I182_XP I1896_P31_24 I1896_P23_16 I1896_P31_16n VDD VSS NAND2_X1
XI1896_I183_XG I1896_P16_1n I1896_G0_0n I1896_G16_1n I1896_G16_0 VDD VSS OAI21_X1
XI1896_I184_XG I1896_P17_2n I1896_G1_0n I1896_G17_2n I1896_G17_0 VDD VSS OAI21_X1
XI1896_I185_XG I1896_P18_3n I1896_G2_0n I1896_G18_3n I1896_G18_0 VDD VSS OAI21_X1
XI1896_I186_XG I1896_P19_4n I1896_G3_0n I1896_G19_4n I1896_G19_0 VDD VSS OAI21_X1
XI1896_I187 I1896_G4_0 I1896_G4_0n VDD VSS INV_X1
XI1896_I188_XG I1896_P20_5n I1896_G4_0n I1896_G20_5n I1896_G20_0 VDD VSS OAI21_X1
XI1896_I189 I1896_G5_0 I1896_G5_0n VDD VSS INV_X1
XI1896_I190_XG I1896_P21_6n I1896_G5_0n I1896_G21_6n I1896_G21_0 VDD VSS OAI21_X1
XI1896_I191 I1896_G6_0 I1896_G6_0n VDD VSS INV_X1
XI1896_I192_XG I1896_P22_7n I1896_G6_0n I1896_G22_7n I1896_G22_0 VDD VSS OAI21_X1
XI1896_I193 I1896_G7_0 I1896_G7_0n VDD VSS INV_X1
XI1896_I194_XG I1896_P23_8n I1896_G7_0n I1896_G23_8n I1896_G23_0 VDD VSS OAI21_X1
XI1896_I195_XG I1896_P24_9n I1896_G8_0n I1896_G24_9n I1896_G24_0 VDD VSS OAI21_X1
XI1896_I196_XG I1896_P25_10n I1896_G9_0n I1896_G25_10n I1896_G25_0 VDD VSS OAI21_X1
XI1896_I197_XG I1896_P26_11n I1896_G10_0n I1896_G26_11n I1896_G26_0 VDD VSS OAI21_X1
XI1896_I198_XG I1896_P27_12n I1896_G11_0n I1896_G27_12n I1896_G27_0 VDD VSS OAI21_X1
XI1896_I199_XG I1896_P28_13n I1896_G12_0n I1896_G28_13n I1896_G28_0 VDD VSS OAI21_X1
XI1896_I200_XG I1896_P29_14n I1896_G13_0n I1896_G29_14n I1896_G29_0 VDD VSS OAI21_X1
XI1896_I201_XG I1896_P30_15n I1896_G14_0n I1896_G30_15n c29_m VDD VSS OAI21_X1
XI1896_I202_XG I1896_P31_16n I1896_G15_0n I1896_G31_16n c29_o VDD VSS OAI21_X1
XI1896_I203 I1896_pn0 qu3_b3_5 p29_0 VDD VSS XNOR2_X1
XI1896_I204 I1896_pn1 I1896_G0_0 p29_1 VDD VSS XNOR2_X1
XI1896_I205 I1896_pn2 I1896_G1_0 p29_2 VDD VSS XNOR2_X1
XI1896_I206 I1896_pn3 I1896_G2_0n p29_3 VDD VSS XOR2_X1
XI1896_I207 I1896_pn4 I1896_G3_0n p29_4 VDD VSS XOR2_X1
XI1896_I208 I1896_pn5 I1896_G4_0 p29_5 VDD VSS XNOR2_X1
XI1896_I209 I1896_pn6 I1896_G5_0 p29_6 VDD VSS XNOR2_X1
XI1896_I210 I1896_pn7 I1896_G6_0 p29_7 VDD VSS XNOR2_X1
XI1896_I211 I1896_pn8 I1896_G7_0 p29_8 VDD VSS XNOR2_X1
XI1896_I212 I1896_pn9 I1896_G8_0n p29_9 VDD VSS XOR2_X1
XI1896_I213 I1896_pn10 I1896_G9_0n p29_10 VDD VSS XOR2_X1
XI1896_I214 I1896_pn11 I1896_G10_0n p29_11 VDD VSS XOR2_X1
XI1896_I215 I1896_pn12 I1896_G11_0n p29_12 VDD VSS XOR2_X1
XI1896_I216 I1896_pn13 I1896_G12_0n p29_13 VDD VSS XOR2_X1
XI1896_I217 I1896_pn14 I1896_G13_0n p29_14 VDD VSS XOR2_X1
XI1896_I218 I1896_pn15 I1896_G14_0n p29_15 VDD VSS XOR2_X1
XI1896_I219 I1896_pn16 I1896_G15_0n p29_16 VDD VSS XOR2_X1
XI1896_I220 I1896_pn17 I1896_G16_0 p29_17 VDD VSS XNOR2_X1
XI1896_I221 I1896_pn18 I1896_G17_0 p29_18 VDD VSS XNOR2_X1
XI1896_I222 I1896_pn19 I1896_G18_0 p29_19 VDD VSS XNOR2_X1
XI1896_I223 I1896_pn20 I1896_G19_0 p29_20 VDD VSS XNOR2_X1
XI1896_I224 I1896_pn21 I1896_G20_0 p29_21 VDD VSS XNOR2_X1
XI1896_I225 I1896_pn22 I1896_G21_0 p29_22 VDD VSS XNOR2_X1
XI1896_I226 I1896_pn23 I1896_G22_0 p29_23 VDD VSS XNOR2_X1
XI1896_I227 I1896_pn24 I1896_G23_0 p29_24 VDD VSS XNOR2_X1
XI1896_I228 I1896_pn25 I1896_G24_0 p29_25 VDD VSS XNOR2_X1
XI1896_I229 I1896_pn26 I1896_G25_0 p29_26 VDD VSS XNOR2_X1
XI1896_I230 I1896_pn27 I1896_G26_0 p29_27 VDD VSS XNOR2_X1
XI1896_I231 I1896_pn28 I1896_G27_0 p29_28 VDD VSS XNOR2_X1
XI1896_I232 I1896_pn29 I1896_G28_0 p29_29 VDD VSS XNOR2_X1
XI1896_I233 I1896_pn30 I1896_G29_0 p29_30 VDD VSS XNOR2_X1
XI1896_I234 I1896_pn31 c29_m p29_31 VDD VSS XNOR2_X1
XI1897 p28_31 qu3_b3_5 h29 VDD VSS XOR2_X1
XI1898 h29 c29_o p29_32 VDD VSS XOR2_X1
XI1899 p29_32 qu2 VDD VSS INV_X4
XI1900 qu2 qu2_b0 VDD VSS INV_X1
XI1901 qu2_b0 qu2_b1_0 VDD VSS INV_X4
XI1902 qu2_b1_0 qu2_b2_0 VDD VSS INV_X4
XI1903 qu2_b1_0 qu2_b2_1 VDD VSS INV_X4
XI1904 qu2_b2_0 qu2_b3_0 VDD VSS INV_X4
XI1905 qu2_b2_0 qu2_b3_1 VDD VSS INV_X4
XI1906 qu2_b2_0 qu2_b3_2 VDD VSS INV_X4
XI1907 qu2_b2_1 qu2_b3_3 VDD VSS INV_X4
XI1908 qu2_b2_1 qu2_b3_4 VDD VSS INV_X4
XI1909 qu2_b2_1 qu2_b3_5 VDD VSS INV_X4
XI1910 B_0_b3_5 qu2_b3_0 b30_0 VDD VSS XOR2_X1
XI1911 dd1_b3_5 qu2_b3_0 b30_1 VDD VSS XOR2_X1
XI1912 dd2_b3_5 qu2_b3_0 b30_2 VDD VSS XOR2_X1
XI1913 dd3_b3_5 qu2_b3_0 b30_3 VDD VSS XOR2_X1
XI1914 dd4_b3_5 qu2_b3_0 b30_4 VDD VSS XOR2_X1
XI1915 dd5_b3_5 qu2_b3_0 b30_5 VDD VSS XOR2_X1
XI1916 dd6_b3_5 qu2_b3_1 b30_6 VDD VSS XOR2_X1
XI1917 dd7_b3_5 qu2_b3_1 b30_7 VDD VSS XOR2_X1
XI1918 dd8_b3_5 qu2_b3_1 b30_8 VDD VSS XOR2_X1
XI1919 dd9_b3_5 qu2_b3_1 b30_9 VDD VSS XOR2_X1
XI1920 dd10_b3_5 qu2_b3_1 b30_10 VDD VSS XOR2_X1
XI1921 dd11_b3_5 qu2_b3_1 b30_11 VDD VSS XOR2_X1
XI1922 dd12_b3_5 qu2_b3_2 b30_12 VDD VSS XOR2_X1
XI1923 dd13_b3_5 qu2_b3_2 b30_13 VDD VSS XOR2_X1
XI1924 dd14_b3_5 qu2_b3_2 b30_14 VDD VSS XOR2_X1
XI1925 dd15_b3_5 qu2_b3_2 b30_15 VDD VSS XOR2_X1
XI1926 dd16_b3_5 qu2_b3_2 b30_16 VDD VSS XOR2_X1
XI1927 dd17_b3_5 qu2_b3_2 b30_17 VDD VSS XOR2_X1
XI1928 dd18_b3_5 qu2_b3_3 b30_18 VDD VSS XOR2_X1
XI1929 dd19_b3_5 qu2_b3_3 b30_19 VDD VSS XOR2_X1
XI1930 dd20_b3_5 qu2_b3_3 b30_20 VDD VSS XOR2_X1
XI1931 dd21_b3_5 qu2_b3_3 b30_21 VDD VSS XOR2_X1
XI1932 dd22_b3_5 qu2_b3_3 b30_22 VDD VSS XOR2_X1
XI1933 dd23_b3_5 qu2_b3_3 b30_23 VDD VSS XOR2_X1
XI1934 dd24_b3_5 qu2_b3_4 b30_24 VDD VSS XOR2_X1
XI1935 dd25_b3_5 qu2_b3_4 b30_25 VDD VSS XOR2_X1
XI1936 dd26_b3_5 qu2_b3_4 b30_26 VDD VSS XOR2_X1
XI1937 dd27_b3_5 qu2_b3_4 b30_27 VDD VSS XOR2_X1
XI1938 dd28_b3_5 qu2_b3_4 b30_28 VDD VSS XOR2_X1
XI1939 dd29_b3_5 qu2_b3_4 b30_29 VDD VSS XOR2_X1
XI1940 dd30_b3_5 qu2_b3_5 b30_30 VDD VSS XOR2_X1
XI1941 dd31_b3_5 qu2_b3_5 b30_31 VDD VSS XOR2_X1
XI1942_I0 aa1 b30_0 I1942_gn0 VDD VSS NAND2_X1
XI1942_I1 p29_0 b30_1 I1942_gn1 VDD VSS NAND2_X1
XI1942_I2 p29_1 b30_2 I1942_gn2 VDD VSS NAND2_X1
XI1942_I3 p29_2 b30_3 I1942_gn3 VDD VSS NAND2_X1
XI1942_I4 p29_3 b30_4 I1942_gn4 VDD VSS NAND2_X1
XI1942_I5 p29_4 b30_5 I1942_gn5 VDD VSS NAND2_X1
XI1942_I6 p29_5 b30_6 I1942_gn6 VDD VSS NAND2_X1
XI1942_I7 p29_6 b30_7 I1942_gn7 VDD VSS NAND2_X1
XI1942_I8 p29_7 b30_8 I1942_gn8 VDD VSS NAND2_X1
XI1942_I9 p29_8 b30_9 I1942_gn9 VDD VSS NAND2_X1
XI1942_I10 p29_9 b30_10 I1942_gn10 VDD VSS NAND2_X1
XI1942_I11 p29_10 b30_11 I1942_gn11 VDD VSS NAND2_X1
XI1942_I12 p29_11 b30_12 I1942_gn12 VDD VSS NAND2_X1
XI1942_I13 p29_12 b30_13 I1942_gn13 VDD VSS NAND2_X1
XI1942_I14 p29_13 b30_14 I1942_gn14 VDD VSS NAND2_X1
XI1942_I15 p29_14 b30_15 I1942_gn15 VDD VSS NAND2_X1
XI1942_I16 p29_15 b30_16 I1942_gn16 VDD VSS NAND2_X1
XI1942_I17 p29_16 b30_17 I1942_gn17 VDD VSS NAND2_X1
XI1942_I18 p29_17 b30_18 I1942_gn18 VDD VSS NAND2_X1
XI1942_I19 p29_18 b30_19 I1942_gn19 VDD VSS NAND2_X1
XI1942_I20 p29_19 b30_20 I1942_gn20 VDD VSS NAND2_X1
XI1942_I21 p29_20 b30_21 I1942_gn21 VDD VSS NAND2_X1
XI1942_I22 p29_21 b30_22 I1942_gn22 VDD VSS NAND2_X1
XI1942_I23 p29_22 b30_23 I1942_gn23 VDD VSS NAND2_X1
XI1942_I24 p29_23 b30_24 I1942_gn24 VDD VSS NAND2_X1
XI1942_I25 p29_24 b30_25 I1942_gn25 VDD VSS NAND2_X1
XI1942_I26 p29_25 b30_26 I1942_gn26 VDD VSS NAND2_X1
XI1942_I27 p29_26 b30_27 I1942_gn27 VDD VSS NAND2_X1
XI1942_I28 p29_27 b30_28 I1942_gn28 VDD VSS NAND2_X1
XI1942_I29 p29_28 b30_29 I1942_gn29 VDD VSS NAND2_X1
XI1942_I30 p29_29 b30_30 I1942_gn30 VDD VSS NAND2_X1
XI1942_I31 p29_30 b30_31 I1942_gn31 VDD VSS NAND2_X1
XI1942_I32 aa1 b30_0 I1942_pn0 VDD VSS XNOR2_X1
XI1942_I33 p29_0 b30_1 I1942_pn1 VDD VSS XNOR2_X1
XI1942_I34 p29_1 b30_2 I1942_pn2 VDD VSS XNOR2_X1
XI1942_I35 p29_2 b30_3 I1942_pn3 VDD VSS XNOR2_X1
XI1942_I36 p29_3 b30_4 I1942_pn4 VDD VSS XNOR2_X1
XI1942_I37 p29_4 b30_5 I1942_pn5 VDD VSS XNOR2_X1
XI1942_I38 p29_5 b30_6 I1942_pn6 VDD VSS XNOR2_X1
XI1942_I39 p29_6 b30_7 I1942_pn7 VDD VSS XNOR2_X1
XI1942_I40 p29_7 b30_8 I1942_pn8 VDD VSS XNOR2_X1
XI1942_I41 p29_8 b30_9 I1942_pn9 VDD VSS XNOR2_X1
XI1942_I42 p29_9 b30_10 I1942_pn10 VDD VSS XNOR2_X1
XI1942_I43 p29_10 b30_11 I1942_pn11 VDD VSS XNOR2_X1
XI1942_I44 p29_11 b30_12 I1942_pn12 VDD VSS XNOR2_X1
XI1942_I45 p29_12 b30_13 I1942_pn13 VDD VSS XNOR2_X1
XI1942_I46 p29_13 b30_14 I1942_pn14 VDD VSS XNOR2_X1
XI1942_I47 p29_14 b30_15 I1942_pn15 VDD VSS XNOR2_X1
XI1942_I48 p29_15 b30_16 I1942_pn16 VDD VSS XNOR2_X1
XI1942_I49 p29_16 b30_17 I1942_pn17 VDD VSS XNOR2_X1
XI1942_I50 p29_17 b30_18 I1942_pn18 VDD VSS XNOR2_X1
XI1942_I51 p29_18 b30_19 I1942_pn19 VDD VSS XNOR2_X1
XI1942_I52 p29_19 b30_20 I1942_pn20 VDD VSS XNOR2_X1
XI1942_I53 p29_20 b30_21 I1942_pn21 VDD VSS XNOR2_X1
XI1942_I54 p29_21 b30_22 I1942_pn22 VDD VSS XNOR2_X1
XI1942_I55 p29_22 b30_23 I1942_pn23 VDD VSS XNOR2_X1
XI1942_I56 p29_23 b30_24 I1942_pn24 VDD VSS XNOR2_X1
XI1942_I57 p29_24 b30_25 I1942_pn25 VDD VSS XNOR2_X1
XI1942_I58 p29_25 b30_26 I1942_pn26 VDD VSS XNOR2_X1
XI1942_I59 p29_26 b30_27 I1942_pn27 VDD VSS XNOR2_X1
XI1942_I60 p29_27 b30_28 I1942_pn28 VDD VSS XNOR2_X1
XI1942_I61 p29_28 b30_29 I1942_pn29 VDD VSS XNOR2_X1
XI1942_I62 p29_29 b30_30 I1942_pn30 VDD VSS XNOR2_X1
XI1942_I63 p29_30 b30_31 I1942_pn31 VDD VSS XNOR2_X1
XI1942_I64 qu2_b3_5 I1942_cinn VDD VSS INV_X1
XI1942_I65_XG I1942_pn0 I1942_cinn I1942_gn0 I1942_G0_0 VDD VSS OAI21_X1
XI1942_I66 I1942_G0_0 I1942_G0_0n VDD VSS INV_X1
XI1942_I67_XG I1942_pn1 I1942_G0_0n I1942_gn1 I1942_G1_0 VDD VSS OAI21_X1
XI1942_I68_XG I1942_pn2 I1942_gn1 I1942_gn2 I1942_G2_1 VDD VSS OAI21_X1
XI1942_I68_XP I1942_pn2 I1942_pn1 I1942_P2_1 VDD VSS NOR2_X1
XI1942_I69_XG I1942_pn3 I1942_gn2 I1942_gn3 I1942_G3_2 VDD VSS OAI21_X1
XI1942_I69_XP I1942_pn3 I1942_pn2 I1942_P3_2 VDD VSS NOR2_X1
XI1942_I70_XG I1942_pn4 I1942_gn3 I1942_gn4 I1942_G4_3 VDD VSS OAI21_X1
XI1942_I70_XP I1942_pn4 I1942_pn3 I1942_P4_3 VDD VSS NOR2_X1
XI1942_I71_XG I1942_pn5 I1942_gn4 I1942_gn5 I1942_G5_4 VDD VSS OAI21_X1
XI1942_I71_XP I1942_pn5 I1942_pn4 I1942_P5_4 VDD VSS NOR2_X1
XI1942_I72_XG I1942_pn6 I1942_gn5 I1942_gn6 I1942_G6_5 VDD VSS OAI21_X1
XI1942_I72_XP I1942_pn6 I1942_pn5 I1942_P6_5 VDD VSS NOR2_X1
XI1942_I73_XG I1942_pn7 I1942_gn6 I1942_gn7 I1942_G7_6 VDD VSS OAI21_X1
XI1942_I73_XP I1942_pn7 I1942_pn6 I1942_P7_6 VDD VSS NOR2_X1
XI1942_I74_XG I1942_pn8 I1942_gn7 I1942_gn8 I1942_G8_7 VDD VSS OAI21_X1
XI1942_I74_XP I1942_pn8 I1942_pn7 I1942_P8_7 VDD VSS NOR2_X1
XI1942_I75_XG I1942_pn9 I1942_gn8 I1942_gn9 I1942_G9_8 VDD VSS OAI21_X1
XI1942_I75_XP I1942_pn9 I1942_pn8 I1942_P9_8 VDD VSS NOR2_X1
XI1942_I76_XG I1942_pn10 I1942_gn9 I1942_gn10 I1942_G10_9 VDD VSS OAI21_X1
XI1942_I76_XP I1942_pn10 I1942_pn9 I1942_P10_9 VDD VSS NOR2_X1
XI1942_I77_XG I1942_pn11 I1942_gn10 I1942_gn11 I1942_G11_10 VDD VSS OAI21_X1
XI1942_I77_XP I1942_pn11 I1942_pn10 I1942_P11_10 VDD VSS NOR2_X1
XI1942_I78_XG I1942_pn12 I1942_gn11 I1942_gn12 I1942_G12_11 VDD VSS OAI21_X1
XI1942_I78_XP I1942_pn12 I1942_pn11 I1942_P12_11 VDD VSS NOR2_X1
XI1942_I79_XG I1942_pn13 I1942_gn12 I1942_gn13 I1942_G13_12 VDD VSS OAI21_X1
XI1942_I79_XP I1942_pn13 I1942_pn12 I1942_P13_12 VDD VSS NOR2_X1
XI1942_I80_XG I1942_pn14 I1942_gn13 I1942_gn14 I1942_G14_13 VDD VSS OAI21_X1
XI1942_I80_XP I1942_pn14 I1942_pn13 I1942_P14_13 VDD VSS NOR2_X1
XI1942_I81_XG I1942_pn15 I1942_gn14 I1942_gn15 I1942_G15_14 VDD VSS OAI21_X1
XI1942_I81_XP I1942_pn15 I1942_pn14 I1942_P15_14 VDD VSS NOR2_X1
XI1942_I82_XG I1942_pn16 I1942_gn15 I1942_gn16 I1942_G16_15 VDD VSS OAI21_X1
XI1942_I82_XP I1942_pn16 I1942_pn15 I1942_P16_15 VDD VSS NOR2_X1
XI1942_I83_XG I1942_pn17 I1942_gn16 I1942_gn17 I1942_G17_16 VDD VSS OAI21_X1
XI1942_I83_XP I1942_pn17 I1942_pn16 I1942_P17_16 VDD VSS NOR2_X1
XI1942_I84_XG I1942_pn18 I1942_gn17 I1942_gn18 I1942_G18_17 VDD VSS OAI21_X1
XI1942_I84_XP I1942_pn18 I1942_pn17 I1942_P18_17 VDD VSS NOR2_X1
XI1942_I85_XG I1942_pn19 I1942_gn18 I1942_gn19 I1942_G19_18 VDD VSS OAI21_X1
XI1942_I85_XP I1942_pn19 I1942_pn18 I1942_P19_18 VDD VSS NOR2_X1
XI1942_I86_XG I1942_pn20 I1942_gn19 I1942_gn20 I1942_G20_19 VDD VSS OAI21_X1
XI1942_I86_XP I1942_pn20 I1942_pn19 I1942_P20_19 VDD VSS NOR2_X1
XI1942_I87_XG I1942_pn21 I1942_gn20 I1942_gn21 I1942_G21_20 VDD VSS OAI21_X1
XI1942_I87_XP I1942_pn21 I1942_pn20 I1942_P21_20 VDD VSS NOR2_X1
XI1942_I88_XG I1942_pn22 I1942_gn21 I1942_gn22 I1942_G22_21 VDD VSS OAI21_X1
XI1942_I88_XP I1942_pn22 I1942_pn21 I1942_P22_21 VDD VSS NOR2_X1
XI1942_I89_XG I1942_pn23 I1942_gn22 I1942_gn23 I1942_G23_22 VDD VSS OAI21_X1
XI1942_I89_XP I1942_pn23 I1942_pn22 I1942_P23_22 VDD VSS NOR2_X1
XI1942_I90_XG I1942_pn24 I1942_gn23 I1942_gn24 I1942_G24_23 VDD VSS OAI21_X1
XI1942_I90_XP I1942_pn24 I1942_pn23 I1942_P24_23 VDD VSS NOR2_X1
XI1942_I91_XG I1942_pn25 I1942_gn24 I1942_gn25 I1942_G25_24 VDD VSS OAI21_X1
XI1942_I91_XP I1942_pn25 I1942_pn24 I1942_P25_24 VDD VSS NOR2_X1
XI1942_I92_XG I1942_pn26 I1942_gn25 I1942_gn26 I1942_G26_25 VDD VSS OAI21_X1
XI1942_I92_XP I1942_pn26 I1942_pn25 I1942_P26_25 VDD VSS NOR2_X1
XI1942_I93_XG I1942_pn27 I1942_gn26 I1942_gn27 I1942_G27_26 VDD VSS OAI21_X1
XI1942_I93_XP I1942_pn27 I1942_pn26 I1942_P27_26 VDD VSS NOR2_X1
XI1942_I94_XG I1942_pn28 I1942_gn27 I1942_gn28 I1942_G28_27 VDD VSS OAI21_X1
XI1942_I94_XP I1942_pn28 I1942_pn27 I1942_P28_27 VDD VSS NOR2_X1
XI1942_I95_XG I1942_pn29 I1942_gn28 I1942_gn29 I1942_G29_28 VDD VSS OAI21_X1
XI1942_I95_XP I1942_pn29 I1942_pn28 I1942_P29_28 VDD VSS NOR2_X1
XI1942_I96_XG I1942_pn30 I1942_gn29 I1942_gn30 I1942_G30_29 VDD VSS OAI21_X1
XI1942_I96_XP I1942_pn30 I1942_pn29 I1942_P30_29 VDD VSS NOR2_X1
XI1942_I97_XG I1942_pn31 I1942_gn30 I1942_gn31 I1942_G31_30 VDD VSS OAI21_X1
XI1942_I97_XP I1942_pn31 I1942_pn30 I1942_P31_30 VDD VSS NOR2_X1
XI1942_I98_XG I1942_P2_1 I1942_G0_0 I1942_G2_1 I1942_G2_0n VDD VSS AOI21_X1
XI1942_I99_XG I1942_P3_2 I1942_G1_0 I1942_G3_2 I1942_G3_0n VDD VSS AOI21_X1
XI1942_I100_XG I1942_P4_3 I1942_G2_1 I1942_G4_3 I1942_G4_1n VDD VSS AOI21_X1
XI1942_I100_XP I1942_P4_3 I1942_P2_1 I1942_P4_1n VDD VSS NAND2_X1
XI1942_I101_XG I1942_P5_4 I1942_G3_2 I1942_G5_4 I1942_G5_2n VDD VSS AOI21_X1
XI1942_I101_XP I1942_P5_4 I1942_P3_2 I1942_P5_2n VDD VSS NAND2_X1
XI1942_I102_XG I1942_P6_5 I1942_G4_3 I1942_G6_5 I1942_G6_3n VDD VSS AOI21_X1
XI1942_I102_XP I1942_P6_5 I1942_P4_3 I1942_P6_3n VDD VSS NAND2_X1
XI1942_I103_XG I1942_P7_6 I1942_G5_4 I1942_G7_6 I1942_G7_4n VDD VSS AOI21_X1
XI1942_I103_XP I1942_P7_6 I1942_P5_4 I1942_P7_4n VDD VSS NAND2_X1
XI1942_I104_XG I1942_P8_7 I1942_G6_5 I1942_G8_7 I1942_G8_5n VDD VSS AOI21_X1
XI1942_I104_XP I1942_P8_7 I1942_P6_5 I1942_P8_5n VDD VSS NAND2_X1
XI1942_I105_XG I1942_P9_8 I1942_G7_6 I1942_G9_8 I1942_G9_6n VDD VSS AOI21_X1
XI1942_I105_XP I1942_P9_8 I1942_P7_6 I1942_P9_6n VDD VSS NAND2_X1
XI1942_I106_XG I1942_P10_9 I1942_G8_7 I1942_G10_9 I1942_G10_7n VDD VSS AOI21_X1
XI1942_I106_XP I1942_P10_9 I1942_P8_7 I1942_P10_7n VDD VSS NAND2_X1
XI1942_I107_XG I1942_P11_10 I1942_G9_8 I1942_G11_10 I1942_G11_8n VDD VSS AOI21_X1
XI1942_I107_XP I1942_P11_10 I1942_P9_8 I1942_P11_8n VDD VSS NAND2_X1
XI1942_I108_XG I1942_P12_11 I1942_G10_9 I1942_G12_11 I1942_G12_9n VDD VSS AOI21_X1
XI1942_I108_XP I1942_P12_11 I1942_P10_9 I1942_P12_9n VDD VSS NAND2_X1
XI1942_I109_XG I1942_P13_12 I1942_G11_10 I1942_G13_12 I1942_G13_10n VDD VSS AOI21_X1
XI1942_I109_XP I1942_P13_12 I1942_P11_10 I1942_P13_10n VDD VSS NAND2_X1
XI1942_I110_XG I1942_P14_13 I1942_G12_11 I1942_G14_13 I1942_G14_11n VDD VSS AOI21_X1
XI1942_I110_XP I1942_P14_13 I1942_P12_11 I1942_P14_11n VDD VSS NAND2_X1
XI1942_I111_XG I1942_P15_14 I1942_G13_12 I1942_G15_14 I1942_G15_12n VDD VSS AOI21_X1
XI1942_I111_XP I1942_P15_14 I1942_P13_12 I1942_P15_12n VDD VSS NAND2_X1
XI1942_I112_XG I1942_P16_15 I1942_G14_13 I1942_G16_15 I1942_G16_13n VDD VSS AOI21_X1
XI1942_I112_XP I1942_P16_15 I1942_P14_13 I1942_P16_13n VDD VSS NAND2_X1
XI1942_I113_XG I1942_P17_16 I1942_G15_14 I1942_G17_16 I1942_G17_14n VDD VSS AOI21_X1
XI1942_I113_XP I1942_P17_16 I1942_P15_14 I1942_P17_14n VDD VSS NAND2_X1
XI1942_I114_XG I1942_P18_17 I1942_G16_15 I1942_G18_17 I1942_G18_15n VDD VSS AOI21_X1
XI1942_I114_XP I1942_P18_17 I1942_P16_15 I1942_P18_15n VDD VSS NAND2_X1
XI1942_I115_XG I1942_P19_18 I1942_G17_16 I1942_G19_18 I1942_G19_16n VDD VSS AOI21_X1
XI1942_I115_XP I1942_P19_18 I1942_P17_16 I1942_P19_16n VDD VSS NAND2_X1
XI1942_I116_XG I1942_P20_19 I1942_G18_17 I1942_G20_19 I1942_G20_17n VDD VSS AOI21_X1
XI1942_I116_XP I1942_P20_19 I1942_P18_17 I1942_P20_17n VDD VSS NAND2_X1
XI1942_I117_XG I1942_P21_20 I1942_G19_18 I1942_G21_20 I1942_G21_18n VDD VSS AOI21_X1
XI1942_I117_XP I1942_P21_20 I1942_P19_18 I1942_P21_18n VDD VSS NAND2_X1
XI1942_I118_XG I1942_P22_21 I1942_G20_19 I1942_G22_21 I1942_G22_19n VDD VSS AOI21_X1
XI1942_I118_XP I1942_P22_21 I1942_P20_19 I1942_P22_19n VDD VSS NAND2_X1
XI1942_I119_XG I1942_P23_22 I1942_G21_20 I1942_G23_22 I1942_G23_20n VDD VSS AOI21_X1
XI1942_I119_XP I1942_P23_22 I1942_P21_20 I1942_P23_20n VDD VSS NAND2_X1
XI1942_I120_XG I1942_P24_23 I1942_G22_21 I1942_G24_23 I1942_G24_21n VDD VSS AOI21_X1
XI1942_I120_XP I1942_P24_23 I1942_P22_21 I1942_P24_21n VDD VSS NAND2_X1
XI1942_I121_XG I1942_P25_24 I1942_G23_22 I1942_G25_24 I1942_G25_22n VDD VSS AOI21_X1
XI1942_I121_XP I1942_P25_24 I1942_P23_22 I1942_P25_22n VDD VSS NAND2_X1
XI1942_I122_XG I1942_P26_25 I1942_G24_23 I1942_G26_25 I1942_G26_23n VDD VSS AOI21_X1
XI1942_I122_XP I1942_P26_25 I1942_P24_23 I1942_P26_23n VDD VSS NAND2_X1
XI1942_I123_XG I1942_P27_26 I1942_G25_24 I1942_G27_26 I1942_G27_24n VDD VSS AOI21_X1
XI1942_I123_XP I1942_P27_26 I1942_P25_24 I1942_P27_24n VDD VSS NAND2_X1
XI1942_I124_XG I1942_P28_27 I1942_G26_25 I1942_G28_27 I1942_G28_25n VDD VSS AOI21_X1
XI1942_I124_XP I1942_P28_27 I1942_P26_25 I1942_P28_25n VDD VSS NAND2_X1
XI1942_I125_XG I1942_P29_28 I1942_G27_26 I1942_G29_28 I1942_G29_26n VDD VSS AOI21_X1
XI1942_I125_XP I1942_P29_28 I1942_P27_26 I1942_P29_26n VDD VSS NAND2_X1
XI1942_I126_XG I1942_P30_29 I1942_G28_27 I1942_G30_29 I1942_G30_27n VDD VSS AOI21_X1
XI1942_I126_XP I1942_P30_29 I1942_P28_27 I1942_P30_27n VDD VSS NAND2_X1
XI1942_I127_XG I1942_P31_30 I1942_G29_28 I1942_G31_30 I1942_G31_28n VDD VSS AOI21_X1
XI1942_I127_XP I1942_P31_30 I1942_P29_28 I1942_P31_28n VDD VSS NAND2_X1
XI1942_I128_XG I1942_P4_1n I1942_G0_0n I1942_G4_1n I1942_G4_0 VDD VSS OAI21_X1
XI1942_I129 I1942_G1_0 I1942_G1_0n VDD VSS INV_X1
XI1942_I130_XG I1942_P5_2n I1942_G1_0n I1942_G5_2n I1942_G5_0 VDD VSS OAI21_X1
XI1942_I131_XG I1942_P6_3n I1942_G2_0n I1942_G6_3n I1942_G6_0 VDD VSS OAI21_X1
XI1942_I132_XG I1942_P7_4n I1942_G3_0n I1942_G7_4n I1942_G7_0 VDD VSS OAI21_X1
XI1942_I133_XG I1942_P8_5n I1942_G4_1n I1942_G8_5n I1942_G8_1 VDD VSS OAI21_X1
XI1942_I133_XP I1942_P8_5n I1942_P4_1n I1942_P8_1 VDD VSS NOR2_X1
XI1942_I134_XG I1942_P9_6n I1942_G5_2n I1942_G9_6n I1942_G9_2 VDD VSS OAI21_X1
XI1942_I134_XP I1942_P9_6n I1942_P5_2n I1942_P9_2 VDD VSS NOR2_X1
XI1942_I135_XG I1942_P10_7n I1942_G6_3n I1942_G10_7n I1942_G10_3 VDD VSS OAI21_X1
XI1942_I135_XP I1942_P10_7n I1942_P6_3n I1942_P10_3 VDD VSS NOR2_X1
XI1942_I136_XG I1942_P11_8n I1942_G7_4n I1942_G11_8n I1942_G11_4 VDD VSS OAI21_X1
XI1942_I136_XP I1942_P11_8n I1942_P7_4n I1942_P11_4 VDD VSS NOR2_X1
XI1942_I137_XG I1942_P12_9n I1942_G8_5n I1942_G12_9n I1942_G12_5 VDD VSS OAI21_X1
XI1942_I137_XP I1942_P12_9n I1942_P8_5n I1942_P12_5 VDD VSS NOR2_X1
XI1942_I138_XG I1942_P13_10n I1942_G9_6n I1942_G13_10n I1942_G13_6 VDD VSS OAI21_X1
XI1942_I138_XP I1942_P13_10n I1942_P9_6n I1942_P13_6 VDD VSS NOR2_X1
XI1942_I139_XG I1942_P14_11n I1942_G10_7n I1942_G14_11n I1942_G14_7 VDD VSS OAI21_X1
XI1942_I139_XP I1942_P14_11n I1942_P10_7n I1942_P14_7 VDD VSS NOR2_X1
XI1942_I140_XG I1942_P15_12n I1942_G11_8n I1942_G15_12n I1942_G15_8 VDD VSS OAI21_X1
XI1942_I140_XP I1942_P15_12n I1942_P11_8n I1942_P15_8 VDD VSS NOR2_X1
XI1942_I141_XG I1942_P16_13n I1942_G12_9n I1942_G16_13n I1942_G16_9 VDD VSS OAI21_X1
XI1942_I141_XP I1942_P16_13n I1942_P12_9n I1942_P16_9 VDD VSS NOR2_X1
XI1942_I142_XG I1942_P17_14n I1942_G13_10n I1942_G17_14n I1942_G17_10 VDD VSS OAI21_X1
XI1942_I142_XP I1942_P17_14n I1942_P13_10n I1942_P17_10 VDD VSS NOR2_X1
XI1942_I143_XG I1942_P18_15n I1942_G14_11n I1942_G18_15n I1942_G18_11 VDD VSS OAI21_X1
XI1942_I143_XP I1942_P18_15n I1942_P14_11n I1942_P18_11 VDD VSS NOR2_X1
XI1942_I144_XG I1942_P19_16n I1942_G15_12n I1942_G19_16n I1942_G19_12 VDD VSS OAI21_X1
XI1942_I144_XP I1942_P19_16n I1942_P15_12n I1942_P19_12 VDD VSS NOR2_X1
XI1942_I145_XG I1942_P20_17n I1942_G16_13n I1942_G20_17n I1942_G20_13 VDD VSS OAI21_X1
XI1942_I145_XP I1942_P20_17n I1942_P16_13n I1942_P20_13 VDD VSS NOR2_X1
XI1942_I146_XG I1942_P21_18n I1942_G17_14n I1942_G21_18n I1942_G21_14 VDD VSS OAI21_X1
XI1942_I146_XP I1942_P21_18n I1942_P17_14n I1942_P21_14 VDD VSS NOR2_X1
XI1942_I147_XG I1942_P22_19n I1942_G18_15n I1942_G22_19n I1942_G22_15 VDD VSS OAI21_X1
XI1942_I147_XP I1942_P22_19n I1942_P18_15n I1942_P22_15 VDD VSS NOR2_X1
XI1942_I148_XG I1942_P23_20n I1942_G19_16n I1942_G23_20n I1942_G23_16 VDD VSS OAI21_X1
XI1942_I148_XP I1942_P23_20n I1942_P19_16n I1942_P23_16 VDD VSS NOR2_X1
XI1942_I149_XG I1942_P24_21n I1942_G20_17n I1942_G24_21n I1942_G24_17 VDD VSS OAI21_X1
XI1942_I149_XP I1942_P24_21n I1942_P20_17n I1942_P24_17 VDD VSS NOR2_X1
XI1942_I150_XG I1942_P25_22n I1942_G21_18n I1942_G25_22n I1942_G25_18 VDD VSS OAI21_X1
XI1942_I150_XP I1942_P25_22n I1942_P21_18n I1942_P25_18 VDD VSS NOR2_X1
XI1942_I151_XG I1942_P26_23n I1942_G22_19n I1942_G26_23n I1942_G26_19 VDD VSS OAI21_X1
XI1942_I151_XP I1942_P26_23n I1942_P22_19n I1942_P26_19 VDD VSS NOR2_X1
XI1942_I152_XG I1942_P27_24n I1942_G23_20n I1942_G27_24n I1942_G27_20 VDD VSS OAI21_X1
XI1942_I152_XP I1942_P27_24n I1942_P23_20n I1942_P27_20 VDD VSS NOR2_X1
XI1942_I153_XG I1942_P28_25n I1942_G24_21n I1942_G28_25n I1942_G28_21 VDD VSS OAI21_X1
XI1942_I153_XP I1942_P28_25n I1942_P24_21n I1942_P28_21 VDD VSS NOR2_X1
XI1942_I154_XG I1942_P29_26n I1942_G25_22n I1942_G29_26n I1942_G29_22 VDD VSS OAI21_X1
XI1942_I154_XP I1942_P29_26n I1942_P25_22n I1942_P29_22 VDD VSS NOR2_X1
XI1942_I155_XG I1942_P30_27n I1942_G26_23n I1942_G30_27n I1942_G30_23 VDD VSS OAI21_X1
XI1942_I155_XP I1942_P30_27n I1942_P26_23n I1942_P30_23 VDD VSS NOR2_X1
XI1942_I156_XG I1942_P31_28n I1942_G27_24n I1942_G31_28n I1942_G31_24 VDD VSS OAI21_X1
XI1942_I156_XP I1942_P31_28n I1942_P27_24n I1942_P31_24 VDD VSS NOR2_X1
XI1942_I157_XG I1942_P8_1 I1942_G0_0 I1942_G8_1 I1942_G8_0n VDD VSS AOI21_X1
XI1942_I158_XG I1942_P9_2 I1942_G1_0 I1942_G9_2 I1942_G9_0n VDD VSS AOI21_X1
XI1942_I159 I1942_G2_0n I1942_G2_0np VDD VSS INV_X1
XI1942_I160_XG I1942_P10_3 I1942_G2_0np I1942_G10_3 I1942_G10_0n VDD VSS AOI21_X1
XI1942_I161 I1942_G3_0n I1942_G3_0np VDD VSS INV_X1
XI1942_I162_XG I1942_P11_4 I1942_G3_0np I1942_G11_4 I1942_G11_0n VDD VSS AOI21_X1
XI1942_I163_XG I1942_P12_5 I1942_G4_0 I1942_G12_5 I1942_G12_0n VDD VSS AOI21_X1
XI1942_I164_XG I1942_P13_6 I1942_G5_0 I1942_G13_6 I1942_G13_0n VDD VSS AOI21_X1
XI1942_I165_XG I1942_P14_7 I1942_G6_0 I1942_G14_7 I1942_G14_0n VDD VSS AOI21_X1
XI1942_I166_XG I1942_P15_8 I1942_G7_0 I1942_G15_8 I1942_G15_0n VDD VSS AOI21_X1
XI1942_I167_XG I1942_P16_9 I1942_G8_1 I1942_G16_9 I1942_G16_1n VDD VSS AOI21_X1
XI1942_I167_XP I1942_P16_9 I1942_P8_1 I1942_P16_1n VDD VSS NAND2_X1
XI1942_I168_XG I1942_P17_10 I1942_G9_2 I1942_G17_10 I1942_G17_2n VDD VSS AOI21_X1
XI1942_I168_XP I1942_P17_10 I1942_P9_2 I1942_P17_2n VDD VSS NAND2_X1
XI1942_I169_XG I1942_P18_11 I1942_G10_3 I1942_G18_11 I1942_G18_3n VDD VSS AOI21_X1
XI1942_I169_XP I1942_P18_11 I1942_P10_3 I1942_P18_3n VDD VSS NAND2_X1
XI1942_I170_XG I1942_P19_12 I1942_G11_4 I1942_G19_12 I1942_G19_4n VDD VSS AOI21_X1
XI1942_I170_XP I1942_P19_12 I1942_P11_4 I1942_P19_4n VDD VSS NAND2_X1
XI1942_I171_XG I1942_P20_13 I1942_G12_5 I1942_G20_13 I1942_G20_5n VDD VSS AOI21_X1
XI1942_I171_XP I1942_P20_13 I1942_P12_5 I1942_P20_5n VDD VSS NAND2_X1
XI1942_I172_XG I1942_P21_14 I1942_G13_6 I1942_G21_14 I1942_G21_6n VDD VSS AOI21_X1
XI1942_I172_XP I1942_P21_14 I1942_P13_6 I1942_P21_6n VDD VSS NAND2_X1
XI1942_I173_XG I1942_P22_15 I1942_G14_7 I1942_G22_15 I1942_G22_7n VDD VSS AOI21_X1
XI1942_I173_XP I1942_P22_15 I1942_P14_7 I1942_P22_7n VDD VSS NAND2_X1
XI1942_I174_XG I1942_P23_16 I1942_G15_8 I1942_G23_16 I1942_G23_8n VDD VSS AOI21_X1
XI1942_I174_XP I1942_P23_16 I1942_P15_8 I1942_P23_8n VDD VSS NAND2_X1
XI1942_I175_XG I1942_P24_17 I1942_G16_9 I1942_G24_17 I1942_G24_9n VDD VSS AOI21_X1
XI1942_I175_XP I1942_P24_17 I1942_P16_9 I1942_P24_9n VDD VSS NAND2_X1
XI1942_I176_XG I1942_P25_18 I1942_G17_10 I1942_G25_18 I1942_G25_10n VDD VSS AOI21_X1
XI1942_I176_XP I1942_P25_18 I1942_P17_10 I1942_P25_10n VDD VSS NAND2_X1
XI1942_I177_XG I1942_P26_19 I1942_G18_11 I1942_G26_19 I1942_G26_11n VDD VSS AOI21_X1
XI1942_I177_XP I1942_P26_19 I1942_P18_11 I1942_P26_11n VDD VSS NAND2_X1
XI1942_I178_XG I1942_P27_20 I1942_G19_12 I1942_G27_20 I1942_G27_12n VDD VSS AOI21_X1
XI1942_I178_XP I1942_P27_20 I1942_P19_12 I1942_P27_12n VDD VSS NAND2_X1
XI1942_I179_XG I1942_P28_21 I1942_G20_13 I1942_G28_21 I1942_G28_13n VDD VSS AOI21_X1
XI1942_I179_XP I1942_P28_21 I1942_P20_13 I1942_P28_13n VDD VSS NAND2_X1
XI1942_I180_XG I1942_P29_22 I1942_G21_14 I1942_G29_22 I1942_G29_14n VDD VSS AOI21_X1
XI1942_I180_XP I1942_P29_22 I1942_P21_14 I1942_P29_14n VDD VSS NAND2_X1
XI1942_I181_XG I1942_P30_23 I1942_G22_15 I1942_G30_23 I1942_G30_15n VDD VSS AOI21_X1
XI1942_I181_XP I1942_P30_23 I1942_P22_15 I1942_P30_15n VDD VSS NAND2_X1
XI1942_I182_XG I1942_P31_24 I1942_G23_16 I1942_G31_24 I1942_G31_16n VDD VSS AOI21_X1
XI1942_I182_XP I1942_P31_24 I1942_P23_16 I1942_P31_16n VDD VSS NAND2_X1
XI1942_I183_XG I1942_P16_1n I1942_G0_0n I1942_G16_1n I1942_G16_0 VDD VSS OAI21_X1
XI1942_I184_XG I1942_P17_2n I1942_G1_0n I1942_G17_2n I1942_G17_0 VDD VSS OAI21_X1
XI1942_I185_XG I1942_P18_3n I1942_G2_0n I1942_G18_3n I1942_G18_0 VDD VSS OAI21_X1
XI1942_I186_XG I1942_P19_4n I1942_G3_0n I1942_G19_4n I1942_G19_0 VDD VSS OAI21_X1
XI1942_I187 I1942_G4_0 I1942_G4_0n VDD VSS INV_X1
XI1942_I188_XG I1942_P20_5n I1942_G4_0n I1942_G20_5n I1942_G20_0 VDD VSS OAI21_X1
XI1942_I189 I1942_G5_0 I1942_G5_0n VDD VSS INV_X1
XI1942_I190_XG I1942_P21_6n I1942_G5_0n I1942_G21_6n I1942_G21_0 VDD VSS OAI21_X1
XI1942_I191 I1942_G6_0 I1942_G6_0n VDD VSS INV_X1
XI1942_I192_XG I1942_P22_7n I1942_G6_0n I1942_G22_7n I1942_G22_0 VDD VSS OAI21_X1
XI1942_I193 I1942_G7_0 I1942_G7_0n VDD VSS INV_X1
XI1942_I194_XG I1942_P23_8n I1942_G7_0n I1942_G23_8n I1942_G23_0 VDD VSS OAI21_X1
XI1942_I195_XG I1942_P24_9n I1942_G8_0n I1942_G24_9n I1942_G24_0 VDD VSS OAI21_X1
XI1942_I196_XG I1942_P25_10n I1942_G9_0n I1942_G25_10n I1942_G25_0 VDD VSS OAI21_X1
XI1942_I197_XG I1942_P26_11n I1942_G10_0n I1942_G26_11n I1942_G26_0 VDD VSS OAI21_X1
XI1942_I198_XG I1942_P27_12n I1942_G11_0n I1942_G27_12n I1942_G27_0 VDD VSS OAI21_X1
XI1942_I199_XG I1942_P28_13n I1942_G12_0n I1942_G28_13n I1942_G28_0 VDD VSS OAI21_X1
XI1942_I200_XG I1942_P29_14n I1942_G13_0n I1942_G29_14n I1942_G29_0 VDD VSS OAI21_X1
XI1942_I201_XG I1942_P30_15n I1942_G14_0n I1942_G30_15n c30_m VDD VSS OAI21_X1
XI1942_I202_XG I1942_P31_16n I1942_G15_0n I1942_G31_16n c30_o VDD VSS OAI21_X1
XI1942_I203 I1942_pn0 qu2_b3_5 p30_0 VDD VSS XNOR2_X1
XI1942_I204 I1942_pn1 I1942_G0_0 p30_1 VDD VSS XNOR2_X1
XI1942_I205 I1942_pn2 I1942_G1_0 p30_2 VDD VSS XNOR2_X1
XI1942_I206 I1942_pn3 I1942_G2_0n p30_3 VDD VSS XOR2_X1
XI1942_I207 I1942_pn4 I1942_G3_0n p30_4 VDD VSS XOR2_X1
XI1942_I208 I1942_pn5 I1942_G4_0 p30_5 VDD VSS XNOR2_X1
XI1942_I209 I1942_pn6 I1942_G5_0 p30_6 VDD VSS XNOR2_X1
XI1942_I210 I1942_pn7 I1942_G6_0 p30_7 VDD VSS XNOR2_X1
XI1942_I211 I1942_pn8 I1942_G7_0 p30_8 VDD VSS XNOR2_X1
XI1942_I212 I1942_pn9 I1942_G8_0n p30_9 VDD VSS XOR2_X1
XI1942_I213 I1942_pn10 I1942_G9_0n p30_10 VDD VSS XOR2_X1
XI1942_I214 I1942_pn11 I1942_G10_0n p30_11 VDD VSS XOR2_X1
XI1942_I215 I1942_pn12 I1942_G11_0n p30_12 VDD VSS XOR2_X1
XI1942_I216 I1942_pn13 I1942_G12_0n p30_13 VDD VSS XOR2_X1
XI1942_I217 I1942_pn14 I1942_G13_0n p30_14 VDD VSS XOR2_X1
XI1942_I218 I1942_pn15 I1942_G14_0n p30_15 VDD VSS XOR2_X1
XI1942_I219 I1942_pn16 I1942_G15_0n p30_16 VDD VSS XOR2_X1
XI1942_I220 I1942_pn17 I1942_G16_0 p30_17 VDD VSS XNOR2_X1
XI1942_I221 I1942_pn18 I1942_G17_0 p30_18 VDD VSS XNOR2_X1
XI1942_I222 I1942_pn19 I1942_G18_0 p30_19 VDD VSS XNOR2_X1
XI1942_I223 I1942_pn20 I1942_G19_0 p30_20 VDD VSS XNOR2_X1
XI1942_I224 I1942_pn21 I1942_G20_0 p30_21 VDD VSS XNOR2_X1
XI1942_I225 I1942_pn22 I1942_G21_0 p30_22 VDD VSS XNOR2_X1
XI1942_I226 I1942_pn23 I1942_G22_0 p30_23 VDD VSS XNOR2_X1
XI1942_I227 I1942_pn24 I1942_G23_0 p30_24 VDD VSS XNOR2_X1
XI1942_I228 I1942_pn25 I1942_G24_0 p30_25 VDD VSS XNOR2_X1
XI1942_I229 I1942_pn26 I1942_G25_0 p30_26 VDD VSS XNOR2_X1
XI1942_I230 I1942_pn27 I1942_G26_0 p30_27 VDD VSS XNOR2_X1
XI1942_I231 I1942_pn28 I1942_G27_0 p30_28 VDD VSS XNOR2_X1
XI1942_I232 I1942_pn29 I1942_G28_0 p30_29 VDD VSS XNOR2_X1
XI1942_I233 I1942_pn30 I1942_G29_0 p30_30 VDD VSS XNOR2_X1
XI1942_I234 I1942_pn31 c30_m p30_31 VDD VSS XNOR2_X1
XI1943 p29_31 qu2_b3_5 h30 VDD VSS XOR2_X1
XI1944 h30 c30_o p30_32 VDD VSS XOR2_X1
XI1945 p30_32 qu1 VDD VSS INV_X4
XI1946 qu1 qu1_b0 VDD VSS INV_X1
XI1947 qu1_b0 qu1_b1_0 VDD VSS INV_X4
XI1948 qu1_b1_0 qu1_b2_0 VDD VSS INV_X4
XI1949 qu1_b1_0 qu1_b2_1 VDD VSS INV_X4
XI1950 qu1_b2_0 qu1_b3_0 VDD VSS INV_X4
XI1951 qu1_b2_0 qu1_b3_1 VDD VSS INV_X4
XI1952 qu1_b2_0 qu1_b3_2 VDD VSS INV_X4
XI1953 qu1_b2_1 qu1_b3_3 VDD VSS INV_X4
XI1954 qu1_b2_1 qu1_b3_4 VDD VSS INV_X4
XI1955 qu1_b2_1 qu1_b3_5 VDD VSS INV_X4
XI1956 B_0_b3_5 qu1_b3_0 b31_0 VDD VSS XOR2_X1
XI1957 dd1_b3_5 qu1_b3_0 b31_1 VDD VSS XOR2_X1
XI1958 dd2_b3_5 qu1_b3_0 b31_2 VDD VSS XOR2_X1
XI1959 dd3_b3_5 qu1_b3_0 b31_3 VDD VSS XOR2_X1
XI1960 dd4_b3_5 qu1_b3_0 b31_4 VDD VSS XOR2_X1
XI1961 dd5_b3_5 qu1_b3_0 b31_5 VDD VSS XOR2_X1
XI1962 dd6_b3_5 qu1_b3_1 b31_6 VDD VSS XOR2_X1
XI1963 dd7_b3_5 qu1_b3_1 b31_7 VDD VSS XOR2_X1
XI1964 dd8_b3_5 qu1_b3_1 b31_8 VDD VSS XOR2_X1
XI1965 dd9_b3_5 qu1_b3_1 b31_9 VDD VSS XOR2_X1
XI1966 dd10_b3_5 qu1_b3_1 b31_10 VDD VSS XOR2_X1
XI1967 dd11_b3_5 qu1_b3_1 b31_11 VDD VSS XOR2_X1
XI1968 dd12_b3_5 qu1_b3_2 b31_12 VDD VSS XOR2_X1
XI1969 dd13_b3_5 qu1_b3_2 b31_13 VDD VSS XOR2_X1
XI1970 dd14_b3_5 qu1_b3_2 b31_14 VDD VSS XOR2_X1
XI1971 dd15_b3_5 qu1_b3_2 b31_15 VDD VSS XOR2_X1
XI1972 dd16_b3_5 qu1_b3_2 b31_16 VDD VSS XOR2_X1
XI1973 dd17_b3_5 qu1_b3_2 b31_17 VDD VSS XOR2_X1
XI1974 dd18_b3_5 qu1_b3_3 b31_18 VDD VSS XOR2_X1
XI1975 dd19_b3_5 qu1_b3_3 b31_19 VDD VSS XOR2_X1
XI1976 dd20_b3_5 qu1_b3_3 b31_20 VDD VSS XOR2_X1
XI1977 dd21_b3_5 qu1_b3_3 b31_21 VDD VSS XOR2_X1
XI1978 dd22_b3_5 qu1_b3_3 b31_22 VDD VSS XOR2_X1
XI1979 dd23_b3_5 qu1_b3_3 b31_23 VDD VSS XOR2_X1
XI1980 dd24_b3_5 qu1_b3_4 b31_24 VDD VSS XOR2_X1
XI1981 dd25_b3_5 qu1_b3_4 b31_25 VDD VSS XOR2_X1
XI1982 dd26_b3_5 qu1_b3_4 b31_26 VDD VSS XOR2_X1
XI1983 dd27_b3_5 qu1_b3_4 b31_27 VDD VSS XOR2_X1
XI1984 dd28_b3_5 qu1_b3_4 b31_28 VDD VSS XOR2_X1
XI1985 dd29_b3_5 qu1_b3_4 b31_29 VDD VSS XOR2_X1
XI1986 dd30_b3_5 qu1_b3_5 b31_30 VDD VSS XOR2_X1
XI1987 dd31_b3_5 qu1_b3_5 b31_31 VDD VSS XOR2_X1
XI1988_I0 A_0 b31_0 I1988_gn0 VDD VSS NAND2_X1
XI1988_I1 p30_0 b31_1 I1988_gn1 VDD VSS NAND2_X1
XI1988_I2 p30_1 b31_2 I1988_gn2 VDD VSS NAND2_X1
XI1988_I3 p30_2 b31_3 I1988_gn3 VDD VSS NAND2_X1
XI1988_I4 p30_3 b31_4 I1988_gn4 VDD VSS NAND2_X1
XI1988_I5 p30_4 b31_5 I1988_gn5 VDD VSS NAND2_X1
XI1988_I6 p30_5 b31_6 I1988_gn6 VDD VSS NAND2_X1
XI1988_I7 p30_6 b31_7 I1988_gn7 VDD VSS NAND2_X1
XI1988_I8 p30_7 b31_8 I1988_gn8 VDD VSS NAND2_X1
XI1988_I9 p30_8 b31_9 I1988_gn9 VDD VSS NAND2_X1
XI1988_I10 p30_9 b31_10 I1988_gn10 VDD VSS NAND2_X1
XI1988_I11 p30_10 b31_11 I1988_gn11 VDD VSS NAND2_X1
XI1988_I12 p30_11 b31_12 I1988_gn12 VDD VSS NAND2_X1
XI1988_I13 p30_12 b31_13 I1988_gn13 VDD VSS NAND2_X1
XI1988_I14 p30_13 b31_14 I1988_gn14 VDD VSS NAND2_X1
XI1988_I15 p30_14 b31_15 I1988_gn15 VDD VSS NAND2_X1
XI1988_I16 p30_15 b31_16 I1988_gn16 VDD VSS NAND2_X1
XI1988_I17 p30_16 b31_17 I1988_gn17 VDD VSS NAND2_X1
XI1988_I18 p30_17 b31_18 I1988_gn18 VDD VSS NAND2_X1
XI1988_I19 p30_18 b31_19 I1988_gn19 VDD VSS NAND2_X1
XI1988_I20 p30_19 b31_20 I1988_gn20 VDD VSS NAND2_X1
XI1988_I21 p30_20 b31_21 I1988_gn21 VDD VSS NAND2_X1
XI1988_I22 p30_21 b31_22 I1988_gn22 VDD VSS NAND2_X1
XI1988_I23 p30_22 b31_23 I1988_gn23 VDD VSS NAND2_X1
XI1988_I24 p30_23 b31_24 I1988_gn24 VDD VSS NAND2_X1
XI1988_I25 p30_24 b31_25 I1988_gn25 VDD VSS NAND2_X1
XI1988_I26 p30_25 b31_26 I1988_gn26 VDD VSS NAND2_X1
XI1988_I27 p30_26 b31_27 I1988_gn27 VDD VSS NAND2_X1
XI1988_I28 p30_27 b31_28 I1988_gn28 VDD VSS NAND2_X1
XI1988_I29 p30_28 b31_29 I1988_gn29 VDD VSS NAND2_X1
XI1988_I30 p30_29 b31_30 I1988_gn30 VDD VSS NAND2_X1
XI1988_I31 p30_30 b31_31 I1988_gn31 VDD VSS NAND2_X1
XI1988_I32 A_0 b31_0 I1988_pn0 VDD VSS XNOR2_X1
XI1988_I33 p30_0 b31_1 I1988_pn1 VDD VSS XNOR2_X1
XI1988_I34 p30_1 b31_2 I1988_pn2 VDD VSS XNOR2_X1
XI1988_I35 p30_2 b31_3 I1988_pn3 VDD VSS XNOR2_X1
XI1988_I36 p30_3 b31_4 I1988_pn4 VDD VSS XNOR2_X1
XI1988_I37 p30_4 b31_5 I1988_pn5 VDD VSS XNOR2_X1
XI1988_I38 p30_5 b31_6 I1988_pn6 VDD VSS XNOR2_X1
XI1988_I39 p30_6 b31_7 I1988_pn7 VDD VSS XNOR2_X1
XI1988_I40 p30_7 b31_8 I1988_pn8 VDD VSS XNOR2_X1
XI1988_I41 p30_8 b31_9 I1988_pn9 VDD VSS XNOR2_X1
XI1988_I42 p30_9 b31_10 I1988_pn10 VDD VSS XNOR2_X1
XI1988_I43 p30_10 b31_11 I1988_pn11 VDD VSS XNOR2_X1
XI1988_I44 p30_11 b31_12 I1988_pn12 VDD VSS XNOR2_X1
XI1988_I45 p30_12 b31_13 I1988_pn13 VDD VSS XNOR2_X1
XI1988_I46 p30_13 b31_14 I1988_pn14 VDD VSS XNOR2_X1
XI1988_I47 p30_14 b31_15 I1988_pn15 VDD VSS XNOR2_X1
XI1988_I48 p30_15 b31_16 I1988_pn16 VDD VSS XNOR2_X1
XI1988_I49 p30_16 b31_17 I1988_pn17 VDD VSS XNOR2_X1
XI1988_I50 p30_17 b31_18 I1988_pn18 VDD VSS XNOR2_X1
XI1988_I51 p30_18 b31_19 I1988_pn19 VDD VSS XNOR2_X1
XI1988_I52 p30_19 b31_20 I1988_pn20 VDD VSS XNOR2_X1
XI1988_I53 p30_20 b31_21 I1988_pn21 VDD VSS XNOR2_X1
XI1988_I54 p30_21 b31_22 I1988_pn22 VDD VSS XNOR2_X1
XI1988_I55 p30_22 b31_23 I1988_pn23 VDD VSS XNOR2_X1
XI1988_I56 p30_23 b31_24 I1988_pn24 VDD VSS XNOR2_X1
XI1988_I57 p30_24 b31_25 I1988_pn25 VDD VSS XNOR2_X1
XI1988_I58 p30_25 b31_26 I1988_pn26 VDD VSS XNOR2_X1
XI1988_I59 p30_26 b31_27 I1988_pn27 VDD VSS XNOR2_X1
XI1988_I60 p30_27 b31_28 I1988_pn28 VDD VSS XNOR2_X1
XI1988_I61 p30_28 b31_29 I1988_pn29 VDD VSS XNOR2_X1
XI1988_I62 p30_29 b31_30 I1988_pn30 VDD VSS XNOR2_X1
XI1988_I63 p30_30 b31_31 I1988_pn31 VDD VSS XNOR2_X1
XI1988_I64 qu1_b3_5 I1988_cinn VDD VSS INV_X1
XI1988_I65_XG I1988_pn0 I1988_cinn I1988_gn0 I1988_G0_0 VDD VSS OAI21_X1
XI1988_I66 I1988_G0_0 I1988_G0_0n VDD VSS INV_X1
XI1988_I67_XG I1988_pn1 I1988_G0_0n I1988_gn1 I1988_G1_0 VDD VSS OAI21_X1
XI1988_I68_XG I1988_pn2 I1988_gn1 I1988_gn2 I1988_G2_1 VDD VSS OAI21_X1
XI1988_I68_XP I1988_pn2 I1988_pn1 I1988_P2_1 VDD VSS NOR2_X1
XI1988_I69_XG I1988_pn3 I1988_gn2 I1988_gn3 I1988_G3_2 VDD VSS OAI21_X1
XI1988_I69_XP I1988_pn3 I1988_pn2 I1988_P3_2 VDD VSS NOR2_X1
XI1988_I70_XG I1988_pn4 I1988_gn3 I1988_gn4 I1988_G4_3 VDD VSS OAI21_X1
XI1988_I70_XP I1988_pn4 I1988_pn3 I1988_P4_3 VDD VSS NOR2_X1
XI1988_I71_XG I1988_pn5 I1988_gn4 I1988_gn5 I1988_G5_4 VDD VSS OAI21_X1
XI1988_I71_XP I1988_pn5 I1988_pn4 I1988_P5_4 VDD VSS NOR2_X1
XI1988_I72_XG I1988_pn6 I1988_gn5 I1988_gn6 I1988_G6_5 VDD VSS OAI21_X1
XI1988_I72_XP I1988_pn6 I1988_pn5 I1988_P6_5 VDD VSS NOR2_X1
XI1988_I73_XG I1988_pn7 I1988_gn6 I1988_gn7 I1988_G7_6 VDD VSS OAI21_X1
XI1988_I73_XP I1988_pn7 I1988_pn6 I1988_P7_6 VDD VSS NOR2_X1
XI1988_I74_XG I1988_pn8 I1988_gn7 I1988_gn8 I1988_G8_7 VDD VSS OAI21_X1
XI1988_I74_XP I1988_pn8 I1988_pn7 I1988_P8_7 VDD VSS NOR2_X1
XI1988_I75_XG I1988_pn9 I1988_gn8 I1988_gn9 I1988_G9_8 VDD VSS OAI21_X1
XI1988_I75_XP I1988_pn9 I1988_pn8 I1988_P9_8 VDD VSS NOR2_X1
XI1988_I76_XG I1988_pn10 I1988_gn9 I1988_gn10 I1988_G10_9 VDD VSS OAI21_X1
XI1988_I76_XP I1988_pn10 I1988_pn9 I1988_P10_9 VDD VSS NOR2_X1
XI1988_I77_XG I1988_pn11 I1988_gn10 I1988_gn11 I1988_G11_10 VDD VSS OAI21_X1
XI1988_I77_XP I1988_pn11 I1988_pn10 I1988_P11_10 VDD VSS NOR2_X1
XI1988_I78_XG I1988_pn12 I1988_gn11 I1988_gn12 I1988_G12_11 VDD VSS OAI21_X1
XI1988_I78_XP I1988_pn12 I1988_pn11 I1988_P12_11 VDD VSS NOR2_X1
XI1988_I79_XG I1988_pn13 I1988_gn12 I1988_gn13 I1988_G13_12 VDD VSS OAI21_X1
XI1988_I79_XP I1988_pn13 I1988_pn12 I1988_P13_12 VDD VSS NOR2_X1
XI1988_I80_XG I1988_pn14 I1988_gn13 I1988_gn14 I1988_G14_13 VDD VSS OAI21_X1
XI1988_I80_XP I1988_pn14 I1988_pn13 I1988_P14_13 VDD VSS NOR2_X1
XI1988_I81_XG I1988_pn15 I1988_gn14 I1988_gn15 I1988_G15_14 VDD VSS OAI21_X1
XI1988_I81_XP I1988_pn15 I1988_pn14 I1988_P15_14 VDD VSS NOR2_X1
XI1988_I82_XG I1988_pn16 I1988_gn15 I1988_gn16 I1988_G16_15 VDD VSS OAI21_X1
XI1988_I82_XP I1988_pn16 I1988_pn15 I1988_P16_15 VDD VSS NOR2_X1
XI1988_I83_XG I1988_pn17 I1988_gn16 I1988_gn17 I1988_G17_16 VDD VSS OAI21_X1
XI1988_I83_XP I1988_pn17 I1988_pn16 I1988_P17_16 VDD VSS NOR2_X1
XI1988_I84_XG I1988_pn18 I1988_gn17 I1988_gn18 I1988_G18_17 VDD VSS OAI21_X1
XI1988_I84_XP I1988_pn18 I1988_pn17 I1988_P18_17 VDD VSS NOR2_X1
XI1988_I85_XG I1988_pn19 I1988_gn18 I1988_gn19 I1988_G19_18 VDD VSS OAI21_X1
XI1988_I85_XP I1988_pn19 I1988_pn18 I1988_P19_18 VDD VSS NOR2_X1
XI1988_I86_XG I1988_pn20 I1988_gn19 I1988_gn20 I1988_G20_19 VDD VSS OAI21_X1
XI1988_I86_XP I1988_pn20 I1988_pn19 I1988_P20_19 VDD VSS NOR2_X1
XI1988_I87_XG I1988_pn21 I1988_gn20 I1988_gn21 I1988_G21_20 VDD VSS OAI21_X1
XI1988_I87_XP I1988_pn21 I1988_pn20 I1988_P21_20 VDD VSS NOR2_X1
XI1988_I88_XG I1988_pn22 I1988_gn21 I1988_gn22 I1988_G22_21 VDD VSS OAI21_X1
XI1988_I88_XP I1988_pn22 I1988_pn21 I1988_P22_21 VDD VSS NOR2_X1
XI1988_I89_XG I1988_pn23 I1988_gn22 I1988_gn23 I1988_G23_22 VDD VSS OAI21_X1
XI1988_I89_XP I1988_pn23 I1988_pn22 I1988_P23_22 VDD VSS NOR2_X1
XI1988_I90_XG I1988_pn24 I1988_gn23 I1988_gn24 I1988_G24_23 VDD VSS OAI21_X1
XI1988_I90_XP I1988_pn24 I1988_pn23 I1988_P24_23 VDD VSS NOR2_X1
XI1988_I91_XG I1988_pn25 I1988_gn24 I1988_gn25 I1988_G25_24 VDD VSS OAI21_X1
XI1988_I91_XP I1988_pn25 I1988_pn24 I1988_P25_24 VDD VSS NOR2_X1
XI1988_I92_XG I1988_pn26 I1988_gn25 I1988_gn26 I1988_G26_25 VDD VSS OAI21_X1
XI1988_I92_XP I1988_pn26 I1988_pn25 I1988_P26_25 VDD VSS NOR2_X1
XI1988_I93_XG I1988_pn27 I1988_gn26 I1988_gn27 I1988_G27_26 VDD VSS OAI21_X1
XI1988_I93_XP I1988_pn27 I1988_pn26 I1988_P27_26 VDD VSS NOR2_X1
XI1988_I94_XG I1988_pn28 I1988_gn27 I1988_gn28 I1988_G28_27 VDD VSS OAI21_X1
XI1988_I94_XP I1988_pn28 I1988_pn27 I1988_P28_27 VDD VSS NOR2_X1
XI1988_I95_XG I1988_pn29 I1988_gn28 I1988_gn29 I1988_G29_28 VDD VSS OAI21_X1
XI1988_I95_XP I1988_pn29 I1988_pn28 I1988_P29_28 VDD VSS NOR2_X1
XI1988_I96_XG I1988_pn30 I1988_gn29 I1988_gn30 I1988_G30_29 VDD VSS OAI21_X1
XI1988_I96_XP I1988_pn30 I1988_pn29 I1988_P30_29 VDD VSS NOR2_X1
XI1988_I97_XG I1988_pn31 I1988_gn30 I1988_gn31 I1988_G31_30 VDD VSS OAI21_X1
XI1988_I97_XP I1988_pn31 I1988_pn30 I1988_P31_30 VDD VSS NOR2_X1
XI1988_I98_XG I1988_P2_1 I1988_G0_0 I1988_G2_1 I1988_G2_0n VDD VSS AOI21_X1
XI1988_I99_XG I1988_P3_2 I1988_G1_0 I1988_G3_2 I1988_G3_0n VDD VSS AOI21_X1
XI1988_I100_XG I1988_P4_3 I1988_G2_1 I1988_G4_3 I1988_G4_1n VDD VSS AOI21_X1
XI1988_I100_XP I1988_P4_3 I1988_P2_1 I1988_P4_1n VDD VSS NAND2_X1
XI1988_I101_XG I1988_P5_4 I1988_G3_2 I1988_G5_4 I1988_G5_2n VDD VSS AOI21_X1
XI1988_I101_XP I1988_P5_4 I1988_P3_2 I1988_P5_2n VDD VSS NAND2_X1
XI1988_I102_XG I1988_P6_5 I1988_G4_3 I1988_G6_5 I1988_G6_3n VDD VSS AOI21_X1
XI1988_I102_XP I1988_P6_5 I1988_P4_3 I1988_P6_3n VDD VSS NAND2_X1
XI1988_I103_XG I1988_P7_6 I1988_G5_4 I1988_G7_6 I1988_G7_4n VDD VSS AOI21_X1
XI1988_I103_XP I1988_P7_6 I1988_P5_4 I1988_P7_4n VDD VSS NAND2_X1
XI1988_I104_XG I1988_P8_7 I1988_G6_5 I1988_G8_7 I1988_G8_5n VDD VSS AOI21_X1
XI1988_I104_XP I1988_P8_7 I1988_P6_5 I1988_P8_5n VDD VSS NAND2_X1
XI1988_I105_XG I1988_P9_8 I1988_G7_6 I1988_G9_8 I1988_G9_6n VDD VSS AOI21_X1
XI1988_I105_XP I1988_P9_8 I1988_P7_6 I1988_P9_6n VDD VSS NAND2_X1
XI1988_I106_XG I1988_P10_9 I1988_G8_7 I1988_G10_9 I1988_G10_7n VDD VSS AOI21_X1
XI1988_I106_XP I1988_P10_9 I1988_P8_7 I1988_P10_7n VDD VSS NAND2_X1
XI1988_I107_XG I1988_P11_10 I1988_G9_8 I1988_G11_10 I1988_G11_8n VDD VSS AOI21_X1
XI1988_I107_XP I1988_P11_10 I1988_P9_8 I1988_P11_8n VDD VSS NAND2_X1
XI1988_I108_XG I1988_P12_11 I1988_G10_9 I1988_G12_11 I1988_G12_9n VDD VSS AOI21_X1
XI1988_I108_XP I1988_P12_11 I1988_P10_9 I1988_P12_9n VDD VSS NAND2_X1
XI1988_I109_XG I1988_P13_12 I1988_G11_10 I1988_G13_12 I1988_G13_10n VDD VSS AOI21_X1
XI1988_I109_XP I1988_P13_12 I1988_P11_10 I1988_P13_10n VDD VSS NAND2_X1
XI1988_I110_XG I1988_P14_13 I1988_G12_11 I1988_G14_13 I1988_G14_11n VDD VSS AOI21_X1
XI1988_I110_XP I1988_P14_13 I1988_P12_11 I1988_P14_11n VDD VSS NAND2_X1
XI1988_I111_XG I1988_P15_14 I1988_G13_12 I1988_G15_14 I1988_G15_12n VDD VSS AOI21_X1
XI1988_I111_XP I1988_P15_14 I1988_P13_12 I1988_P15_12n VDD VSS NAND2_X1
XI1988_I112_XG I1988_P16_15 I1988_G14_13 I1988_G16_15 I1988_G16_13n VDD VSS AOI21_X1
XI1988_I112_XP I1988_P16_15 I1988_P14_13 I1988_P16_13n VDD VSS NAND2_X1
XI1988_I113_XG I1988_P17_16 I1988_G15_14 I1988_G17_16 I1988_G17_14n VDD VSS AOI21_X1
XI1988_I113_XP I1988_P17_16 I1988_P15_14 I1988_P17_14n VDD VSS NAND2_X1
XI1988_I114_XG I1988_P18_17 I1988_G16_15 I1988_G18_17 I1988_G18_15n VDD VSS AOI21_X1
XI1988_I114_XP I1988_P18_17 I1988_P16_15 I1988_P18_15n VDD VSS NAND2_X1
XI1988_I115_XG I1988_P19_18 I1988_G17_16 I1988_G19_18 I1988_G19_16n VDD VSS AOI21_X1
XI1988_I115_XP I1988_P19_18 I1988_P17_16 I1988_P19_16n VDD VSS NAND2_X1
XI1988_I116_XG I1988_P20_19 I1988_G18_17 I1988_G20_19 I1988_G20_17n VDD VSS AOI21_X1
XI1988_I116_XP I1988_P20_19 I1988_P18_17 I1988_P20_17n VDD VSS NAND2_X1
XI1988_I117_XG I1988_P21_20 I1988_G19_18 I1988_G21_20 I1988_G21_18n VDD VSS AOI21_X1
XI1988_I117_XP I1988_P21_20 I1988_P19_18 I1988_P21_18n VDD VSS NAND2_X1
XI1988_I118_XG I1988_P22_21 I1988_G20_19 I1988_G22_21 I1988_G22_19n VDD VSS AOI21_X1
XI1988_I118_XP I1988_P22_21 I1988_P20_19 I1988_P22_19n VDD VSS NAND2_X1
XI1988_I119_XG I1988_P23_22 I1988_G21_20 I1988_G23_22 I1988_G23_20n VDD VSS AOI21_X1
XI1988_I119_XP I1988_P23_22 I1988_P21_20 I1988_P23_20n VDD VSS NAND2_X1
XI1988_I120_XG I1988_P24_23 I1988_G22_21 I1988_G24_23 I1988_G24_21n VDD VSS AOI21_X1
XI1988_I120_XP I1988_P24_23 I1988_P22_21 I1988_P24_21n VDD VSS NAND2_X1
XI1988_I121_XG I1988_P25_24 I1988_G23_22 I1988_G25_24 I1988_G25_22n VDD VSS AOI21_X1
XI1988_I121_XP I1988_P25_24 I1988_P23_22 I1988_P25_22n VDD VSS NAND2_X1
XI1988_I122_XG I1988_P26_25 I1988_G24_23 I1988_G26_25 I1988_G26_23n VDD VSS AOI21_X1
XI1988_I122_XP I1988_P26_25 I1988_P24_23 I1988_P26_23n VDD VSS NAND2_X1
XI1988_I123_XG I1988_P27_26 I1988_G25_24 I1988_G27_26 I1988_G27_24n VDD VSS AOI21_X1
XI1988_I123_XP I1988_P27_26 I1988_P25_24 I1988_P27_24n VDD VSS NAND2_X1
XI1988_I124_XG I1988_P28_27 I1988_G26_25 I1988_G28_27 I1988_G28_25n VDD VSS AOI21_X1
XI1988_I124_XP I1988_P28_27 I1988_P26_25 I1988_P28_25n VDD VSS NAND2_X1
XI1988_I125_XG I1988_P29_28 I1988_G27_26 I1988_G29_28 I1988_G29_26n VDD VSS AOI21_X1
XI1988_I125_XP I1988_P29_28 I1988_P27_26 I1988_P29_26n VDD VSS NAND2_X1
XI1988_I126_XG I1988_P30_29 I1988_G28_27 I1988_G30_29 I1988_G30_27n VDD VSS AOI21_X1
XI1988_I126_XP I1988_P30_29 I1988_P28_27 I1988_P30_27n VDD VSS NAND2_X1
XI1988_I127_XG I1988_P31_30 I1988_G29_28 I1988_G31_30 I1988_G31_28n VDD VSS AOI21_X1
XI1988_I127_XP I1988_P31_30 I1988_P29_28 I1988_P31_28n VDD VSS NAND2_X1
XI1988_I128_XG I1988_P4_1n I1988_G0_0n I1988_G4_1n I1988_G4_0 VDD VSS OAI21_X1
XI1988_I129 I1988_G1_0 I1988_G1_0n VDD VSS INV_X1
XI1988_I130_XG I1988_P5_2n I1988_G1_0n I1988_G5_2n I1988_G5_0 VDD VSS OAI21_X1
XI1988_I131_XG I1988_P6_3n I1988_G2_0n I1988_G6_3n I1988_G6_0 VDD VSS OAI21_X1
XI1988_I132_XG I1988_P7_4n I1988_G3_0n I1988_G7_4n I1988_G7_0 VDD VSS OAI21_X1
XI1988_I133_XG I1988_P8_5n I1988_G4_1n I1988_G8_5n I1988_G8_1 VDD VSS OAI21_X1
XI1988_I133_XP I1988_P8_5n I1988_P4_1n I1988_P8_1 VDD VSS NOR2_X1
XI1988_I134_XG I1988_P9_6n I1988_G5_2n I1988_G9_6n I1988_G9_2 VDD VSS OAI21_X1
XI1988_I134_XP I1988_P9_6n I1988_P5_2n I1988_P9_2 VDD VSS NOR2_X1
XI1988_I135_XG I1988_P10_7n I1988_G6_3n I1988_G10_7n I1988_G10_3 VDD VSS OAI21_X1
XI1988_I135_XP I1988_P10_7n I1988_P6_3n I1988_P10_3 VDD VSS NOR2_X1
XI1988_I136_XG I1988_P11_8n I1988_G7_4n I1988_G11_8n I1988_G11_4 VDD VSS OAI21_X1
XI1988_I136_XP I1988_P11_8n I1988_P7_4n I1988_P11_4 VDD VSS NOR2_X1
XI1988_I137_XG I1988_P12_9n I1988_G8_5n I1988_G12_9n I1988_G12_5 VDD VSS OAI21_X1
XI1988_I137_XP I1988_P12_9n I1988_P8_5n I1988_P12_5 VDD VSS NOR2_X1
XI1988_I138_XG I1988_P13_10n I1988_G9_6n I1988_G13_10n I1988_G13_6 VDD VSS OAI21_X1
XI1988_I138_XP I1988_P13_10n I1988_P9_6n I1988_P13_6 VDD VSS NOR2_X1
XI1988_I139_XG I1988_P14_11n I1988_G10_7n I1988_G14_11n I1988_G14_7 VDD VSS OAI21_X1
XI1988_I139_XP I1988_P14_11n I1988_P10_7n I1988_P14_7 VDD VSS NOR2_X1
XI1988_I140_XG I1988_P15_12n I1988_G11_8n I1988_G15_12n I1988_G15_8 VDD VSS OAI21_X1
XI1988_I140_XP I1988_P15_12n I1988_P11_8n I1988_P15_8 VDD VSS NOR2_X1
XI1988_I141_XG I1988_P16_13n I1988_G12_9n I1988_G16_13n I1988_G16_9 VDD VSS OAI21_X1
XI1988_I141_XP I1988_P16_13n I1988_P12_9n I1988_P16_9 VDD VSS NOR2_X1
XI1988_I142_XG I1988_P17_14n I1988_G13_10n I1988_G17_14n I1988_G17_10 VDD VSS OAI21_X1
XI1988_I142_XP I1988_P17_14n I1988_P13_10n I1988_P17_10 VDD VSS NOR2_X1
XI1988_I143_XG I1988_P18_15n I1988_G14_11n I1988_G18_15n I1988_G18_11 VDD VSS OAI21_X1
XI1988_I143_XP I1988_P18_15n I1988_P14_11n I1988_P18_11 VDD VSS NOR2_X1
XI1988_I144_XG I1988_P19_16n I1988_G15_12n I1988_G19_16n I1988_G19_12 VDD VSS OAI21_X1
XI1988_I144_XP I1988_P19_16n I1988_P15_12n I1988_P19_12 VDD VSS NOR2_X1
XI1988_I145_XG I1988_P20_17n I1988_G16_13n I1988_G20_17n I1988_G20_13 VDD VSS OAI21_X1
XI1988_I145_XP I1988_P20_17n I1988_P16_13n I1988_P20_13 VDD VSS NOR2_X1
XI1988_I146_XG I1988_P21_18n I1988_G17_14n I1988_G21_18n I1988_G21_14 VDD VSS OAI21_X1
XI1988_I146_XP I1988_P21_18n I1988_P17_14n I1988_P21_14 VDD VSS NOR2_X1
XI1988_I147_XG I1988_P22_19n I1988_G18_15n I1988_G22_19n I1988_G22_15 VDD VSS OAI21_X1
XI1988_I147_XP I1988_P22_19n I1988_P18_15n I1988_P22_15 VDD VSS NOR2_X1
XI1988_I148_XG I1988_P23_20n I1988_G19_16n I1988_G23_20n I1988_G23_16 VDD VSS OAI21_X1
XI1988_I148_XP I1988_P23_20n I1988_P19_16n I1988_P23_16 VDD VSS NOR2_X1
XI1988_I149_XG I1988_P24_21n I1988_G20_17n I1988_G24_21n I1988_G24_17 VDD VSS OAI21_X1
XI1988_I149_XP I1988_P24_21n I1988_P20_17n I1988_P24_17 VDD VSS NOR2_X1
XI1988_I150_XG I1988_P25_22n I1988_G21_18n I1988_G25_22n I1988_G25_18 VDD VSS OAI21_X1
XI1988_I150_XP I1988_P25_22n I1988_P21_18n I1988_P25_18 VDD VSS NOR2_X1
XI1988_I151_XG I1988_P26_23n I1988_G22_19n I1988_G26_23n I1988_G26_19 VDD VSS OAI21_X1
XI1988_I151_XP I1988_P26_23n I1988_P22_19n I1988_P26_19 VDD VSS NOR2_X1
XI1988_I152_XG I1988_P27_24n I1988_G23_20n I1988_G27_24n I1988_G27_20 VDD VSS OAI21_X1
XI1988_I152_XP I1988_P27_24n I1988_P23_20n I1988_P27_20 VDD VSS NOR2_X1
XI1988_I153_XG I1988_P28_25n I1988_G24_21n I1988_G28_25n I1988_G28_21 VDD VSS OAI21_X1
XI1988_I153_XP I1988_P28_25n I1988_P24_21n I1988_P28_21 VDD VSS NOR2_X1
XI1988_I154_XG I1988_P29_26n I1988_G25_22n I1988_G29_26n I1988_G29_22 VDD VSS OAI21_X1
XI1988_I154_XP I1988_P29_26n I1988_P25_22n I1988_P29_22 VDD VSS NOR2_X1
XI1988_I155_XG I1988_P30_27n I1988_G26_23n I1988_G30_27n I1988_G30_23 VDD VSS OAI21_X1
XI1988_I155_XP I1988_P30_27n I1988_P26_23n I1988_P30_23 VDD VSS NOR2_X1
XI1988_I156_XG I1988_P31_28n I1988_G27_24n I1988_G31_28n I1988_G31_24 VDD VSS OAI21_X1
XI1988_I156_XP I1988_P31_28n I1988_P27_24n I1988_P31_24 VDD VSS NOR2_X1
XI1988_I157_XG I1988_P8_1 I1988_G0_0 I1988_G8_1 I1988_G8_0n VDD VSS AOI21_X1
XI1988_I158_XG I1988_P9_2 I1988_G1_0 I1988_G9_2 I1988_G9_0n VDD VSS AOI21_X1
XI1988_I159 I1988_G2_0n I1988_G2_0np VDD VSS INV_X1
XI1988_I160_XG I1988_P10_3 I1988_G2_0np I1988_G10_3 I1988_G10_0n VDD VSS AOI21_X1
XI1988_I161 I1988_G3_0n I1988_G3_0np VDD VSS INV_X1
XI1988_I162_XG I1988_P11_4 I1988_G3_0np I1988_G11_4 I1988_G11_0n VDD VSS AOI21_X1
XI1988_I163_XG I1988_P12_5 I1988_G4_0 I1988_G12_5 I1988_G12_0n VDD VSS AOI21_X1
XI1988_I164_XG I1988_P13_6 I1988_G5_0 I1988_G13_6 I1988_G13_0n VDD VSS AOI21_X1
XI1988_I165_XG I1988_P14_7 I1988_G6_0 I1988_G14_7 I1988_G14_0n VDD VSS AOI21_X1
XI1988_I166_XG I1988_P15_8 I1988_G7_0 I1988_G15_8 I1988_G15_0n VDD VSS AOI21_X1
XI1988_I167_XG I1988_P16_9 I1988_G8_1 I1988_G16_9 I1988_G16_1n VDD VSS AOI21_X1
XI1988_I167_XP I1988_P16_9 I1988_P8_1 I1988_P16_1n VDD VSS NAND2_X1
XI1988_I168_XG I1988_P17_10 I1988_G9_2 I1988_G17_10 I1988_G17_2n VDD VSS AOI21_X1
XI1988_I168_XP I1988_P17_10 I1988_P9_2 I1988_P17_2n VDD VSS NAND2_X1
XI1988_I169_XG I1988_P18_11 I1988_G10_3 I1988_G18_11 I1988_G18_3n VDD VSS AOI21_X1
XI1988_I169_XP I1988_P18_11 I1988_P10_3 I1988_P18_3n VDD VSS NAND2_X1
XI1988_I170_XG I1988_P19_12 I1988_G11_4 I1988_G19_12 I1988_G19_4n VDD VSS AOI21_X1
XI1988_I170_XP I1988_P19_12 I1988_P11_4 I1988_P19_4n VDD VSS NAND2_X1
XI1988_I171_XG I1988_P20_13 I1988_G12_5 I1988_G20_13 I1988_G20_5n VDD VSS AOI21_X1
XI1988_I171_XP I1988_P20_13 I1988_P12_5 I1988_P20_5n VDD VSS NAND2_X1
XI1988_I172_XG I1988_P21_14 I1988_G13_6 I1988_G21_14 I1988_G21_6n VDD VSS AOI21_X1
XI1988_I172_XP I1988_P21_14 I1988_P13_6 I1988_P21_6n VDD VSS NAND2_X1
XI1988_I173_XG I1988_P22_15 I1988_G14_7 I1988_G22_15 I1988_G22_7n VDD VSS AOI21_X1
XI1988_I173_XP I1988_P22_15 I1988_P14_7 I1988_P22_7n VDD VSS NAND2_X1
XI1988_I174_XG I1988_P23_16 I1988_G15_8 I1988_G23_16 I1988_G23_8n VDD VSS AOI21_X1
XI1988_I174_XP I1988_P23_16 I1988_P15_8 I1988_P23_8n VDD VSS NAND2_X1
XI1988_I175_XG I1988_P24_17 I1988_G16_9 I1988_G24_17 I1988_G24_9n VDD VSS AOI21_X1
XI1988_I175_XP I1988_P24_17 I1988_P16_9 I1988_P24_9n VDD VSS NAND2_X1
XI1988_I176_XG I1988_P25_18 I1988_G17_10 I1988_G25_18 I1988_G25_10n VDD VSS AOI21_X1
XI1988_I176_XP I1988_P25_18 I1988_P17_10 I1988_P25_10n VDD VSS NAND2_X1
XI1988_I177_XG I1988_P26_19 I1988_G18_11 I1988_G26_19 I1988_G26_11n VDD VSS AOI21_X1
XI1988_I177_XP I1988_P26_19 I1988_P18_11 I1988_P26_11n VDD VSS NAND2_X1
XI1988_I178_XG I1988_P27_20 I1988_G19_12 I1988_G27_20 I1988_G27_12n VDD VSS AOI21_X1
XI1988_I178_XP I1988_P27_20 I1988_P19_12 I1988_P27_12n VDD VSS NAND2_X1
XI1988_I179_XG I1988_P28_21 I1988_G20_13 I1988_G28_21 I1988_G28_13n VDD VSS AOI21_X1
XI1988_I179_XP I1988_P28_21 I1988_P20_13 I1988_P28_13n VDD VSS NAND2_X1
XI1988_I180_XG I1988_P29_22 I1988_G21_14 I1988_G29_22 I1988_G29_14n VDD VSS AOI21_X1
XI1988_I180_XP I1988_P29_22 I1988_P21_14 I1988_P29_14n VDD VSS NAND2_X1
XI1988_I181_XG I1988_P30_23 I1988_G22_15 I1988_G30_23 I1988_G30_15n VDD VSS AOI21_X1
XI1988_I181_XP I1988_P30_23 I1988_P22_15 I1988_P30_15n VDD VSS NAND2_X1
XI1988_I182_XG I1988_P31_24 I1988_G23_16 I1988_G31_24 I1988_G31_16n VDD VSS AOI21_X1
XI1988_I182_XP I1988_P31_24 I1988_P23_16 I1988_P31_16n VDD VSS NAND2_X1
XI1988_I183_XG I1988_P16_1n I1988_G0_0n I1988_G16_1n I1988_G16_0 VDD VSS OAI21_X1
XI1988_I184_XG I1988_P17_2n I1988_G1_0n I1988_G17_2n I1988_G17_0 VDD VSS OAI21_X1
XI1988_I185_XG I1988_P18_3n I1988_G2_0n I1988_G18_3n I1988_G18_0 VDD VSS OAI21_X1
XI1988_I186_XG I1988_P19_4n I1988_G3_0n I1988_G19_4n I1988_G19_0 VDD VSS OAI21_X1
XI1988_I187 I1988_G4_0 I1988_G4_0n VDD VSS INV_X1
XI1988_I188_XG I1988_P20_5n I1988_G4_0n I1988_G20_5n I1988_G20_0 VDD VSS OAI21_X1
XI1988_I189 I1988_G5_0 I1988_G5_0n VDD VSS INV_X1
XI1988_I190_XG I1988_P21_6n I1988_G5_0n I1988_G21_6n I1988_G21_0 VDD VSS OAI21_X1
XI1988_I191 I1988_G6_0 I1988_G6_0n VDD VSS INV_X1
XI1988_I192_XG I1988_P22_7n I1988_G6_0n I1988_G22_7n I1988_G22_0 VDD VSS OAI21_X1
XI1988_I193 I1988_G7_0 I1988_G7_0n VDD VSS INV_X1
XI1988_I194_XG I1988_P23_8n I1988_G7_0n I1988_G23_8n I1988_G23_0 VDD VSS OAI21_X1
XI1988_I195_XG I1988_P24_9n I1988_G8_0n I1988_G24_9n I1988_G24_0 VDD VSS OAI21_X1
XI1988_I196_XG I1988_P25_10n I1988_G9_0n I1988_G25_10n I1988_G25_0 VDD VSS OAI21_X1
XI1988_I197_XG I1988_P26_11n I1988_G10_0n I1988_G26_11n I1988_G26_0 VDD VSS OAI21_X1
XI1988_I198_XG I1988_P27_12n I1988_G11_0n I1988_G27_12n I1988_G27_0 VDD VSS OAI21_X1
XI1988_I199_XG I1988_P28_13n I1988_G12_0n I1988_G28_13n I1988_G28_0 VDD VSS OAI21_X1
XI1988_I200_XG I1988_P29_14n I1988_G13_0n I1988_G29_14n I1988_G29_0 VDD VSS OAI21_X1
XI1988_I201_XG I1988_P30_15n I1988_G14_0n I1988_G30_15n c31_m VDD VSS OAI21_X1
XI1988_I202_XG I1988_P31_16n I1988_G15_0n I1988_G31_16n c31_o VDD VSS OAI21_X1
XI1988_I203 I1988_pn0 qu1_b3_5 p31_0 VDD VSS XNOR2_X1
XI1988_I204 I1988_pn1 I1988_G0_0 p31_1 VDD VSS XNOR2_X1
XI1988_I205 I1988_pn2 I1988_G1_0 p31_2 VDD VSS XNOR2_X1
XI1988_I206 I1988_pn3 I1988_G2_0n p31_3 VDD VSS XOR2_X1
XI1988_I207 I1988_pn4 I1988_G3_0n p31_4 VDD VSS XOR2_X1
XI1988_I208 I1988_pn5 I1988_G4_0 p31_5 VDD VSS XNOR2_X1
XI1988_I209 I1988_pn6 I1988_G5_0 p31_6 VDD VSS XNOR2_X1
XI1988_I210 I1988_pn7 I1988_G6_0 p31_7 VDD VSS XNOR2_X1
XI1988_I211 I1988_pn8 I1988_G7_0 p31_8 VDD VSS XNOR2_X1
XI1988_I212 I1988_pn9 I1988_G8_0n p31_9 VDD VSS XOR2_X1
XI1988_I213 I1988_pn10 I1988_G9_0n p31_10 VDD VSS XOR2_X1
XI1988_I214 I1988_pn11 I1988_G10_0n p31_11 VDD VSS XOR2_X1
XI1988_I215 I1988_pn12 I1988_G11_0n p31_12 VDD VSS XOR2_X1
XI1988_I216 I1988_pn13 I1988_G12_0n p31_13 VDD VSS XOR2_X1
XI1988_I217 I1988_pn14 I1988_G13_0n p31_14 VDD VSS XOR2_X1
XI1988_I218 I1988_pn15 I1988_G14_0n p31_15 VDD VSS XOR2_X1
XI1988_I219 I1988_pn16 I1988_G15_0n p31_16 VDD VSS XOR2_X1
XI1988_I220 I1988_pn17 I1988_G16_0 p31_17 VDD VSS XNOR2_X1
XI1988_I221 I1988_pn18 I1988_G17_0 p31_18 VDD VSS XNOR2_X1
XI1988_I222 I1988_pn19 I1988_G18_0 p31_19 VDD VSS XNOR2_X1
XI1988_I223 I1988_pn20 I1988_G19_0 p31_20 VDD VSS XNOR2_X1
XI1988_I224 I1988_pn21 I1988_G20_0 p31_21 VDD VSS XNOR2_X1
XI1988_I225 I1988_pn22 I1988_G21_0 p31_22 VDD VSS XNOR2_X1
XI1988_I226 I1988_pn23 I1988_G22_0 p31_23 VDD VSS XNOR2_X1
XI1988_I227 I1988_pn24 I1988_G23_0 p31_24 VDD VSS XNOR2_X1
XI1988_I228 I1988_pn25 I1988_G24_0 p31_25 VDD VSS XNOR2_X1
XI1988_I229 I1988_pn26 I1988_G25_0 p31_26 VDD VSS XNOR2_X1
XI1988_I230 I1988_pn27 I1988_G26_0 p31_27 VDD VSS XNOR2_X1
XI1988_I231 I1988_pn28 I1988_G27_0 p31_28 VDD VSS XNOR2_X1
XI1988_I232 I1988_pn29 I1988_G28_0 p31_29 VDD VSS XNOR2_X1
XI1988_I233 I1988_pn30 I1988_G29_0 p31_30 VDD VSS XNOR2_X1
XI1988_I234 I1988_pn31 c31_m p31_31 VDD VSS XNOR2_X1
XI1989 p30_31 qu1_b3_5 h31 VDD VSS XOR2_X1
XI1990 h31 c31_o p31_32 VDD VSS XOR2_X1
XI1991 p31_32 p31_32_b0 VDD VSS INV_X1
XI1992 p31_32_b0 p31_32_b1_0 VDD VSS INV_X4
XI1993 p31_32_b1_0 p31_32_b2_0 VDD VSS INV_X4
XI1994 p31_32_b1_0 p31_32_b2_1 VDD VSS INV_X4
XI1995 p31_32_b2_0 p31_32_b3_0 VDD VSS INV_X4
XI1996 p31_32_b2_0 p31_32_b3_1 VDD VSS INV_X4
XI1997 p31_32_b2_0 p31_32_b3_2 VDD VSS INV_X4
XI1998 p31_32_b2_1 p31_32_b3_3 VDD VSS INV_X4
XI1999 p31_32_b2_1 p31_32_b3_4 VDD VSS INV_X4
XI2000 p31_32_b2_1 p31_32_b3_5 VDD VSS INV_X4
XI2001 p31_32_b3_0 Q_0 VDD VSS INV_X1
XI2002 B_0_b3_5 p31_32_b3_0 dmn0 VDD VSS NAND2_X1
XI2003 dmn0 dm0 VDD VSS INV_X1
XI2004 dd1_b3_5 p31_32_b3_0 dmn1 VDD VSS NAND2_X1
XI2005 dmn1 dm1 VDD VSS INV_X1
XI2006 dd2_b3_5 p31_32_b3_0 dmn2 VDD VSS NAND2_X1
XI2007 dmn2 dm2 VDD VSS INV_X1
XI2008 dd3_b3_5 p31_32_b3_0 dmn3 VDD VSS NAND2_X1
XI2009 dmn3 dm3 VDD VSS INV_X1
XI2010 dd4_b3_5 p31_32_b3_0 dmn4 VDD VSS NAND2_X1
XI2011 dmn4 dm4 VDD VSS INV_X1
XI2012 dd5_b3_5 p31_32_b3_1 dmn5 VDD VSS NAND2_X1
XI2013 dmn5 dm5 VDD VSS INV_X1
XI2014 dd6_b3_5 p31_32_b3_1 dmn6 VDD VSS NAND2_X1
XI2015 dmn6 dm6 VDD VSS INV_X1
XI2016 dd7_b3_5 p31_32_b3_1 dmn7 VDD VSS NAND2_X1
XI2017 dmn7 dm7 VDD VSS INV_X1
XI2018 dd8_b3_5 p31_32_b3_1 dmn8 VDD VSS NAND2_X1
XI2019 dmn8 dm8 VDD VSS INV_X1
XI2020 dd9_b3_5 p31_32_b3_1 dmn9 VDD VSS NAND2_X1
XI2021 dmn9 dm9 VDD VSS INV_X1
XI2022 dd10_b3_5 p31_32_b3_2 dmn10 VDD VSS NAND2_X1
XI2023 dmn10 dm10 VDD VSS INV_X1
XI2024 dd11_b3_5 p31_32_b3_2 dmn11 VDD VSS NAND2_X1
XI2025 dmn11 dm11 VDD VSS INV_X1
XI2026 dd12_b3_5 p31_32_b3_2 dmn12 VDD VSS NAND2_X1
XI2027 dmn12 dm12 VDD VSS INV_X1
XI2028 dd13_b3_5 p31_32_b3_2 dmn13 VDD VSS NAND2_X1
XI2029 dmn13 dm13 VDD VSS INV_X1
XI2030 dd14_b3_5 p31_32_b3_2 dmn14 VDD VSS NAND2_X1
XI2031 dmn14 dm14 VDD VSS INV_X1
XI2032 dd15_b3_5 p31_32_b3_2 dmn15 VDD VSS NAND2_X1
XI2033 dmn15 dm15 VDD VSS INV_X1
XI2034 dd16_b3_5 p31_32_b3_3 dmn16 VDD VSS NAND2_X1
XI2035 dmn16 dm16 VDD VSS INV_X1
XI2036 dd17_b3_5 p31_32_b3_3 dmn17 VDD VSS NAND2_X1
XI2037 dmn17 dm17 VDD VSS INV_X1
XI2038 dd18_b3_5 p31_32_b3_3 dmn18 VDD VSS NAND2_X1
XI2039 dmn18 dm18 VDD VSS INV_X1
XI2040 dd19_b3_5 p31_32_b3_3 dmn19 VDD VSS NAND2_X1
XI2041 dmn19 dm19 VDD VSS INV_X1
XI2042 dd20_b3_5 p31_32_b3_3 dmn20 VDD VSS NAND2_X1
XI2043 dmn20 dm20 VDD VSS INV_X1
XI2044 dd21_b3_5 p31_32_b3_4 dmn21 VDD VSS NAND2_X1
XI2045 dmn21 dm21 VDD VSS INV_X1
XI2046 dd22_b3_5 p31_32_b3_4 dmn22 VDD VSS NAND2_X1
XI2047 dmn22 dm22 VDD VSS INV_X1
XI2048 dd23_b3_5 p31_32_b3_4 dmn23 VDD VSS NAND2_X1
XI2049 dmn23 dm23 VDD VSS INV_X1
XI2050 dd24_b3_5 p31_32_b3_4 dmn24 VDD VSS NAND2_X1
XI2051 dmn24 dm24 VDD VSS INV_X1
XI2052 dd25_b3_5 p31_32_b3_4 dmn25 VDD VSS NAND2_X1
XI2053 dmn25 dm25 VDD VSS INV_X1
XI2054 dd26_b3_5 p31_32_b3_4 dmn26 VDD VSS NAND2_X1
XI2055 dmn26 dm26 VDD VSS INV_X1
XI2056 dd27_b3_5 p31_32_b3_5 dmn27 VDD VSS NAND2_X1
XI2057 dmn27 dm27 VDD VSS INV_X1
XI2058 dd28_b3_5 p31_32_b3_5 dmn28 VDD VSS NAND2_X1
XI2059 dmn28 dm28 VDD VSS INV_X1
XI2060 dd29_b3_5 p31_32_b3_5 dmn29 VDD VSS NAND2_X1
XI2061 dmn29 dm29 VDD VSS INV_X1
XI2062 dd30_b3_5 p31_32_b3_5 dmn30 VDD VSS NAND2_X1
XI2063 dmn30 dm30 VDD VSS INV_X1
XI2064 dd31_b3_5 p31_32_b3_5 dmn31 VDD VSS NAND2_X1
XI2065 dmn31 dm31 VDD VSS INV_X1
XI2066_I0 p31_0 dm0 I2066_gn0 VDD VSS NAND2_X1
XI2066_I1 p31_1 dm1 I2066_gn1 VDD VSS NAND2_X1
XI2066_I2 p31_2 dm2 I2066_gn2 VDD VSS NAND2_X1
XI2066_I3 p31_3 dm3 I2066_gn3 VDD VSS NAND2_X1
XI2066_I4 p31_4 dm4 I2066_gn4 VDD VSS NAND2_X1
XI2066_I5 p31_5 dm5 I2066_gn5 VDD VSS NAND2_X1
XI2066_I6 p31_6 dm6 I2066_gn6 VDD VSS NAND2_X1
XI2066_I7 p31_7 dm7 I2066_gn7 VDD VSS NAND2_X1
XI2066_I8 p31_8 dm8 I2066_gn8 VDD VSS NAND2_X1
XI2066_I9 p31_9 dm9 I2066_gn9 VDD VSS NAND2_X1
XI2066_I10 p31_10 dm10 I2066_gn10 VDD VSS NAND2_X1
XI2066_I11 p31_11 dm11 I2066_gn11 VDD VSS NAND2_X1
XI2066_I12 p31_12 dm12 I2066_gn12 VDD VSS NAND2_X1
XI2066_I13 p31_13 dm13 I2066_gn13 VDD VSS NAND2_X1
XI2066_I14 p31_14 dm14 I2066_gn14 VDD VSS NAND2_X1
XI2066_I15 p31_15 dm15 I2066_gn15 VDD VSS NAND2_X1
XI2066_I16 p31_16 dm16 I2066_gn16 VDD VSS NAND2_X1
XI2066_I17 p31_17 dm17 I2066_gn17 VDD VSS NAND2_X1
XI2066_I18 p31_18 dm18 I2066_gn18 VDD VSS NAND2_X1
XI2066_I19 p31_19 dm19 I2066_gn19 VDD VSS NAND2_X1
XI2066_I20 p31_20 dm20 I2066_gn20 VDD VSS NAND2_X1
XI2066_I21 p31_21 dm21 I2066_gn21 VDD VSS NAND2_X1
XI2066_I22 p31_22 dm22 I2066_gn22 VDD VSS NAND2_X1
XI2066_I23 p31_23 dm23 I2066_gn23 VDD VSS NAND2_X1
XI2066_I24 p31_24 dm24 I2066_gn24 VDD VSS NAND2_X1
XI2066_I25 p31_25 dm25 I2066_gn25 VDD VSS NAND2_X1
XI2066_I26 p31_26 dm26 I2066_gn26 VDD VSS NAND2_X1
XI2066_I27 p31_27 dm27 I2066_gn27 VDD VSS NAND2_X1
XI2066_I28 p31_28 dm28 I2066_gn28 VDD VSS NAND2_X1
XI2066_I29 p31_29 dm29 I2066_gn29 VDD VSS NAND2_X1
XI2066_I30 p31_30 dm30 I2066_gn30 VDD VSS NAND2_X1
XI2066_I31 p31_31 dm31 I2066_gn31 VDD VSS NAND2_X1
XI2066_I32 p31_0 dm0 I2066_pn0 VDD VSS XNOR2_X1
XI2066_I33 p31_1 dm1 I2066_pn1 VDD VSS XNOR2_X1
XI2066_I34 p31_2 dm2 I2066_pn2 VDD VSS XNOR2_X1
XI2066_I35 p31_3 dm3 I2066_pn3 VDD VSS XNOR2_X1
XI2066_I36 p31_4 dm4 I2066_pn4 VDD VSS XNOR2_X1
XI2066_I37 p31_5 dm5 I2066_pn5 VDD VSS XNOR2_X1
XI2066_I38 p31_6 dm6 I2066_pn6 VDD VSS XNOR2_X1
XI2066_I39 p31_7 dm7 I2066_pn7 VDD VSS XNOR2_X1
XI2066_I40 p31_8 dm8 I2066_pn8 VDD VSS XNOR2_X1
XI2066_I41 p31_9 dm9 I2066_pn9 VDD VSS XNOR2_X1
XI2066_I42 p31_10 dm10 I2066_pn10 VDD VSS XNOR2_X1
XI2066_I43 p31_11 dm11 I2066_pn11 VDD VSS XNOR2_X1
XI2066_I44 p31_12 dm12 I2066_pn12 VDD VSS XNOR2_X1
XI2066_I45 p31_13 dm13 I2066_pn13 VDD VSS XNOR2_X1
XI2066_I46 p31_14 dm14 I2066_pn14 VDD VSS XNOR2_X1
XI2066_I47 p31_15 dm15 I2066_pn15 VDD VSS XNOR2_X1
XI2066_I48 p31_16 dm16 I2066_pn16 VDD VSS XNOR2_X1
XI2066_I49 p31_17 dm17 I2066_pn17 VDD VSS XNOR2_X1
XI2066_I50 p31_18 dm18 I2066_pn18 VDD VSS XNOR2_X1
XI2066_I51 p31_19 dm19 I2066_pn19 VDD VSS XNOR2_X1
XI2066_I52 p31_20 dm20 I2066_pn20 VDD VSS XNOR2_X1
XI2066_I53 p31_21 dm21 I2066_pn21 VDD VSS XNOR2_X1
XI2066_I54 p31_22 dm22 I2066_pn22 VDD VSS XNOR2_X1
XI2066_I55 p31_23 dm23 I2066_pn23 VDD VSS XNOR2_X1
XI2066_I56 p31_24 dm24 I2066_pn24 VDD VSS XNOR2_X1
XI2066_I57 p31_25 dm25 I2066_pn25 VDD VSS XNOR2_X1
XI2066_I58 p31_26 dm26 I2066_pn26 VDD VSS XNOR2_X1
XI2066_I59 p31_27 dm27 I2066_pn27 VDD VSS XNOR2_X1
XI2066_I60 p31_28 dm28 I2066_pn28 VDD VSS XNOR2_X1
XI2066_I61 p31_29 dm29 I2066_pn29 VDD VSS XNOR2_X1
XI2066_I62 p31_30 dm30 I2066_pn30 VDD VSS XNOR2_X1
XI2066_I63 p31_31 dm31 I2066_pn31 VDD VSS XNOR2_X1
XI2066_I64 VSS I2066_cinn VDD VSS INV_X1
XI2066_I65_XG I2066_pn0 I2066_cinn I2066_gn0 I2066_G0_0 VDD VSS OAI21_X1
XI2066_I66 I2066_G0_0 I2066_G0_0n VDD VSS INV_X1
XI2066_I67_XG I2066_pn1 I2066_G0_0n I2066_gn1 I2066_G1_0 VDD VSS OAI21_X1
XI2066_I68_XG I2066_pn2 I2066_gn1 I2066_gn2 I2066_G2_1 VDD VSS OAI21_X1
XI2066_I68_XP I2066_pn2 I2066_pn1 I2066_P2_1 VDD VSS NOR2_X1
XI2066_I69_XG I2066_pn3 I2066_gn2 I2066_gn3 I2066_G3_2 VDD VSS OAI21_X1
XI2066_I69_XP I2066_pn3 I2066_pn2 I2066_P3_2 VDD VSS NOR2_X1
XI2066_I70_XG I2066_pn4 I2066_gn3 I2066_gn4 I2066_G4_3 VDD VSS OAI21_X1
XI2066_I70_XP I2066_pn4 I2066_pn3 I2066_P4_3 VDD VSS NOR2_X1
XI2066_I71_XG I2066_pn5 I2066_gn4 I2066_gn5 I2066_G5_4 VDD VSS OAI21_X1
XI2066_I71_XP I2066_pn5 I2066_pn4 I2066_P5_4 VDD VSS NOR2_X1
XI2066_I72_XG I2066_pn6 I2066_gn5 I2066_gn6 I2066_G6_5 VDD VSS OAI21_X1
XI2066_I72_XP I2066_pn6 I2066_pn5 I2066_P6_5 VDD VSS NOR2_X1
XI2066_I73_XG I2066_pn7 I2066_gn6 I2066_gn7 I2066_G7_6 VDD VSS OAI21_X1
XI2066_I73_XP I2066_pn7 I2066_pn6 I2066_P7_6 VDD VSS NOR2_X1
XI2066_I74_XG I2066_pn8 I2066_gn7 I2066_gn8 I2066_G8_7 VDD VSS OAI21_X1
XI2066_I74_XP I2066_pn8 I2066_pn7 I2066_P8_7 VDD VSS NOR2_X1
XI2066_I75_XG I2066_pn9 I2066_gn8 I2066_gn9 I2066_G9_8 VDD VSS OAI21_X1
XI2066_I75_XP I2066_pn9 I2066_pn8 I2066_P9_8 VDD VSS NOR2_X1
XI2066_I76_XG I2066_pn10 I2066_gn9 I2066_gn10 I2066_G10_9 VDD VSS OAI21_X1
XI2066_I76_XP I2066_pn10 I2066_pn9 I2066_P10_9 VDD VSS NOR2_X1
XI2066_I77_XG I2066_pn11 I2066_gn10 I2066_gn11 I2066_G11_10 VDD VSS OAI21_X1
XI2066_I77_XP I2066_pn11 I2066_pn10 I2066_P11_10 VDD VSS NOR2_X1
XI2066_I78_XG I2066_pn12 I2066_gn11 I2066_gn12 I2066_G12_11 VDD VSS OAI21_X1
XI2066_I78_XP I2066_pn12 I2066_pn11 I2066_P12_11 VDD VSS NOR2_X1
XI2066_I79_XG I2066_pn13 I2066_gn12 I2066_gn13 I2066_G13_12 VDD VSS OAI21_X1
XI2066_I79_XP I2066_pn13 I2066_pn12 I2066_P13_12 VDD VSS NOR2_X1
XI2066_I80_XG I2066_pn14 I2066_gn13 I2066_gn14 I2066_G14_13 VDD VSS OAI21_X1
XI2066_I80_XP I2066_pn14 I2066_pn13 I2066_P14_13 VDD VSS NOR2_X1
XI2066_I81_XG I2066_pn15 I2066_gn14 I2066_gn15 I2066_G15_14 VDD VSS OAI21_X1
XI2066_I81_XP I2066_pn15 I2066_pn14 I2066_P15_14 VDD VSS NOR2_X1
XI2066_I82_XG I2066_pn16 I2066_gn15 I2066_gn16 I2066_G16_15 VDD VSS OAI21_X1
XI2066_I82_XP I2066_pn16 I2066_pn15 I2066_P16_15 VDD VSS NOR2_X1
XI2066_I83_XG I2066_pn17 I2066_gn16 I2066_gn17 I2066_G17_16 VDD VSS OAI21_X1
XI2066_I83_XP I2066_pn17 I2066_pn16 I2066_P17_16 VDD VSS NOR2_X1
XI2066_I84_XG I2066_pn18 I2066_gn17 I2066_gn18 I2066_G18_17 VDD VSS OAI21_X1
XI2066_I84_XP I2066_pn18 I2066_pn17 I2066_P18_17 VDD VSS NOR2_X1
XI2066_I85_XG I2066_pn19 I2066_gn18 I2066_gn19 I2066_G19_18 VDD VSS OAI21_X1
XI2066_I85_XP I2066_pn19 I2066_pn18 I2066_P19_18 VDD VSS NOR2_X1
XI2066_I86_XG I2066_pn20 I2066_gn19 I2066_gn20 I2066_G20_19 VDD VSS OAI21_X1
XI2066_I86_XP I2066_pn20 I2066_pn19 I2066_P20_19 VDD VSS NOR2_X1
XI2066_I87_XG I2066_pn21 I2066_gn20 I2066_gn21 I2066_G21_20 VDD VSS OAI21_X1
XI2066_I87_XP I2066_pn21 I2066_pn20 I2066_P21_20 VDD VSS NOR2_X1
XI2066_I88_XG I2066_pn22 I2066_gn21 I2066_gn22 I2066_G22_21 VDD VSS OAI21_X1
XI2066_I88_XP I2066_pn22 I2066_pn21 I2066_P22_21 VDD VSS NOR2_X1
XI2066_I89_XG I2066_pn23 I2066_gn22 I2066_gn23 I2066_G23_22 VDD VSS OAI21_X1
XI2066_I89_XP I2066_pn23 I2066_pn22 I2066_P23_22 VDD VSS NOR2_X1
XI2066_I90_XG I2066_pn24 I2066_gn23 I2066_gn24 I2066_G24_23 VDD VSS OAI21_X1
XI2066_I90_XP I2066_pn24 I2066_pn23 I2066_P24_23 VDD VSS NOR2_X1
XI2066_I91_XG I2066_pn25 I2066_gn24 I2066_gn25 I2066_G25_24 VDD VSS OAI21_X1
XI2066_I91_XP I2066_pn25 I2066_pn24 I2066_P25_24 VDD VSS NOR2_X1
XI2066_I92_XG I2066_pn26 I2066_gn25 I2066_gn26 I2066_G26_25 VDD VSS OAI21_X1
XI2066_I92_XP I2066_pn26 I2066_pn25 I2066_P26_25 VDD VSS NOR2_X1
XI2066_I93_XG I2066_pn27 I2066_gn26 I2066_gn27 I2066_G27_26 VDD VSS OAI21_X1
XI2066_I93_XP I2066_pn27 I2066_pn26 I2066_P27_26 VDD VSS NOR2_X1
XI2066_I94_XG I2066_pn28 I2066_gn27 I2066_gn28 I2066_G28_27 VDD VSS OAI21_X1
XI2066_I94_XP I2066_pn28 I2066_pn27 I2066_P28_27 VDD VSS NOR2_X1
XI2066_I95_XG I2066_pn29 I2066_gn28 I2066_gn29 I2066_G29_28 VDD VSS OAI21_X1
XI2066_I95_XP I2066_pn29 I2066_pn28 I2066_P29_28 VDD VSS NOR2_X1
XI2066_I96_XG I2066_pn30 I2066_gn29 I2066_gn30 I2066_G30_29 VDD VSS OAI21_X1
XI2066_I96_XP I2066_pn30 I2066_pn29 I2066_P30_29 VDD VSS NOR2_X1
XI2066_I97_XG I2066_pn31 I2066_gn30 I2066_gn31 I2066_G31_30 VDD VSS OAI21_X1
XI2066_I97_XP I2066_pn31 I2066_pn30 I2066_P31_30 VDD VSS NOR2_X1
XI2066_I98_XG I2066_P2_1 I2066_G0_0 I2066_G2_1 I2066_G2_0n VDD VSS AOI21_X1
XI2066_I99_XG I2066_P3_2 I2066_G1_0 I2066_G3_2 I2066_G3_0n VDD VSS AOI21_X1
XI2066_I100_XG I2066_P4_3 I2066_G2_1 I2066_G4_3 I2066_G4_1n VDD VSS AOI21_X1
XI2066_I100_XP I2066_P4_3 I2066_P2_1 I2066_P4_1n VDD VSS NAND2_X1
XI2066_I101_XG I2066_P5_4 I2066_G3_2 I2066_G5_4 I2066_G5_2n VDD VSS AOI21_X1
XI2066_I101_XP I2066_P5_4 I2066_P3_2 I2066_P5_2n VDD VSS NAND2_X1
XI2066_I102_XG I2066_P6_5 I2066_G4_3 I2066_G6_5 I2066_G6_3n VDD VSS AOI21_X1
XI2066_I102_XP I2066_P6_5 I2066_P4_3 I2066_P6_3n VDD VSS NAND2_X1
XI2066_I103_XG I2066_P7_6 I2066_G5_4 I2066_G7_6 I2066_G7_4n VDD VSS AOI21_X1
XI2066_I103_XP I2066_P7_6 I2066_P5_4 I2066_P7_4n VDD VSS NAND2_X1
XI2066_I104_XG I2066_P8_7 I2066_G6_5 I2066_G8_7 I2066_G8_5n VDD VSS AOI21_X1
XI2066_I104_XP I2066_P8_7 I2066_P6_5 I2066_P8_5n VDD VSS NAND2_X1
XI2066_I105_XG I2066_P9_8 I2066_G7_6 I2066_G9_8 I2066_G9_6n VDD VSS AOI21_X1
XI2066_I105_XP I2066_P9_8 I2066_P7_6 I2066_P9_6n VDD VSS NAND2_X1
XI2066_I106_XG I2066_P10_9 I2066_G8_7 I2066_G10_9 I2066_G10_7n VDD VSS AOI21_X1
XI2066_I106_XP I2066_P10_9 I2066_P8_7 I2066_P10_7n VDD VSS NAND2_X1
XI2066_I107_XG I2066_P11_10 I2066_G9_8 I2066_G11_10 I2066_G11_8n VDD VSS AOI21_X1
XI2066_I107_XP I2066_P11_10 I2066_P9_8 I2066_P11_8n VDD VSS NAND2_X1
XI2066_I108_XG I2066_P12_11 I2066_G10_9 I2066_G12_11 I2066_G12_9n VDD VSS AOI21_X1
XI2066_I108_XP I2066_P12_11 I2066_P10_9 I2066_P12_9n VDD VSS NAND2_X1
XI2066_I109_XG I2066_P13_12 I2066_G11_10 I2066_G13_12 I2066_G13_10n VDD VSS AOI21_X1
XI2066_I109_XP I2066_P13_12 I2066_P11_10 I2066_P13_10n VDD VSS NAND2_X1
XI2066_I110_XG I2066_P14_13 I2066_G12_11 I2066_G14_13 I2066_G14_11n VDD VSS AOI21_X1
XI2066_I110_XP I2066_P14_13 I2066_P12_11 I2066_P14_11n VDD VSS NAND2_X1
XI2066_I111_XG I2066_P15_14 I2066_G13_12 I2066_G15_14 I2066_G15_12n VDD VSS AOI21_X1
XI2066_I111_XP I2066_P15_14 I2066_P13_12 I2066_P15_12n VDD VSS NAND2_X1
XI2066_I112_XG I2066_P16_15 I2066_G14_13 I2066_G16_15 I2066_G16_13n VDD VSS AOI21_X1
XI2066_I112_XP I2066_P16_15 I2066_P14_13 I2066_P16_13n VDD VSS NAND2_X1
XI2066_I113_XG I2066_P17_16 I2066_G15_14 I2066_G17_16 I2066_G17_14n VDD VSS AOI21_X1
XI2066_I113_XP I2066_P17_16 I2066_P15_14 I2066_P17_14n VDD VSS NAND2_X1
XI2066_I114_XG I2066_P18_17 I2066_G16_15 I2066_G18_17 I2066_G18_15n VDD VSS AOI21_X1
XI2066_I114_XP I2066_P18_17 I2066_P16_15 I2066_P18_15n VDD VSS NAND2_X1
XI2066_I115_XG I2066_P19_18 I2066_G17_16 I2066_G19_18 I2066_G19_16n VDD VSS AOI21_X1
XI2066_I115_XP I2066_P19_18 I2066_P17_16 I2066_P19_16n VDD VSS NAND2_X1
XI2066_I116_XG I2066_P20_19 I2066_G18_17 I2066_G20_19 I2066_G20_17n VDD VSS AOI21_X1
XI2066_I116_XP I2066_P20_19 I2066_P18_17 I2066_P20_17n VDD VSS NAND2_X1
XI2066_I117_XG I2066_P21_20 I2066_G19_18 I2066_G21_20 I2066_G21_18n VDD VSS AOI21_X1
XI2066_I117_XP I2066_P21_20 I2066_P19_18 I2066_P21_18n VDD VSS NAND2_X1
XI2066_I118_XG I2066_P22_21 I2066_G20_19 I2066_G22_21 I2066_G22_19n VDD VSS AOI21_X1
XI2066_I118_XP I2066_P22_21 I2066_P20_19 I2066_P22_19n VDD VSS NAND2_X1
XI2066_I119_XG I2066_P23_22 I2066_G21_20 I2066_G23_22 I2066_G23_20n VDD VSS AOI21_X1
XI2066_I119_XP I2066_P23_22 I2066_P21_20 I2066_P23_20n VDD VSS NAND2_X1
XI2066_I120_XG I2066_P24_23 I2066_G22_21 I2066_G24_23 I2066_G24_21n VDD VSS AOI21_X1
XI2066_I120_XP I2066_P24_23 I2066_P22_21 I2066_P24_21n VDD VSS NAND2_X1
XI2066_I121_XG I2066_P25_24 I2066_G23_22 I2066_G25_24 I2066_G25_22n VDD VSS AOI21_X1
XI2066_I121_XP I2066_P25_24 I2066_P23_22 I2066_P25_22n VDD VSS NAND2_X1
XI2066_I122_XG I2066_P26_25 I2066_G24_23 I2066_G26_25 I2066_G26_23n VDD VSS AOI21_X1
XI2066_I122_XP I2066_P26_25 I2066_P24_23 I2066_P26_23n VDD VSS NAND2_X1
XI2066_I123_XG I2066_P27_26 I2066_G25_24 I2066_G27_26 I2066_G27_24n VDD VSS AOI21_X1
XI2066_I123_XP I2066_P27_26 I2066_P25_24 I2066_P27_24n VDD VSS NAND2_X1
XI2066_I124_XG I2066_P28_27 I2066_G26_25 I2066_G28_27 I2066_G28_25n VDD VSS AOI21_X1
XI2066_I124_XP I2066_P28_27 I2066_P26_25 I2066_P28_25n VDD VSS NAND2_X1
XI2066_I125_XG I2066_P29_28 I2066_G27_26 I2066_G29_28 I2066_G29_26n VDD VSS AOI21_X1
XI2066_I125_XP I2066_P29_28 I2066_P27_26 I2066_P29_26n VDD VSS NAND2_X1
XI2066_I126_XG I2066_P30_29 I2066_G28_27 I2066_G30_29 I2066_G30_27n VDD VSS AOI21_X1
XI2066_I126_XP I2066_P30_29 I2066_P28_27 I2066_P30_27n VDD VSS NAND2_X1
XI2066_I127_XG I2066_P31_30 I2066_G29_28 I2066_G31_30 I2066_G31_28n VDD VSS AOI21_X1
XI2066_I127_XP I2066_P31_30 I2066_P29_28 I2066_P31_28n VDD VSS NAND2_X1
XI2066_I128_XG I2066_P4_1n I2066_G0_0n I2066_G4_1n I2066_G4_0 VDD VSS OAI21_X1
XI2066_I129 I2066_G1_0 I2066_G1_0n VDD VSS INV_X1
XI2066_I130_XG I2066_P5_2n I2066_G1_0n I2066_G5_2n I2066_G5_0 VDD VSS OAI21_X1
XI2066_I131_XG I2066_P6_3n I2066_G2_0n I2066_G6_3n I2066_G6_0 VDD VSS OAI21_X1
XI2066_I132_XG I2066_P7_4n I2066_G3_0n I2066_G7_4n I2066_G7_0 VDD VSS OAI21_X1
XI2066_I133_XG I2066_P8_5n I2066_G4_1n I2066_G8_5n I2066_G8_1 VDD VSS OAI21_X1
XI2066_I133_XP I2066_P8_5n I2066_P4_1n I2066_P8_1 VDD VSS NOR2_X1
XI2066_I134_XG I2066_P9_6n I2066_G5_2n I2066_G9_6n I2066_G9_2 VDD VSS OAI21_X1
XI2066_I134_XP I2066_P9_6n I2066_P5_2n I2066_P9_2 VDD VSS NOR2_X1
XI2066_I135_XG I2066_P10_7n I2066_G6_3n I2066_G10_7n I2066_G10_3 VDD VSS OAI21_X1
XI2066_I135_XP I2066_P10_7n I2066_P6_3n I2066_P10_3 VDD VSS NOR2_X1
XI2066_I136_XG I2066_P11_8n I2066_G7_4n I2066_G11_8n I2066_G11_4 VDD VSS OAI21_X1
XI2066_I136_XP I2066_P11_8n I2066_P7_4n I2066_P11_4 VDD VSS NOR2_X1
XI2066_I137_XG I2066_P12_9n I2066_G8_5n I2066_G12_9n I2066_G12_5 VDD VSS OAI21_X1
XI2066_I137_XP I2066_P12_9n I2066_P8_5n I2066_P12_5 VDD VSS NOR2_X1
XI2066_I138_XG I2066_P13_10n I2066_G9_6n I2066_G13_10n I2066_G13_6 VDD VSS OAI21_X1
XI2066_I138_XP I2066_P13_10n I2066_P9_6n I2066_P13_6 VDD VSS NOR2_X1
XI2066_I139_XG I2066_P14_11n I2066_G10_7n I2066_G14_11n I2066_G14_7 VDD VSS OAI21_X1
XI2066_I139_XP I2066_P14_11n I2066_P10_7n I2066_P14_7 VDD VSS NOR2_X1
XI2066_I140_XG I2066_P15_12n I2066_G11_8n I2066_G15_12n I2066_G15_8 VDD VSS OAI21_X1
XI2066_I140_XP I2066_P15_12n I2066_P11_8n I2066_P15_8 VDD VSS NOR2_X1
XI2066_I141_XG I2066_P16_13n I2066_G12_9n I2066_G16_13n I2066_G16_9 VDD VSS OAI21_X1
XI2066_I141_XP I2066_P16_13n I2066_P12_9n I2066_P16_9 VDD VSS NOR2_X1
XI2066_I142_XG I2066_P17_14n I2066_G13_10n I2066_G17_14n I2066_G17_10 VDD VSS OAI21_X1
XI2066_I142_XP I2066_P17_14n I2066_P13_10n I2066_P17_10 VDD VSS NOR2_X1
XI2066_I143_XG I2066_P18_15n I2066_G14_11n I2066_G18_15n I2066_G18_11 VDD VSS OAI21_X1
XI2066_I143_XP I2066_P18_15n I2066_P14_11n I2066_P18_11 VDD VSS NOR2_X1
XI2066_I144_XG I2066_P19_16n I2066_G15_12n I2066_G19_16n I2066_G19_12 VDD VSS OAI21_X1
XI2066_I144_XP I2066_P19_16n I2066_P15_12n I2066_P19_12 VDD VSS NOR2_X1
XI2066_I145_XG I2066_P20_17n I2066_G16_13n I2066_G20_17n I2066_G20_13 VDD VSS OAI21_X1
XI2066_I145_XP I2066_P20_17n I2066_P16_13n I2066_P20_13 VDD VSS NOR2_X1
XI2066_I146_XG I2066_P21_18n I2066_G17_14n I2066_G21_18n I2066_G21_14 VDD VSS OAI21_X1
XI2066_I146_XP I2066_P21_18n I2066_P17_14n I2066_P21_14 VDD VSS NOR2_X1
XI2066_I147_XG I2066_P22_19n I2066_G18_15n I2066_G22_19n I2066_G22_15 VDD VSS OAI21_X1
XI2066_I147_XP I2066_P22_19n I2066_P18_15n I2066_P22_15 VDD VSS NOR2_X1
XI2066_I148_XG I2066_P23_20n I2066_G19_16n I2066_G23_20n I2066_G23_16 VDD VSS OAI21_X1
XI2066_I148_XP I2066_P23_20n I2066_P19_16n I2066_P23_16 VDD VSS NOR2_X1
XI2066_I149_XG I2066_P24_21n I2066_G20_17n I2066_G24_21n I2066_G24_17 VDD VSS OAI21_X1
XI2066_I149_XP I2066_P24_21n I2066_P20_17n I2066_P24_17 VDD VSS NOR2_X1
XI2066_I150_XG I2066_P25_22n I2066_G21_18n I2066_G25_22n I2066_G25_18 VDD VSS OAI21_X1
XI2066_I150_XP I2066_P25_22n I2066_P21_18n I2066_P25_18 VDD VSS NOR2_X1
XI2066_I151_XG I2066_P26_23n I2066_G22_19n I2066_G26_23n I2066_G26_19 VDD VSS OAI21_X1
XI2066_I151_XP I2066_P26_23n I2066_P22_19n I2066_P26_19 VDD VSS NOR2_X1
XI2066_I152_XG I2066_P27_24n I2066_G23_20n I2066_G27_24n I2066_G27_20 VDD VSS OAI21_X1
XI2066_I152_XP I2066_P27_24n I2066_P23_20n I2066_P27_20 VDD VSS NOR2_X1
XI2066_I153_XG I2066_P28_25n I2066_G24_21n I2066_G28_25n I2066_G28_21 VDD VSS OAI21_X1
XI2066_I153_XP I2066_P28_25n I2066_P24_21n I2066_P28_21 VDD VSS NOR2_X1
XI2066_I154_XG I2066_P29_26n I2066_G25_22n I2066_G29_26n I2066_G29_22 VDD VSS OAI21_X1
XI2066_I154_XP I2066_P29_26n I2066_P25_22n I2066_P29_22 VDD VSS NOR2_X1
XI2066_I155_XG I2066_P30_27n I2066_G26_23n I2066_G30_27n I2066_G30_23 VDD VSS OAI21_X1
XI2066_I155_XP I2066_P30_27n I2066_P26_23n I2066_P30_23 VDD VSS NOR2_X1
XI2066_I156_XG I2066_P31_28n I2066_G27_24n I2066_G31_28n I2066_G31_24 VDD VSS OAI21_X1
XI2066_I156_XP I2066_P31_28n I2066_P27_24n I2066_P31_24 VDD VSS NOR2_X1
XI2066_I157_XG I2066_P8_1 I2066_G0_0 I2066_G8_1 I2066_G8_0n VDD VSS AOI21_X1
XI2066_I158_XG I2066_P9_2 I2066_G1_0 I2066_G9_2 I2066_G9_0n VDD VSS AOI21_X1
XI2066_I159 I2066_G2_0n I2066_G2_0np VDD VSS INV_X1
XI2066_I160_XG I2066_P10_3 I2066_G2_0np I2066_G10_3 I2066_G10_0n VDD VSS AOI21_X1
XI2066_I161 I2066_G3_0n I2066_G3_0np VDD VSS INV_X1
XI2066_I162_XG I2066_P11_4 I2066_G3_0np I2066_G11_4 I2066_G11_0n VDD VSS AOI21_X1
XI2066_I163_XG I2066_P12_5 I2066_G4_0 I2066_G12_5 I2066_G12_0n VDD VSS AOI21_X1
XI2066_I164_XG I2066_P13_6 I2066_G5_0 I2066_G13_6 I2066_G13_0n VDD VSS AOI21_X1
XI2066_I165_XG I2066_P14_7 I2066_G6_0 I2066_G14_7 I2066_G14_0n VDD VSS AOI21_X1
XI2066_I166_XG I2066_P15_8 I2066_G7_0 I2066_G15_8 I2066_G15_0n VDD VSS AOI21_X1
XI2066_I167_XG I2066_P16_9 I2066_G8_1 I2066_G16_9 I2066_G16_1n VDD VSS AOI21_X1
XI2066_I167_XP I2066_P16_9 I2066_P8_1 I2066_P16_1n VDD VSS NAND2_X1
XI2066_I168_XG I2066_P17_10 I2066_G9_2 I2066_G17_10 I2066_G17_2n VDD VSS AOI21_X1
XI2066_I168_XP I2066_P17_10 I2066_P9_2 I2066_P17_2n VDD VSS NAND2_X1
XI2066_I169_XG I2066_P18_11 I2066_G10_3 I2066_G18_11 I2066_G18_3n VDD VSS AOI21_X1
XI2066_I169_XP I2066_P18_11 I2066_P10_3 I2066_P18_3n VDD VSS NAND2_X1
XI2066_I170_XG I2066_P19_12 I2066_G11_4 I2066_G19_12 I2066_G19_4n VDD VSS AOI21_X1
XI2066_I170_XP I2066_P19_12 I2066_P11_4 I2066_P19_4n VDD VSS NAND2_X1
XI2066_I171_XG I2066_P20_13 I2066_G12_5 I2066_G20_13 I2066_G20_5n VDD VSS AOI21_X1
XI2066_I171_XP I2066_P20_13 I2066_P12_5 I2066_P20_5n VDD VSS NAND2_X1
XI2066_I172_XG I2066_P21_14 I2066_G13_6 I2066_G21_14 I2066_G21_6n VDD VSS AOI21_X1
XI2066_I172_XP I2066_P21_14 I2066_P13_6 I2066_P21_6n VDD VSS NAND2_X1
XI2066_I173_XG I2066_P22_15 I2066_G14_7 I2066_G22_15 I2066_G22_7n VDD VSS AOI21_X1
XI2066_I173_XP I2066_P22_15 I2066_P14_7 I2066_P22_7n VDD VSS NAND2_X1
XI2066_I174_XG I2066_P23_16 I2066_G15_8 I2066_G23_16 I2066_G23_8n VDD VSS AOI21_X1
XI2066_I174_XP I2066_P23_16 I2066_P15_8 I2066_P23_8n VDD VSS NAND2_X1
XI2066_I175_XG I2066_P24_17 I2066_G16_9 I2066_G24_17 I2066_G24_9n VDD VSS AOI21_X1
XI2066_I175_XP I2066_P24_17 I2066_P16_9 I2066_P24_9n VDD VSS NAND2_X1
XI2066_I176_XG I2066_P25_18 I2066_G17_10 I2066_G25_18 I2066_G25_10n VDD VSS AOI21_X1
XI2066_I176_XP I2066_P25_18 I2066_P17_10 I2066_P25_10n VDD VSS NAND2_X1
XI2066_I177_XG I2066_P26_19 I2066_G18_11 I2066_G26_19 I2066_G26_11n VDD VSS AOI21_X1
XI2066_I177_XP I2066_P26_19 I2066_P18_11 I2066_P26_11n VDD VSS NAND2_X1
XI2066_I178_XG I2066_P27_20 I2066_G19_12 I2066_G27_20 I2066_G27_12n VDD VSS AOI21_X1
XI2066_I178_XP I2066_P27_20 I2066_P19_12 I2066_P27_12n VDD VSS NAND2_X1
XI2066_I179_XG I2066_P28_21 I2066_G20_13 I2066_G28_21 I2066_G28_13n VDD VSS AOI21_X1
XI2066_I179_XP I2066_P28_21 I2066_P20_13 I2066_P28_13n VDD VSS NAND2_X1
XI2066_I180_XG I2066_P29_22 I2066_G21_14 I2066_G29_22 I2066_G29_14n VDD VSS AOI21_X1
XI2066_I180_XP I2066_P29_22 I2066_P21_14 I2066_P29_14n VDD VSS NAND2_X1
XI2066_I181_XG I2066_P30_23 I2066_G22_15 I2066_G30_23 I2066_G30_15n VDD VSS AOI21_X1
XI2066_I181_XP I2066_P30_23 I2066_P22_15 I2066_P30_15n VDD VSS NAND2_X1
XI2066_I182_XG I2066_P31_24 I2066_G23_16 I2066_G31_24 I2066_G31_16n VDD VSS AOI21_X1
XI2066_I182_XP I2066_P31_24 I2066_P23_16 I2066_P31_16n VDD VSS NAND2_X1
XI2066_I183_XG I2066_P16_1n I2066_G0_0n I2066_G16_1n I2066_G16_0 VDD VSS OAI21_X1
XI2066_I184_XG I2066_P17_2n I2066_G1_0n I2066_G17_2n I2066_G17_0 VDD VSS OAI21_X1
XI2066_I185_XG I2066_P18_3n I2066_G2_0n I2066_G18_3n I2066_G18_0 VDD VSS OAI21_X1
XI2066_I186_XG I2066_P19_4n I2066_G3_0n I2066_G19_4n I2066_G19_0 VDD VSS OAI21_X1
XI2066_I187 I2066_G4_0 I2066_G4_0n VDD VSS INV_X1
XI2066_I188_XG I2066_P20_5n I2066_G4_0n I2066_G20_5n I2066_G20_0 VDD VSS OAI21_X1
XI2066_I189 I2066_G5_0 I2066_G5_0n VDD VSS INV_X1
XI2066_I190_XG I2066_P21_6n I2066_G5_0n I2066_G21_6n I2066_G21_0 VDD VSS OAI21_X1
XI2066_I191 I2066_G6_0 I2066_G6_0n VDD VSS INV_X1
XI2066_I192_XG I2066_P22_7n I2066_G6_0n I2066_G22_7n I2066_G22_0 VDD VSS OAI21_X1
XI2066_I193 I2066_G7_0 I2066_G7_0n VDD VSS INV_X1
XI2066_I194_XG I2066_P23_8n I2066_G7_0n I2066_G23_8n I2066_G23_0 VDD VSS OAI21_X1
XI2066_I195_XG I2066_P24_9n I2066_G8_0n I2066_G24_9n I2066_G24_0 VDD VSS OAI21_X1
XI2066_I196_XG I2066_P25_10n I2066_G9_0n I2066_G25_10n I2066_G25_0 VDD VSS OAI21_X1
XI2066_I197_XG I2066_P26_11n I2066_G10_0n I2066_G26_11n I2066_G26_0 VDD VSS OAI21_X1
XI2066_I198_XG I2066_P27_12n I2066_G11_0n I2066_G27_12n I2066_G27_0 VDD VSS OAI21_X1
XI2066_I199_XG I2066_P28_13n I2066_G12_0n I2066_G28_13n I2066_G28_0 VDD VSS OAI21_X1
XI2066_I200_XG I2066_P29_14n I2066_G13_0n I2066_G29_14n I2066_G29_0 VDD VSS OAI21_X1
XI2066_I201_XG I2066_P30_15n I2066_G14_0n I2066_G30_15n rcm VDD VSS OAI21_X1
XI2066_I202_XG I2066_P31_16n I2066_G15_0n I2066_G31_16n rco VDD VSS OAI21_X1
XI2066_I203 I2066_pn0 VSS R_0 VDD VSS XNOR2_X1
XI2066_I204 I2066_pn1 I2066_G0_0 ru1 VDD VSS XNOR2_X1
XI2066_I205 I2066_pn2 I2066_G1_0 ru2 VDD VSS XNOR2_X1
XI2066_I206 I2066_pn3 I2066_G2_0n ru3 VDD VSS XOR2_X1
XI2066_I207 I2066_pn4 I2066_G3_0n ru4 VDD VSS XOR2_X1
XI2066_I208 I2066_pn5 I2066_G4_0 ru5 VDD VSS XNOR2_X1
XI2066_I209 I2066_pn6 I2066_G5_0 ru6 VDD VSS XNOR2_X1
XI2066_I210 I2066_pn7 I2066_G6_0 ru7 VDD VSS XNOR2_X1
XI2066_I211 I2066_pn8 I2066_G7_0 ru8 VDD VSS XNOR2_X1
XI2066_I212 I2066_pn9 I2066_G8_0n ru9 VDD VSS XOR2_X1
XI2066_I213 I2066_pn10 I2066_G9_0n ru10 VDD VSS XOR2_X1
XI2066_I214 I2066_pn11 I2066_G10_0n ru11 VDD VSS XOR2_X1
XI2066_I215 I2066_pn12 I2066_G11_0n ru12 VDD VSS XOR2_X1
XI2066_I216 I2066_pn13 I2066_G12_0n ru13 VDD VSS XOR2_X1
XI2066_I217 I2066_pn14 I2066_G13_0n ru14 VDD VSS XOR2_X1
XI2066_I218 I2066_pn15 I2066_G14_0n ru15 VDD VSS XOR2_X1
XI2066_I219 I2066_pn16 I2066_G15_0n ru16 VDD VSS XOR2_X1
XI2066_I220 I2066_pn17 I2066_G16_0 ru17 VDD VSS XNOR2_X1
XI2066_I221 I2066_pn18 I2066_G17_0 ru18 VDD VSS XNOR2_X1
XI2066_I222 I2066_pn19 I2066_G18_0 ru19 VDD VSS XNOR2_X1
XI2066_I223 I2066_pn20 I2066_G19_0 ru20 VDD VSS XNOR2_X1
XI2066_I224 I2066_pn21 I2066_G20_0 ru21 VDD VSS XNOR2_X1
XI2066_I225 I2066_pn22 I2066_G21_0 ru22 VDD VSS XNOR2_X1
XI2066_I226 I2066_pn23 I2066_G22_0 ru23 VDD VSS XNOR2_X1
XI2066_I227 I2066_pn24 I2066_G23_0 ru24 VDD VSS XNOR2_X1
XI2066_I228 I2066_pn25 I2066_G24_0 ru25 VDD VSS XNOR2_X1
XI2066_I229 I2066_pn26 I2066_G25_0 ru26 VDD VSS XNOR2_X1
XI2066_I230 I2066_pn27 I2066_G26_0 ru27 VDD VSS XNOR2_X1
XI2066_I231 I2066_pn28 I2066_G27_0 ru28 VDD VSS XNOR2_X1
XI2066_I232 I2066_pn29 I2066_G28_0 ru29 VDD VSS XNOR2_X1
XI2066_I233 I2066_pn30 I2066_G29_0 ru30 VDD VSS XNOR2_X1
XI2066_I234 I2066_pn31 rcm ru31 VDD VSS XNOR2_X1
XI2067 A_31_b3_5 B_31_b3_5 sq VDD VSS XOR2_X1
XI2068 sq sq_b0 VDD VSS INV_X1
XI2069 sq_b0 sq_b1_0 VDD VSS INV_X4
XI2070 sq_b1_0 sq_b2_0 VDD VSS INV_X4
XI2071 sq_b1_0 sq_b2_1 VDD VSS INV_X4
XI2072 sq_b2_0 sq_b3_0 VDD VSS INV_X4
XI2073 sq_b2_0 sq_b3_1 VDD VSS INV_X4
XI2074 sq_b2_0 sq_b3_2 VDD VSS INV_X4
XI2075 sq_b2_1 sq_b3_3 VDD VSS INV_X4
XI2076 sq_b2_1 sq_b3_4 VDD VSS INV_X4
XI2077 sq_b2_1 sq_b3_5 VDD VSS INV_X4
XI2078 sq_b3_0 Q_0 nqkn1 VDD VSS NAND2_X1
XI2079 qu1_b3_5 nqkn1 Q_1 VDD VSS XNOR2_X1
XI2080 nqkn1 nqk1 VDD VSS INV_X1
XI2081 sq_b3_0 qu1_b3_5 nqk1 nqkn2 VDD VSS AOI21_X1
XI2082 qu2_b3_5 nqkn2 Q_2 VDD VSS XNOR2_X1
XI2083 nqkn2 nqk2 VDD VSS INV_X1
XI2084 sq_b3_0 qu2_b3_5 nqk2 nqkn3 VDD VSS AOI21_X1
XI2085 qu3_b3_5 nqkn3 Q_3 VDD VSS XNOR2_X1
XI2086 nqkn3 nqk3 VDD VSS INV_X1
XI2087 sq_b3_0 qu3_b3_5 nqk3 nqkn4 VDD VSS AOI21_X1
XI2088 qu4_b3_5 nqkn4 Q_4 VDD VSS XNOR2_X1
XI2089 nqkn4 nqk4 VDD VSS INV_X1
XI2090 sq_b3_0 qu4_b3_5 nqk4 nqkn5 VDD VSS AOI21_X1
XI2091 qu5_b3_5 nqkn5 Q_5 VDD VSS XNOR2_X1
XI2092 nqkn5 nqk5 VDD VSS INV_X1
XI2093 sq_b3_0 qu5_b3_5 nqk5 nqkn6 VDD VSS AOI21_X1
XI2094 qu6_b3_5 nqkn6 Q_6 VDD VSS XNOR2_X1
XI2095 nqkn6 nqk6 VDD VSS INV_X1
XI2096 sq_b3_1 qu6_b3_5 nqk6 nqkn7 VDD VSS AOI21_X1
XI2097 qu7_b3_5 nqkn7 Q_7 VDD VSS XNOR2_X1
XI2098 nqkn7 nqk7 VDD VSS INV_X1
XI2099 sq_b3_1 qu7_b3_5 nqk7 nqkn8 VDD VSS AOI21_X1
XI2100 qu8_b3_5 nqkn8 Q_8 VDD VSS XNOR2_X1
XI2101 nqkn8 nqk8 VDD VSS INV_X1
XI2102 sq_b3_1 qu8_b3_5 nqk8 nqkn9 VDD VSS AOI21_X1
XI2103 qu9_b3_5 nqkn9 Q_9 VDD VSS XNOR2_X1
XI2104 nqkn9 nqk9 VDD VSS INV_X1
XI2105 sq_b3_1 qu9_b3_5 nqk9 nqkn10 VDD VSS AOI21_X1
XI2106 qu10_b3_5 nqkn10 Q_10 VDD VSS XNOR2_X1
XI2107 nqkn10 nqk10 VDD VSS INV_X1
XI2108 sq_b3_1 qu10_b3_5 nqk10 nqkn11 VDD VSS AOI21_X1
XI2109 qu11_b3_5 nqkn11 Q_11 VDD VSS XNOR2_X1
XI2110 nqkn11 nqk11 VDD VSS INV_X1
XI2111 sq_b3_2 qu11_b3_5 nqk11 nqkn12 VDD VSS AOI21_X1
XI2112 qu12_b3_5 nqkn12 Q_12 VDD VSS XNOR2_X1
XI2113 nqkn12 nqk12 VDD VSS INV_X1
XI2114 sq_b3_2 qu12_b3_5 nqk12 nqkn13 VDD VSS AOI21_X1
XI2115 qu13_b3_5 nqkn13 Q_13 VDD VSS XNOR2_X1
XI2116 nqkn13 nqk13 VDD VSS INV_X1
XI2117 sq_b3_2 qu13_b3_5 nqk13 nqkn14 VDD VSS AOI21_X1
XI2118 qu14_b3_5 nqkn14 Q_14 VDD VSS XNOR2_X1
XI2119 nqkn14 nqk14 VDD VSS INV_X1
XI2120 sq_b3_2 qu14_b3_5 nqk14 nqkn15 VDD VSS AOI21_X1
XI2121 qu15_b3_5 nqkn15 Q_15 VDD VSS XNOR2_X1
XI2122 nqkn15 nqk15 VDD VSS INV_X1
XI2123 sq_b3_2 qu15_b3_5 nqk15 nqkn16 VDD VSS AOI21_X1
XI2124 qu16_b3_5 nqkn16 Q_16 VDD VSS XNOR2_X1
XI2125 nqkn16 nqk16 VDD VSS INV_X1
XI2126 sq_b3_3 qu16_b3_5 nqk16 nqkn17 VDD VSS AOI21_X1
XI2127 qu17_b3_5 nqkn17 Q_17 VDD VSS XNOR2_X1
XI2128 nqkn17 nqk17 VDD VSS INV_X1
XI2129 sq_b3_3 qu17_b3_5 nqk17 nqkn18 VDD VSS AOI21_X1
XI2130 qu18_b3_5 nqkn18 Q_18 VDD VSS XNOR2_X1
XI2131 nqkn18 nqk18 VDD VSS INV_X1
XI2132 sq_b3_3 qu18_b3_5 nqk18 nqkn19 VDD VSS AOI21_X1
XI2133 qu19_b3_5 nqkn19 Q_19 VDD VSS XNOR2_X1
XI2134 nqkn19 nqk19 VDD VSS INV_X1
XI2135 sq_b3_3 qu19_b3_5 nqk19 nqkn20 VDD VSS AOI21_X1
XI2136 qu20_b3_5 nqkn20 Q_20 VDD VSS XNOR2_X1
XI2137 nqkn20 nqk20 VDD VSS INV_X1
XI2138 sq_b3_3 qu20_b3_5 nqk20 nqkn21 VDD VSS AOI21_X1
XI2139 qu21_b3_5 nqkn21 Q_21 VDD VSS XNOR2_X1
XI2140 nqkn21 nqk21 VDD VSS INV_X1
XI2141 sq_b3_3 qu21_b3_5 nqk21 nqkn22 VDD VSS AOI21_X1
XI2142 qu22_b3_5 nqkn22 Q_22 VDD VSS XNOR2_X1
XI2143 nqkn22 nqk22 VDD VSS INV_X1
XI2144 sq_b3_4 qu22_b3_5 nqk22 nqkn23 VDD VSS AOI21_X1
XI2145 qu23_b3_5 nqkn23 Q_23 VDD VSS XNOR2_X1
XI2146 nqkn23 nqk23 VDD VSS INV_X1
XI2147 sq_b3_4 qu23_b3_5 nqk23 nqkn24 VDD VSS AOI21_X1
XI2148 qu24_b3_5 nqkn24 Q_24 VDD VSS XNOR2_X1
XI2149 nqkn24 nqk24 VDD VSS INV_X1
XI2150 sq_b3_4 qu24_b3_5 nqk24 nqkn25 VDD VSS AOI21_X1
XI2151 qu25_b3_5 nqkn25 Q_25 VDD VSS XNOR2_X1
XI2152 nqkn25 nqk25 VDD VSS INV_X1
XI2153 sq_b3_4 qu25_b3_5 nqk25 nqkn26 VDD VSS AOI21_X1
XI2154 qu26_b3_5 nqkn26 Q_26 VDD VSS XNOR2_X1
XI2155 nqkn26 nqk26 VDD VSS INV_X1
XI2156 sq_b3_4 qu26_b3_5 nqk26 nqkn27 VDD VSS AOI21_X1
XI2157 qu27_b3_5 nqkn27 Q_27 VDD VSS XNOR2_X1
XI2158 nqkn27 nqk27 VDD VSS INV_X1
XI2159 sq_b3_5 qu27_b3_5 nqk27 nqkn28 VDD VSS AOI21_X1
XI2160 qu28_b3_5 nqkn28 Q_28 VDD VSS XNOR2_X1
XI2161 nqkn28 nqk28 VDD VSS INV_X1
XI2162 sq_b3_5 qu28_b3_5 nqk28 nqkn29 VDD VSS AOI21_X1
XI2163 qu29_b3_5 nqkn29 Q_29 VDD VSS XNOR2_X1
XI2164 nqkn29 nqk29 VDD VSS INV_X1
XI2165 sq_b3_5 qu29_b3_5 nqk29 nqkn30 VDD VSS AOI21_X1
XI2166 qu30_b3_5 nqkn30 Q_30 VDD VSS XNOR2_X1
XI2167 nqkn30 nqk30 VDD VSS INV_X1
XI2168 sq_b3_5 qu30_b3_5 nqk30 nqkn31 VDD VSS AOI21_X1
XI2169 qu31_b3_5 nqkn31 Q_31 VDD VSS XNOR2_X1
XI2170 A_31_b3_5 R_0 nrkn1 VDD VSS NAND2_X1
XI2171 ru1 nrkn1 R_1 VDD VSS XNOR2_X1
XI2172 nrkn1 nrk1 VDD VSS INV_X1
XI2173 A_31_b3_5 ru1 nrk1 nrkn2 VDD VSS AOI21_X1
XI2174 ru2 nrkn2 R_2 VDD VSS XNOR2_X1
XI2175 nrkn2 nrk2 VDD VSS INV_X1
XI2176 A_31_b3_6 ru2 nrk2 nrkn3 VDD VSS AOI21_X1
XI2177 ru3 nrkn3 R_3 VDD VSS XNOR2_X1
XI2178 nrkn3 nrk3 VDD VSS INV_X1
XI2179 A_31_b3_6 ru3 nrk3 nrkn4 VDD VSS AOI21_X1
XI2180 ru4 nrkn4 R_4 VDD VSS XNOR2_X1
XI2181 nrkn4 nrk4 VDD VSS INV_X1
XI2182 A_31_b3_6 ru4 nrk4 nrkn5 VDD VSS AOI21_X1
XI2183 ru5 nrkn5 R_5 VDD VSS XNOR2_X1
XI2184 nrkn5 nrk5 VDD VSS INV_X1
XI2185 A_31_b3_6 ru5 nrk5 nrkn6 VDD VSS AOI21_X1
XI2186 ru6 nrkn6 R_6 VDD VSS XNOR2_X1
XI2187 nrkn6 nrk6 VDD VSS INV_X1
XI2188 A_31_b3_6 ru6 nrk6 nrkn7 VDD VSS AOI21_X1
XI2189 ru7 nrkn7 R_7 VDD VSS XNOR2_X1
XI2190 nrkn7 nrk7 VDD VSS INV_X1
XI2191 A_31_b3_6 ru7 nrk7 nrkn8 VDD VSS AOI21_X1
XI2192 ru8 nrkn8 R_8 VDD VSS XNOR2_X1
XI2193 nrkn8 nrk8 VDD VSS INV_X1
XI2194 A_31_b3_7 ru8 nrk8 nrkn9 VDD VSS AOI21_X1
XI2195 ru9 nrkn9 R_9 VDD VSS XNOR2_X1
XI2196 nrkn9 nrk9 VDD VSS INV_X1
XI2197 A_31_b3_7 ru9 nrk9 nrkn10 VDD VSS AOI21_X1
XI2198 ru10 nrkn10 R_10 VDD VSS XNOR2_X1
XI2199 nrkn10 nrk10 VDD VSS INV_X1
XI2200 A_31_b3_7 ru10 nrk10 nrkn11 VDD VSS AOI21_X1
XI2201 ru11 nrkn11 R_11 VDD VSS XNOR2_X1
XI2202 nrkn11 nrk11 VDD VSS INV_X1
XI2203 A_31_b3_7 ru11 nrk11 nrkn12 VDD VSS AOI21_X1
XI2204 ru12 nrkn12 R_12 VDD VSS XNOR2_X1
XI2205 nrkn12 nrk12 VDD VSS INV_X1
XI2206 A_31_b3_7 ru12 nrk12 nrkn13 VDD VSS AOI21_X1
XI2207 ru13 nrkn13 R_13 VDD VSS XNOR2_X1
XI2208 nrkn13 nrk13 VDD VSS INV_X1
XI2209 A_31_b3_7 ru13 nrk13 nrkn14 VDD VSS AOI21_X1
XI2210 ru14 nrkn14 R_14 VDD VSS XNOR2_X1
XI2211 nrkn14 nrk14 VDD VSS INV_X1
XI2212 A_31_b3_8 ru14 nrk14 nrkn15 VDD VSS AOI21_X1
XI2213 ru15 nrkn15 R_15 VDD VSS XNOR2_X1
XI2214 nrkn15 nrk15 VDD VSS INV_X1
XI2215 A_31_b3_8 ru15 nrk15 nrkn16 VDD VSS AOI21_X1
XI2216 ru16 nrkn16 R_16 VDD VSS XNOR2_X1
XI2217 nrkn16 nrk16 VDD VSS INV_X1
XI2218 A_31_b3_8 ru16 nrk16 nrkn17 VDD VSS AOI21_X1
XI2219 ru17 nrkn17 R_17 VDD VSS XNOR2_X1
XI2220 nrkn17 nrk17 VDD VSS INV_X1
XI2221 A_31_b3_8 ru17 nrk17 nrkn18 VDD VSS AOI21_X1
XI2222 ru18 nrkn18 R_18 VDD VSS XNOR2_X1
XI2223 nrkn18 nrk18 VDD VSS INV_X1
XI2224 A_31_b3_8 ru18 nrk18 nrkn19 VDD VSS AOI21_X1
XI2225 ru19 nrkn19 R_19 VDD VSS XNOR2_X1
XI2226 nrkn19 nrk19 VDD VSS INV_X1
XI2227 A_31_b3_8 ru19 nrk19 nrkn20 VDD VSS AOI21_X1
XI2228 ru20 nrkn20 R_20 VDD VSS XNOR2_X1
XI2229 nrkn20 nrk20 VDD VSS INV_X1
XI2230 A_31_b3_9 ru20 nrk20 nrkn21 VDD VSS AOI21_X1
XI2231 ru21 nrkn21 R_21 VDD VSS XNOR2_X1
XI2232 nrkn21 nrk21 VDD VSS INV_X1
XI2233 A_31_b3_9 ru21 nrk21 nrkn22 VDD VSS AOI21_X1
XI2234 ru22 nrkn22 R_22 VDD VSS XNOR2_X1
XI2235 nrkn22 nrk22 VDD VSS INV_X1
XI2236 A_31_b3_9 ru22 nrk22 nrkn23 VDD VSS AOI21_X1
XI2237 ru23 nrkn23 R_23 VDD VSS XNOR2_X1
XI2238 nrkn23 nrk23 VDD VSS INV_X1
XI2239 A_31_b3_9 ru23 nrk23 nrkn24 VDD VSS AOI21_X1
XI2240 ru24 nrkn24 R_24 VDD VSS XNOR2_X1
XI2241 nrkn24 nrk24 VDD VSS INV_X1
XI2242 A_31_b3_9 ru24 nrk24 nrkn25 VDD VSS AOI21_X1
XI2243 ru25 nrkn25 R_25 VDD VSS XNOR2_X1
XI2244 nrkn25 nrk25 VDD VSS INV_X1
XI2245 A_31_b3_9 ru25 nrk25 nrkn26 VDD VSS AOI21_X1
XI2246 ru26 nrkn26 R_26 VDD VSS XNOR2_X1
XI2247 nrkn26 nrk26 VDD VSS INV_X1
XI2248 A_31_b3_10 ru26 nrk26 nrkn27 VDD VSS AOI21_X1
XI2249 ru27 nrkn27 R_27 VDD VSS XNOR2_X1
XI2250 nrkn27 nrk27 VDD VSS INV_X1
XI2251 A_31_b3_10 ru27 nrk27 nrkn28 VDD VSS AOI21_X1
XI2252 ru28 nrkn28 R_28 VDD VSS XNOR2_X1
XI2253 nrkn28 nrk28 VDD VSS INV_X1
XI2254 A_31_b3_10 ru28 nrk28 nrkn29 VDD VSS AOI21_X1
XI2255 ru29 nrkn29 R_29 VDD VSS XNOR2_X1
XI2256 nrkn29 nrk29 VDD VSS INV_X1
XI2257 A_31_b3_10 ru29 nrk29 nrkn30 VDD VSS AOI21_X1
XI2258 ru30 nrkn30 R_30 VDD VSS XNOR2_X1
XI2259 nrkn30 nrk30 VDD VSS INV_X1
XI2260 A_31_b3_10 ru30 nrk30 nrkn31 VDD VSS AOI21_X1
XI2261 ru31 nrkn31 R_31 VDD VSS XNOR2_X1
XI2262 B_0_b3_5 B_1 z0_0 VDD VSS NOR2_X1
XI2263 B_2 B_3 z0_1 VDD VSS NOR2_X1
XI2264 B_4 B_5 z0_2 VDD VSS NOR2_X1
XI2265 B_6 B_7 z0_3 VDD VSS NOR2_X1
XI2266 B_8 B_9 z0_4 VDD VSS NOR2_X1
XI2267 B_10 B_11 z0_5 VDD VSS NOR2_X1
XI2268 B_12 B_13 z0_6 VDD VSS NOR2_X1
XI2269 B_14 B_15 z0_7 VDD VSS NOR2_X1
XI2270 B_16 B_17 z0_8 VDD VSS NOR2_X1
XI2271 B_18 B_19 z0_9 VDD VSS NOR2_X1
XI2272 B_20 B_21 z0_10 VDD VSS NOR2_X1
XI2273 B_22 B_23 z0_11 VDD VSS NOR2_X1
XI2274 B_24 B_25 z0_12 VDD VSS NOR2_X1
XI2275 B_26 B_27 z0_13 VDD VSS NOR2_X1
XI2276 B_28 B_29 z0_14 VDD VSS NOR2_X1
XI2277 B_30 B_31_b3_5 z0_15 VDD VSS NOR2_X1
XI2278 z0_0 z0_1 z1_0 VDD VSS NAND2_X1
XI2279 z0_2 z0_3 z1_1 VDD VSS NAND2_X1
XI2280 z0_4 z0_5 z1_2 VDD VSS NAND2_X1
XI2281 z0_6 z0_7 z1_3 VDD VSS NAND2_X1
XI2282 z0_8 z0_9 z1_4 VDD VSS NAND2_X1
XI2283 z0_10 z0_11 z1_5 VDD VSS NAND2_X1
XI2284 z0_12 z0_13 z1_6 VDD VSS NAND2_X1
XI2285 z0_14 z0_15 z1_7 VDD VSS NAND2_X1
XI2286 z1_0 z1_1 z2_0 VDD VSS NOR2_X1
XI2287 z1_2 z1_3 z2_1 VDD VSS NOR2_X1
XI2288 z1_4 z1_5 z2_2 VDD VSS NOR2_X1
XI2289 z1_6 z1_7 z2_3 VDD VSS NOR2_X1
XI2290 z2_0 z2_1 z3_0 VDD VSS NAND2_X1
XI2291 z2_2 z2_3 z3_1 VDD VSS NAND2_X1
XI2292 z3_0 z3_1 DZ VDD VSS NOR2_X1
XI2293 sq_b3_5 sqn VDD VSS INV_X1
XI2294 Q_31 sqn vn VDD VSS NAND2_X1
XI2295 vn DZ V VDD VSS NOR2_X1
.ENDS DIV32
