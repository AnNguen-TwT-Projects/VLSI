// ALU32_p2 sau layout (Assura RCX), corner SS
simulator lang=spectre
include "/home/buet/cadence/gpdk090_v4.6/models/spectre/gpdk090.scs" section=SS
include "../../../tang1_cell/cells.scs"
include "ALU32_rcx.scs"
include "../../tb/tb_ALU32_p2_slow.scs"
