// CORE32_p0 sau layout (Assura RCX), corner SS
simulator lang=spectre
include "/home/buet/cadence/gpdk090_v4.6/models/spectre/gpdk090.scs" section=SS
include "../../../tang1_cell/cells.scs"
include "CORE32_rcx.scs"
include "../../tb/tb_CORE32_p0_slow.scs"
