// ALU32_p0 sau layout (Assura RCX), corner FF
simulator lang=spectre
include "/home/buet/cadence/gpdk090_v4.6/models/spectre/gpdk090.scs" section=FF
include "../../../tang1_cell/cells.scs"
include "ALU32_rcx.scs"
include "../../tb/tb_ALU32_p0.scs"
