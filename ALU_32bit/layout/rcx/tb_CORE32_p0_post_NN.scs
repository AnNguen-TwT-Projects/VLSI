// CORE32_p0 sau layout (Assura RCX), corner NN
simulator lang=spectre
include "/home/buet/cadence/gpdk090_v4.6/models/spectre/gpdk090.scs" section=NN
include "../../../tang1_cell/cells.scs"
include "CORE32_rcx.scs"
include "../../tb/tb_CORE32_p0.scs"
