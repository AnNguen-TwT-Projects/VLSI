// CORE32: loi ALU 32 bit = ADDSUB32 + LOGIC32 + DEC_OP + OUTMUX32 + FLAGS32
simulator lang=spectre
subckt CORE32 A_0 A_1 A_2 A_3 A_4 A_5 A_6 A_7 A_8 A_9 A_10 A_11 A_12 A_13 A_14 A_15 A_16 \
    A_17 A_18 A_19 A_20 A_21 A_22 A_23 A_24 A_25 A_26 A_27 A_28 A_29 A_30 A_31 B_0 B_1 B_2 \
    B_3 B_4 B_5 B_6 B_7 B_8 B_9 B_10 B_11 B_12 B_13 B_14 B_15 B_16 B_17 B_18 B_19 B_20 \
    B_21 B_22 B_23 B_24 B_25 B_26 B_27 B_28 B_29 B_30 B_31 OP_0 OP_1 OP_2 OP_3 MULP_0 \
    MULP_1 MULP_2 MULP_3 MULP_4 MULP_5 MULP_6 MULP_7 MULP_8 MULP_9 MULP_10 MULP_11 MULP_12 \
    MULP_13 MULP_14 MULP_15 MULP_16 MULP_17 MULP_18 MULP_19 MULP_20 MULP_21 MULP_22 \
    MULP_23 MULP_24 MULP_25 MULP_26 MULP_27 MULP_28 MULP_29 MULP_30 MULP_31 MULP_32 \
    MULP_33 MULP_34 MULP_35 MULP_36 MULP_37 MULP_38 MULP_39 MULP_40 MULP_41 MULP_42 \
    MULP_43 MULP_44 MULP_45 MULP_46 MULP_47 MULP_48 MULP_49 MULP_50 MULP_51 MULP_52 \
    MULP_53 MULP_54 MULP_55 MULP_56 MULP_57 MULP_58 MULP_59 MULP_60 MULP_61 MULP_62 \
    MULP_63 DIVQ_0 DIVQ_1 DIVQ_2 DIVQ_3 DIVQ_4 DIVQ_5 DIVQ_6 DIVQ_7 DIVQ_8 DIVQ_9 DIVQ_10 \
    DIVQ_11 DIVQ_12 DIVQ_13 DIVQ_14 DIVQ_15 DIVQ_16 DIVQ_17 DIVQ_18 DIVQ_19 DIVQ_20 \
    DIVQ_21 DIVQ_22 DIVQ_23 DIVQ_24 DIVQ_25 DIVQ_26 DIVQ_27 DIVQ_28 DIVQ_29 DIVQ_30 \
    DIVQ_31 DIVR_0 DIVR_1 DIVR_2 DIVR_3 DIVR_4 DIVR_5 DIVR_6 DIVR_7 DIVR_8 DIVR_9 DIVR_10 \
    DIVR_11 DIVR_12 DIVR_13 DIVR_14 DIVR_15 DIVR_16 DIVR_17 DIVR_18 DIVR_19 DIVR_20 \
    DIVR_21 DIVR_22 DIVR_23 DIVR_24 DIVR_25 DIVR_26 DIVR_27 DIVR_28 DIVR_29 DIVR_30 \
    DIVR_31 DIVV DIVDZ Y_0 Y_1 Y_2 Y_3 Y_4 Y_5 Y_6 Y_7 Y_8 Y_9 Y_10 Y_11 Y_12 Y_13 Y_14 \
    Y_15 Y_16 Y_17 Y_18 Y_19 Y_20 Y_21 Y_22 Y_23 Y_24 Y_25 Y_26 Y_27 Y_28 Y_29 Y_30 Y_31 \
    Y_32 Y_33 Y_34 Y_35 Y_36 Y_37 Y_38 Y_39 Y_40 Y_41 Y_42 Y_43 Y_44 Y_45 Y_46 Y_47 Y_48 \
    Y_49 Y_50 Y_51 Y_52 Y_53 Y_54 Y_55 Y_56 Y_57 Y_58 Y_59 Y_60 Y_61 Y_62 Y_63 Z C V DZ \
    VDD VSS
I0 (OP_0 OP_1 OP_2 OP_3 SEL_AS SEL_AND SEL_OR SEL_XOR SEL_NOT SEL_MUL SEL_DIV VDD VSS) \
    DEC_OP
I1 (A_0 A_1 A_2 A_3 A_4 A_5 A_6 A_7 A_8 A_9 A_10 A_11 A_12 A_13 A_14 A_15 A_16 A_17 A_18 \
    A_19 A_20 A_21 A_22 A_23 A_24 A_25 A_26 A_27 A_28 A_29 A_30 A_31 B_0 B_1 B_2 B_3 B_4 \
    B_5 B_6 B_7 B_8 B_9 B_10 B_11 B_12 B_13 B_14 B_15 B_16 B_17 B_18 B_19 B_20 B_21 B_22 \
    B_23 B_24 B_25 B_26 B_27 B_28 B_29 B_30 B_31 OP_0 S_0 S_1 S_2 S_3 S_4 S_5 S_6 S_7 S_8 \
    S_9 S_10 S_11 S_12 S_13 S_14 S_15 S_16 S_17 S_18 S_19 S_20 S_21 S_22 S_23 S_24 S_25 \
    S_26 S_27 S_28 S_29 S_30 S_31 CM CO VDD VSS) ADDSUB32
I2 (A_0 A_1 A_2 A_3 A_4 A_5 A_6 A_7 A_8 A_9 A_10 A_11 A_12 A_13 A_14 A_15 A_16 A_17 A_18 \
    A_19 A_20 A_21 A_22 A_23 A_24 A_25 A_26 A_27 A_28 A_29 A_30 A_31 B_0 B_1 B_2 B_3 B_4 \
    B_5 B_6 B_7 B_8 B_9 B_10 B_11 B_12 B_13 B_14 B_15 B_16 B_17 B_18 B_19 B_20 B_21 B_22 \
    B_23 B_24 B_25 B_26 B_27 B_28 B_29 B_30 B_31 AND_0 AND_1 AND_2 AND_3 AND_4 AND_5 AND_6 \
    AND_7 AND_8 AND_9 AND_10 AND_11 AND_12 AND_13 AND_14 AND_15 AND_16 AND_17 AND_18 \
    AND_19 AND_20 AND_21 AND_22 AND_23 AND_24 AND_25 AND_26 AND_27 AND_28 AND_29 AND_30 \
    AND_31 OR_0 OR_1 OR_2 OR_3 OR_4 OR_5 OR_6 OR_7 OR_8 OR_9 OR_10 OR_11 OR_12 OR_13 OR_14 \
    OR_15 OR_16 OR_17 OR_18 OR_19 OR_20 OR_21 OR_22 OR_23 OR_24 OR_25 OR_26 OR_27 OR_28 \
    OR_29 OR_30 OR_31 XOR_0 XOR_1 XOR_2 XOR_3 XOR_4 XOR_5 XOR_6 XOR_7 XOR_8 XOR_9 XOR_10 \
    XOR_11 XOR_12 XOR_13 XOR_14 XOR_15 XOR_16 XOR_17 XOR_18 XOR_19 XOR_20 XOR_21 XOR_22 \
    XOR_23 XOR_24 XOR_25 XOR_26 XOR_27 XOR_28 XOR_29 XOR_30 XOR_31 NOT_0 NOT_1 NOT_2 NOT_3 \
    NOT_4 NOT_5 NOT_6 NOT_7 NOT_8 NOT_9 NOT_10 NOT_11 NOT_12 NOT_13 NOT_14 NOT_15 NOT_16 \
    NOT_17 NOT_18 NOT_19 NOT_20 NOT_21 NOT_22 NOT_23 NOT_24 NOT_25 NOT_26 NOT_27 NOT_28 \
    NOT_29 NOT_30 NOT_31 VDD VSS) LOGIC32
I3 (S_0 S_1 S_2 S_3 S_4 S_5 S_6 S_7 S_8 S_9 S_10 S_11 S_12 S_13 S_14 S_15 S_16 S_17 S_18 \
    S_19 S_20 S_21 S_22 S_23 S_24 S_25 S_26 S_27 S_28 S_29 S_30 S_31 AND_0 AND_1 AND_2 \
    AND_3 AND_4 AND_5 AND_6 AND_7 AND_8 AND_9 AND_10 AND_11 AND_12 AND_13 AND_14 AND_15 \
    AND_16 AND_17 AND_18 AND_19 AND_20 AND_21 AND_22 AND_23 AND_24 AND_25 AND_26 AND_27 \
    AND_28 AND_29 AND_30 AND_31 OR_0 OR_1 OR_2 OR_3 OR_4 OR_5 OR_6 OR_7 OR_8 OR_9 OR_10 \
    OR_11 OR_12 OR_13 OR_14 OR_15 OR_16 OR_17 OR_18 OR_19 OR_20 OR_21 OR_22 OR_23 OR_24 \
    OR_25 OR_26 OR_27 OR_28 OR_29 OR_30 OR_31 XOR_0 XOR_1 XOR_2 XOR_3 XOR_4 XOR_5 XOR_6 \
    XOR_7 XOR_8 XOR_9 XOR_10 XOR_11 XOR_12 XOR_13 XOR_14 XOR_15 XOR_16 XOR_17 XOR_18 \
    XOR_19 XOR_20 XOR_21 XOR_22 XOR_23 XOR_24 XOR_25 XOR_26 XOR_27 XOR_28 XOR_29 XOR_30 \
    XOR_31 NOT_0 NOT_1 NOT_2 NOT_3 NOT_4 NOT_5 NOT_6 NOT_7 NOT_8 NOT_9 NOT_10 NOT_11 \
    NOT_12 NOT_13 NOT_14 NOT_15 NOT_16 NOT_17 NOT_18 NOT_19 NOT_20 NOT_21 NOT_22 NOT_23 \
    NOT_24 NOT_25 NOT_26 NOT_27 NOT_28 NOT_29 NOT_30 NOT_31 MULP_0 MULP_1 MULP_2 MULP_3 \
    MULP_4 MULP_5 MULP_6 MULP_7 MULP_8 MULP_9 MULP_10 MULP_11 MULP_12 MULP_13 MULP_14 \
    MULP_15 MULP_16 MULP_17 MULP_18 MULP_19 MULP_20 MULP_21 MULP_22 MULP_23 MULP_24 \
    MULP_25 MULP_26 MULP_27 MULP_28 MULP_29 MULP_30 MULP_31 MULP_32 MULP_33 MULP_34 \
    MULP_35 MULP_36 MULP_37 MULP_38 MULP_39 MULP_40 MULP_41 MULP_42 MULP_43 MULP_44 \
    MULP_45 MULP_46 MULP_47 MULP_48 MULP_49 MULP_50 MULP_51 MULP_52 MULP_53 MULP_54 \
    MULP_55 MULP_56 MULP_57 MULP_58 MULP_59 MULP_60 MULP_61 MULP_62 MULP_63 DIVQ_0 DIVQ_1 \
    DIVQ_2 DIVQ_3 DIVQ_4 DIVQ_5 DIVQ_6 DIVQ_7 DIVQ_8 DIVQ_9 DIVQ_10 DIVQ_11 DIVQ_12 \
    DIVQ_13 DIVQ_14 DIVQ_15 DIVQ_16 DIVQ_17 DIVQ_18 DIVQ_19 DIVQ_20 DIVQ_21 DIVQ_22 \
    DIVQ_23 DIVQ_24 DIVQ_25 DIVQ_26 DIVQ_27 DIVQ_28 DIVQ_29 DIVQ_30 DIVQ_31 DIVR_0 DIVR_1 \
    DIVR_2 DIVR_3 DIVR_4 DIVR_5 DIVR_6 DIVR_7 DIVR_8 DIVR_9 DIVR_10 DIVR_11 DIVR_12 \
    DIVR_13 DIVR_14 DIVR_15 DIVR_16 DIVR_17 DIVR_18 DIVR_19 DIVR_20 DIVR_21 DIVR_22 \
    DIVR_23 DIVR_24 DIVR_25 DIVR_26 DIVR_27 DIVR_28 DIVR_29 DIVR_30 DIVR_31 SEL_AS SEL_AND \
    SEL_OR SEL_XOR SEL_NOT SEL_MUL SEL_DIV Y_0 Y_1 Y_2 Y_3 Y_4 Y_5 Y_6 Y_7 Y_8 Y_9 Y_10 \
    Y_11 Y_12 Y_13 Y_14 Y_15 Y_16 Y_17 Y_18 Y_19 Y_20 Y_21 Y_22 Y_23 Y_24 Y_25 Y_26 Y_27 \
    Y_28 Y_29 Y_30 Y_31 Y_32 Y_33 Y_34 Y_35 Y_36 Y_37 Y_38 Y_39 Y_40 Y_41 Y_42 Y_43 Y_44 \
    Y_45 Y_46 Y_47 Y_48 Y_49 Y_50 Y_51 Y_52 Y_53 Y_54 Y_55 Y_56 Y_57 Y_58 Y_59 Y_60 Y_61 \
    Y_62 Y_63 VDD VSS) OUTMUX32
I4 (Y_0 Y_1 Y_2 Y_3 Y_4 Y_5 Y_6 Y_7 Y_8 Y_9 Y_10 Y_11 Y_12 Y_13 Y_14 Y_15 Y_16 Y_17 Y_18 \
    Y_19 Y_20 Y_21 Y_22 Y_23 Y_24 Y_25 Y_26 Y_27 Y_28 Y_29 Y_30 Y_31 Y_32 Y_33 Y_34 Y_35 \
    Y_36 Y_37 Y_38 Y_39 Y_40 Y_41 Y_42 Y_43 Y_44 Y_45 Y_46 Y_47 Y_48 Y_49 Y_50 Y_51 Y_52 \
    Y_53 Y_54 Y_55 Y_56 Y_57 Y_58 Y_59 Y_60 Y_61 Y_62 Y_63 CM CO DIVV DIVDZ SEL_AS SEL_DIV \
    Z C V DZ VDD VSS) FLAGS32
ends CORE32
