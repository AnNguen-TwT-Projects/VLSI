// KSA64: bo cong Kogge-Stone 64 bit (bo cong cuoi cua MUL32)
simulator lang=spectre
subckt KSA64 A_0 A_1 A_2 A_3 A_4 A_5 A_6 A_7 A_8 A_9 A_10 A_11 A_12 A_13 A_14 A_15 A_16 \
    A_17 A_18 A_19 A_20 A_21 A_22 A_23 A_24 A_25 A_26 A_27 A_28 A_29 A_30 A_31 A_32 A_33 \
    A_34 A_35 A_36 A_37 A_38 A_39 A_40 A_41 A_42 A_43 A_44 A_45 A_46 A_47 A_48 A_49 A_50 \
    A_51 A_52 A_53 A_54 A_55 A_56 A_57 A_58 A_59 A_60 A_61 A_62 A_63 B_0 B_1 B_2 B_3 B_4 \
    B_5 B_6 B_7 B_8 B_9 B_10 B_11 B_12 B_13 B_14 B_15 B_16 B_17 B_18 B_19 B_20 B_21 B_22 \
    B_23 B_24 B_25 B_26 B_27 B_28 B_29 B_30 B_31 B_32 B_33 B_34 B_35 B_36 B_37 B_38 B_39 \
    B_40 B_41 B_42 B_43 B_44 B_45 B_46 B_47 B_48 B_49 B_50 B_51 B_52 B_53 B_54 B_55 B_56 \
    B_57 B_58 B_59 B_60 B_61 B_62 B_63 CIN S_0 S_1 S_2 S_3 S_4 S_5 S_6 S_7 S_8 S_9 S_10 \
    S_11 S_12 S_13 S_14 S_15 S_16 S_17 S_18 S_19 S_20 S_21 S_22 S_23 S_24 S_25 S_26 S_27 \
    S_28 S_29 S_30 S_31 S_32 S_33 S_34 S_35 S_36 S_37 S_38 S_39 S_40 S_41 S_42 S_43 S_44 \
    S_45 S_46 S_47 S_48 S_49 S_50 S_51 S_52 S_53 S_54 S_55 S_56 S_57 S_58 S_59 S_60 S_61 \
    S_62 S_63 CM CO VDD VSS
I0 (A_0 B_0 gn0 VDD VSS) NAND2_X1
I1 (A_1 B_1 gn1 VDD VSS) NAND2_X1
I2 (A_2 B_2 gn2 VDD VSS) NAND2_X1
I3 (A_3 B_3 gn3 VDD VSS) NAND2_X1
I4 (A_4 B_4 gn4 VDD VSS) NAND2_X1
I5 (A_5 B_5 gn5 VDD VSS) NAND2_X1
I6 (A_6 B_6 gn6 VDD VSS) NAND2_X1
I7 (A_7 B_7 gn7 VDD VSS) NAND2_X1
I8 (A_8 B_8 gn8 VDD VSS) NAND2_X1
I9 (A_9 B_9 gn9 VDD VSS) NAND2_X1
I10 (A_10 B_10 gn10 VDD VSS) NAND2_X1
I11 (A_11 B_11 gn11 VDD VSS) NAND2_X1
I12 (A_12 B_12 gn12 VDD VSS) NAND2_X1
I13 (A_13 B_13 gn13 VDD VSS) NAND2_X1
I14 (A_14 B_14 gn14 VDD VSS) NAND2_X1
I15 (A_15 B_15 gn15 VDD VSS) NAND2_X1
I16 (A_16 B_16 gn16 VDD VSS) NAND2_X1
I17 (A_17 B_17 gn17 VDD VSS) NAND2_X1
I18 (A_18 B_18 gn18 VDD VSS) NAND2_X1
I19 (A_19 B_19 gn19 VDD VSS) NAND2_X1
I20 (A_20 B_20 gn20 VDD VSS) NAND2_X1
I21 (A_21 B_21 gn21 VDD VSS) NAND2_X1
I22 (A_22 B_22 gn22 VDD VSS) NAND2_X1
I23 (A_23 B_23 gn23 VDD VSS) NAND2_X1
I24 (A_24 B_24 gn24 VDD VSS) NAND2_X1
I25 (A_25 B_25 gn25 VDD VSS) NAND2_X1
I26 (A_26 B_26 gn26 VDD VSS) NAND2_X1
I27 (A_27 B_27 gn27 VDD VSS) NAND2_X1
I28 (A_28 B_28 gn28 VDD VSS) NAND2_X1
I29 (A_29 B_29 gn29 VDD VSS) NAND2_X1
I30 (A_30 B_30 gn30 VDD VSS) NAND2_X1
I31 (A_31 B_31 gn31 VDD VSS) NAND2_X1
I32 (A_32 B_32 gn32 VDD VSS) NAND2_X1
I33 (A_33 B_33 gn33 VDD VSS) NAND2_X1
I34 (A_34 B_34 gn34 VDD VSS) NAND2_X1
I35 (A_35 B_35 gn35 VDD VSS) NAND2_X1
I36 (A_36 B_36 gn36 VDD VSS) NAND2_X1
I37 (A_37 B_37 gn37 VDD VSS) NAND2_X1
I38 (A_38 B_38 gn38 VDD VSS) NAND2_X1
I39 (A_39 B_39 gn39 VDD VSS) NAND2_X1
I40 (A_40 B_40 gn40 VDD VSS) NAND2_X1
I41 (A_41 B_41 gn41 VDD VSS) NAND2_X1
I42 (A_42 B_42 gn42 VDD VSS) NAND2_X1
I43 (A_43 B_43 gn43 VDD VSS) NAND2_X1
I44 (A_44 B_44 gn44 VDD VSS) NAND2_X1
I45 (A_45 B_45 gn45 VDD VSS) NAND2_X1
I46 (A_46 B_46 gn46 VDD VSS) NAND2_X1
I47 (A_47 B_47 gn47 VDD VSS) NAND2_X1
I48 (A_48 B_48 gn48 VDD VSS) NAND2_X1
I49 (A_49 B_49 gn49 VDD VSS) NAND2_X1
I50 (A_50 B_50 gn50 VDD VSS) NAND2_X1
I51 (A_51 B_51 gn51 VDD VSS) NAND2_X1
I52 (A_52 B_52 gn52 VDD VSS) NAND2_X1
I53 (A_53 B_53 gn53 VDD VSS) NAND2_X1
I54 (A_54 B_54 gn54 VDD VSS) NAND2_X1
I55 (A_55 B_55 gn55 VDD VSS) NAND2_X1
I56 (A_56 B_56 gn56 VDD VSS) NAND2_X1
I57 (A_57 B_57 gn57 VDD VSS) NAND2_X1
I58 (A_58 B_58 gn58 VDD VSS) NAND2_X1
I59 (A_59 B_59 gn59 VDD VSS) NAND2_X1
I60 (A_60 B_60 gn60 VDD VSS) NAND2_X1
I61 (A_61 B_61 gn61 VDD VSS) NAND2_X1
I62 (A_62 B_62 gn62 VDD VSS) NAND2_X1
I63 (A_63 B_63 gn63 VDD VSS) NAND2_X1
I64 (A_0 B_0 pn0 VDD VSS) XNOR2_X1
I65 (A_1 B_1 pn1 VDD VSS) XNOR2_X1
I66 (A_2 B_2 pn2 VDD VSS) XNOR2_X1
I67 (A_3 B_3 pn3 VDD VSS) XNOR2_X1
I68 (A_4 B_4 pn4 VDD VSS) XNOR2_X1
I69 (A_5 B_5 pn5 VDD VSS) XNOR2_X1
I70 (A_6 B_6 pn6 VDD VSS) XNOR2_X1
I71 (A_7 B_7 pn7 VDD VSS) XNOR2_X1
I72 (A_8 B_8 pn8 VDD VSS) XNOR2_X1
I73 (A_9 B_9 pn9 VDD VSS) XNOR2_X1
I74 (A_10 B_10 pn10 VDD VSS) XNOR2_X1
I75 (A_11 B_11 pn11 VDD VSS) XNOR2_X1
I76 (A_12 B_12 pn12 VDD VSS) XNOR2_X1
I77 (A_13 B_13 pn13 VDD VSS) XNOR2_X1
I78 (A_14 B_14 pn14 VDD VSS) XNOR2_X1
I79 (A_15 B_15 pn15 VDD VSS) XNOR2_X1
I80 (A_16 B_16 pn16 VDD VSS) XNOR2_X1
I81 (A_17 B_17 pn17 VDD VSS) XNOR2_X1
I82 (A_18 B_18 pn18 VDD VSS) XNOR2_X1
I83 (A_19 B_19 pn19 VDD VSS) XNOR2_X1
I84 (A_20 B_20 pn20 VDD VSS) XNOR2_X1
I85 (A_21 B_21 pn21 VDD VSS) XNOR2_X1
I86 (A_22 B_22 pn22 VDD VSS) XNOR2_X1
I87 (A_23 B_23 pn23 VDD VSS) XNOR2_X1
I88 (A_24 B_24 pn24 VDD VSS) XNOR2_X1
I89 (A_25 B_25 pn25 VDD VSS) XNOR2_X1
I90 (A_26 B_26 pn26 VDD VSS) XNOR2_X1
I91 (A_27 B_27 pn27 VDD VSS) XNOR2_X1
I92 (A_28 B_28 pn28 VDD VSS) XNOR2_X1
I93 (A_29 B_29 pn29 VDD VSS) XNOR2_X1
I94 (A_30 B_30 pn30 VDD VSS) XNOR2_X1
I95 (A_31 B_31 pn31 VDD VSS) XNOR2_X1
I96 (A_32 B_32 pn32 VDD VSS) XNOR2_X1
I97 (A_33 B_33 pn33 VDD VSS) XNOR2_X1
I98 (A_34 B_34 pn34 VDD VSS) XNOR2_X1
I99 (A_35 B_35 pn35 VDD VSS) XNOR2_X1
I100 (A_36 B_36 pn36 VDD VSS) XNOR2_X1
I101 (A_37 B_37 pn37 VDD VSS) XNOR2_X1
I102 (A_38 B_38 pn38 VDD VSS) XNOR2_X1
I103 (A_39 B_39 pn39 VDD VSS) XNOR2_X1
I104 (A_40 B_40 pn40 VDD VSS) XNOR2_X1
I105 (A_41 B_41 pn41 VDD VSS) XNOR2_X1
I106 (A_42 B_42 pn42 VDD VSS) XNOR2_X1
I107 (A_43 B_43 pn43 VDD VSS) XNOR2_X1
I108 (A_44 B_44 pn44 VDD VSS) XNOR2_X1
I109 (A_45 B_45 pn45 VDD VSS) XNOR2_X1
I110 (A_46 B_46 pn46 VDD VSS) XNOR2_X1
I111 (A_47 B_47 pn47 VDD VSS) XNOR2_X1
I112 (A_48 B_48 pn48 VDD VSS) XNOR2_X1
I113 (A_49 B_49 pn49 VDD VSS) XNOR2_X1
I114 (A_50 B_50 pn50 VDD VSS) XNOR2_X1
I115 (A_51 B_51 pn51 VDD VSS) XNOR2_X1
I116 (A_52 B_52 pn52 VDD VSS) XNOR2_X1
I117 (A_53 B_53 pn53 VDD VSS) XNOR2_X1
I118 (A_54 B_54 pn54 VDD VSS) XNOR2_X1
I119 (A_55 B_55 pn55 VDD VSS) XNOR2_X1
I120 (A_56 B_56 pn56 VDD VSS) XNOR2_X1
I121 (A_57 B_57 pn57 VDD VSS) XNOR2_X1
I122 (A_58 B_58 pn58 VDD VSS) XNOR2_X1
I123 (A_59 B_59 pn59 VDD VSS) XNOR2_X1
I124 (A_60 B_60 pn60 VDD VSS) XNOR2_X1
I125 (A_61 B_61 pn61 VDD VSS) XNOR2_X1
I126 (A_62 B_62 pn62 VDD VSS) XNOR2_X1
I127 (A_63 B_63 pn63 VDD VSS) XNOR2_X1
I128 (CIN cinn VDD VSS) INV_X1
I129 (gn0 pn0 cinn G0_0 VDD VSS) GRY_N
I130 (G0_0 G0_0n VDD VSS) INV_X1
I131 (gn1 pn1 G0_0n G1_0 VDD VSS) GRY_N
I132 (gn2 pn2 gn1 pn1 G2_1 P2_1 VDD VSS) BLK_N
I133 (gn3 pn3 gn2 pn2 G3_2 P3_2 VDD VSS) BLK_N
I134 (gn4 pn4 gn3 pn3 G4_3 P4_3 VDD VSS) BLK_N
I135 (gn5 pn5 gn4 pn4 G5_4 P5_4 VDD VSS) BLK_N
I136 (gn6 pn6 gn5 pn5 G6_5 P6_5 VDD VSS) BLK_N
I137 (gn7 pn7 gn6 pn6 G7_6 P7_6 VDD VSS) BLK_N
I138 (gn8 pn8 gn7 pn7 G8_7 P8_7 VDD VSS) BLK_N
I139 (gn9 pn9 gn8 pn8 G9_8 P9_8 VDD VSS) BLK_N
I140 (gn10 pn10 gn9 pn9 G10_9 P10_9 VDD VSS) BLK_N
I141 (gn11 pn11 gn10 pn10 G11_10 P11_10 VDD VSS) BLK_N
I142 (gn12 pn12 gn11 pn11 G12_11 P12_11 VDD VSS) BLK_N
I143 (gn13 pn13 gn12 pn12 G13_12 P13_12 VDD VSS) BLK_N
I144 (gn14 pn14 gn13 pn13 G14_13 P14_13 VDD VSS) BLK_N
I145 (gn15 pn15 gn14 pn14 G15_14 P15_14 VDD VSS) BLK_N
I146 (gn16 pn16 gn15 pn15 G16_15 P16_15 VDD VSS) BLK_N
I147 (gn17 pn17 gn16 pn16 G17_16 P17_16 VDD VSS) BLK_N
I148 (gn18 pn18 gn17 pn17 G18_17 P18_17 VDD VSS) BLK_N
I149 (gn19 pn19 gn18 pn18 G19_18 P19_18 VDD VSS) BLK_N
I150 (gn20 pn20 gn19 pn19 G20_19 P20_19 VDD VSS) BLK_N
I151 (gn21 pn21 gn20 pn20 G21_20 P21_20 VDD VSS) BLK_N
I152 (gn22 pn22 gn21 pn21 G22_21 P22_21 VDD VSS) BLK_N
I153 (gn23 pn23 gn22 pn22 G23_22 P23_22 VDD VSS) BLK_N
I154 (gn24 pn24 gn23 pn23 G24_23 P24_23 VDD VSS) BLK_N
I155 (gn25 pn25 gn24 pn24 G25_24 P25_24 VDD VSS) BLK_N
I156 (gn26 pn26 gn25 pn25 G26_25 P26_25 VDD VSS) BLK_N
I157 (gn27 pn27 gn26 pn26 G27_26 P27_26 VDD VSS) BLK_N
I158 (gn28 pn28 gn27 pn27 G28_27 P28_27 VDD VSS) BLK_N
I159 (gn29 pn29 gn28 pn28 G29_28 P29_28 VDD VSS) BLK_N
I160 (gn30 pn30 gn29 pn29 G30_29 P30_29 VDD VSS) BLK_N
I161 (gn31 pn31 gn30 pn30 G31_30 P31_30 VDD VSS) BLK_N
I162 (gn32 pn32 gn31 pn31 G32_31 P32_31 VDD VSS) BLK_N
I163 (gn33 pn33 gn32 pn32 G33_32 P33_32 VDD VSS) BLK_N
I164 (gn34 pn34 gn33 pn33 G34_33 P34_33 VDD VSS) BLK_N
I165 (gn35 pn35 gn34 pn34 G35_34 P35_34 VDD VSS) BLK_N
I166 (gn36 pn36 gn35 pn35 G36_35 P36_35 VDD VSS) BLK_N
I167 (gn37 pn37 gn36 pn36 G37_36 P37_36 VDD VSS) BLK_N
I168 (gn38 pn38 gn37 pn37 G38_37 P38_37 VDD VSS) BLK_N
I169 (gn39 pn39 gn38 pn38 G39_38 P39_38 VDD VSS) BLK_N
I170 (gn40 pn40 gn39 pn39 G40_39 P40_39 VDD VSS) BLK_N
I171 (gn41 pn41 gn40 pn40 G41_40 P41_40 VDD VSS) BLK_N
I172 (gn42 pn42 gn41 pn41 G42_41 P42_41 VDD VSS) BLK_N
I173 (gn43 pn43 gn42 pn42 G43_42 P43_42 VDD VSS) BLK_N
I174 (gn44 pn44 gn43 pn43 G44_43 P44_43 VDD VSS) BLK_N
I175 (gn45 pn45 gn44 pn44 G45_44 P45_44 VDD VSS) BLK_N
I176 (gn46 pn46 gn45 pn45 G46_45 P46_45 VDD VSS) BLK_N
I177 (gn47 pn47 gn46 pn46 G47_46 P47_46 VDD VSS) BLK_N
I178 (gn48 pn48 gn47 pn47 G48_47 P48_47 VDD VSS) BLK_N
I179 (gn49 pn49 gn48 pn48 G49_48 P49_48 VDD VSS) BLK_N
I180 (gn50 pn50 gn49 pn49 G50_49 P50_49 VDD VSS) BLK_N
I181 (gn51 pn51 gn50 pn50 G51_50 P51_50 VDD VSS) BLK_N
I182 (gn52 pn52 gn51 pn51 G52_51 P52_51 VDD VSS) BLK_N
I183 (gn53 pn53 gn52 pn52 G53_52 P53_52 VDD VSS) BLK_N
I184 (gn54 pn54 gn53 pn53 G54_53 P54_53 VDD VSS) BLK_N
I185 (gn55 pn55 gn54 pn54 G55_54 P55_54 VDD VSS) BLK_N
I186 (gn56 pn56 gn55 pn55 G56_55 P56_55 VDD VSS) BLK_N
I187 (gn57 pn57 gn56 pn56 G57_56 P57_56 VDD VSS) BLK_N
I188 (gn58 pn58 gn57 pn57 G58_57 P58_57 VDD VSS) BLK_N
I189 (gn59 pn59 gn58 pn58 G59_58 P59_58 VDD VSS) BLK_N
I190 (gn60 pn60 gn59 pn59 G60_59 P60_59 VDD VSS) BLK_N
I191 (gn61 pn61 gn60 pn60 G61_60 P61_60 VDD VSS) BLK_N
I192 (gn62 pn62 gn61 pn61 G62_61 P62_61 VDD VSS) BLK_N
I193 (gn63 pn63 gn62 pn62 G63_62 P63_62 VDD VSS) BLK_N
I194 (G2_1 P2_1 G0_0 G2_0n VDD VSS) GRY_P
I195 (G3_2 P3_2 G1_0 G3_0n VDD VSS) GRY_P
I196 (G4_3 P4_3 G2_1 P2_1 G4_1n P4_1n VDD VSS) BLK_P
I197 (G5_4 P5_4 G3_2 P3_2 G5_2n P5_2n VDD VSS) BLK_P
I198 (G6_5 P6_5 G4_3 P4_3 G6_3n P6_3n VDD VSS) BLK_P
I199 (G7_6 P7_6 G5_4 P5_4 G7_4n P7_4n VDD VSS) BLK_P
I200 (G8_7 P8_7 G6_5 P6_5 G8_5n P8_5n VDD VSS) BLK_P
I201 (G9_8 P9_8 G7_6 P7_6 G9_6n P9_6n VDD VSS) BLK_P
I202 (G10_9 P10_9 G8_7 P8_7 G10_7n P10_7n VDD VSS) BLK_P
I203 (G11_10 P11_10 G9_8 P9_8 G11_8n P11_8n VDD VSS) BLK_P
I204 (G12_11 P12_11 G10_9 P10_9 G12_9n P12_9n VDD VSS) BLK_P
I205 (G13_12 P13_12 G11_10 P11_10 G13_10n P13_10n VDD VSS) BLK_P
I206 (G14_13 P14_13 G12_11 P12_11 G14_11n P14_11n VDD VSS) BLK_P
I207 (G15_14 P15_14 G13_12 P13_12 G15_12n P15_12n VDD VSS) BLK_P
I208 (G16_15 P16_15 G14_13 P14_13 G16_13n P16_13n VDD VSS) BLK_P
I209 (G17_16 P17_16 G15_14 P15_14 G17_14n P17_14n VDD VSS) BLK_P
I210 (G18_17 P18_17 G16_15 P16_15 G18_15n P18_15n VDD VSS) BLK_P
I211 (G19_18 P19_18 G17_16 P17_16 G19_16n P19_16n VDD VSS) BLK_P
I212 (G20_19 P20_19 G18_17 P18_17 G20_17n P20_17n VDD VSS) BLK_P
I213 (G21_20 P21_20 G19_18 P19_18 G21_18n P21_18n VDD VSS) BLK_P
I214 (G22_21 P22_21 G20_19 P20_19 G22_19n P22_19n VDD VSS) BLK_P
I215 (G23_22 P23_22 G21_20 P21_20 G23_20n P23_20n VDD VSS) BLK_P
I216 (G24_23 P24_23 G22_21 P22_21 G24_21n P24_21n VDD VSS) BLK_P
I217 (G25_24 P25_24 G23_22 P23_22 G25_22n P25_22n VDD VSS) BLK_P
I218 (G26_25 P26_25 G24_23 P24_23 G26_23n P26_23n VDD VSS) BLK_P
I219 (G27_26 P27_26 G25_24 P25_24 G27_24n P27_24n VDD VSS) BLK_P
I220 (G28_27 P28_27 G26_25 P26_25 G28_25n P28_25n VDD VSS) BLK_P
I221 (G29_28 P29_28 G27_26 P27_26 G29_26n P29_26n VDD VSS) BLK_P
I222 (G30_29 P30_29 G28_27 P28_27 G30_27n P30_27n VDD VSS) BLK_P
I223 (G31_30 P31_30 G29_28 P29_28 G31_28n P31_28n VDD VSS) BLK_P
I224 (G32_31 P32_31 G30_29 P30_29 G32_29n P32_29n VDD VSS) BLK_P
I225 (G33_32 P33_32 G31_30 P31_30 G33_30n P33_30n VDD VSS) BLK_P
I226 (G34_33 P34_33 G32_31 P32_31 G34_31n P34_31n VDD VSS) BLK_P
I227 (G35_34 P35_34 G33_32 P33_32 G35_32n P35_32n VDD VSS) BLK_P
I228 (G36_35 P36_35 G34_33 P34_33 G36_33n P36_33n VDD VSS) BLK_P
I229 (G37_36 P37_36 G35_34 P35_34 G37_34n P37_34n VDD VSS) BLK_P
I230 (G38_37 P38_37 G36_35 P36_35 G38_35n P38_35n VDD VSS) BLK_P
I231 (G39_38 P39_38 G37_36 P37_36 G39_36n P39_36n VDD VSS) BLK_P
I232 (G40_39 P40_39 G38_37 P38_37 G40_37n P40_37n VDD VSS) BLK_P
I233 (G41_40 P41_40 G39_38 P39_38 G41_38n P41_38n VDD VSS) BLK_P
I234 (G42_41 P42_41 G40_39 P40_39 G42_39n P42_39n VDD VSS) BLK_P
I235 (G43_42 P43_42 G41_40 P41_40 G43_40n P43_40n VDD VSS) BLK_P
I236 (G44_43 P44_43 G42_41 P42_41 G44_41n P44_41n VDD VSS) BLK_P
I237 (G45_44 P45_44 G43_42 P43_42 G45_42n P45_42n VDD VSS) BLK_P
I238 (G46_45 P46_45 G44_43 P44_43 G46_43n P46_43n VDD VSS) BLK_P
I239 (G47_46 P47_46 G45_44 P45_44 G47_44n P47_44n VDD VSS) BLK_P
I240 (G48_47 P48_47 G46_45 P46_45 G48_45n P48_45n VDD VSS) BLK_P
I241 (G49_48 P49_48 G47_46 P47_46 G49_46n P49_46n VDD VSS) BLK_P
I242 (G50_49 P50_49 G48_47 P48_47 G50_47n P50_47n VDD VSS) BLK_P
I243 (G51_50 P51_50 G49_48 P49_48 G51_48n P51_48n VDD VSS) BLK_P
I244 (G52_51 P52_51 G50_49 P50_49 G52_49n P52_49n VDD VSS) BLK_P
I245 (G53_52 P53_52 G51_50 P51_50 G53_50n P53_50n VDD VSS) BLK_P
I246 (G54_53 P54_53 G52_51 P52_51 G54_51n P54_51n VDD VSS) BLK_P
I247 (G55_54 P55_54 G53_52 P53_52 G55_52n P55_52n VDD VSS) BLK_P
I248 (G56_55 P56_55 G54_53 P54_53 G56_53n P56_53n VDD VSS) BLK_P
I249 (G57_56 P57_56 G55_54 P55_54 G57_54n P57_54n VDD VSS) BLK_P
I250 (G58_57 P58_57 G56_55 P56_55 G58_55n P58_55n VDD VSS) BLK_P
I251 (G59_58 P59_58 G57_56 P57_56 G59_56n P59_56n VDD VSS) BLK_P
I252 (G60_59 P60_59 G58_57 P58_57 G60_57n P60_57n VDD VSS) BLK_P
I253 (G61_60 P61_60 G59_58 P59_58 G61_58n P61_58n VDD VSS) BLK_P
I254 (G62_61 P62_61 G60_59 P60_59 G62_59n P62_59n VDD VSS) BLK_P
I255 (G63_62 P63_62 G61_60 P61_60 G63_60n P63_60n VDD VSS) BLK_P
I256 (G4_1n P4_1n G0_0n G4_0 VDD VSS) GRY_N
I257 (G1_0 G1_0n VDD VSS) INV_X1
I258 (G5_2n P5_2n G1_0n G5_0 VDD VSS) GRY_N
I259 (G6_3n P6_3n G2_0n G6_0 VDD VSS) GRY_N
I260 (G7_4n P7_4n G3_0n G7_0 VDD VSS) GRY_N
I261 (G8_5n P8_5n G4_1n P4_1n G8_1 P8_1 VDD VSS) BLK_N
I262 (G9_6n P9_6n G5_2n P5_2n G9_2 P9_2 VDD VSS) BLK_N
I263 (G10_7n P10_7n G6_3n P6_3n G10_3 P10_3 VDD VSS) BLK_N
I264 (G11_8n P11_8n G7_4n P7_4n G11_4 P11_4 VDD VSS) BLK_N
I265 (G12_9n P12_9n G8_5n P8_5n G12_5 P12_5 VDD VSS) BLK_N
I266 (G13_10n P13_10n G9_6n P9_6n G13_6 P13_6 VDD VSS) BLK_N
I267 (G14_11n P14_11n G10_7n P10_7n G14_7 P14_7 VDD VSS) BLK_N
I268 (G15_12n P15_12n G11_8n P11_8n G15_8 P15_8 VDD VSS) BLK_N
I269 (G16_13n P16_13n G12_9n P12_9n G16_9 P16_9 VDD VSS) BLK_N
I270 (G17_14n P17_14n G13_10n P13_10n G17_10 P17_10 VDD VSS) BLK_N
I271 (G18_15n P18_15n G14_11n P14_11n G18_11 P18_11 VDD VSS) BLK_N
I272 (G19_16n P19_16n G15_12n P15_12n G19_12 P19_12 VDD VSS) BLK_N
I273 (G20_17n P20_17n G16_13n P16_13n G20_13 P20_13 VDD VSS) BLK_N
I274 (G21_18n P21_18n G17_14n P17_14n G21_14 P21_14 VDD VSS) BLK_N
I275 (G22_19n P22_19n G18_15n P18_15n G22_15 P22_15 VDD VSS) BLK_N
I276 (G23_20n P23_20n G19_16n P19_16n G23_16 P23_16 VDD VSS) BLK_N
I277 (G24_21n P24_21n G20_17n P20_17n G24_17 P24_17 VDD VSS) BLK_N
I278 (G25_22n P25_22n G21_18n P21_18n G25_18 P25_18 VDD VSS) BLK_N
I279 (G26_23n P26_23n G22_19n P22_19n G26_19 P26_19 VDD VSS) BLK_N
I280 (G27_24n P27_24n G23_20n P23_20n G27_20 P27_20 VDD VSS) BLK_N
I281 (G28_25n P28_25n G24_21n P24_21n G28_21 P28_21 VDD VSS) BLK_N
I282 (G29_26n P29_26n G25_22n P25_22n G29_22 P29_22 VDD VSS) BLK_N
I283 (G30_27n P30_27n G26_23n P26_23n G30_23 P30_23 VDD VSS) BLK_N
I284 (G31_28n P31_28n G27_24n P27_24n G31_24 P31_24 VDD VSS) BLK_N
I285 (G32_29n P32_29n G28_25n P28_25n G32_25 P32_25 VDD VSS) BLK_N
I286 (G33_30n P33_30n G29_26n P29_26n G33_26 P33_26 VDD VSS) BLK_N
I287 (G34_31n P34_31n G30_27n P30_27n G34_27 P34_27 VDD VSS) BLK_N
I288 (G35_32n P35_32n G31_28n P31_28n G35_28 P35_28 VDD VSS) BLK_N
I289 (G36_33n P36_33n G32_29n P32_29n G36_29 P36_29 VDD VSS) BLK_N
I290 (G37_34n P37_34n G33_30n P33_30n G37_30 P37_30 VDD VSS) BLK_N
I291 (G38_35n P38_35n G34_31n P34_31n G38_31 P38_31 VDD VSS) BLK_N
I292 (G39_36n P39_36n G35_32n P35_32n G39_32 P39_32 VDD VSS) BLK_N
I293 (G40_37n P40_37n G36_33n P36_33n G40_33 P40_33 VDD VSS) BLK_N
I294 (G41_38n P41_38n G37_34n P37_34n G41_34 P41_34 VDD VSS) BLK_N
I295 (G42_39n P42_39n G38_35n P38_35n G42_35 P42_35 VDD VSS) BLK_N
I296 (G43_40n P43_40n G39_36n P39_36n G43_36 P43_36 VDD VSS) BLK_N
I297 (G44_41n P44_41n G40_37n P40_37n G44_37 P44_37 VDD VSS) BLK_N
I298 (G45_42n P45_42n G41_38n P41_38n G45_38 P45_38 VDD VSS) BLK_N
I299 (G46_43n P46_43n G42_39n P42_39n G46_39 P46_39 VDD VSS) BLK_N
I300 (G47_44n P47_44n G43_40n P43_40n G47_40 P47_40 VDD VSS) BLK_N
I301 (G48_45n P48_45n G44_41n P44_41n G48_41 P48_41 VDD VSS) BLK_N
I302 (G49_46n P49_46n G45_42n P45_42n G49_42 P49_42 VDD VSS) BLK_N
I303 (G50_47n P50_47n G46_43n P46_43n G50_43 P50_43 VDD VSS) BLK_N
I304 (G51_48n P51_48n G47_44n P47_44n G51_44 P51_44 VDD VSS) BLK_N
I305 (G52_49n P52_49n G48_45n P48_45n G52_45 P52_45 VDD VSS) BLK_N
I306 (G53_50n P53_50n G49_46n P49_46n G53_46 P53_46 VDD VSS) BLK_N
I307 (G54_51n P54_51n G50_47n P50_47n G54_47 P54_47 VDD VSS) BLK_N
I308 (G55_52n P55_52n G51_48n P51_48n G55_48 P55_48 VDD VSS) BLK_N
I309 (G56_53n P56_53n G52_49n P52_49n G56_49 P56_49 VDD VSS) BLK_N
I310 (G57_54n P57_54n G53_50n P53_50n G57_50 P57_50 VDD VSS) BLK_N
I311 (G58_55n P58_55n G54_51n P54_51n G58_51 P58_51 VDD VSS) BLK_N
I312 (G59_56n P59_56n G55_52n P55_52n G59_52 P59_52 VDD VSS) BLK_N
I313 (G60_57n P60_57n G56_53n P56_53n G60_53 P60_53 VDD VSS) BLK_N
I314 (G61_58n P61_58n G57_54n P57_54n G61_54 P61_54 VDD VSS) BLK_N
I315 (G62_59n P62_59n G58_55n P58_55n G62_55 P62_55 VDD VSS) BLK_N
I316 (G63_60n P63_60n G59_56n P59_56n G63_56 P63_56 VDD VSS) BLK_N
I317 (G8_1 P8_1 G0_0 G8_0n VDD VSS) GRY_P
I318 (G9_2 P9_2 G1_0 G9_0n VDD VSS) GRY_P
I319 (G2_0n G2_0np VDD VSS) INV_X1
I320 (G10_3 P10_3 G2_0np G10_0n VDD VSS) GRY_P
I321 (G3_0n G3_0np VDD VSS) INV_X1
I322 (G11_4 P11_4 G3_0np G11_0n VDD VSS) GRY_P
I323 (G12_5 P12_5 G4_0 G12_0n VDD VSS) GRY_P
I324 (G13_6 P13_6 G5_0 G13_0n VDD VSS) GRY_P
I325 (G14_7 P14_7 G6_0 G14_0n VDD VSS) GRY_P
I326 (G15_8 P15_8 G7_0 G15_0n VDD VSS) GRY_P
I327 (G16_9 P16_9 G8_1 P8_1 G16_1n P16_1n VDD VSS) BLK_P
I328 (G17_10 P17_10 G9_2 P9_2 G17_2n P17_2n VDD VSS) BLK_P
I329 (G18_11 P18_11 G10_3 P10_3 G18_3n P18_3n VDD VSS) BLK_P
I330 (G19_12 P19_12 G11_4 P11_4 G19_4n P19_4n VDD VSS) BLK_P
I331 (G20_13 P20_13 G12_5 P12_5 G20_5n P20_5n VDD VSS) BLK_P
I332 (G21_14 P21_14 G13_6 P13_6 G21_6n P21_6n VDD VSS) BLK_P
I333 (G22_15 P22_15 G14_7 P14_7 G22_7n P22_7n VDD VSS) BLK_P
I334 (G23_16 P23_16 G15_8 P15_8 G23_8n P23_8n VDD VSS) BLK_P
I335 (G24_17 P24_17 G16_9 P16_9 G24_9n P24_9n VDD VSS) BLK_P
I336 (G25_18 P25_18 G17_10 P17_10 G25_10n P25_10n VDD VSS) BLK_P
I337 (G26_19 P26_19 G18_11 P18_11 G26_11n P26_11n VDD VSS) BLK_P
I338 (G27_20 P27_20 G19_12 P19_12 G27_12n P27_12n VDD VSS) BLK_P
I339 (G28_21 P28_21 G20_13 P20_13 G28_13n P28_13n VDD VSS) BLK_P
I340 (G29_22 P29_22 G21_14 P21_14 G29_14n P29_14n VDD VSS) BLK_P
I341 (G30_23 P30_23 G22_15 P22_15 G30_15n P30_15n VDD VSS) BLK_P
I342 (G31_24 P31_24 G23_16 P23_16 G31_16n P31_16n VDD VSS) BLK_P
I343 (G32_25 P32_25 G24_17 P24_17 G32_17n P32_17n VDD VSS) BLK_P
I344 (G33_26 P33_26 G25_18 P25_18 G33_18n P33_18n VDD VSS) BLK_P
I345 (G34_27 P34_27 G26_19 P26_19 G34_19n P34_19n VDD VSS) BLK_P
I346 (G35_28 P35_28 G27_20 P27_20 G35_20n P35_20n VDD VSS) BLK_P
I347 (G36_29 P36_29 G28_21 P28_21 G36_21n P36_21n VDD VSS) BLK_P
I348 (G37_30 P37_30 G29_22 P29_22 G37_22n P37_22n VDD VSS) BLK_P
I349 (G38_31 P38_31 G30_23 P30_23 G38_23n P38_23n VDD VSS) BLK_P
I350 (G39_32 P39_32 G31_24 P31_24 G39_24n P39_24n VDD VSS) BLK_P
I351 (G40_33 P40_33 G32_25 P32_25 G40_25n P40_25n VDD VSS) BLK_P
I352 (G41_34 P41_34 G33_26 P33_26 G41_26n P41_26n VDD VSS) BLK_P
I353 (G42_35 P42_35 G34_27 P34_27 G42_27n P42_27n VDD VSS) BLK_P
I354 (G43_36 P43_36 G35_28 P35_28 G43_28n P43_28n VDD VSS) BLK_P
I355 (G44_37 P44_37 G36_29 P36_29 G44_29n P44_29n VDD VSS) BLK_P
I356 (G45_38 P45_38 G37_30 P37_30 G45_30n P45_30n VDD VSS) BLK_P
I357 (G46_39 P46_39 G38_31 P38_31 G46_31n P46_31n VDD VSS) BLK_P
I358 (G47_40 P47_40 G39_32 P39_32 G47_32n P47_32n VDD VSS) BLK_P
I359 (G48_41 P48_41 G40_33 P40_33 G48_33n P48_33n VDD VSS) BLK_P
I360 (G49_42 P49_42 G41_34 P41_34 G49_34n P49_34n VDD VSS) BLK_P
I361 (G50_43 P50_43 G42_35 P42_35 G50_35n P50_35n VDD VSS) BLK_P
I362 (G51_44 P51_44 G43_36 P43_36 G51_36n P51_36n VDD VSS) BLK_P
I363 (G52_45 P52_45 G44_37 P44_37 G52_37n P52_37n VDD VSS) BLK_P
I364 (G53_46 P53_46 G45_38 P45_38 G53_38n P53_38n VDD VSS) BLK_P
I365 (G54_47 P54_47 G46_39 P46_39 G54_39n P54_39n VDD VSS) BLK_P
I366 (G55_48 P55_48 G47_40 P47_40 G55_40n P55_40n VDD VSS) BLK_P
I367 (G56_49 P56_49 G48_41 P48_41 G56_41n P56_41n VDD VSS) BLK_P
I368 (G57_50 P57_50 G49_42 P49_42 G57_42n P57_42n VDD VSS) BLK_P
I369 (G58_51 P58_51 G50_43 P50_43 G58_43n P58_43n VDD VSS) BLK_P
I370 (G59_52 P59_52 G51_44 P51_44 G59_44n P59_44n VDD VSS) BLK_P
I371 (G60_53 P60_53 G52_45 P52_45 G60_45n P60_45n VDD VSS) BLK_P
I372 (G61_54 P61_54 G53_46 P53_46 G61_46n P61_46n VDD VSS) BLK_P
I373 (G62_55 P62_55 G54_47 P54_47 G62_47n P62_47n VDD VSS) BLK_P
I374 (G63_56 P63_56 G55_48 P55_48 G63_48n P63_48n VDD VSS) BLK_P
I375 (G16_1n P16_1n G0_0n G16_0 VDD VSS) GRY_N
I376 (G17_2n P17_2n G1_0n G17_0 VDD VSS) GRY_N
I377 (G18_3n P18_3n G2_0n G18_0 VDD VSS) GRY_N
I378 (G19_4n P19_4n G3_0n G19_0 VDD VSS) GRY_N
I379 (G4_0 G4_0n VDD VSS) INV_X1
I380 (G20_5n P20_5n G4_0n G20_0 VDD VSS) GRY_N
I381 (G5_0 G5_0n VDD VSS) INV_X1
I382 (G21_6n P21_6n G5_0n G21_0 VDD VSS) GRY_N
I383 (G6_0 G6_0n VDD VSS) INV_X1
I384 (G22_7n P22_7n G6_0n G22_0 VDD VSS) GRY_N
I385 (G7_0 G7_0n VDD VSS) INV_X1
I386 (G23_8n P23_8n G7_0n G23_0 VDD VSS) GRY_N
I387 (G24_9n P24_9n G8_0n G24_0 VDD VSS) GRY_N
I388 (G25_10n P25_10n G9_0n G25_0 VDD VSS) GRY_N
I389 (G26_11n P26_11n G10_0n G26_0 VDD VSS) GRY_N
I390 (G27_12n P27_12n G11_0n G27_0 VDD VSS) GRY_N
I391 (G28_13n P28_13n G12_0n G28_0 VDD VSS) GRY_N
I392 (G29_14n P29_14n G13_0n G29_0 VDD VSS) GRY_N
I393 (G30_15n P30_15n G14_0n G30_0 VDD VSS) GRY_N
I394 (G31_16n P31_16n G15_0n G31_0 VDD VSS) GRY_N
I395 (G32_17n P32_17n G16_1n P16_1n G32_1 P32_1 VDD VSS) BLK_N
I396 (G33_18n P33_18n G17_2n P17_2n G33_2 P33_2 VDD VSS) BLK_N
I397 (G34_19n P34_19n G18_3n P18_3n G34_3 P34_3 VDD VSS) BLK_N
I398 (G35_20n P35_20n G19_4n P19_4n G35_4 P35_4 VDD VSS) BLK_N
I399 (G36_21n P36_21n G20_5n P20_5n G36_5 P36_5 VDD VSS) BLK_N
I400 (G37_22n P37_22n G21_6n P21_6n G37_6 P37_6 VDD VSS) BLK_N
I401 (G38_23n P38_23n G22_7n P22_7n G38_7 P38_7 VDD VSS) BLK_N
I402 (G39_24n P39_24n G23_8n P23_8n G39_8 P39_8 VDD VSS) BLK_N
I403 (G40_25n P40_25n G24_9n P24_9n G40_9 P40_9 VDD VSS) BLK_N
I404 (G41_26n P41_26n G25_10n P25_10n G41_10 P41_10 VDD VSS) BLK_N
I405 (G42_27n P42_27n G26_11n P26_11n G42_11 P42_11 VDD VSS) BLK_N
I406 (G43_28n P43_28n G27_12n P27_12n G43_12 P43_12 VDD VSS) BLK_N
I407 (G44_29n P44_29n G28_13n P28_13n G44_13 P44_13 VDD VSS) BLK_N
I408 (G45_30n P45_30n G29_14n P29_14n G45_14 P45_14 VDD VSS) BLK_N
I409 (G46_31n P46_31n G30_15n P30_15n G46_15 P46_15 VDD VSS) BLK_N
I410 (G47_32n P47_32n G31_16n P31_16n G47_16 P47_16 VDD VSS) BLK_N
I411 (G48_33n P48_33n G32_17n P32_17n G48_17 P48_17 VDD VSS) BLK_N
I412 (G49_34n P49_34n G33_18n P33_18n G49_18 P49_18 VDD VSS) BLK_N
I413 (G50_35n P50_35n G34_19n P34_19n G50_19 P50_19 VDD VSS) BLK_N
I414 (G51_36n P51_36n G35_20n P35_20n G51_20 P51_20 VDD VSS) BLK_N
I415 (G52_37n P52_37n G36_21n P36_21n G52_21 P52_21 VDD VSS) BLK_N
I416 (G53_38n P53_38n G37_22n P37_22n G53_22 P53_22 VDD VSS) BLK_N
I417 (G54_39n P54_39n G38_23n P38_23n G54_23 P54_23 VDD VSS) BLK_N
I418 (G55_40n P55_40n G39_24n P39_24n G55_24 P55_24 VDD VSS) BLK_N
I419 (G56_41n P56_41n G40_25n P40_25n G56_25 P56_25 VDD VSS) BLK_N
I420 (G57_42n P57_42n G41_26n P41_26n G57_26 P57_26 VDD VSS) BLK_N
I421 (G58_43n P58_43n G42_27n P42_27n G58_27 P58_27 VDD VSS) BLK_N
I422 (G59_44n P59_44n G43_28n P43_28n G59_28 P59_28 VDD VSS) BLK_N
I423 (G60_45n P60_45n G44_29n P44_29n G60_29 P60_29 VDD VSS) BLK_N
I424 (G61_46n P61_46n G45_30n P45_30n G61_30 P61_30 VDD VSS) BLK_N
I425 (G62_47n P62_47n G46_31n P46_31n G62_31 P62_31 VDD VSS) BLK_N
I426 (G63_48n P63_48n G47_32n P47_32n G63_32 P63_32 VDD VSS) BLK_N
I427 (G32_1 P32_1 G0_0 G32_0n VDD VSS) GRY_P
I428 (G33_2 P33_2 G1_0 G33_0n VDD VSS) GRY_P
I429 (G34_3 P34_3 G2_0np G34_0n VDD VSS) GRY_P
I430 (G35_4 P35_4 G3_0np G35_0n VDD VSS) GRY_P
I431 (G36_5 P36_5 G4_0 G36_0n VDD VSS) GRY_P
I432 (G37_6 P37_6 G5_0 G37_0n VDD VSS) GRY_P
I433 (G38_7 P38_7 G6_0 G38_0n VDD VSS) GRY_P
I434 (G39_8 P39_8 G7_0 G39_0n VDD VSS) GRY_P
I435 (G8_0n G8_0np VDD VSS) INV_X1
I436 (G40_9 P40_9 G8_0np G40_0n VDD VSS) GRY_P
I437 (G9_0n G9_0np VDD VSS) INV_X1
I438 (G41_10 P41_10 G9_0np G41_0n VDD VSS) GRY_P
I439 (G10_0n G10_0np VDD VSS) INV_X1
I440 (G42_11 P42_11 G10_0np G42_0n VDD VSS) GRY_P
I441 (G11_0n G11_0np VDD VSS) INV_X1
I442 (G43_12 P43_12 G11_0np G43_0n VDD VSS) GRY_P
I443 (G12_0n G12_0np VDD VSS) INV_X1
I444 (G44_13 P44_13 G12_0np G44_0n VDD VSS) GRY_P
I445 (G13_0n G13_0np VDD VSS) INV_X1
I446 (G45_14 P45_14 G13_0np G45_0n VDD VSS) GRY_P
I447 (G14_0n G14_0np VDD VSS) INV_X1
I448 (G46_15 P46_15 G14_0np G46_0n VDD VSS) GRY_P
I449 (G15_0n G15_0np VDD VSS) INV_X1
I450 (G47_16 P47_16 G15_0np G47_0n VDD VSS) GRY_P
I451 (G48_17 P48_17 G16_0 G48_0n VDD VSS) GRY_P
I452 (G49_18 P49_18 G17_0 G49_0n VDD VSS) GRY_P
I453 (G50_19 P50_19 G18_0 G50_0n VDD VSS) GRY_P
I454 (G51_20 P51_20 G19_0 G51_0n VDD VSS) GRY_P
I455 (G52_21 P52_21 G20_0 G52_0n VDD VSS) GRY_P
I456 (G53_22 P53_22 G21_0 G53_0n VDD VSS) GRY_P
I457 (G54_23 P54_23 G22_0 G54_0n VDD VSS) GRY_P
I458 (G55_24 P55_24 G23_0 G55_0n VDD VSS) GRY_P
I459 (G56_25 P56_25 G24_0 G56_0n VDD VSS) GRY_P
I460 (G57_26 P57_26 G25_0 G57_0n VDD VSS) GRY_P
I461 (G58_27 P58_27 G26_0 G58_0n VDD VSS) GRY_P
I462 (G59_28 P59_28 G27_0 G59_0n VDD VSS) GRY_P
I463 (G60_29 P60_29 G28_0 G60_0n VDD VSS) GRY_P
I464 (G61_30 P61_30 G29_0 G61_0n VDD VSS) GRY_P
I465 (G62_31 P62_31 G30_0 G62_0n VDD VSS) GRY_P
I466 (G63_32 P63_32 G31_0 G63_0n VDD VSS) GRY_P
I467 (pn0 CIN S_0 VDD VSS) XNOR2_X1
I468 (pn1 G0_0 S_1 VDD VSS) XNOR2_X1
I469 (pn2 G1_0 S_2 VDD VSS) XNOR2_X1
I470 (pn3 G2_0n S_3 VDD VSS) XOR2_X1
I471 (pn4 G3_0n S_4 VDD VSS) XOR2_X1
I472 (pn5 G4_0 S_5 VDD VSS) XNOR2_X1
I473 (pn6 G5_0 S_6 VDD VSS) XNOR2_X1
I474 (pn7 G6_0 S_7 VDD VSS) XNOR2_X1
I475 (pn8 G7_0 S_8 VDD VSS) XNOR2_X1
I476 (pn9 G8_0n S_9 VDD VSS) XOR2_X1
I477 (pn10 G9_0n S_10 VDD VSS) XOR2_X1
I478 (pn11 G10_0n S_11 VDD VSS) XOR2_X1
I479 (pn12 G11_0n S_12 VDD VSS) XOR2_X1
I480 (pn13 G12_0n S_13 VDD VSS) XOR2_X1
I481 (pn14 G13_0n S_14 VDD VSS) XOR2_X1
I482 (pn15 G14_0n S_15 VDD VSS) XOR2_X1
I483 (pn16 G15_0n S_16 VDD VSS) XOR2_X1
I484 (pn17 G16_0 S_17 VDD VSS) XNOR2_X1
I485 (pn18 G17_0 S_18 VDD VSS) XNOR2_X1
I486 (pn19 G18_0 S_19 VDD VSS) XNOR2_X1
I487 (pn20 G19_0 S_20 VDD VSS) XNOR2_X1
I488 (pn21 G20_0 S_21 VDD VSS) XNOR2_X1
I489 (pn22 G21_0 S_22 VDD VSS) XNOR2_X1
I490 (pn23 G22_0 S_23 VDD VSS) XNOR2_X1
I491 (pn24 G23_0 S_24 VDD VSS) XNOR2_X1
I492 (pn25 G24_0 S_25 VDD VSS) XNOR2_X1
I493 (pn26 G25_0 S_26 VDD VSS) XNOR2_X1
I494 (pn27 G26_0 S_27 VDD VSS) XNOR2_X1
I495 (pn28 G27_0 S_28 VDD VSS) XNOR2_X1
I496 (pn29 G28_0 S_29 VDD VSS) XNOR2_X1
I497 (pn30 G29_0 S_30 VDD VSS) XNOR2_X1
I498 (pn31 G30_0 S_31 VDD VSS) XNOR2_X1
I499 (pn32 G31_0 S_32 VDD VSS) XNOR2_X1
I500 (pn33 G32_0n S_33 VDD VSS) XOR2_X1
I501 (pn34 G33_0n S_34 VDD VSS) XOR2_X1
I502 (pn35 G34_0n S_35 VDD VSS) XOR2_X1
I503 (pn36 G35_0n S_36 VDD VSS) XOR2_X1
I504 (pn37 G36_0n S_37 VDD VSS) XOR2_X1
I505 (pn38 G37_0n S_38 VDD VSS) XOR2_X1
I506 (pn39 G38_0n S_39 VDD VSS) XOR2_X1
I507 (pn40 G39_0n S_40 VDD VSS) XOR2_X1
I508 (pn41 G40_0n S_41 VDD VSS) XOR2_X1
I509 (pn42 G41_0n S_42 VDD VSS) XOR2_X1
I510 (pn43 G42_0n S_43 VDD VSS) XOR2_X1
I511 (pn44 G43_0n S_44 VDD VSS) XOR2_X1
I512 (pn45 G44_0n S_45 VDD VSS) XOR2_X1
I513 (pn46 G45_0n S_46 VDD VSS) XOR2_X1
I514 (pn47 G46_0n S_47 VDD VSS) XOR2_X1
I515 (pn48 G47_0n S_48 VDD VSS) XOR2_X1
I516 (pn49 G48_0n S_49 VDD VSS) XOR2_X1
I517 (pn50 G49_0n S_50 VDD VSS) XOR2_X1
I518 (pn51 G50_0n S_51 VDD VSS) XOR2_X1
I519 (pn52 G51_0n S_52 VDD VSS) XOR2_X1
I520 (pn53 G52_0n S_53 VDD VSS) XOR2_X1
I521 (pn54 G53_0n S_54 VDD VSS) XOR2_X1
I522 (pn55 G54_0n S_55 VDD VSS) XOR2_X1
I523 (pn56 G55_0n S_56 VDD VSS) XOR2_X1
I524 (pn57 G56_0n S_57 VDD VSS) XOR2_X1
I525 (pn58 G57_0n S_58 VDD VSS) XOR2_X1
I526 (pn59 G58_0n S_59 VDD VSS) XOR2_X1
I527 (pn60 G59_0n S_60 VDD VSS) XOR2_X1
I528 (pn61 G60_0n S_61 VDD VSS) XOR2_X1
I529 (pn62 G61_0n S_62 VDD VSS) XOR2_X1
I530 (pn63 G62_0n S_63 VDD VSS) XOR2_X1
I531 (G62_0n CM VDD VSS) INV_X1
I532 (G63_0n CO VDD VSS) INV_X1
ends KSA64
