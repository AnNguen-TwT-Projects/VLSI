// HA_X1 (owner C): generated by blocks/ALU_MUL/gen_mul.py - do not edit by hand
// S = A^B (XOR2 12T), CO = A&B (NAND2+INV).
// Pins: A B S CO VDD VSS. 18 transistors.
simulator lang=spectre
subckt HA_X1 A B S CO VDD VSS
    MN1 (xan A VSS VSS) gpdk090_nmos1v w=0.12u l=0.1u
    MP2 (xan A VDD VDD) gpdk090_pmos1v w=0.24u l=0.1u
    MN3 (xbn B VSS VSS) gpdk090_nmos1v w=0.12u l=0.1u
    MP4 (xbn B VDD VDD) gpdk090_pmos1v w=0.24u l=0.1u
    MN5 (S A xn1 VSS) gpdk090_nmos1v w=0.24u l=0.1u
    MN6 (xn1 B VSS VSS) gpdk090_nmos1v w=0.24u l=0.1u
    MN7 (S xan xn2 VSS) gpdk090_nmos1v w=0.24u l=0.1u
    MN8 (xn2 xbn VSS VSS) gpdk090_nmos1v w=0.24u l=0.1u
    MP9 (xp1 A VDD VDD) gpdk090_pmos1v w=0.48u l=0.1u
    MP10 (xp1 B VDD VDD) gpdk090_pmos1v w=0.48u l=0.1u
    MP11 (S xan xp1 VDD) gpdk090_pmos1v w=0.48u l=0.1u
    MP12 (S xbn xp1 VDD) gpdk090_pmos1v w=0.48u l=0.1u
    MN13 (con A an VSS) gpdk090_nmos1v w=0.24u l=0.1u
    MN14 (an B VSS VSS) gpdk090_nmos1v w=0.24u l=0.1u
    MP15 (con A VDD VDD) gpdk090_pmos1v w=0.24u l=0.1u
    MP16 (con B VDD VDD) gpdk090_pmos1v w=0.24u l=0.1u
    MN17 (CO con VSS VSS) gpdk090_nmos1v w=0.12u l=0.1u
    MP18 (CO con VDD VDD) gpdk090_pmos1v w=0.24u l=0.1u
ends HA_X1
