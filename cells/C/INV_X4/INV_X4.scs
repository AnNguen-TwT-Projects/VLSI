// INV_X4 (owner C): generated by blocks/ALU_MUL/gen_mul.py - do not edit by hand
// Buffer (C): inverter 4x INV_X1 (n 0.48u / p 0.96u), drives the high-fanout q net of each DIV8 row (docs/sizing.md).
// Pins: A Y VDD VSS. 2 transistors.
simulator lang=spectre
subckt INV_X4 A Y VDD VSS
    MN1 (Y A VSS VSS) gpdk090_nmos1v w=0.48u l=0.1u
    MP2 (Y A VDD VDD) gpdk090_pmos1v w=0.96u l=0.1u
ends INV_X4
