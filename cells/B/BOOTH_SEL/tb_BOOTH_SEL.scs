// generated by cells/A/check_cells.py gen -- do not edit by hand
// BOOTH_SEL: 161 vectors x 500 ps, edges 20 ps, FO4 (4x INV_X1) per output
// vector sequence (AJ AJM ONE TWO NEG): 00000 10000 00000 01000 11000 01000 00000 00100 10100 00100 01100 11100 01100 00100 00000 00010 10010 00010 01010 11010 01010 00010 00110 10110 00110 01110 11110 01110 00110 00010 00000 00001 10001 00001 01001 11001 01001 00001 00101 10101 00101 01101 11101 01101 00101 00001 00011 10011 00011 01011 11011 01011 00011 00111 10111 00111 01111 11111 10111 11111 11011 10011 11011 11111 11101 10101 11101 11001 10001 11001 11101 11111 11110 10110 11110 11010 10010 11010 11110 11100 10100 11100 11000 10000 10100 10000 10010 10110 10010 10000 10001 10101 10001 10011 10111 10101 10111 10110 10100 10101 10100 10110 10111 10011 10010 10011 10001 10000 11000 11010 11000 11001 11011 11010 11011 11001 11000 11100 11101 11100 11110 11111 01111 01011 01111 01101 01001 01101 01111 01110 01010 01110 01100 01000 01010 01000 01001 01011 01010 01011 01001 01000 01100 01101 01100 01110 01111 00111 00101 00111 00110 00100 00101 00100 00110 00111 00011 00010 00011 00001 00000
simulator lang=spectre
global 0
include "/home/buet/cadence/gpdk090_v4.6/models/spectre/gpdk090.scs" section=NN
include "BOOTH_SEL.scs"
include "../../A/INV_X1/INV_X1.scs"
parameters vdd=1.2
Vvdd (VDD 0) vsource dc=vdd
Vvss (VSS 0) vsource dc=0
VAJ (AJ 0) vsource type=pwl wave=[ 0 0.0 500p 0.0 520p 1.2 1000p 1.2 1020p 0.0 2000p 0.0 2020p 1.2 2500p 1.2 2520p 0.0 4000p 0.0 4020p 1.2 4500p 1.2 4520p 0.0 5500p 0.0 5520p 1.2 6000p 1.2 6020p 0.0 8000p 0.0 8020p 1.2 8500p 1.2 8520p 0.0 9500p 0.0 9520p 1.2 10000p 1.2 10020p 0.0 11500p 0.0 11520p 1.2 12000p 1.2 12020p 0.0 13000p 0.0 13020p 1.2 13500p 1.2 13520p 0.0 16000p 0.0 16020p 1.2 16500p 1.2 16520p 0.0 17500p 0.0 17520p 1.2 18000p 1.2 18020p 0.0 19500p 0.0 19520p 1.2 20000p 1.2 20020p 0.0 21000p 0.0 21020p 1.2 21500p 1.2 21520p 0.0 23500p 0.0 23520p 1.2 24000p 1.2 24020p 0.0 25000p 0.0 25020p 1.2 25500p 1.2 25520p 0.0 27000p 0.0 27020p 1.2 27500p 1.2 27520p 0.0 28500p 0.0 28520p 1.2 61000p 1.2 61020p 0.0 ]
VAJM (AJM 0) vsource type=pwl wave=[ 0 0.0 1500p 0.0 1520p 1.2 3000p 1.2 3020p 0.0 5000p 0.0 5020p 1.2 6500p 1.2 6520p 0.0 9000p 0.0 9020p 1.2 10500p 1.2 10520p 0.0 12500p 0.0 12520p 1.2 14000p 1.2 14020p 0.0 17000p 0.0 17020p 1.2 18500p 1.2 18520p 0.0 20500p 0.0 20520p 1.2 22000p 1.2 22020p 0.0 24500p 0.0 24520p 1.2 26000p 1.2 26020p 0.0 28000p 0.0 28020p 1.2 29000p 1.2 29020p 0.0 29500p 0.0 29520p 1.2 30500p 1.2 30520p 0.0 31000p 0.0 31020p 1.2 32500p 1.2 32520p 0.0 33000p 0.0 33020p 1.2 34000p 1.2 34020p 0.0 34500p 0.0 34520p 1.2 36500p 1.2 36520p 0.0 37000p 0.0 37020p 1.2 38000p 1.2 38020p 0.0 38500p 0.0 38520p 1.2 40000p 1.2 40020p 0.0 40500p 0.0 40520p 1.2 41500p 1.2 41520p 0.0 54000p 0.0 54020p 1.2 73500p 1.2 73520p 0.0 ]
VONE (ONE 0) vsource type=pwl wave=[ 0 0.0 3500p 0.0 3520p 1.2 7000p 1.2 7020p 0.0 11000p 0.0 11020p 1.2 14500p 1.2 14520p 0.0 19000p 0.0 19020p 1.2 22500p 1.2 22520p 0.0 26500p 0.0 26520p 1.2 30000p 1.2 30020p 0.0 31500p 0.0 31520p 1.2 33500p 1.2 33520p 0.0 35000p 0.0 35020p 1.2 37500p 1.2 37520p 0.0 39000p 0.0 39020p 1.2 41000p 1.2 41020p 0.0 42000p 0.0 42020p 1.2 42500p 1.2 42520p 0.0 43500p 0.0 43520p 1.2 44000p 1.2 44020p 0.0 45500p 0.0 45520p 1.2 46000p 1.2 46020p 0.0 47000p 0.0 47020p 1.2 51500p 1.2 51520p 0.0 58500p 0.0 58520p 1.2 61500p 1.2 61520p 0.0 62000p 0.0 62020p 1.2 63000p 1.2 63020p 0.0 63500p 0.0 63520p 1.2 65000p 1.2 65020p 0.0 65500p 0.0 65520p 1.2 66500p 1.2 66520p 0.0 71000p 0.0 71020p 1.2 78000p 1.2 78020p 0.0 ]
VTWO (TWO 0) vsource type=pwl wave=[ 0 0.0 7500p 0.0 7520p 1.2 15000p 1.2 15020p 0.0 23000p 0.0 23020p 1.2 32000p 1.2 32020p 0.0 35500p 0.0 35520p 1.2 39500p 1.2 39520p 0.0 43000p 0.0 43020p 1.2 44500p 1.2 44520p 0.0 46500p 0.0 46520p 1.2 47500p 1.2 47520p 0.0 48000p 0.0 48020p 1.2 49000p 1.2 49020p 0.0 50500p 0.0 50520p 1.2 53000p 1.2 53020p 0.0 54500p 0.0 54520p 1.2 55000p 1.2 55020p 0.0 56000p 0.0 56020p 1.2 57500p 1.2 57520p 0.0 60000p 0.0 60020p 1.2 62500p 1.2 62520p 0.0 64000p 0.0 64020p 1.2 66000p 1.2 66020p 0.0 67000p 0.0 67020p 1.2 67500p 1.2 67520p 0.0 68500p 0.0 68520p 1.2 70000p 1.2 70020p 0.0 72500p 0.0 72520p 1.2 74000p 1.2 74020p 0.0 74500p 0.0 74520p 1.2 75500p 1.2 75520p 0.0 77000p 0.0 77020p 1.2 79500p 1.2 79520p 0.0 ]
VNEG (NEG 0) vsource type=pwl wave=[ 0 0.0 15500p 0.0 15520p 1.2 36000p 1.2 36020p 0.0 45000p 0.0 45020p 1.2 48500p 1.2 48520p 0.0 49500p 0.0 49520p 1.2 50000p 1.2 50020p 0.0 51000p 0.0 51020p 1.2 52000p 1.2 52020p 0.0 52500p 0.0 52520p 1.2 53500p 1.2 53520p 0.0 55500p 0.0 55520p 1.2 56500p 1.2 56520p 0.0 57000p 0.0 57020p 1.2 58000p 1.2 58020p 0.0 59000p 0.0 59020p 1.2 59500p 1.2 59520p 0.0 60500p 0.0 60520p 1.2 64500p 1.2 64520p 0.0 68000p 0.0 68020p 1.2 69000p 1.2 69020p 0.0 69500p 0.0 69520p 1.2 70500p 1.2 70520p 0.0 71500p 0.0 71520p 1.2 72000p 1.2 72020p 0.0 73000p 0.0 73020p 1.2 75000p 1.2 75020p 0.0 76000p 0.0 76020p 1.2 76500p 1.2 76520p 0.0 77500p 0.0 77520p 1.2 78500p 1.2 78520p 0.0 79000p 0.0 79020p 1.2 80000p 1.2 80020p 0.0 ]
XDUT (AJ AJM ONE TWO NEG PP VDD VSS) BOOTH_SEL
XL_PP_0 (PP L_PP_0 VDD VSS) INV_X1
XL_PP_1 (PP L_PP_1 VDD VSS) INV_X1
XL_PP_2 (PP L_PP_2 VDD VSS) INV_X1
XL_PP_3 (PP L_PP_3 VDD VSS) INV_X1
saveOpts options save=selected
save AJ AJM ONE TWO NEG PP
tr tran stop=80500p maxstep=1p errpreset=conservative
