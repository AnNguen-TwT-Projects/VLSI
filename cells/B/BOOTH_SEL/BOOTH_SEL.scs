// BOOTH_SEL (owner B): generated by blocks/ALU_MUL/gen_mul.py - do not edit by hand
// Booth selector: PP = (ONE&AJ | TWO&AJM) ^ NEG = XNOR(AOI22, NEG).
// Pins: AJ AJM ONE TWO NEG PP VDD VSS. 20 transistors.
simulator lang=spectre
subckt BOOTH_SEL AJ AJM ONE TWO NEG PP VDD VSS
    MN1 (xn ONE n1 VSS) gpdk090_nmos1v w=0.24u l=0.1u
    MN2 (n1 AJ VSS VSS) gpdk090_nmos1v w=0.24u l=0.1u
    MN3 (xn TWO n2 VSS) gpdk090_nmos1v w=0.24u l=0.1u
    MN4 (n2 AJM VSS VSS) gpdk090_nmos1v w=0.24u l=0.1u
    MP5 (p1 ONE VDD VDD) gpdk090_pmos1v w=0.48u l=0.1u
    MP6 (p1 AJ VDD VDD) gpdk090_pmos1v w=0.48u l=0.1u
    MP7 (xn TWO p1 VDD) gpdk090_pmos1v w=0.48u l=0.1u
    MP8 (xn AJM p1 VDD) gpdk090_pmos1v w=0.48u l=0.1u
    MN9 (xan xn VSS VSS) gpdk090_nmos1v w=0.12u l=0.1u
    MP10 (xan xn VDD VDD) gpdk090_pmos1v w=0.24u l=0.1u
    MN11 (xbn NEG VSS VSS) gpdk090_nmos1v w=0.12u l=0.1u
    MP12 (xbn NEG VDD VDD) gpdk090_pmos1v w=0.24u l=0.1u
    MN13 (PP xn xn1 VSS) gpdk090_nmos1v w=0.24u l=0.1u
    MN14 (xn1 xbn VSS VSS) gpdk090_nmos1v w=0.24u l=0.1u
    MN15 (PP xan xn2 VSS) gpdk090_nmos1v w=0.24u l=0.1u
    MN16 (xn2 NEG VSS VSS) gpdk090_nmos1v w=0.24u l=0.1u
    MP17 (xp1 xn VDD VDD) gpdk090_pmos1v w=0.48u l=0.1u
    MP18 (xp1 xbn VDD VDD) gpdk090_pmos1v w=0.48u l=0.1u
    MP19 (PP xan xp1 VDD) gpdk090_pmos1v w=0.48u l=0.1u
    MP20 (PP NEG xp1 VDD) gpdk090_pmos1v w=0.48u l=0.1u
ends BOOTH_SEL
