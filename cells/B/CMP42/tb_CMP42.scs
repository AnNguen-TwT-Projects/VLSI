// generated by cells/A/check_cells.py gen -- do not edit by hand
// CMP42: 161 vectors x 1000 ps, edges 20 ps, FO4 (4x INV_X1) per output
// vector sequence (X1 X2 X3 X4 CI): 00000 10000 00000 01000 11000 01000 00000 00100 10100 00100 01100 11100 01100 00100 00000 00010 10010 00010 01010 11010 01010 00010 00110 10110 00110 01110 11110 01110 00110 00010 00000 00001 10001 00001 01001 11001 01001 00001 00101 10101 00101 01101 11101 01101 00101 00001 00011 10011 00011 01011 11011 01011 00011 00111 10111 00111 01111 11111 10111 11111 11011 10011 11011 11111 11101 10101 11101 11001 10001 11001 11101 11111 11110 10110 11110 11010 10010 11010 11110 11100 10100 11100 11000 10000 10100 10000 10010 10110 10010 10000 10001 10101 10001 10011 10111 10101 10111 10110 10100 10101 10100 10110 10111 10011 10010 10011 10001 10000 11000 11010 11000 11001 11011 11010 11011 11001 11000 11100 11101 11100 11110 11111 01111 01011 01111 01101 01001 01101 01111 01110 01010 01110 01100 01000 01010 01000 01001 01011 01010 01011 01001 01000 01100 01101 01100 01110 01111 00111 00101 00111 00110 00100 00101 00100 00110 00111 00011 00010 00011 00001 00000
simulator lang=spectre
global 0
include "/home/buet/cadence/gpdk090_v4.6/models/spectre/gpdk090.scs" section=NN
include "CMP42.scs"
include "../../A/INV_X1/INV_X1.scs"
parameters vdd=1.2
Vvdd (VDD 0) vsource dc=vdd
Vvss (VSS 0) vsource dc=0
VX1 (X1 0) vsource type=pwl wave=[ 0 0.0 1000p 0.0 1020p 1.2 2000p 1.2 2020p 0.0 4000p 0.0 4020p 1.2 5000p 1.2 5020p 0.0 8000p 0.0 8020p 1.2 9000p 1.2 9020p 0.0 11000p 0.0 11020p 1.2 12000p 1.2 12020p 0.0 16000p 0.0 16020p 1.2 17000p 1.2 17020p 0.0 19000p 0.0 19020p 1.2 20000p 1.2 20020p 0.0 23000p 0.0 23020p 1.2 24000p 1.2 24020p 0.0 26000p 0.0 26020p 1.2 27000p 1.2 27020p 0.0 32000p 0.0 32020p 1.2 33000p 1.2 33020p 0.0 35000p 0.0 35020p 1.2 36000p 1.2 36020p 0.0 39000p 0.0 39020p 1.2 40000p 1.2 40020p 0.0 42000p 0.0 42020p 1.2 43000p 1.2 43020p 0.0 47000p 0.0 47020p 1.2 48000p 1.2 48020p 0.0 50000p 0.0 50020p 1.2 51000p 1.2 51020p 0.0 54000p 0.0 54020p 1.2 55000p 1.2 55020p 0.0 57000p 0.0 57020p 1.2 122000p 1.2 122020p 0.0 ]
VX2 (X2 0) vsource type=pwl wave=[ 0 0.0 3000p 0.0 3020p 1.2 6000p 1.2 6020p 0.0 10000p 0.0 10020p 1.2 13000p 1.2 13020p 0.0 18000p 0.0 18020p 1.2 21000p 1.2 21020p 0.0 25000p 0.0 25020p 1.2 28000p 1.2 28020p 0.0 34000p 0.0 34020p 1.2 37000p 1.2 37020p 0.0 41000p 0.0 41020p 1.2 44000p 1.2 44020p 0.0 49000p 0.0 49020p 1.2 52000p 1.2 52020p 0.0 56000p 0.0 56020p 1.2 58000p 1.2 58020p 0.0 59000p 0.0 59020p 1.2 61000p 1.2 61020p 0.0 62000p 0.0 62020p 1.2 65000p 1.2 65020p 0.0 66000p 0.0 66020p 1.2 68000p 1.2 68020p 0.0 69000p 0.0 69020p 1.2 73000p 1.2 73020p 0.0 74000p 0.0 74020p 1.2 76000p 1.2 76020p 0.0 77000p 0.0 77020p 1.2 80000p 1.2 80020p 0.0 81000p 0.0 81020p 1.2 83000p 1.2 83020p 0.0 108000p 0.0 108020p 1.2 147000p 1.2 147020p 0.0 ]
VX3 (X3 0) vsource type=pwl wave=[ 0 0.0 7000p 0.0 7020p 1.2 14000p 1.2 14020p 0.0 22000p 0.0 22020p 1.2 29000p 1.2 29020p 0.0 38000p 0.0 38020p 1.2 45000p 1.2 45020p 0.0 53000p 0.0 53020p 1.2 60000p 1.2 60020p 0.0 63000p 0.0 63020p 1.2 67000p 1.2 67020p 0.0 70000p 0.0 70020p 1.2 75000p 1.2 75020p 0.0 78000p 0.0 78020p 1.2 82000p 1.2 82020p 0.0 84000p 0.0 84020p 1.2 85000p 1.2 85020p 0.0 87000p 0.0 87020p 1.2 88000p 1.2 88020p 0.0 91000p 0.0 91020p 1.2 92000p 1.2 92020p 0.0 94000p 0.0 94020p 1.2 103000p 1.2 103020p 0.0 117000p 0.0 117020p 1.2 123000p 1.2 123020p 0.0 124000p 0.0 124020p 1.2 126000p 1.2 126020p 0.0 127000p 0.0 127020p 1.2 130000p 1.2 130020p 0.0 131000p 0.0 131020p 1.2 133000p 1.2 133020p 0.0 142000p 0.0 142020p 1.2 156000p 1.2 156020p 0.0 ]
VX4 (X4 0) vsource type=pwl wave=[ 0 0.0 15000p 0.0 15020p 1.2 30000p 1.2 30020p 0.0 46000p 0.0 46020p 1.2 64000p 1.2 64020p 0.0 71000p 0.0 71020p 1.2 79000p 1.2 79020p 0.0 86000p 0.0 86020p 1.2 89000p 1.2 89020p 0.0 93000p 0.0 93020p 1.2 95000p 1.2 95020p 0.0 96000p 0.0 96020p 1.2 98000p 1.2 98020p 0.0 101000p 0.0 101020p 1.2 106000p 1.2 106020p 0.0 109000p 0.0 109020p 1.2 110000p 1.2 110020p 0.0 112000p 0.0 112020p 1.2 115000p 1.2 115020p 0.0 120000p 0.0 120020p 1.2 125000p 1.2 125020p 0.0 128000p 0.0 128020p 1.2 132000p 1.2 132020p 0.0 134000p 0.0 134020p 1.2 135000p 1.2 135020p 0.0 137000p 0.0 137020p 1.2 140000p 1.2 140020p 0.0 145000p 0.0 145020p 1.2 148000p 1.2 148020p 0.0 149000p 0.0 149020p 1.2 151000p 1.2 151020p 0.0 154000p 0.0 154020p 1.2 159000p 1.2 159020p 0.0 ]
VCI (CI 0) vsource type=pwl wave=[ 0 0.0 31000p 0.0 31020p 1.2 72000p 1.2 72020p 0.0 90000p 0.0 90020p 1.2 97000p 1.2 97020p 0.0 99000p 0.0 99020p 1.2 100000p 1.2 100020p 0.0 102000p 0.0 102020p 1.2 104000p 1.2 104020p 0.0 105000p 0.0 105020p 1.2 107000p 1.2 107020p 0.0 111000p 0.0 111020p 1.2 113000p 1.2 113020p 0.0 114000p 0.0 114020p 1.2 116000p 1.2 116020p 0.0 118000p 0.0 118020p 1.2 119000p 1.2 119020p 0.0 121000p 0.0 121020p 1.2 129000p 1.2 129020p 0.0 136000p 0.0 136020p 1.2 138000p 1.2 138020p 0.0 139000p 0.0 139020p 1.2 141000p 1.2 141020p 0.0 143000p 0.0 143020p 1.2 144000p 1.2 144020p 0.0 146000p 0.0 146020p 1.2 150000p 1.2 150020p 0.0 152000p 0.0 152020p 1.2 153000p 1.2 153020p 0.0 155000p 0.0 155020p 1.2 157000p 1.2 157020p 0.0 158000p 0.0 158020p 1.2 160000p 1.2 160020p 0.0 ]
XDUT (X1 X2 X3 X4 CI S C CO VDD VSS) CMP42
XL_S_0 (S L_S_0 VDD VSS) INV_X1
XL_S_1 (S L_S_1 VDD VSS) INV_X1
XL_S_2 (S L_S_2 VDD VSS) INV_X1
XL_S_3 (S L_S_3 VDD VSS) INV_X1
XL_C_0 (C L_C_0 VDD VSS) INV_X1
XL_C_1 (C L_C_1 VDD VSS) INV_X1
XL_C_2 (C L_C_2 VDD VSS) INV_X1
XL_C_3 (C L_C_3 VDD VSS) INV_X1
XL_CO_0 (CO L_CO_0 VDD VSS) INV_X1
XL_CO_1 (CO L_CO_1 VDD VSS) INV_X1
XL_CO_2 (CO L_CO_2 VDD VSS) INV_X1
XL_CO_3 (CO L_CO_3 VDD VSS) INV_X1
saveOpts options save=selected
save X1 X2 X3 X4 CI S C CO
tr tran stop=161000p maxstep=1p errpreset=conservative
