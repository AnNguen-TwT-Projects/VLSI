// CMP42 (owner B): generated by blocks/ALU_MUL/gen_mul.py - do not edit by hand
// 4:2 compressor = 2 mirror FAs (flat): FA(X1,X2,X3) -> s1, CO; FA(s1,X4,CI) -> S, C. X1+X2+X3+X4+CI = S + 2(C+CO); CO does not depend on CI.
// Pins: X1 X2 X3 X4 CI S C CO VDD VSS. 56 transistors.
simulator lang=spectre
subckt CMP42 X1 X2 X3 X4 CI S C CO VDD VSS
    MN1 (an1 X1 VSS VSS) gpdk090_nmos1v w=0.24u l=0.1u
    MN2 (acon X2 an1 VSS) gpdk090_nmos1v w=0.24u l=0.1u
    MN3 (an2 X1 VSS VSS) gpdk090_nmos1v w=0.24u l=0.1u
    MN4 (an2 X2 VSS VSS) gpdk090_nmos1v w=0.24u l=0.1u
    MN5 (acon X3 an2 VSS) gpdk090_nmos1v w=0.24u l=0.1u
    MN6 (an3 X1 VSS VSS) gpdk090_nmos1v w=0.24u l=0.1u
    MN7 (an3 X2 VSS VSS) gpdk090_nmos1v w=0.24u l=0.1u
    MN8 (an3 X3 VSS VSS) gpdk090_nmos1v w=0.24u l=0.1u
    MN9 (asn acon an3 VSS) gpdk090_nmos1v w=0.24u l=0.1u
    MN10 (an4 X1 VSS VSS) gpdk090_nmos1v w=0.36u l=0.1u
    MN11 (an5 X2 an4 VSS) gpdk090_nmos1v w=0.36u l=0.1u
    MN12 (asn X3 an5 VSS) gpdk090_nmos1v w=0.36u l=0.1u
    MP13 (ap1 X1 VDD VDD) gpdk090_pmos1v w=0.48u l=0.1u
    MP14 (acon X2 ap1 VDD) gpdk090_pmos1v w=0.48u l=0.1u
    MP15 (ap2 X1 VDD VDD) gpdk090_pmos1v w=0.48u l=0.1u
    MP16 (ap2 X2 VDD VDD) gpdk090_pmos1v w=0.48u l=0.1u
    MP17 (acon X3 ap2 VDD) gpdk090_pmos1v w=0.48u l=0.1u
    MP18 (ap3 X1 VDD VDD) gpdk090_pmos1v w=0.48u l=0.1u
    MP19 (ap3 X2 VDD VDD) gpdk090_pmos1v w=0.48u l=0.1u
    MP20 (ap3 X3 VDD VDD) gpdk090_pmos1v w=0.48u l=0.1u
    MP21 (asn acon ap3 VDD) gpdk090_pmos1v w=0.48u l=0.1u
    MP22 (ap4 X1 VDD VDD) gpdk090_pmos1v w=0.72u l=0.1u
    MP23 (ap5 X2 ap4 VDD) gpdk090_pmos1v w=0.72u l=0.1u
    MP24 (asn X3 ap5 VDD) gpdk090_pmos1v w=0.72u l=0.1u
    MN25 (s1 asn VSS VSS) gpdk090_nmos1v w=0.12u l=0.1u
    MP26 (s1 asn VDD VDD) gpdk090_pmos1v w=0.24u l=0.1u
    MN27 (CO acon VSS VSS) gpdk090_nmos1v w=0.12u l=0.1u
    MP28 (CO acon VDD VDD) gpdk090_pmos1v w=0.24u l=0.1u
    MN29 (bn1 s1 VSS VSS) gpdk090_nmos1v w=0.24u l=0.1u
    MN30 (bcon X4 bn1 VSS) gpdk090_nmos1v w=0.24u l=0.1u
    MN31 (bn2 s1 VSS VSS) gpdk090_nmos1v w=0.24u l=0.1u
    MN32 (bn2 X4 VSS VSS) gpdk090_nmos1v w=0.24u l=0.1u
    MN33 (bcon CI bn2 VSS) gpdk090_nmos1v w=0.24u l=0.1u
    MN34 (bn3 s1 VSS VSS) gpdk090_nmos1v w=0.24u l=0.1u
    MN35 (bn3 X4 VSS VSS) gpdk090_nmos1v w=0.24u l=0.1u
    MN36 (bn3 CI VSS VSS) gpdk090_nmos1v w=0.24u l=0.1u
    MN37 (bsn bcon bn3 VSS) gpdk090_nmos1v w=0.24u l=0.1u
    MN38 (bn4 s1 VSS VSS) gpdk090_nmos1v w=0.36u l=0.1u
    MN39 (bn5 X4 bn4 VSS) gpdk090_nmos1v w=0.36u l=0.1u
    MN40 (bsn CI bn5 VSS) gpdk090_nmos1v w=0.36u l=0.1u
    MP41 (bp1 s1 VDD VDD) gpdk090_pmos1v w=0.48u l=0.1u
    MP42 (bcon X4 bp1 VDD) gpdk090_pmos1v w=0.48u l=0.1u
    MP43 (bp2 s1 VDD VDD) gpdk090_pmos1v w=0.48u l=0.1u
    MP44 (bp2 X4 VDD VDD) gpdk090_pmos1v w=0.48u l=0.1u
    MP45 (bcon CI bp2 VDD) gpdk090_pmos1v w=0.48u l=0.1u
    MP46 (bp3 s1 VDD VDD) gpdk090_pmos1v w=0.48u l=0.1u
    MP47 (bp3 X4 VDD VDD) gpdk090_pmos1v w=0.48u l=0.1u
    MP48 (bp3 CI VDD VDD) gpdk090_pmos1v w=0.48u l=0.1u
    MP49 (bsn bcon bp3 VDD) gpdk090_pmos1v w=0.48u l=0.1u
    MP50 (bp4 s1 VDD VDD) gpdk090_pmos1v w=0.72u l=0.1u
    MP51 (bp5 X4 bp4 VDD) gpdk090_pmos1v w=0.72u l=0.1u
    MP52 (bsn CI bp5 VDD) gpdk090_pmos1v w=0.72u l=0.1u
    MN53 (S bsn VSS VSS) gpdk090_nmos1v w=0.12u l=0.1u
    MP54 (S bsn VDD VDD) gpdk090_pmos1v w=0.24u l=0.1u
    MN55 (C bcon VSS VSS) gpdk090_nmos1v w=0.12u l=0.1u
    MP56 (C bcon VDD VDD) gpdk090_pmos1v w=0.24u l=0.1u
ends CMP42
