// generated by cells/A/check_cells.py gen -- do not edit by hand
// BLK_P: 65 vectors x 500 ps, edges 20 ps, FO4 (4x INV_X1) per output
// vector sequence (GI PI GK PK): 0000 1000 0000 0100 1100 0100 0000 0010 1010 0010 0110 1110 0110 0010 0000 0001 1001 0001 0101 1101 0101 0001 0011 1011 0011 0111 1111 1011 1111 1101 1001 1101 1111 1110 1010 1110 1100 1000 1010 1000 1001 1011 1010 1011 1001 1000 1100 1101 1100 1110 1111 0111 0101 0111 0110 0100 0101 0100 0110 0111 0011 0010 0011 0001 0000
simulator lang=spectre
global 0
include "/home/buet/cadence/gpdk090_v4.6/models/spectre/gpdk090.scs" section=NN
include "../cells_A.scs"
parameters vdd=1.2
Vvdd (VDD 0) vsource dc=vdd
Vvss (VSS 0) vsource dc=0
VGI (GI 0) vsource type=pwl wave=[ 0 0.0 500p 0.0 520p 1.2 1000p 1.2 1020p 0.0 2000p 0.0 2020p 1.2 2500p 1.2 2520p 0.0 4000p 0.0 4020p 1.2 4500p 1.2 4520p 0.0 5500p 0.0 5520p 1.2 6000p 1.2 6020p 0.0 8000p 0.0 8020p 1.2 8500p 1.2 8520p 0.0 9500p 0.0 9520p 1.2 10000p 1.2 10020p 0.0 11500p 0.0 11520p 1.2 12000p 1.2 12020p 0.0 13000p 0.0 13020p 1.2 25500p 1.2 25520p 0.0 ]
VPI (PI 0) vsource type=pwl wave=[ 0 0.0 1500p 0.0 1520p 1.2 3000p 1.2 3020p 0.0 5000p 0.0 5020p 1.2 6500p 1.2 6520p 0.0 9000p 0.0 9020p 1.2 10500p 1.2 10520p 0.0 12500p 0.0 12520p 1.2 13500p 1.2 13520p 0.0 14000p 0.0 14020p 1.2 15000p 1.2 15020p 0.0 15500p 0.0 15520p 1.2 17000p 1.2 17020p 0.0 17500p 0.0 17520p 1.2 18500p 1.2 18520p 0.0 23000p 0.0 23020p 1.2 30000p 1.2 30020p 0.0 ]
VGK (GK 0) vsource type=pwl wave=[ 0 0.0 3500p 0.0 3520p 1.2 7000p 1.2 7020p 0.0 11000p 0.0 11020p 1.2 14500p 1.2 14520p 0.0 16000p 0.0 16020p 1.2 18000p 1.2 18020p 0.0 19000p 0.0 19020p 1.2 19500p 1.2 19520p 0.0 20500p 0.0 20520p 1.2 22000p 1.2 22020p 0.0 24500p 0.0 24520p 1.2 26000p 1.2 26020p 0.0 26500p 0.0 26520p 1.2 27500p 1.2 27520p 0.0 29000p 0.0 29020p 1.2 31500p 1.2 31520p 0.0 ]
VPK (PK 0) vsource type=pwl wave=[ 0 0.0 7500p 0.0 7520p 1.2 16500p 1.2 16520p 0.0 20000p 0.0 20020p 1.2 21000p 1.2 21020p 0.0 21500p 0.0 21520p 1.2 22500p 1.2 22520p 0.0 23500p 0.0 23520p 1.2 24000p 1.2 24020p 0.0 25000p 0.0 25020p 1.2 27000p 1.2 27020p 0.0 28000p 0.0 28020p 1.2 28500p 1.2 28520p 0.0 29500p 0.0 29520p 1.2 30500p 1.2 30520p 0.0 31000p 0.0 31020p 1.2 32000p 1.2 32020p 0.0 ]
XDUT (GI PI GK PK GON PON VDD VSS) BLK_P
XL_GON_0 (GON L_GON_0 VDD VSS) INV_X1
XL_GON_1 (GON L_GON_1 VDD VSS) INV_X1
XL_GON_2 (GON L_GON_2 VDD VSS) INV_X1
XL_GON_3 (GON L_GON_3 VDD VSS) INV_X1
XL_PON_0 (PON L_PON_0 VDD VSS) INV_X1
XL_PON_1 (PON L_PON_1 VDD VSS) INV_X1
XL_PON_2 (PON L_PON_2 VDD VSS) INV_X1
XL_PON_3 (PON L_PON_3 VDD VSS) INV_X1
saveOpts options save=selected
save GI PI GK PK GON PON
tr tran stop=32500p maxstep=1p errpreset=conservative
