// BLK_P (ALU_CELLS_A, owner A). Black cell, positive-in / negative-out.
// GON = !(GI | PI & GK) (AOI21: A1=PI A2=GK B=GI), PON = !(PI & PK) (NAND2)
// Pins: GI PI GK PK GON PON VDD VSS   (docs/CONVENTIONS.md section 4)
// Subcells come from cells/A/cells_A.scs (include that file, not this one, in testbenches/blocks).
simulator lang=spectre
subckt BLK_P GI PI GK PK GON PON VDD VSS
    XG (PI GK GI GON VDD VSS) AOI21_X1
    XP (PI PK PON VDD VSS) NAND2_X1
ends BLK_P
