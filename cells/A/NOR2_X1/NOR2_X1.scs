// NOR2_X1 (ALU_CELLS_A, owner A).  Y = !(A | B)
// Pins: A B Y VDD VSS   (docs/CONVENTIONS.md section 4)
simulator lang=spectre
subckt NOR2_X1 A B Y VDD VSS
    MN0 (Y A VSS VSS) gpdk090_nmos1v w=0.12u l=0.1u
    MN1 (Y B VSS VSS) gpdk090_nmos1v w=0.12u l=0.1u
    MP0 (p1 A VDD VDD) gpdk090_pmos1v w=0.48u l=0.1u
    MP1 (Y B p1 VDD) gpdk090_pmos1v w=0.48u l=0.1u
ends NOR2_X1
