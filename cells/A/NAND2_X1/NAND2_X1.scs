// NAND2_X1 (ALU_CELLS_A, owner A).  Y = !(A & B)
// Pins: A B Y VDD VSS   (docs/CONVENTIONS.md section 4)
simulator lang=spectre
subckt NAND2_X1 A B Y VDD VSS
    MN0 (Y A n1 VSS) gpdk090_nmos1v w=0.24u l=0.1u
    MN1 (n1 B VSS VSS) gpdk090_nmos1v w=0.24u l=0.1u
    MP0 (Y A VDD VDD) gpdk090_pmos1v w=0.24u l=0.1u
    MP1 (Y B VDD VDD) gpdk090_pmos1v w=0.24u l=0.1u
ends NAND2_X1
