// generated by cells/A/check_cells.py gen -- do not edit by hand
// CAS_X1: 65 vectors x 1000 ps, edges 20 ps, FO4 (4x INV_X1) per output
// vector sequence (X D T CI): 0000 1000 0000 0100 1100 0100 0000 0010 1010 0010 0110 1110 0110 0010 0000 0001 1001 0001 0101 1101 0101 0001 0011 1011 0011 0111 1111 1011 1111 1101 1001 1101 1111 1110 1010 1110 1100 1000 1010 1000 1001 1011 1010 1011 1001 1000 1100 1101 1100 1110 1111 0111 0101 0111 0110 0100 0101 0100 0110 0111 0011 0010 0011 0001 0000
simulator lang=spectre
global 0
include "/home/buet/cadence/gpdk090_v4.6/models/spectre/gpdk090.scs" section=NN
include "../../A/cells_A.scs"
include "../../_stub_B/XOR2_X1/XOR2_X1.scs"
include "CAS_X1.scs"
parameters vdd=1.2
Vvdd (VDD 0) vsource dc=vdd
Vvss (VSS 0) vsource dc=0
VX (X 0) vsource type=pwl wave=[ 0 0.0 1000p 0.0 1020p 1.2 2000p 1.2 2020p 0.0 4000p 0.0 4020p 1.2 5000p 1.2 5020p 0.0 8000p 0.0 8020p 1.2 9000p 1.2 9020p 0.0 11000p 0.0 11020p 1.2 12000p 1.2 12020p 0.0 16000p 0.0 16020p 1.2 17000p 1.2 17020p 0.0 19000p 0.0 19020p 1.2 20000p 1.2 20020p 0.0 23000p 0.0 23020p 1.2 24000p 1.2 24020p 0.0 26000p 0.0 26020p 1.2 51000p 1.2 51020p 0.0 ]
VD (D 0) vsource type=pwl wave=[ 0 0.0 3000p 0.0 3020p 1.2 6000p 1.2 6020p 0.0 10000p 0.0 10020p 1.2 13000p 1.2 13020p 0.0 18000p 0.0 18020p 1.2 21000p 1.2 21020p 0.0 25000p 0.0 25020p 1.2 27000p 1.2 27020p 0.0 28000p 0.0 28020p 1.2 30000p 1.2 30020p 0.0 31000p 0.0 31020p 1.2 34000p 1.2 34020p 0.0 35000p 0.0 35020p 1.2 37000p 1.2 37020p 0.0 46000p 0.0 46020p 1.2 60000p 1.2 60020p 0.0 ]
VT (T 0) vsource type=pwl wave=[ 0 0.0 7000p 0.0 7020p 1.2 14000p 1.2 14020p 0.0 22000p 0.0 22020p 1.2 29000p 1.2 29020p 0.0 32000p 0.0 32020p 1.2 36000p 1.2 36020p 0.0 38000p 0.0 38020p 1.2 39000p 1.2 39020p 0.0 41000p 0.0 41020p 1.2 44000p 1.2 44020p 0.0 49000p 0.0 49020p 1.2 52000p 1.2 52020p 0.0 53000p 0.0 53020p 1.2 55000p 1.2 55020p 0.0 58000p 0.0 58020p 1.2 63000p 1.2 63020p 0.0 ]
VCI (CI 0) vsource type=pwl wave=[ 0 0.0 15000p 0.0 15020p 1.2 33000p 1.2 33020p 0.0 40000p 0.0 40020p 1.2 42000p 1.2 42020p 0.0 43000p 0.0 43020p 1.2 45000p 1.2 45020p 0.0 47000p 0.0 47020p 1.2 48000p 1.2 48020p 0.0 50000p 0.0 50020p 1.2 54000p 1.2 54020p 0.0 56000p 0.0 56020p 1.2 57000p 1.2 57020p 0.0 59000p 0.0 59020p 1.2 61000p 1.2 61020p 0.0 62000p 0.0 62020p 1.2 64000p 1.2 64020p 0.0 ]
XDUT (X D T CI S CO VDD VSS) CAS_X1
XL_S_0 (S L_S_0 VDD VSS) INV_X1
XL_S_1 (S L_S_1 VDD VSS) INV_X1
XL_S_2 (S L_S_2 VDD VSS) INV_X1
XL_S_3 (S L_S_3 VDD VSS) INV_X1
XL_CO_0 (CO L_CO_0 VDD VSS) INV_X1
XL_CO_1 (CO L_CO_1 VDD VSS) INV_X1
XL_CO_2 (CO L_CO_2 VDD VSS) INV_X1
XL_CO_3 (CO L_CO_3 VDD VSS) INV_X1
saveOpts options save=selected
save X D T CI S CO
tr tran stop=65000p maxstep=1p errpreset=conservative
