;; generated by tools/scs2skill.py from ALU_CELLS_A=cells/A ALU_STUB_B=cells/_stub_B ALU_CELLS_B=cells/B ALU_CELLS_C=cells/C ALU_CELLS_D=cells/D ALU_ADD=blocks/ALU_ADD/KSA8.scs ALU_ADD=blocks/ALU_ADD/ADDSUB8.scs ALU_CORE=blocks/ALU_CORE/LOGIC8.scs ALU_CORE=blocks/ALU_CORE/DEC_OP.scs ALU_CORE=blocks/ALU_CORE/OUTMUX.scs ALU_CORE=blocks/ALU_CORE/FLAGS.scs ALU_CORE=blocks/ALU_CORE/ALU_CORE.scs ALU_MUL=blocks/ALU_MUL/MUL8.scs ALU_MUL=blocks/ALU_MUL/MUL8_DADDA.scs ALU_DIV=blocks/ALU_DIV/DIV8.scs ALU_TOP=blocks/ALU_TOP/ALU_TOP.scs -- do not edit
;; run in the VM:  cd ~/ALU_PROJ && virtuoso -nograph -restore <this file> < /dev/null
;; run with < /dev/null; any SKILL error -> message + exit, never a hanging CIW prompt
unless(errset(progn(
sbDir = or(getShellEnvVar("SB_DIR") "/mnt/hgfs/Share/VLSI_work/skill")
load(strcat(sbDir "/sch_build.il"))
sbBegin()
sbLib("ALU_MUL" "gpdk090")
sbLib("ALU_DIV" "gpdk090")
sbLib("ALU_TOP" "gpdk090")
unless(errset(sbCell("ALU_MUL" "MUL8" '(("A_0" "input") ("A_1" "input") ("A_2" "input") ("A_3" "input") ("A_4" "input") ("A_5" "input") ("A_6" "input") ("A_7" "input") ("B_0" "input") ("B_1" "input") ("B_2" "input") ("B_3" "input") ("B_4" "input") ("B_5" "input") ("B_6" "input") ("B_7" "input") ("P_0" "output") ("P_1" "output") ("P_2" "output") ("P_3" "output") ("P_4" "output") ("P_5" "output") ("P_6" "output") ("P_7" "output") ("P_8" "output") ("P_9" "output") ("P_10" "output") ("P_11" "output") ("P_12" "output") ("P_13" "output") ("P_14" "output") ("P_15" "output") ("VDD" "inputOutput") ("VSS" "inputOutput"))
 '(
  ("I0" "ALU_CELLS_B" "BOOTH_ENC" (("X2" "B_1") ("X1" "B_0") ("X0" "VSS") ("ONE" "one0") ("TWO" "two0") ("VDD" "VDD") ("VSS" "VSS")) ())
  ("I1" "ALU_CELLS_B" "BOOTH_SEL" (("AJ" "A_0") ("AJM" "VSS") ("ONE" "one0") ("TWO" "two0") ("NEG" "B_1") ("PP" "pp0_0") ("VDD" "VDD") ("VSS" "VSS")) ())
  ("I2" "ALU_CELLS_B" "BOOTH_SEL" (("AJ" "A_1") ("AJM" "A_0") ("ONE" "one0") ("TWO" "two0") ("NEG" "B_1") ("PP" "pp0_1") ("VDD" "VDD") ("VSS" "VSS")) ())
  ("I3" "ALU_CELLS_B" "BOOTH_SEL" (("AJ" "A_2") ("AJM" "A_1") ("ONE" "one0") ("TWO" "two0") ("NEG" "B_1") ("PP" "pp0_2") ("VDD" "VDD") ("VSS" "VSS")) ())
  ("I4" "ALU_CELLS_B" "BOOTH_SEL" (("AJ" "A_3") ("AJM" "A_2") ("ONE" "one0") ("TWO" "two0") ("NEG" "B_1") ("PP" "pp0_3") ("VDD" "VDD") ("VSS" "VSS")) ())
  ("I5" "ALU_CELLS_B" "BOOTH_SEL" (("AJ" "A_4") ("AJM" "A_3") ("ONE" "one0") ("TWO" "two0") ("NEG" "B_1") ("PP" "pp0_4") ("VDD" "VDD") ("VSS" "VSS")) ())
  ("I6" "ALU_CELLS_B" "BOOTH_SEL" (("AJ" "A_5") ("AJM" "A_4") ("ONE" "one0") ("TWO" "two0") ("NEG" "B_1") ("PP" "pp0_5") ("VDD" "VDD") ("VSS" "VSS")) ())
  ("I7" "ALU_CELLS_B" "BOOTH_SEL" (("AJ" "A_6") ("AJM" "A_5") ("ONE" "one0") ("TWO" "two0") ("NEG" "B_1") ("PP" "pp0_6") ("VDD" "VDD") ("VSS" "VSS")) ())
  ("I8" "ALU_CELLS_B" "BOOTH_SEL" (("AJ" "A_7") ("AJM" "A_6") ("ONE" "one0") ("TWO" "two0") ("NEG" "B_1") ("PP" "pp0_7") ("VDD" "VDD") ("VSS" "VSS")) ())
  ("I9" "ALU_CELLS_B" "BOOTH_SEL" (("AJ" "A_7") ("AJM" "A_7") ("ONE" "one0") ("TWO" "two0") ("NEG" "B_1") ("PP" "pp0_8") ("VDD" "VDD") ("VSS" "VSS")) ())
  ("I10" "ALU_CELLS_A" "INV_X1" (("A" "pp0_8") ("Y" "sn0") ("VDD" "VDD") ("VSS" "VSS")) ())
  ("I11" "ALU_CELLS_B" "BOOTH_ENC" (("X2" "B_3") ("X1" "B_2") ("X0" "B_1") ("ONE" "one1") ("TWO" "two1") ("VDD" "VDD") ("VSS" "VSS")) ())
  ("I12" "ALU_CELLS_B" "BOOTH_SEL" (("AJ" "A_0") ("AJM" "VSS") ("ONE" "one1") ("TWO" "two1") ("NEG" "B_3") ("PP" "pp1_0") ("VDD" "VDD") ("VSS" "VSS")) ())
  ("I13" "ALU_CELLS_B" "BOOTH_SEL" (("AJ" "A_1") ("AJM" "A_0") ("ONE" "one1") ("TWO" "two1") ("NEG" "B_3") ("PP" "pp1_1") ("VDD" "VDD") ("VSS" "VSS")) ())
  ("I14" "ALU_CELLS_B" "BOOTH_SEL" (("AJ" "A_2") ("AJM" "A_1") ("ONE" "one1") ("TWO" "two1") ("NEG" "B_3") ("PP" "pp1_2") ("VDD" "VDD") ("VSS" "VSS")) ())
  ("I15" "ALU_CELLS_B" "BOOTH_SEL" (("AJ" "A_3") ("AJM" "A_2") ("ONE" "one1") ("TWO" "two1") ("NEG" "B_3") ("PP" "pp1_3") ("VDD" "VDD") ("VSS" "VSS")) ())
  ("I16" "ALU_CELLS_B" "BOOTH_SEL" (("AJ" "A_4") ("AJM" "A_3") ("ONE" "one1") ("TWO" "two1") ("NEG" "B_3") ("PP" "pp1_4") ("VDD" "VDD") ("VSS" "VSS")) ())
  ("I17" "ALU_CELLS_B" "BOOTH_SEL" (("AJ" "A_5") ("AJM" "A_4") ("ONE" "one1") ("TWO" "two1") ("NEG" "B_3") ("PP" "pp1_5") ("VDD" "VDD") ("VSS" "VSS")) ())
  ("I18" "ALU_CELLS_B" "BOOTH_SEL" (("AJ" "A_6") ("AJM" "A_5") ("ONE" "one1") ("TWO" "two1") ("NEG" "B_3") ("PP" "pp1_6") ("VDD" "VDD") ("VSS" "VSS")) ())
  ("I19" "ALU_CELLS_B" "BOOTH_SEL" (("AJ" "A_7") ("AJM" "A_6") ("ONE" "one1") ("TWO" "two1") ("NEG" "B_3") ("PP" "pp1_7") ("VDD" "VDD") ("VSS" "VSS")) ())
  ("I20" "ALU_CELLS_B" "BOOTH_SEL" (("AJ" "A_7") ("AJM" "A_7") ("ONE" "one1") ("TWO" "two1") ("NEG" "B_3") ("PP" "pp1_8") ("VDD" "VDD") ("VSS" "VSS")) ())
  ("I21" "ALU_CELLS_A" "INV_X1" (("A" "pp1_8") ("Y" "sn1") ("VDD" "VDD") ("VSS" "VSS")) ())
  ("I22" "ALU_CELLS_B" "BOOTH_ENC" (("X2" "B_5") ("X1" "B_4") ("X0" "B_3") ("ONE" "one2") ("TWO" "two2") ("VDD" "VDD") ("VSS" "VSS")) ())
  ("I23" "ALU_CELLS_B" "BOOTH_SEL" (("AJ" "A_0") ("AJM" "VSS") ("ONE" "one2") ("TWO" "two2") ("NEG" "B_5") ("PP" "pp2_0") ("VDD" "VDD") ("VSS" "VSS")) ())
  ("I24" "ALU_CELLS_B" "BOOTH_SEL" (("AJ" "A_1") ("AJM" "A_0") ("ONE" "one2") ("TWO" "two2") ("NEG" "B_5") ("PP" "pp2_1") ("VDD" "VDD") ("VSS" "VSS")) ())
  ("I25" "ALU_CELLS_B" "BOOTH_SEL" (("AJ" "A_2") ("AJM" "A_1") ("ONE" "one2") ("TWO" "two2") ("NEG" "B_5") ("PP" "pp2_2") ("VDD" "VDD") ("VSS" "VSS")) ())
  ("I26" "ALU_CELLS_B" "BOOTH_SEL" (("AJ" "A_3") ("AJM" "A_2") ("ONE" "one2") ("TWO" "two2") ("NEG" "B_5") ("PP" "pp2_3") ("VDD" "VDD") ("VSS" "VSS")) ())
  ("I27" "ALU_CELLS_B" "BOOTH_SEL" (("AJ" "A_4") ("AJM" "A_3") ("ONE" "one2") ("TWO" "two2") ("NEG" "B_5") ("PP" "pp2_4") ("VDD" "VDD") ("VSS" "VSS")) ())
  ("I28" "ALU_CELLS_B" "BOOTH_SEL" (("AJ" "A_5") ("AJM" "A_4") ("ONE" "one2") ("TWO" "two2") ("NEG" "B_5") ("PP" "pp2_5") ("VDD" "VDD") ("VSS" "VSS")) ())
  ("I29" "ALU_CELLS_B" "BOOTH_SEL" (("AJ" "A_6") ("AJM" "A_5") ("ONE" "one2") ("TWO" "two2") ("NEG" "B_5") ("PP" "pp2_6") ("VDD" "VDD") ("VSS" "VSS")) ())
  ("I30" "ALU_CELLS_B" "BOOTH_SEL" (("AJ" "A_7") ("AJM" "A_6") ("ONE" "one2") ("TWO" "two2") ("NEG" "B_5") ("PP" "pp2_7") ("VDD" "VDD") ("VSS" "VSS")) ())
  ("I31" "ALU_CELLS_B" "BOOTH_SEL" (("AJ" "A_7") ("AJM" "A_7") ("ONE" "one2") ("TWO" "two2") ("NEG" "B_5") ("PP" "pp2_8") ("VDD" "VDD") ("VSS" "VSS")) ())
  ("I32" "ALU_CELLS_A" "INV_X1" (("A" "pp2_8") ("Y" "sn2") ("VDD" "VDD") ("VSS" "VSS")) ())
  ("I33" "ALU_CELLS_B" "BOOTH_ENC" (("X2" "B_7") ("X1" "B_6") ("X0" "B_5") ("ONE" "one3") ("TWO" "two3") ("VDD" "VDD") ("VSS" "VSS")) ())
  ("I34" "ALU_CELLS_B" "BOOTH_SEL" (("AJ" "A_0") ("AJM" "VSS") ("ONE" "one3") ("TWO" "two3") ("NEG" "B_7") ("PP" "pp3_0") ("VDD" "VDD") ("VSS" "VSS")) ())
  ("I35" "ALU_CELLS_B" "BOOTH_SEL" (("AJ" "A_1") ("AJM" "A_0") ("ONE" "one3") ("TWO" "two3") ("NEG" "B_7") ("PP" "pp3_1") ("VDD" "VDD") ("VSS" "VSS")) ())
  ("I36" "ALU_CELLS_B" "BOOTH_SEL" (("AJ" "A_2") ("AJM" "A_1") ("ONE" "one3") ("TWO" "two3") ("NEG" "B_7") ("PP" "pp3_2") ("VDD" "VDD") ("VSS" "VSS")) ())
  ("I37" "ALU_CELLS_B" "BOOTH_SEL" (("AJ" "A_3") ("AJM" "A_2") ("ONE" "one3") ("TWO" "two3") ("NEG" "B_7") ("PP" "pp3_3") ("VDD" "VDD") ("VSS" "VSS")) ())
  ("I38" "ALU_CELLS_B" "BOOTH_SEL" (("AJ" "A_4") ("AJM" "A_3") ("ONE" "one3") ("TWO" "two3") ("NEG" "B_7") ("PP" "pp3_4") ("VDD" "VDD") ("VSS" "VSS")) ())
  ("I39" "ALU_CELLS_B" "BOOTH_SEL" (("AJ" "A_5") ("AJM" "A_4") ("ONE" "one3") ("TWO" "two3") ("NEG" "B_7") ("PP" "pp3_5") ("VDD" "VDD") ("VSS" "VSS")) ())
  ("I40" "ALU_CELLS_B" "BOOTH_SEL" (("AJ" "A_6") ("AJM" "A_5") ("ONE" "one3") ("TWO" "two3") ("NEG" "B_7") ("PP" "pp3_6") ("VDD" "VDD") ("VSS" "VSS")) ())
  ("I41" "ALU_CELLS_B" "BOOTH_SEL" (("AJ" "A_7") ("AJM" "A_6") ("ONE" "one3") ("TWO" "two3") ("NEG" "B_7") ("PP" "pp3_7") ("VDD" "VDD") ("VSS" "VSS")) ())
  ("I42" "ALU_CELLS_B" "BOOTH_SEL" (("AJ" "A_7") ("AJM" "A_7") ("ONE" "one3") ("TWO" "two3") ("NEG" "B_7") ("PP" "pp3_8") ("VDD" "VDD") ("VSS" "VSS")) ())
  ("I43" "ALU_CELLS_A" "INV_X1" (("A" "pp3_8") ("Y" "sn3") ("VDD" "VDD") ("VSS" "VSS")) ())
  ("I44" "ALU_CELLS_C" "FA_X1" (("A" "pp0_2") ("B" "pp1_0") ("CI" "B_3") ("S" "fa1_0") ("CO" "fa1_1") ("VDD" "VDD") ("VSS" "VSS")) ())
  ("I45" "ALU_CELLS_C" "HA_X1" (("A" "pp0_3") ("B" "pp1_1") ("S" "ha2_0") ("CO" "ha2_1") ("VDD" "VDD") ("VSS" "VSS")) ())
  ("I46" "ALU_CELLS_C" "FA_X1" (("A" "pp0_4") ("B" "pp1_2") ("CI" "pp2_0") ("S" "fa3_0") ("CO" "fa3_1") ("VDD" "VDD") ("VSS" "VSS")) ())
  ("I47" "ALU_CELLS_C" "FA_X1" (("A" "pp0_5") ("B" "pp1_3") ("CI" "pp2_1") ("S" "fa4_0") ("CO" "fa4_1") ("VDD" "VDD") ("VSS" "VSS")) ())
  ("I48" "ALU_CELLS_B" "CMP42" (("X1" "pp0_6") ("X2" "pp1_4") ("X3" "pp2_2") ("X4" "pp3_0") ("CI" "B_7") ("S" "cm5_0") ("C" "cm5_1") ("CO" "cm5_2") ("VDD" "VDD") ("VSS" "VSS")) ())
  ("I49" "ALU_CELLS_B" "CMP42" (("X1" "pp0_7") ("X2" "pp1_5") ("X3" "pp2_3") ("X4" "pp3_1") ("CI" "cm5_2") ("S" "cm6_0") ("C" "cm6_1") ("CO" "cm6_2") ("VDD" "VDD") ("VSS" "VSS")) ())
  ("I50" "ALU_CELLS_B" "CMP42" (("X1" "pp0_8") ("X2" "pp1_6") ("X3" "pp2_4") ("X4" "pp3_2") ("CI" "cm6_2") ("S" "cm7_0") ("C" "cm7_1") ("CO" "cm7_2") ("VDD" "VDD") ("VSS" "VSS")) ())
  ("I51" "ALU_CELLS_B" "CMP42" (("X1" "pp0_8") ("X2" "pp1_7") ("X3" "pp2_5") ("X4" "pp3_3") ("CI" "cm7_2") ("S" "cm8_0") ("C" "cm8_1") ("CO" "cm8_2") ("VDD" "VDD") ("VSS" "VSS")) ())
  ("I52" "ALU_CELLS_B" "CMP42" (("X1" "pp0_8") ("X2" "pp1_8") ("X3" "pp2_6") ("X4" "pp3_4") ("CI" "cm8_2") ("S" "cm9_0") ("C" "cm9_1") ("CO" "cm9_2") ("VDD" "VDD") ("VSS" "VSS")) ())
  ("I53" "ALU_CELLS_B" "CMP42" (("X1" "sn0") ("X2" "sn1") ("X3" "pp2_7") ("X4" "pp3_5") ("CI" "cm9_2") ("S" "cm10_0") ("C" "cm10_1") ("CO" "cm10_2") ("VDD" "VDD") ("VSS" "VSS")) ())
  ("I54" "ALU_CELLS_B" "CMP42" (("X1" "VDD") ("X2" "pp2_8") ("X3" "pp3_6") ("X4" "VSS") ("CI" "cm10_2") ("S" "cm11_0") ("C" "cm11_1") ("CO" "cm11_2") ("VDD" "VDD") ("VSS" "VSS")) ())
  ("I55" "ALU_CELLS_C" "FA_X1" (("A" "sn2") ("B" "pp3_7") ("CI" "cm11_2") ("S" "fa12_0") ("CO" "fa12_1") ("VDD" "VDD") ("VSS" "VSS")) ())
  ("I56" "ALU_CELLS_C" "HA_X1" (("A" "VDD") ("B" "pp3_8") ("S" "ha13_0") ("CO" "ha13_1") ("VDD" "VDD") ("VSS" "VSS")) ())
  ("I57" "ALU_CELLS_C" "FA_X1" (("A" "ha2_1") ("B" "fa3_0") ("CI" "B_5") ("S" "fa14_0") ("CO" "fa14_1") ("VDD" "VDD") ("VSS" "VSS")) ())
  ("I58" "ALU_CELLS_C" "HA_X1" (("A" "fa3_1") ("B" "fa4_0") ("S" "ha15_0") ("CO" "ha15_1") ("VDD" "VDD") ("VSS" "VSS")) ())
  ("I59" "ALU_CELLS_C" "HA_X1" (("A" "fa4_1") ("B" "cm5_0") ("S" "ha16_0") ("CO" "ha16_1") ("VDD" "VDD") ("VSS" "VSS")) ())
  ("I60" "ALU_CELLS_C" "HA_X1" (("A" "cm5_1") ("B" "cm6_0") ("S" "ha17_0") ("CO" "ha17_1") ("VDD" "VDD") ("VSS" "VSS")) ())
  ("I61" "ALU_CELLS_C" "HA_X1" (("A" "cm6_1") ("B" "cm7_0") ("S" "ha18_0") ("CO" "ha18_1") ("VDD" "VDD") ("VSS" "VSS")) ())
  ("I62" "ALU_CELLS_C" "HA_X1" (("A" "cm7_1") ("B" "cm8_0") ("S" "ha19_0") ("CO" "ha19_1") ("VDD" "VDD") ("VSS" "VSS")) ())
  ("I63" "ALU_CELLS_C" "HA_X1" (("A" "cm8_1") ("B" "cm9_0") ("S" "ha20_0") ("CO" "ha20_1") ("VDD" "VDD") ("VSS" "VSS")) ())
  ("I64" "ALU_CELLS_C" "HA_X1" (("A" "cm9_1") ("B" "cm10_0") ("S" "ha21_0") ("CO" "ha21_1") ("VDD" "VDD") ("VSS" "VSS")) ())
  ("I65" "ALU_CELLS_C" "HA_X1" (("A" "cm10_1") ("B" "cm11_0") ("S" "ha22_0") ("CO" "ha22_1") ("VDD" "VDD") ("VSS" "VSS")) ())
  ("I66" "ALU_CELLS_C" "HA_X1" (("A" "cm11_1") ("B" "fa12_0") ("S" "ha23_0") ("CO" "ha23_1") ("VDD" "VDD") ("VSS" "VSS")) ())
  ("I67" "ALU_CELLS_C" "HA_X1" (("A" "fa12_1") ("B" "ha13_0") ("S" "ha24_0") ("CO" "ha24_1") ("VDD" "VDD") ("VSS" "VSS")) ())
  ("I68" "ALU_CELLS_C" "HA_X1" (("A" "ha13_1") ("B" "sn3") ("S" "ha25_0") ("CO" "ha25_1") ("VDD" "VDD") ("VSS" "VSS")) ())
  ("I69" "ALU_CELLS_C" "HA_X1" (("A" "pp0_0") ("B" "B_1") ("S" "P_0") ("CO" "rc1") ("VDD" "VDD") ("VSS" "VSS")) ())
  ("I70" "ALU_CELLS_C" "HA_X1" (("A" "pp0_1") ("B" "rc1") ("S" "P_1") ("CO" "rc2") ("VDD" "VDD") ("VSS" "VSS")) ())
  ("I71" "ALU_CELLS_C" "HA_X1" (("A" "fa1_0") ("B" "rc2") ("S" "P_2") ("CO" "rc3") ("VDD" "VDD") ("VSS" "VSS")) ())
  ("I72" "ALU_CELLS_C" "FA_X1" (("A" "fa1_1") ("B" "ha2_0") ("CI" "rc3") ("S" "P_3") ("CO" "rc4") ("VDD" "VDD") ("VSS" "VSS")) ())
  ("I73" "ALU_CELLS_C" "HA_X1" (("A" "fa14_0") ("B" "rc4") ("S" "P_4") ("CO" "rc5") ("VDD" "VDD") ("VSS" "VSS")) ())
  ("I74" "ALU_CELLS_C" "FA_X1" (("A" "fa14_1") ("B" "ha15_0") ("CI" "rc5") ("S" "P_5") ("CO" "rc6") ("VDD" "VDD") ("VSS" "VSS")) ())
  ("I75" "ALU_CELLS_C" "FA_X1" (("A" "ha15_1") ("B" "ha16_0") ("CI" "rc6") ("S" "P_6") ("CO" "rc7") ("VDD" "VDD") ("VSS" "VSS")) ())
  ("I76" "ALU_CELLS_C" "FA_X1" (("A" "ha16_1") ("B" "ha17_0") ("CI" "rc7") ("S" "P_7") ("CO" "rc8") ("VDD" "VDD") ("VSS" "VSS")) ())
  ("I77" "ALU_ADD" "KSA8" (("A_0" "ha17_1") ("A_1" "ha18_1") ("A_2" "ha19_1") ("A_3" "ha20_1") ("A_4" "ha21_1") ("A_5" "ha22_1") ("A_6" "ha23_1") ("A_7" "ha24_1") ("B_0" "ha18_0") ("B_1" "ha19_0") ("B_2" "ha20_0") ("B_3" "ha21_0") ("B_4" "ha22_0") ("B_5" "ha23_0") ("B_6" "ha24_0") ("B_7" "ha25_0") ("CIN" "rc8") ("S_0" "P_8") ("S_1" "P_9") ("S_2" "P_10") ("S_3" "P_11") ("S_4" "P_12") ("S_5" "P_13") ("S_6" "P_14") ("S_7" "P_15") ("C7" "kc7") ("C8" "kc8") ("VDD" "VDD") ("VSS" "VSS")) ()))) t)
  sbErrors++ printf("SB_ERROR MUL8: %L\n" errset.errset))
unless(errset(sbCell("ALU_MUL" "MUL8_DADDA" '(("A_0" "input") ("A_1" "input") ("A_2" "input") ("A_3" "input") ("A_4" "input") ("A_5" "input") ("A_6" "input") ("A_7" "input") ("B_0" "input") ("B_1" "input") ("B_2" "input") ("B_3" "input") ("B_4" "input") ("B_5" "input") ("B_6" "input") ("B_7" "input") ("P_0" "output") ("P_1" "output") ("P_2" "output") ("P_3" "output") ("P_4" "output") ("P_5" "output") ("P_6" "output") ("P_7" "output") ("P_8" "output") ("P_9" "output") ("P_10" "output") ("P_11" "output") ("P_12" "output") ("P_13" "output") ("P_14" "output") ("P_15" "output") ("VDD" "inputOutput") ("VSS" "inputOutput"))
 '(
  ("I0" "ALU_CELLS_A" "NAND2_X1" (("A" "A_0") ("B" "B_0") ("Y" "pn0_0") ("VDD" "VDD") ("VSS" "VSS")) ())
  ("I1" "ALU_CELLS_A" "INV_X1" (("A" "pn0_0") ("Y" "P_0") ("VDD" "VDD") ("VSS" "VSS")) ())
  ("I2" "ALU_CELLS_A" "NAND2_X1" (("A" "A_0") ("B" "B_1") ("Y" "pn0_1") ("VDD" "VDD") ("VSS" "VSS")) ())
  ("I3" "ALU_CELLS_A" "INV_X1" (("A" "pn0_1") ("Y" "pp0_1") ("VDD" "VDD") ("VSS" "VSS")) ())
  ("I4" "ALU_CELLS_A" "NAND2_X1" (("A" "A_0") ("B" "B_2") ("Y" "pn0_2") ("VDD" "VDD") ("VSS" "VSS")) ())
  ("I5" "ALU_CELLS_A" "INV_X1" (("A" "pn0_2") ("Y" "pp0_2") ("VDD" "VDD") ("VSS" "VSS")) ())
  ("I6" "ALU_CELLS_A" "NAND2_X1" (("A" "A_0") ("B" "B_3") ("Y" "pn0_3") ("VDD" "VDD") ("VSS" "VSS")) ())
  ("I7" "ALU_CELLS_A" "INV_X1" (("A" "pn0_3") ("Y" "pp0_3") ("VDD" "VDD") ("VSS" "VSS")) ())
  ("I8" "ALU_CELLS_A" "NAND2_X1" (("A" "A_0") ("B" "B_4") ("Y" "pn0_4") ("VDD" "VDD") ("VSS" "VSS")) ())
  ("I9" "ALU_CELLS_A" "INV_X1" (("A" "pn0_4") ("Y" "pp0_4") ("VDD" "VDD") ("VSS" "VSS")) ())
  ("I10" "ALU_CELLS_A" "NAND2_X1" (("A" "A_0") ("B" "B_5") ("Y" "pn0_5") ("VDD" "VDD") ("VSS" "VSS")) ())
  ("I11" "ALU_CELLS_A" "INV_X1" (("A" "pn0_5") ("Y" "pp0_5") ("VDD" "VDD") ("VSS" "VSS")) ())
  ("I12" "ALU_CELLS_A" "NAND2_X1" (("A" "A_0") ("B" "B_6") ("Y" "pn0_6") ("VDD" "VDD") ("VSS" "VSS")) ())
  ("I13" "ALU_CELLS_A" "INV_X1" (("A" "pn0_6") ("Y" "pp0_6") ("VDD" "VDD") ("VSS" "VSS")) ())
  ("I14" "ALU_CELLS_A" "NAND2_X1" (("A" "A_0") ("B" "B_7") ("Y" "pn0_7") ("VDD" "VDD") ("VSS" "VSS")) ())
  ("I15" "ALU_CELLS_A" "NAND2_X1" (("A" "A_1") ("B" "B_0") ("Y" "pn1_0") ("VDD" "VDD") ("VSS" "VSS")) ())
  ("I16" "ALU_CELLS_A" "INV_X1" (("A" "pn1_0") ("Y" "pp1_0") ("VDD" "VDD") ("VSS" "VSS")) ())
  ("I17" "ALU_CELLS_A" "NAND2_X1" (("A" "A_1") ("B" "B_1") ("Y" "pn1_1") ("VDD" "VDD") ("VSS" "VSS")) ())
  ("I18" "ALU_CELLS_A" "INV_X1" (("A" "pn1_1") ("Y" "pp1_1") ("VDD" "VDD") ("VSS" "VSS")) ())
  ("I19" "ALU_CELLS_A" "NAND2_X1" (("A" "A_1") ("B" "B_2") ("Y" "pn1_2") ("VDD" "VDD") ("VSS" "VSS")) ())
  ("I20" "ALU_CELLS_A" "INV_X1" (("A" "pn1_2") ("Y" "pp1_2") ("VDD" "VDD") ("VSS" "VSS")) ())
  ("I21" "ALU_CELLS_A" "NAND2_X1" (("A" "A_1") ("B" "B_3") ("Y" "pn1_3") ("VDD" "VDD") ("VSS" "VSS")) ())
  ("I22" "ALU_CELLS_A" "INV_X1" (("A" "pn1_3") ("Y" "pp1_3") ("VDD" "VDD") ("VSS" "VSS")) ())
  ("I23" "ALU_CELLS_A" "NAND2_X1" (("A" "A_1") ("B" "B_4") ("Y" "pn1_4") ("VDD" "VDD") ("VSS" "VSS")) ())
  ("I24" "ALU_CELLS_A" "INV_X1" (("A" "pn1_4") ("Y" "pp1_4") ("VDD" "VDD") ("VSS" "VSS")) ())
  ("I25" "ALU_CELLS_A" "NAND2_X1" (("A" "A_1") ("B" "B_5") ("Y" "pn1_5") ("VDD" "VDD") ("VSS" "VSS")) ())
  ("I26" "ALU_CELLS_A" "INV_X1" (("A" "pn1_5") ("Y" "pp1_5") ("VDD" "VDD") ("VSS" "VSS")) ())
  ("I27" "ALU_CELLS_A" "NAND2_X1" (("A" "A_1") ("B" "B_6") ("Y" "pn1_6") ("VDD" "VDD") ("VSS" "VSS")) ())
  ("I28" "ALU_CELLS_A" "INV_X1" (("A" "pn1_6") ("Y" "pp1_6") ("VDD" "VDD") ("VSS" "VSS")) ())
  ("I29" "ALU_CELLS_A" "NAND2_X1" (("A" "A_1") ("B" "B_7") ("Y" "pn1_7") ("VDD" "VDD") ("VSS" "VSS")) ())
  ("I30" "ALU_CELLS_A" "NAND2_X1" (("A" "A_2") ("B" "B_0") ("Y" "pn2_0") ("VDD" "VDD") ("VSS" "VSS")) ())
  ("I31" "ALU_CELLS_A" "INV_X1" (("A" "pn2_0") ("Y" "pp2_0") ("VDD" "VDD") ("VSS" "VSS")) ())
  ("I32" "ALU_CELLS_A" "NAND2_X1" (("A" "A_2") ("B" "B_1") ("Y" "pn2_1") ("VDD" "VDD") ("VSS" "VSS")) ())
  ("I33" "ALU_CELLS_A" "INV_X1" (("A" "pn2_1") ("Y" "pp2_1") ("VDD" "VDD") ("VSS" "VSS")) ())
  ("I34" "ALU_CELLS_A" "NAND2_X1" (("A" "A_2") ("B" "B_2") ("Y" "pn2_2") ("VDD" "VDD") ("VSS" "VSS")) ())
  ("I35" "ALU_CELLS_A" "INV_X1" (("A" "pn2_2") ("Y" "pp2_2") ("VDD" "VDD") ("VSS" "VSS")) ())
  ("I36" "ALU_CELLS_A" "NAND2_X1" (("A" "A_2") ("B" "B_3") ("Y" "pn2_3") ("VDD" "VDD") ("VSS" "VSS")) ())
  ("I37" "ALU_CELLS_A" "INV_X1" (("A" "pn2_3") ("Y" "pp2_3") ("VDD" "VDD") ("VSS" "VSS")) ())
  ("I38" "ALU_CELLS_A" "NAND2_X1" (("A" "A_2") ("B" "B_4") ("Y" "pn2_4") ("VDD" "VDD") ("VSS" "VSS")) ())
  ("I39" "ALU_CELLS_A" "INV_X1" (("A" "pn2_4") ("Y" "pp2_4") ("VDD" "VDD") ("VSS" "VSS")) ())
  ("I40" "ALU_CELLS_A" "NAND2_X1" (("A" "A_2") ("B" "B_5") ("Y" "pn2_5") ("VDD" "VDD") ("VSS" "VSS")) ())
  ("I41" "ALU_CELLS_A" "INV_X1" (("A" "pn2_5") ("Y" "pp2_5") ("VDD" "VDD") ("VSS" "VSS")) ())
  ("I42" "ALU_CELLS_A" "NAND2_X1" (("A" "A_2") ("B" "B_6") ("Y" "pn2_6") ("VDD" "VDD") ("VSS" "VSS")) ())
  ("I43" "ALU_CELLS_A" "INV_X1" (("A" "pn2_6") ("Y" "pp2_6") ("VDD" "VDD") ("VSS" "VSS")) ())
  ("I44" "ALU_CELLS_A" "NAND2_X1" (("A" "A_2") ("B" "B_7") ("Y" "pn2_7") ("VDD" "VDD") ("VSS" "VSS")) ())
  ("I45" "ALU_CELLS_A" "NAND2_X1" (("A" "A_3") ("B" "B_0") ("Y" "pn3_0") ("VDD" "VDD") ("VSS" "VSS")) ())
  ("I46" "ALU_CELLS_A" "INV_X1" (("A" "pn3_0") ("Y" "pp3_0") ("VDD" "VDD") ("VSS" "VSS")) ())
  ("I47" "ALU_CELLS_A" "NAND2_X1" (("A" "A_3") ("B" "B_1") ("Y" "pn3_1") ("VDD" "VDD") ("VSS" "VSS")) ())
  ("I48" "ALU_CELLS_A" "INV_X1" (("A" "pn3_1") ("Y" "pp3_1") ("VDD" "VDD") ("VSS" "VSS")) ())
  ("I49" "ALU_CELLS_A" "NAND2_X1" (("A" "A_3") ("B" "B_2") ("Y" "pn3_2") ("VDD" "VDD") ("VSS" "VSS")) ())
  ("I50" "ALU_CELLS_A" "INV_X1" (("A" "pn3_2") ("Y" "pp3_2") ("VDD" "VDD") ("VSS" "VSS")) ())
  ("I51" "ALU_CELLS_A" "NAND2_X1" (("A" "A_3") ("B" "B_3") ("Y" "pn3_3") ("VDD" "VDD") ("VSS" "VSS")) ())
  ("I52" "ALU_CELLS_A" "INV_X1" (("A" "pn3_3") ("Y" "pp3_3") ("VDD" "VDD") ("VSS" "VSS")) ())
  ("I53" "ALU_CELLS_A" "NAND2_X1" (("A" "A_3") ("B" "B_4") ("Y" "pn3_4") ("VDD" "VDD") ("VSS" "VSS")) ())
  ("I54" "ALU_CELLS_A" "INV_X1" (("A" "pn3_4") ("Y" "pp3_4") ("VDD" "VDD") ("VSS" "VSS")) ())
  ("I55" "ALU_CELLS_A" "NAND2_X1" (("A" "A_3") ("B" "B_5") ("Y" "pn3_5") ("VDD" "VDD") ("VSS" "VSS")) ())
  ("I56" "ALU_CELLS_A" "INV_X1" (("A" "pn3_5") ("Y" "pp3_5") ("VDD" "VDD") ("VSS" "VSS")) ())
  ("I57" "ALU_CELLS_A" "NAND2_X1" (("A" "A_3") ("B" "B_6") ("Y" "pn3_6") ("VDD" "VDD") ("VSS" "VSS")) ())
  ("I58" "ALU_CELLS_A" "INV_X1" (("A" "pn3_6") ("Y" "pp3_6") ("VDD" "VDD") ("VSS" "VSS")) ())
  ("I59" "ALU_CELLS_A" "NAND2_X1" (("A" "A_3") ("B" "B_7") ("Y" "pn3_7") ("VDD" "VDD") ("VSS" "VSS")) ())
  ("I60" "ALU_CELLS_A" "NAND2_X1" (("A" "A_4") ("B" "B_0") ("Y" "pn4_0") ("VDD" "VDD") ("VSS" "VSS")) ())
  ("I61" "ALU_CELLS_A" "INV_X1" (("A" "pn4_0") ("Y" "pp4_0") ("VDD" "VDD") ("VSS" "VSS")) ())
  ("I62" "ALU_CELLS_A" "NAND2_X1" (("A" "A_4") ("B" "B_1") ("Y" "pn4_1") ("VDD" "VDD") ("VSS" "VSS")) ())
  ("I63" "ALU_CELLS_A" "INV_X1" (("A" "pn4_1") ("Y" "pp4_1") ("VDD" "VDD") ("VSS" "VSS")) ())
  ("I64" "ALU_CELLS_A" "NAND2_X1" (("A" "A_4") ("B" "B_2") ("Y" "pn4_2") ("VDD" "VDD") ("VSS" "VSS")) ())
  ("I65" "ALU_CELLS_A" "INV_X1" (("A" "pn4_2") ("Y" "pp4_2") ("VDD" "VDD") ("VSS" "VSS")) ())
  ("I66" "ALU_CELLS_A" "NAND2_X1" (("A" "A_4") ("B" "B_3") ("Y" "pn4_3") ("VDD" "VDD") ("VSS" "VSS")) ())
  ("I67" "ALU_CELLS_A" "INV_X1" (("A" "pn4_3") ("Y" "pp4_3") ("VDD" "VDD") ("VSS" "VSS")) ())
  ("I68" "ALU_CELLS_A" "NAND2_X1" (("A" "A_4") ("B" "B_4") ("Y" "pn4_4") ("VDD" "VDD") ("VSS" "VSS")) ())
  ("I69" "ALU_CELLS_A" "INV_X1" (("A" "pn4_4") ("Y" "pp4_4") ("VDD" "VDD") ("VSS" "VSS")) ())
  ("I70" "ALU_CELLS_A" "NAND2_X1" (("A" "A_4") ("B" "B_5") ("Y" "pn4_5") ("VDD" "VDD") ("VSS" "VSS")) ())
  ("I71" "ALU_CELLS_A" "INV_X1" (("A" "pn4_5") ("Y" "pp4_5") ("VDD" "VDD") ("VSS" "VSS")) ())
  ("I72" "ALU_CELLS_A" "NAND2_X1" (("A" "A_4") ("B" "B_6") ("Y" "pn4_6") ("VDD" "VDD") ("VSS" "VSS")) ())
  ("I73" "ALU_CELLS_A" "INV_X1" (("A" "pn4_6") ("Y" "pp4_6") ("VDD" "VDD") ("VSS" "VSS")) ())
  ("I74" "ALU_CELLS_A" "NAND2_X1" (("A" "A_4") ("B" "B_7") ("Y" "pn4_7") ("VDD" "VDD") ("VSS" "VSS")) ())
  ("I75" "ALU_CELLS_A" "NAND2_X1" (("A" "A_5") ("B" "B_0") ("Y" "pn5_0") ("VDD" "VDD") ("VSS" "VSS")) ())
  ("I76" "ALU_CELLS_A" "INV_X1" (("A" "pn5_0") ("Y" "pp5_0") ("VDD" "VDD") ("VSS" "VSS")) ())
  ("I77" "ALU_CELLS_A" "NAND2_X1" (("A" "A_5") ("B" "B_1") ("Y" "pn5_1") ("VDD" "VDD") ("VSS" "VSS")) ())
  ("I78" "ALU_CELLS_A" "INV_X1" (("A" "pn5_1") ("Y" "pp5_1") ("VDD" "VDD") ("VSS" "VSS")) ())
  ("I79" "ALU_CELLS_A" "NAND2_X1" (("A" "A_5") ("B" "B_2") ("Y" "pn5_2") ("VDD" "VDD") ("VSS" "VSS")) ())
  ("I80" "ALU_CELLS_A" "INV_X1" (("A" "pn5_2") ("Y" "pp5_2") ("VDD" "VDD") ("VSS" "VSS")) ())
  ("I81" "ALU_CELLS_A" "NAND2_X1" (("A" "A_5") ("B" "B_3") ("Y" "pn5_3") ("VDD" "VDD") ("VSS" "VSS")) ())
  ("I82" "ALU_CELLS_A" "INV_X1" (("A" "pn5_3") ("Y" "pp5_3") ("VDD" "VDD") ("VSS" "VSS")) ())
  ("I83" "ALU_CELLS_A" "NAND2_X1" (("A" "A_5") ("B" "B_4") ("Y" "pn5_4") ("VDD" "VDD") ("VSS" "VSS")) ())
  ("I84" "ALU_CELLS_A" "INV_X1" (("A" "pn5_4") ("Y" "pp5_4") ("VDD" "VDD") ("VSS" "VSS")) ())
  ("I85" "ALU_CELLS_A" "NAND2_X1" (("A" "A_5") ("B" "B_5") ("Y" "pn5_5") ("VDD" "VDD") ("VSS" "VSS")) ())
  ("I86" "ALU_CELLS_A" "INV_X1" (("A" "pn5_5") ("Y" "pp5_5") ("VDD" "VDD") ("VSS" "VSS")) ())
  ("I87" "ALU_CELLS_A" "NAND2_X1" (("A" "A_5") ("B" "B_6") ("Y" "pn5_6") ("VDD" "VDD") ("VSS" "VSS")) ())
  ("I88" "ALU_CELLS_A" "INV_X1" (("A" "pn5_6") ("Y" "pp5_6") ("VDD" "VDD") ("VSS" "VSS")) ())
  ("I89" "ALU_CELLS_A" "NAND2_X1" (("A" "A_5") ("B" "B_7") ("Y" "pn5_7") ("VDD" "VDD") ("VSS" "VSS")) ())
  ("I90" "ALU_CELLS_A" "NAND2_X1" (("A" "A_6") ("B" "B_0") ("Y" "pn6_0") ("VDD" "VDD") ("VSS" "VSS")) ())
  ("I91" "ALU_CELLS_A" "INV_X1" (("A" "pn6_0") ("Y" "pp6_0") ("VDD" "VDD") ("VSS" "VSS")) ())
  ("I92" "ALU_CELLS_A" "NAND2_X1" (("A" "A_6") ("B" "B_1") ("Y" "pn6_1") ("VDD" "VDD") ("VSS" "VSS")) ())
  ("I93" "ALU_CELLS_A" "INV_X1" (("A" "pn6_1") ("Y" "pp6_1") ("VDD" "VDD") ("VSS" "VSS")) ())
  ("I94" "ALU_CELLS_A" "NAND2_X1" (("A" "A_6") ("B" "B_2") ("Y" "pn6_2") ("VDD" "VDD") ("VSS" "VSS")) ())
  ("I95" "ALU_CELLS_A" "INV_X1" (("A" "pn6_2") ("Y" "pp6_2") ("VDD" "VDD") ("VSS" "VSS")) ())
  ("I96" "ALU_CELLS_A" "NAND2_X1" (("A" "A_6") ("B" "B_3") ("Y" "pn6_3") ("VDD" "VDD") ("VSS" "VSS")) ())
  ("I97" "ALU_CELLS_A" "INV_X1" (("A" "pn6_3") ("Y" "pp6_3") ("VDD" "VDD") ("VSS" "VSS")) ())
  ("I98" "ALU_CELLS_A" "NAND2_X1" (("A" "A_6") ("B" "B_4") ("Y" "pn6_4") ("VDD" "VDD") ("VSS" "VSS")) ())
  ("I99" "ALU_CELLS_A" "INV_X1" (("A" "pn6_4") ("Y" "pp6_4") ("VDD" "VDD") ("VSS" "VSS")) ())
  ("I100" "ALU_CELLS_A" "NAND2_X1" (("A" "A_6") ("B" "B_5") ("Y" "pn6_5") ("VDD" "VDD") ("VSS" "VSS")) ())
  ("I101" "ALU_CELLS_A" "INV_X1" (("A" "pn6_5") ("Y" "pp6_5") ("VDD" "VDD") ("VSS" "VSS")) ())
  ("I102" "ALU_CELLS_A" "NAND2_X1" (("A" "A_6") ("B" "B_6") ("Y" "pn6_6") ("VDD" "VDD") ("VSS" "VSS")) ())
  ("I103" "ALU_CELLS_A" "INV_X1" (("A" "pn6_6") ("Y" "pp6_6") ("VDD" "VDD") ("VSS" "VSS")) ())
  ("I104" "ALU_CELLS_A" "NAND2_X1" (("A" "A_6") ("B" "B_7") ("Y" "pn6_7") ("VDD" "VDD") ("VSS" "VSS")) ())
  ("I105" "ALU_CELLS_A" "NAND2_X1" (("A" "A_7") ("B" "B_0") ("Y" "pn7_0") ("VDD" "VDD") ("VSS" "VSS")) ())
  ("I106" "ALU_CELLS_A" "NAND2_X1" (("A" "A_7") ("B" "B_1") ("Y" "pn7_1") ("VDD" "VDD") ("VSS" "VSS")) ())
  ("I107" "ALU_CELLS_A" "NAND2_X1" (("A" "A_7") ("B" "B_2") ("Y" "pn7_2") ("VDD" "VDD") ("VSS" "VSS")) ())
  ("I108" "ALU_CELLS_A" "NAND2_X1" (("A" "A_7") ("B" "B_3") ("Y" "pn7_3") ("VDD" "VDD") ("VSS" "VSS")) ())
  ("I109" "ALU_CELLS_A" "NAND2_X1" (("A" "A_7") ("B" "B_4") ("Y" "pn7_4") ("VDD" "VDD") ("VSS" "VSS")) ())
  ("I110" "ALU_CELLS_A" "NAND2_X1" (("A" "A_7") ("B" "B_5") ("Y" "pn7_5") ("VDD" "VDD") ("VSS" "VSS")) ())
  ("I111" "ALU_CELLS_A" "NAND2_X1" (("A" "A_7") ("B" "B_6") ("Y" "pn7_6") ("VDD" "VDD") ("VSS" "VSS")) ())
  ("I112" "ALU_CELLS_A" "NAND2_X1" (("A" "A_7") ("B" "B_7") ("Y" "pn7_7") ("VDD" "VDD") ("VSS" "VSS")) ())
  ("I113" "ALU_CELLS_A" "INV_X1" (("A" "pn7_7") ("Y" "pp7_7") ("VDD" "VDD") ("VSS" "VSS")) ())
  ("I114" "ALU_CELLS_C" "HA_X1" (("A" "pp0_6") ("B" "pp1_5") ("S" "d1_s") ("CO" "d1_c") ("VDD" "VDD") ("VSS" "VSS")) ())
  ("I115" "ALU_CELLS_C" "FA_X1" (("A" "pn0_7") ("B" "pp1_6") ("CI" "pp2_5") ("S" "d2_s") ("CO" "d2_c") ("VDD" "VDD") ("VSS" "VSS")) ())
  ("I116" "ALU_CELLS_C" "HA_X1" (("A" "pp3_4") ("B" "pp4_3") ("S" "d3_s") ("CO" "d3_c") ("VDD" "VDD") ("VSS" "VSS")) ())
  ("I117" "ALU_CELLS_C" "FA_X1" (("A" "pn1_7") ("B" "pp2_6") ("CI" "pp3_5") ("S" "d4_s") ("CO" "d4_c") ("VDD" "VDD") ("VSS" "VSS")) ())
  ("I118" "ALU_CELLS_C" "FA_X1" (("A" "pp4_4") ("B" "pp5_3") ("CI" "pp6_2") ("S" "d5_s") ("CO" "d5_c") ("VDD" "VDD") ("VSS" "VSS")) ())
  ("I119" "ALU_CELLS_C" "FA_X1" (("A" "pn2_7") ("B" "pp3_6") ("CI" "pp4_5") ("S" "d6_s") ("CO" "d6_c") ("VDD" "VDD") ("VSS" "VSS")) ())
  ("I120" "ALU_CELLS_C" "HA_X1" (("A" "pp0_4") ("B" "pp1_3") ("S" "d7_s") ("CO" "d7_c") ("VDD" "VDD") ("VSS" "VSS")) ())
  ("I121" "ALU_CELLS_C" "FA_X1" (("A" "pp0_5") ("B" "pp1_4") ("CI" "pp2_3") ("S" "d8_s") ("CO" "d8_c") ("VDD" "VDD") ("VSS" "VSS")) ())
  ("I122" "ALU_CELLS_C" "HA_X1" (("A" "pp3_2") ("B" "pp4_1") ("S" "d9_s") ("CO" "d9_c") ("VDD" "VDD") ("VSS" "VSS")) ())
  ("I123" "ALU_CELLS_C" "FA_X1" (("A" "d1_s") ("B" "pp2_4") ("CI" "pp3_3") ("S" "d10_s") ("CO" "d10_c") ("VDD" "VDD") ("VSS" "VSS")) ())
  ("I124" "ALU_CELLS_C" "FA_X1" (("A" "pp4_2") ("B" "pp5_1") ("CI" "pp6_0") ("S" "d11_s") ("CO" "d11_c") ("VDD" "VDD") ("VSS" "VSS")) ())
  ("I125" "ALU_CELLS_C" "FA_X1" (("A" "d1_c") ("B" "d2_s") ("CI" "d3_s") ("S" "d12_s") ("CO" "d12_c") ("VDD" "VDD") ("VSS" "VSS")) ())
  ("I126" "ALU_CELLS_C" "FA_X1" (("A" "pp5_2") ("B" "pp6_1") ("CI" "pn7_0") ("S" "d13_s") ("CO" "d13_c") ("VDD" "VDD") ("VSS" "VSS")) ())
  ("I127" "ALU_CELLS_C" "FA_X1" (("A" "d2_c") ("B" "d3_c") ("CI" "d4_s") ("S" "d14_s") ("CO" "d14_c") ("VDD" "VDD") ("VSS" "VSS")) ())
  ("I128" "ALU_CELLS_C" "FA_X1" (("A" "d5_s") ("B" "pn7_1") ("CI" "VDD") ("S" "d15_s") ("CO" "d15_c") ("VDD" "VDD") ("VSS" "VSS")) ())
  ("I129" "ALU_CELLS_C" "FA_X1" (("A" "d4_c") ("B" "d5_c") ("CI" "d6_s") ("S" "d16_s") ("CO" "d16_c") ("VDD" "VDD") ("VSS" "VSS")) ())
  ("I130" "ALU_CELLS_C" "FA_X1" (("A" "pp5_4") ("B" "pp6_3") ("CI" "pn7_2") ("S" "d17_s") ("CO" "d17_c") ("VDD" "VDD") ("VSS" "VSS")) ())
  ("I131" "ALU_CELLS_C" "FA_X1" (("A" "d6_c") ("B" "pn3_7") ("CI" "pp4_6") ("S" "d18_s") ("CO" "d18_c") ("VDD" "VDD") ("VSS" "VSS")) ())
  ("I132" "ALU_CELLS_C" "FA_X1" (("A" "pp5_5") ("B" "pp6_4") ("CI" "pn7_3") ("S" "d19_s") ("CO" "d19_c") ("VDD" "VDD") ("VSS" "VSS")) ())
  ("I133" "ALU_CELLS_C" "FA_X1" (("A" "pn4_7") ("B" "pp5_6") ("CI" "pp6_5") ("S" "d20_s") ("CO" "d20_c") ("VDD" "VDD") ("VSS" "VSS")) ())
  ("I134" "ALU_CELLS_C" "HA_X1" (("A" "pp0_3") ("B" "pp1_2") ("S" "d21_s") ("CO" "d21_c") ("VDD" "VDD") ("VSS" "VSS")) ())
  ("I135" "ALU_CELLS_C" "FA_X1" (("A" "d7_s") ("B" "pp2_2") ("CI" "pp3_1") ("S" "d22_s") ("CO" "d22_c") ("VDD" "VDD") ("VSS" "VSS")) ())
  ("I136" "ALU_CELLS_C" "FA_X1" (("A" "d7_c") ("B" "d8_s") ("CI" "d9_s") ("S" "d23_s") ("CO" "d23_c") ("VDD" "VDD") ("VSS" "VSS")) ())
  ("I137" "ALU_CELLS_C" "FA_X1" (("A" "d8_c") ("B" "d9_c") ("CI" "d10_s") ("S" "d24_s") ("CO" "d24_c") ("VDD" "VDD") ("VSS" "VSS")) ())
  ("I138" "ALU_CELLS_C" "FA_X1" (("A" "d10_c") ("B" "d11_c") ("CI" "d12_s") ("S" "d25_s") ("CO" "d25_c") ("VDD" "VDD") ("VSS" "VSS")) ())
  ("I139" "ALU_CELLS_C" "FA_X1" (("A" "d12_c") ("B" "d13_c") ("CI" "d14_s") ("S" "d26_s") ("CO" "d26_c") ("VDD" "VDD") ("VSS" "VSS")) ())
  ("I140" "ALU_CELLS_C" "FA_X1" (("A" "d14_c") ("B" "d15_c") ("CI" "d16_s") ("S" "d27_s") ("CO" "d27_c") ("VDD" "VDD") ("VSS" "VSS")) ())
  ("I141" "ALU_CELLS_C" "FA_X1" (("A" "d16_c") ("B" "d17_c") ("CI" "d18_s") ("S" "d28_s") ("CO" "d28_c") ("VDD" "VDD") ("VSS" "VSS")) ())
  ("I142" "ALU_CELLS_C" "FA_X1" (("A" "d18_c") ("B" "d19_c") ("CI" "d20_s") ("S" "d29_s") ("CO" "d29_c") ("VDD" "VDD") ("VSS" "VSS")) ())
  ("I143" "ALU_CELLS_C" "FA_X1" (("A" "d20_c") ("B" "pn5_7") ("CI" "pp6_6") ("S" "d30_s") ("CO" "d30_c") ("VDD" "VDD") ("VSS" "VSS")) ())
  ("I144" "ALU_CELLS_C" "HA_X1" (("A" "pp0_2") ("B" "pp1_1") ("S" "d31_s") ("CO" "d31_c") ("VDD" "VDD") ("VSS" "VSS")) ())
  ("I145" "ALU_CELLS_C" "FA_X1" (("A" "d21_s") ("B" "pp2_1") ("CI" "pp3_0") ("S" "d32_s") ("CO" "d32_c") ("VDD" "VDD") ("VSS" "VSS")) ())
  ("I146" "ALU_CELLS_C" "FA_X1" (("A" "d21_c") ("B" "d22_s") ("CI" "pp4_0") ("S" "d33_s") ("CO" "d33_c") ("VDD" "VDD") ("VSS" "VSS")) ())
  ("I147" "ALU_CELLS_C" "FA_X1" (("A" "d22_c") ("B" "d23_s") ("CI" "pp5_0") ("S" "d34_s") ("CO" "d34_c") ("VDD" "VDD") ("VSS" "VSS")) ())
  ("I148" "ALU_CELLS_C" "FA_X1" (("A" "d23_c") ("B" "d24_s") ("CI" "d11_s") ("S" "d35_s") ("CO" "d35_c") ("VDD" "VDD") ("VSS" "VSS")) ())
  ("I149" "ALU_CELLS_C" "FA_X1" (("A" "d24_c") ("B" "d25_s") ("CI" "d13_s") ("S" "d36_s") ("CO" "d36_c") ("VDD" "VDD") ("VSS" "VSS")) ())
  ("I150" "ALU_CELLS_C" "FA_X1" (("A" "d25_c") ("B" "d26_s") ("CI" "d15_s") ("S" "d37_s") ("CO" "d37_c") ("VDD" "VDD") ("VSS" "VSS")) ())
  ("I151" "ALU_CELLS_C" "FA_X1" (("A" "d26_c") ("B" "d27_s") ("CI" "d17_s") ("S" "d38_s") ("CO" "d38_c") ("VDD" "VDD") ("VSS" "VSS")) ())
  ("I152" "ALU_CELLS_C" "FA_X1" (("A" "d27_c") ("B" "d28_s") ("CI" "d19_s") ("S" "d39_s") ("CO" "d39_c") ("VDD" "VDD") ("VSS" "VSS")) ())
  ("I153" "ALU_CELLS_C" "FA_X1" (("A" "d28_c") ("B" "d29_s") ("CI" "pn7_4") ("S" "d40_s") ("CO" "d40_c") ("VDD" "VDD") ("VSS" "VSS")) ())
  ("I154" "ALU_CELLS_C" "FA_X1" (("A" "d29_c") ("B" "d30_s") ("CI" "pn7_5") ("S" "d41_s") ("CO" "d41_c") ("VDD" "VDD") ("VSS" "VSS")) ())
  ("I155" "ALU_CELLS_C" "FA_X1" (("A" "d30_c") ("B" "pn6_7") ("CI" "pn7_6") ("S" "d42_s") ("CO" "d42_c") ("VDD" "VDD") ("VSS" "VSS")) ())
  ("I156" "ALU_CELLS_C" "HA_X1" (("A" "pp0_1") ("B" "pp1_0") ("S" "P_1") ("CO" "rc2") ("VDD" "VDD") ("VSS" "VSS")) ())
  ("I157" "ALU_CELLS_C" "FA_X1" (("A" "d31_s") ("B" "pp2_0") ("CI" "rc2") ("S" "P_2") ("CO" "rc3") ("VDD" "VDD") ("VSS" "VSS")) ())
  ("I158" "ALU_CELLS_C" "FA_X1" (("A" "d31_c") ("B" "d32_s") ("CI" "rc3") ("S" "P_3") ("CO" "rc4") ("VDD" "VDD") ("VSS" "VSS")) ())
  ("I159" "ALU_CELLS_C" "FA_X1" (("A" "d32_c") ("B" "d33_s") ("CI" "rc4") ("S" "P_4") ("CO" "rc5") ("VDD" "VDD") ("VSS" "VSS")) ())
  ("I160" "ALU_CELLS_C" "FA_X1" (("A" "d33_c") ("B" "d34_s") ("CI" "rc5") ("S" "P_5") ("CO" "rc6") ("VDD" "VDD") ("VSS" "VSS")) ())
  ("I161" "ALU_CELLS_C" "FA_X1" (("A" "d34_c") ("B" "d35_s") ("CI" "rc6") ("S" "P_6") ("CO" "rc7") ("VDD" "VDD") ("VSS" "VSS")) ())
  ("I162" "ALU_CELLS_C" "FA_X1" (("A" "d35_c") ("B" "d36_s") ("CI" "rc7") ("S" "P_7") ("CO" "rc8") ("VDD" "VDD") ("VSS" "VSS")) ())
  ("I163" "ALU_ADD" "KSA8" (("A_0" "d36_c") ("A_1" "d37_c") ("A_2" "d38_c") ("A_3" "d39_c") ("A_4" "d40_c") ("A_5" "d41_c") ("A_6" "d42_c") ("A_7" "VDD") ("B_0" "d37_s") ("B_1" "d38_s") ("B_2" "d39_s") ("B_3" "d40_s") ("B_4" "d41_s") ("B_5" "d42_s") ("B_6" "pp7_7") ("B_7" "VSS") ("CIN" "rc8") ("S_0" "P_8") ("S_1" "P_9") ("S_2" "P_10") ("S_3" "P_11") ("S_4" "P_12") ("S_5" "P_13") ("S_6" "P_14") ("S_7" "P_15") ("C7" "kc7") ("C8" "kc8") ("VDD" "VDD") ("VSS" "VSS")) ()))) t)
  sbErrors++ printf("SB_ERROR MUL8_DADDA: %L\n" errset.errset))
unless(errset(sbCell("ALU_DIV" "DIV8" '(("A_0" "input") ("A_1" "input") ("A_2" "input") ("A_3" "input") ("A_4" "input") ("A_5" "input") ("A_6" "input") ("A_7" "input") ("B_0" "input") ("B_1" "input") ("B_2" "input") ("B_3" "input") ("B_4" "input") ("B_5" "input") ("B_6" "input") ("B_7" "input") ("Q_0" "output") ("Q_1" "output") ("Q_2" "output") ("Q_3" "output") ("Q_4" "output") ("Q_5" "output") ("Q_6" "output") ("Q_7" "output") ("R_0" "output") ("R_1" "output") ("R_2" "output") ("R_3" "output") ("R_4" "output") ("R_5" "output") ("R_6" "output") ("R_7" "output") ("V" "output") ("DZ" "output") ("VDD" "inputOutput") ("VSS" "inputOutput"))
 '(
  ("I0" "ALU_CELLS_A" "NAND2_X1" (("A" "A_7") ("B" "A_0") ("Y" "nakn1") ("VDD" "VDD") ("VSS" "VSS")) ())
  ("I1" "ALU_STUB_B" "XNOR2_X1" (("A" "A_1") ("B" "nakn1") ("Y" "aa1") ("VDD" "VDD") ("VSS" "VSS")) ())
  ("I2" "ALU_CELLS_A" "INV_X1" (("A" "nakn1") ("Y" "nak1") ("VDD" "VDD") ("VSS" "VSS")) ())
  ("I3" "ALU_CELLS_A" "AOI21_X1" (("A1" "A_7") ("A2" "A_1") ("B" "nak1") ("Y" "nakn2") ("VDD" "VDD") ("VSS" "VSS")) ())
  ("I4" "ALU_STUB_B" "XNOR2_X1" (("A" "A_2") ("B" "nakn2") ("Y" "aa2") ("VDD" "VDD") ("VSS" "VSS")) ())
  ("I5" "ALU_CELLS_A" "INV_X1" (("A" "nakn2") ("Y" "nak2") ("VDD" "VDD") ("VSS" "VSS")) ())
  ("I6" "ALU_CELLS_A" "AOI21_X1" (("A1" "A_7") ("A2" "A_2") ("B" "nak2") ("Y" "nakn3") ("VDD" "VDD") ("VSS" "VSS")) ())
  ("I7" "ALU_STUB_B" "XNOR2_X1" (("A" "A_3") ("B" "nakn3") ("Y" "aa3") ("VDD" "VDD") ("VSS" "VSS")) ())
  ("I8" "ALU_CELLS_A" "INV_X1" (("A" "nakn3") ("Y" "nak3") ("VDD" "VDD") ("VSS" "VSS")) ())
  ("I9" "ALU_CELLS_A" "AOI21_X1" (("A1" "A_7") ("A2" "A_3") ("B" "nak3") ("Y" "nakn4") ("VDD" "VDD") ("VSS" "VSS")) ())
  ("I10" "ALU_STUB_B" "XNOR2_X1" (("A" "A_4") ("B" "nakn4") ("Y" "aa4") ("VDD" "VDD") ("VSS" "VSS")) ())
  ("I11" "ALU_CELLS_A" "INV_X1" (("A" "nakn4") ("Y" "nak4") ("VDD" "VDD") ("VSS" "VSS")) ())
  ("I12" "ALU_CELLS_A" "AOI21_X1" (("A1" "A_7") ("A2" "A_4") ("B" "nak4") ("Y" "nakn5") ("VDD" "VDD") ("VSS" "VSS")) ())
  ("I13" "ALU_STUB_B" "XNOR2_X1" (("A" "A_5") ("B" "nakn5") ("Y" "aa5") ("VDD" "VDD") ("VSS" "VSS")) ())
  ("I14" "ALU_CELLS_A" "INV_X1" (("A" "nakn5") ("Y" "nak5") ("VDD" "VDD") ("VSS" "VSS")) ())
  ("I15" "ALU_CELLS_A" "AOI21_X1" (("A1" "A_7") ("A2" "A_5") ("B" "nak5") ("Y" "nakn6") ("VDD" "VDD") ("VSS" "VSS")) ())
  ("I16" "ALU_STUB_B" "XNOR2_X1" (("A" "A_6") ("B" "nakn6") ("Y" "aa6") ("VDD" "VDD") ("VSS" "VSS")) ())
  ("I17" "ALU_CELLS_A" "INV_X1" (("A" "nakn6") ("Y" "nak6") ("VDD" "VDD") ("VSS" "VSS")) ())
  ("I18" "ALU_CELLS_A" "AOI21_X1" (("A1" "A_7") ("A2" "A_6") ("B" "nak6") ("Y" "nakn7") ("VDD" "VDD") ("VSS" "VSS")) ())
  ("I19" "ALU_STUB_B" "XNOR2_X1" (("A" "A_7") ("B" "nakn7") ("Y" "aa7") ("VDD" "VDD") ("VSS" "VSS")) ())
  ("I20" "ALU_CELLS_A" "NAND2_X1" (("A" "B_7") ("B" "B_0") ("Y" "nbkn1") ("VDD" "VDD") ("VSS" "VSS")) ())
  ("I21" "ALU_STUB_B" "XNOR2_X1" (("A" "B_1") ("B" "nbkn1") ("Y" "dd1") ("VDD" "VDD") ("VSS" "VSS")) ())
  ("I22" "ALU_CELLS_A" "INV_X1" (("A" "nbkn1") ("Y" "nbk1") ("VDD" "VDD") ("VSS" "VSS")) ())
  ("I23" "ALU_CELLS_A" "AOI21_X1" (("A1" "B_7") ("A2" "B_1") ("B" "nbk1") ("Y" "nbkn2") ("VDD" "VDD") ("VSS" "VSS")) ())
  ("I24" "ALU_STUB_B" "XNOR2_X1" (("A" "B_2") ("B" "nbkn2") ("Y" "dd2") ("VDD" "VDD") ("VSS" "VSS")) ())
  ("I25" "ALU_CELLS_A" "INV_X1" (("A" "nbkn2") ("Y" "nbk2") ("VDD" "VDD") ("VSS" "VSS")) ())
  ("I26" "ALU_CELLS_A" "AOI21_X1" (("A1" "B_7") ("A2" "B_2") ("B" "nbk2") ("Y" "nbkn3") ("VDD" "VDD") ("VSS" "VSS")) ())
  ("I27" "ALU_STUB_B" "XNOR2_X1" (("A" "B_3") ("B" "nbkn3") ("Y" "dd3") ("VDD" "VDD") ("VSS" "VSS")) ())
  ("I28" "ALU_CELLS_A" "INV_X1" (("A" "nbkn3") ("Y" "nbk3") ("VDD" "VDD") ("VSS" "VSS")) ())
  ("I29" "ALU_CELLS_A" "AOI21_X1" (("A1" "B_7") ("A2" "B_3") ("B" "nbk3") ("Y" "nbkn4") ("VDD" "VDD") ("VSS" "VSS")) ())
  ("I30" "ALU_STUB_B" "XNOR2_X1" (("A" "B_4") ("B" "nbkn4") ("Y" "dd4") ("VDD" "VDD") ("VSS" "VSS")) ())
  ("I31" "ALU_CELLS_A" "INV_X1" (("A" "nbkn4") ("Y" "nbk4") ("VDD" "VDD") ("VSS" "VSS")) ())
  ("I32" "ALU_CELLS_A" "AOI21_X1" (("A1" "B_7") ("A2" "B_4") ("B" "nbk4") ("Y" "nbkn5") ("VDD" "VDD") ("VSS" "VSS")) ())
  ("I33" "ALU_STUB_B" "XNOR2_X1" (("A" "B_5") ("B" "nbkn5") ("Y" "dd5") ("VDD" "VDD") ("VSS" "VSS")) ())
  ("I34" "ALU_CELLS_A" "INV_X1" (("A" "nbkn5") ("Y" "nbk5") ("VDD" "VDD") ("VSS" "VSS")) ())
  ("I35" "ALU_CELLS_A" "AOI21_X1" (("A1" "B_7") ("A2" "B_5") ("B" "nbk5") ("Y" "nbkn6") ("VDD" "VDD") ("VSS" "VSS")) ())
  ("I36" "ALU_STUB_B" "XNOR2_X1" (("A" "B_6") ("B" "nbkn6") ("Y" "dd6") ("VDD" "VDD") ("VSS" "VSS")) ())
  ("I37" "ALU_CELLS_A" "INV_X1" (("A" "nbkn6") ("Y" "nbk6") ("VDD" "VDD") ("VSS" "VSS")) ())
  ("I38" "ALU_CELLS_A" "AOI21_X1" (("A1" "B_7") ("A2" "B_6") ("B" "nbk6") ("Y" "nbkn7") ("VDD" "VDD") ("VSS" "VSS")) ())
  ("I39" "ALU_STUB_B" "XNOR2_X1" (("A" "B_7") ("B" "nbkn7") ("Y" "dd7") ("VDD" "VDD") ("VSS" "VSS")) ())
  ("I40" "ALU_CELLS_D" "CAS_X1" (("X" "aa7") ("D" "B_0") ("T" "VDD") ("CI" "VDD") ("S" "p0_0") ("CO" "c0_0") ("VDD" "VDD") ("VSS" "VSS")) ())
  ("I41" "ALU_CELLS_D" "CAS_X1" (("X" "VSS") ("D" "dd1") ("T" "VDD") ("CI" "c0_0") ("S" "p0_1") ("CO" "c0_1") ("VDD" "VDD") ("VSS" "VSS")) ())
  ("I42" "ALU_CELLS_D" "CAS_X1" (("X" "VSS") ("D" "dd2") ("T" "VDD") ("CI" "c0_1") ("S" "p0_2") ("CO" "c0_2") ("VDD" "VDD") ("VSS" "VSS")) ())
  ("I43" "ALU_CELLS_D" "CAS_X1" (("X" "VSS") ("D" "dd3") ("T" "VDD") ("CI" "c0_2") ("S" "p0_3") ("CO" "c0_3") ("VDD" "VDD") ("VSS" "VSS")) ())
  ("I44" "ALU_CELLS_D" "CAS_X1" (("X" "VSS") ("D" "dd4") ("T" "VDD") ("CI" "c0_3") ("S" "p0_4") ("CO" "c0_4") ("VDD" "VDD") ("VSS" "VSS")) ())
  ("I45" "ALU_CELLS_D" "CAS_X1" (("X" "VSS") ("D" "dd5") ("T" "VDD") ("CI" "c0_4") ("S" "p0_5") ("CO" "c0_5") ("VDD" "VDD") ("VSS" "VSS")) ())
  ("I46" "ALU_CELLS_D" "CAS_X1" (("X" "VSS") ("D" "dd6") ("T" "VDD") ("CI" "c0_5") ("S" "p0_6") ("CO" "c0_6") ("VDD" "VDD") ("VSS" "VSS")) ())
  ("I47" "ALU_CELLS_D" "CAS_X1" (("X" "VSS") ("D" "dd7") ("T" "VDD") ("CI" "c0_6") ("S" "p0_7") ("CO" "c0_7") ("VDD" "VDD") ("VSS" "VSS")) ())
  ("I48" "ALU_CELLS_D" "CAS_X1" (("X" "VSS") ("D" "VSS") ("T" "VDD") ("CI" "c0_7") ("S" "p0_8") ("CO" "c0_8") ("VDD" "VDD") ("VSS" "VSS")) ())
  ("I49" "ALU_CELLS_A" "INV_X1" (("A" "p0_8") ("Y" "qu7") ("VDD" "VDD") ("VSS" "VSS")) ())
  ("I50" "ALU_CELLS_D" "CAS_X1" (("X" "aa6") ("D" "B_0") ("T" "qu7") ("CI" "qu7") ("S" "p1_0") ("CO" "c1_0") ("VDD" "VDD") ("VSS" "VSS")) ())
  ("I51" "ALU_CELLS_D" "CAS_X1" (("X" "p0_0") ("D" "dd1") ("T" "qu7") ("CI" "c1_0") ("S" "p1_1") ("CO" "c1_1") ("VDD" "VDD") ("VSS" "VSS")) ())
  ("I52" "ALU_CELLS_D" "CAS_X1" (("X" "p0_1") ("D" "dd2") ("T" "qu7") ("CI" "c1_1") ("S" "p1_2") ("CO" "c1_2") ("VDD" "VDD") ("VSS" "VSS")) ())
  ("I53" "ALU_CELLS_D" "CAS_X1" (("X" "p0_2") ("D" "dd3") ("T" "qu7") ("CI" "c1_2") ("S" "p1_3") ("CO" "c1_3") ("VDD" "VDD") ("VSS" "VSS")) ())
  ("I54" "ALU_CELLS_D" "CAS_X1" (("X" "p0_3") ("D" "dd4") ("T" "qu7") ("CI" "c1_3") ("S" "p1_4") ("CO" "c1_4") ("VDD" "VDD") ("VSS" "VSS")) ())
  ("I55" "ALU_CELLS_D" "CAS_X1" (("X" "p0_4") ("D" "dd5") ("T" "qu7") ("CI" "c1_4") ("S" "p1_5") ("CO" "c1_5") ("VDD" "VDD") ("VSS" "VSS")) ())
  ("I56" "ALU_CELLS_D" "CAS_X1" (("X" "p0_5") ("D" "dd6") ("T" "qu7") ("CI" "c1_5") ("S" "p1_6") ("CO" "c1_6") ("VDD" "VDD") ("VSS" "VSS")) ())
  ("I57" "ALU_CELLS_D" "CAS_X1" (("X" "p0_6") ("D" "dd7") ("T" "qu7") ("CI" "c1_6") ("S" "p1_7") ("CO" "c1_7") ("VDD" "VDD") ("VSS" "VSS")) ())
  ("I58" "ALU_CELLS_D" "CAS_X1" (("X" "p0_7") ("D" "VSS") ("T" "qu7") ("CI" "c1_7") ("S" "p1_8") ("CO" "c1_8") ("VDD" "VDD") ("VSS" "VSS")) ())
  ("I59" "ALU_CELLS_A" "INV_X1" (("A" "p1_8") ("Y" "qu6") ("VDD" "VDD") ("VSS" "VSS")) ())
  ("I60" "ALU_CELLS_D" "CAS_X1" (("X" "aa5") ("D" "B_0") ("T" "qu6") ("CI" "qu6") ("S" "p2_0") ("CO" "c2_0") ("VDD" "VDD") ("VSS" "VSS")) ())
  ("I61" "ALU_CELLS_D" "CAS_X1" (("X" "p1_0") ("D" "dd1") ("T" "qu6") ("CI" "c2_0") ("S" "p2_1") ("CO" "c2_1") ("VDD" "VDD") ("VSS" "VSS")) ())
  ("I62" "ALU_CELLS_D" "CAS_X1" (("X" "p1_1") ("D" "dd2") ("T" "qu6") ("CI" "c2_1") ("S" "p2_2") ("CO" "c2_2") ("VDD" "VDD") ("VSS" "VSS")) ())
  ("I63" "ALU_CELLS_D" "CAS_X1" (("X" "p1_2") ("D" "dd3") ("T" "qu6") ("CI" "c2_2") ("S" "p2_3") ("CO" "c2_3") ("VDD" "VDD") ("VSS" "VSS")) ())
  ("I64" "ALU_CELLS_D" "CAS_X1" (("X" "p1_3") ("D" "dd4") ("T" "qu6") ("CI" "c2_3") ("S" "p2_4") ("CO" "c2_4") ("VDD" "VDD") ("VSS" "VSS")) ())
  ("I65" "ALU_CELLS_D" "CAS_X1" (("X" "p1_4") ("D" "dd5") ("T" "qu6") ("CI" "c2_4") ("S" "p2_5") ("CO" "c2_5") ("VDD" "VDD") ("VSS" "VSS")) ())
  ("I66" "ALU_CELLS_D" "CAS_X1" (("X" "p1_5") ("D" "dd6") ("T" "qu6") ("CI" "c2_5") ("S" "p2_6") ("CO" "c2_6") ("VDD" "VDD") ("VSS" "VSS")) ())
  ("I67" "ALU_CELLS_D" "CAS_X1" (("X" "p1_6") ("D" "dd7") ("T" "qu6") ("CI" "c2_6") ("S" "p2_7") ("CO" "c2_7") ("VDD" "VDD") ("VSS" "VSS")) ())
  ("I68" "ALU_CELLS_D" "CAS_X1" (("X" "p1_7") ("D" "VSS") ("T" "qu6") ("CI" "c2_7") ("S" "p2_8") ("CO" "c2_8") ("VDD" "VDD") ("VSS" "VSS")) ())
  ("I69" "ALU_CELLS_A" "INV_X1" (("A" "p2_8") ("Y" "qu5") ("VDD" "VDD") ("VSS" "VSS")) ())
  ("I70" "ALU_CELLS_D" "CAS_X1" (("X" "aa4") ("D" "B_0") ("T" "qu5") ("CI" "qu5") ("S" "p3_0") ("CO" "c3_0") ("VDD" "VDD") ("VSS" "VSS")) ())
  ("I71" "ALU_CELLS_D" "CAS_X1" (("X" "p2_0") ("D" "dd1") ("T" "qu5") ("CI" "c3_0") ("S" "p3_1") ("CO" "c3_1") ("VDD" "VDD") ("VSS" "VSS")) ())
  ("I72" "ALU_CELLS_D" "CAS_X1" (("X" "p2_1") ("D" "dd2") ("T" "qu5") ("CI" "c3_1") ("S" "p3_2") ("CO" "c3_2") ("VDD" "VDD") ("VSS" "VSS")) ())
  ("I73" "ALU_CELLS_D" "CAS_X1" (("X" "p2_2") ("D" "dd3") ("T" "qu5") ("CI" "c3_2") ("S" "p3_3") ("CO" "c3_3") ("VDD" "VDD") ("VSS" "VSS")) ())
  ("I74" "ALU_CELLS_D" "CAS_X1" (("X" "p2_3") ("D" "dd4") ("T" "qu5") ("CI" "c3_3") ("S" "p3_4") ("CO" "c3_4") ("VDD" "VDD") ("VSS" "VSS")) ())
  ("I75" "ALU_CELLS_D" "CAS_X1" (("X" "p2_4") ("D" "dd5") ("T" "qu5") ("CI" "c3_4") ("S" "p3_5") ("CO" "c3_5") ("VDD" "VDD") ("VSS" "VSS")) ())
  ("I76" "ALU_CELLS_D" "CAS_X1" (("X" "p2_5") ("D" "dd6") ("T" "qu5") ("CI" "c3_5") ("S" "p3_6") ("CO" "c3_6") ("VDD" "VDD") ("VSS" "VSS")) ())
  ("I77" "ALU_CELLS_D" "CAS_X1" (("X" "p2_6") ("D" "dd7") ("T" "qu5") ("CI" "c3_6") ("S" "p3_7") ("CO" "c3_7") ("VDD" "VDD") ("VSS" "VSS")) ())
  ("I78" "ALU_CELLS_D" "CAS_X1" (("X" "p2_7") ("D" "VSS") ("T" "qu5") ("CI" "c3_7") ("S" "p3_8") ("CO" "c3_8") ("VDD" "VDD") ("VSS" "VSS")) ())
  ("I79" "ALU_CELLS_A" "INV_X1" (("A" "p3_8") ("Y" "qu4") ("VDD" "VDD") ("VSS" "VSS")) ())
  ("I80" "ALU_CELLS_D" "CAS_X1" (("X" "aa3") ("D" "B_0") ("T" "qu4") ("CI" "qu4") ("S" "p4_0") ("CO" "c4_0") ("VDD" "VDD") ("VSS" "VSS")) ())
  ("I81" "ALU_CELLS_D" "CAS_X1" (("X" "p3_0") ("D" "dd1") ("T" "qu4") ("CI" "c4_0") ("S" "p4_1") ("CO" "c4_1") ("VDD" "VDD") ("VSS" "VSS")) ())
  ("I82" "ALU_CELLS_D" "CAS_X1" (("X" "p3_1") ("D" "dd2") ("T" "qu4") ("CI" "c4_1") ("S" "p4_2") ("CO" "c4_2") ("VDD" "VDD") ("VSS" "VSS")) ())
  ("I83" "ALU_CELLS_D" "CAS_X1" (("X" "p3_2") ("D" "dd3") ("T" "qu4") ("CI" "c4_2") ("S" "p4_3") ("CO" "c4_3") ("VDD" "VDD") ("VSS" "VSS")) ())
  ("I84" "ALU_CELLS_D" "CAS_X1" (("X" "p3_3") ("D" "dd4") ("T" "qu4") ("CI" "c4_3") ("S" "p4_4") ("CO" "c4_4") ("VDD" "VDD") ("VSS" "VSS")) ())
  ("I85" "ALU_CELLS_D" "CAS_X1" (("X" "p3_4") ("D" "dd5") ("T" "qu4") ("CI" "c4_4") ("S" "p4_5") ("CO" "c4_5") ("VDD" "VDD") ("VSS" "VSS")) ())
  ("I86" "ALU_CELLS_D" "CAS_X1" (("X" "p3_5") ("D" "dd6") ("T" "qu4") ("CI" "c4_5") ("S" "p4_6") ("CO" "c4_6") ("VDD" "VDD") ("VSS" "VSS")) ())
  ("I87" "ALU_CELLS_D" "CAS_X1" (("X" "p3_6") ("D" "dd7") ("T" "qu4") ("CI" "c4_6") ("S" "p4_7") ("CO" "c4_7") ("VDD" "VDD") ("VSS" "VSS")) ())
  ("I88" "ALU_CELLS_D" "CAS_X1" (("X" "p3_7") ("D" "VSS") ("T" "qu4") ("CI" "c4_7") ("S" "p4_8") ("CO" "c4_8") ("VDD" "VDD") ("VSS" "VSS")) ())
  ("I89" "ALU_CELLS_A" "INV_X1" (("A" "p4_8") ("Y" "qu3") ("VDD" "VDD") ("VSS" "VSS")) ())
  ("I90" "ALU_CELLS_D" "CAS_X1" (("X" "aa2") ("D" "B_0") ("T" "qu3") ("CI" "qu3") ("S" "p5_0") ("CO" "c5_0") ("VDD" "VDD") ("VSS" "VSS")) ())
  ("I91" "ALU_CELLS_D" "CAS_X1" (("X" "p4_0") ("D" "dd1") ("T" "qu3") ("CI" "c5_0") ("S" "p5_1") ("CO" "c5_1") ("VDD" "VDD") ("VSS" "VSS")) ())
  ("I92" "ALU_CELLS_D" "CAS_X1" (("X" "p4_1") ("D" "dd2") ("T" "qu3") ("CI" "c5_1") ("S" "p5_2") ("CO" "c5_2") ("VDD" "VDD") ("VSS" "VSS")) ())
  ("I93" "ALU_CELLS_D" "CAS_X1" (("X" "p4_2") ("D" "dd3") ("T" "qu3") ("CI" "c5_2") ("S" "p5_3") ("CO" "c5_3") ("VDD" "VDD") ("VSS" "VSS")) ())
  ("I94" "ALU_CELLS_D" "CAS_X1" (("X" "p4_3") ("D" "dd4") ("T" "qu3") ("CI" "c5_3") ("S" "p5_4") ("CO" "c5_4") ("VDD" "VDD") ("VSS" "VSS")) ())
  ("I95" "ALU_CELLS_D" "CAS_X1" (("X" "p4_4") ("D" "dd5") ("T" "qu3") ("CI" "c5_4") ("S" "p5_5") ("CO" "c5_5") ("VDD" "VDD") ("VSS" "VSS")) ())
  ("I96" "ALU_CELLS_D" "CAS_X1" (("X" "p4_5") ("D" "dd6") ("T" "qu3") ("CI" "c5_5") ("S" "p5_6") ("CO" "c5_6") ("VDD" "VDD") ("VSS" "VSS")) ())
  ("I97" "ALU_CELLS_D" "CAS_X1" (("X" "p4_6") ("D" "dd7") ("T" "qu3") ("CI" "c5_6") ("S" "p5_7") ("CO" "c5_7") ("VDD" "VDD") ("VSS" "VSS")) ())
  ("I98" "ALU_CELLS_D" "CAS_X1" (("X" "p4_7") ("D" "VSS") ("T" "qu3") ("CI" "c5_7") ("S" "p5_8") ("CO" "c5_8") ("VDD" "VDD") ("VSS" "VSS")) ())
  ("I99" "ALU_CELLS_A" "INV_X1" (("A" "p5_8") ("Y" "qu2") ("VDD" "VDD") ("VSS" "VSS")) ())
  ("I100" "ALU_CELLS_D" "CAS_X1" (("X" "aa1") ("D" "B_0") ("T" "qu2") ("CI" "qu2") ("S" "p6_0") ("CO" "c6_0") ("VDD" "VDD") ("VSS" "VSS")) ())
  ("I101" "ALU_CELLS_D" "CAS_X1" (("X" "p5_0") ("D" "dd1") ("T" "qu2") ("CI" "c6_0") ("S" "p6_1") ("CO" "c6_1") ("VDD" "VDD") ("VSS" "VSS")) ())
  ("I102" "ALU_CELLS_D" "CAS_X1" (("X" "p5_1") ("D" "dd2") ("T" "qu2") ("CI" "c6_1") ("S" "p6_2") ("CO" "c6_2") ("VDD" "VDD") ("VSS" "VSS")) ())
  ("I103" "ALU_CELLS_D" "CAS_X1" (("X" "p5_2") ("D" "dd3") ("T" "qu2") ("CI" "c6_2") ("S" "p6_3") ("CO" "c6_3") ("VDD" "VDD") ("VSS" "VSS")) ())
  ("I104" "ALU_CELLS_D" "CAS_X1" (("X" "p5_3") ("D" "dd4") ("T" "qu2") ("CI" "c6_3") ("S" "p6_4") ("CO" "c6_4") ("VDD" "VDD") ("VSS" "VSS")) ())
  ("I105" "ALU_CELLS_D" "CAS_X1" (("X" "p5_4") ("D" "dd5") ("T" "qu2") ("CI" "c6_4") ("S" "p6_5") ("CO" "c6_5") ("VDD" "VDD") ("VSS" "VSS")) ())
  ("I106" "ALU_CELLS_D" "CAS_X1" (("X" "p5_5") ("D" "dd6") ("T" "qu2") ("CI" "c6_5") ("S" "p6_6") ("CO" "c6_6") ("VDD" "VDD") ("VSS" "VSS")) ())
  ("I107" "ALU_CELLS_D" "CAS_X1" (("X" "p5_6") ("D" "dd7") ("T" "qu2") ("CI" "c6_6") ("S" "p6_7") ("CO" "c6_7") ("VDD" "VDD") ("VSS" "VSS")) ())
  ("I108" "ALU_CELLS_D" "CAS_X1" (("X" "p5_7") ("D" "VSS") ("T" "qu2") ("CI" "c6_7") ("S" "p6_8") ("CO" "c6_8") ("VDD" "VDD") ("VSS" "VSS")) ())
  ("I109" "ALU_CELLS_A" "INV_X1" (("A" "p6_8") ("Y" "qu1") ("VDD" "VDD") ("VSS" "VSS")) ())
  ("I110" "ALU_CELLS_D" "CAS_X1" (("X" "A_0") ("D" "B_0") ("T" "qu1") ("CI" "qu1") ("S" "p7_0") ("CO" "c7_0") ("VDD" "VDD") ("VSS" "VSS")) ())
  ("I111" "ALU_CELLS_D" "CAS_X1" (("X" "p6_0") ("D" "dd1") ("T" "qu1") ("CI" "c7_0") ("S" "p7_1") ("CO" "c7_1") ("VDD" "VDD") ("VSS" "VSS")) ())
  ("I112" "ALU_CELLS_D" "CAS_X1" (("X" "p6_1") ("D" "dd2") ("T" "qu1") ("CI" "c7_1") ("S" "p7_2") ("CO" "c7_2") ("VDD" "VDD") ("VSS" "VSS")) ())
  ("I113" "ALU_CELLS_D" "CAS_X1" (("X" "p6_2") ("D" "dd3") ("T" "qu1") ("CI" "c7_2") ("S" "p7_3") ("CO" "c7_3") ("VDD" "VDD") ("VSS" "VSS")) ())
  ("I114" "ALU_CELLS_D" "CAS_X1" (("X" "p6_3") ("D" "dd4") ("T" "qu1") ("CI" "c7_3") ("S" "p7_4") ("CO" "c7_4") ("VDD" "VDD") ("VSS" "VSS")) ())
  ("I115" "ALU_CELLS_D" "CAS_X1" (("X" "p6_4") ("D" "dd5") ("T" "qu1") ("CI" "c7_4") ("S" "p7_5") ("CO" "c7_5") ("VDD" "VDD") ("VSS" "VSS")) ())
  ("I116" "ALU_CELLS_D" "CAS_X1" (("X" "p6_5") ("D" "dd6") ("T" "qu1") ("CI" "c7_5") ("S" "p7_6") ("CO" "c7_6") ("VDD" "VDD") ("VSS" "VSS")) ())
  ("I117" "ALU_CELLS_D" "CAS_X1" (("X" "p6_6") ("D" "dd7") ("T" "qu1") ("CI" "c7_6") ("S" "p7_7") ("CO" "c7_7") ("VDD" "VDD") ("VSS" "VSS")) ())
  ("I118" "ALU_CELLS_D" "CAS_X1" (("X" "p6_7") ("D" "VSS") ("T" "qu1") ("CI" "c7_7") ("S" "p7_8") ("CO" "c7_8") ("VDD" "VDD") ("VSS" "VSS")) ())
  ("I119" "ALU_CELLS_A" "INV_X1" (("A" "p7_8") ("Y" "Q_0") ("VDD" "VDD") ("VSS" "VSS")) ())
  ("I120" "ALU_CELLS_A" "NAND2_X1" (("A" "B_0") ("B" "p7_8") ("Y" "dmn0") ("VDD" "VDD") ("VSS" "VSS")) ())
  ("I121" "ALU_CELLS_A" "INV_X1" (("A" "dmn0") ("Y" "dm0") ("VDD" "VDD") ("VSS" "VSS")) ())
  ("I122" "ALU_CELLS_D" "CAS_X1" (("X" "p7_0") ("D" "dm0") ("T" "VSS") ("CI" "VSS") ("S" "R_0") ("CO" "rc0") ("VDD" "VDD") ("VSS" "VSS")) ())
  ("I123" "ALU_CELLS_A" "NAND2_X1" (("A" "dd1") ("B" "p7_8") ("Y" "dmn1") ("VDD" "VDD") ("VSS" "VSS")) ())
  ("I124" "ALU_CELLS_A" "INV_X1" (("A" "dmn1") ("Y" "dm1") ("VDD" "VDD") ("VSS" "VSS")) ())
  ("I125" "ALU_CELLS_D" "CAS_X1" (("X" "p7_1") ("D" "dm1") ("T" "VSS") ("CI" "rc0") ("S" "ru1") ("CO" "rc1") ("VDD" "VDD") ("VSS" "VSS")) ())
  ("I126" "ALU_CELLS_A" "NAND2_X1" (("A" "dd2") ("B" "p7_8") ("Y" "dmn2") ("VDD" "VDD") ("VSS" "VSS")) ())
  ("I127" "ALU_CELLS_A" "INV_X1" (("A" "dmn2") ("Y" "dm2") ("VDD" "VDD") ("VSS" "VSS")) ())
  ("I128" "ALU_CELLS_D" "CAS_X1" (("X" "p7_2") ("D" "dm2") ("T" "VSS") ("CI" "rc1") ("S" "ru2") ("CO" "rc2") ("VDD" "VDD") ("VSS" "VSS")) ())
  ("I129" "ALU_CELLS_A" "NAND2_X1" (("A" "dd3") ("B" "p7_8") ("Y" "dmn3") ("VDD" "VDD") ("VSS" "VSS")) ())
  ("I130" "ALU_CELLS_A" "INV_X1" (("A" "dmn3") ("Y" "dm3") ("VDD" "VDD") ("VSS" "VSS")) ())
  ("I131" "ALU_CELLS_D" "CAS_X1" (("X" "p7_3") ("D" "dm3") ("T" "VSS") ("CI" "rc2") ("S" "ru3") ("CO" "rc3") ("VDD" "VDD") ("VSS" "VSS")) ())
  ("I132" "ALU_CELLS_A" "NAND2_X1" (("A" "dd4") ("B" "p7_8") ("Y" "dmn4") ("VDD" "VDD") ("VSS" "VSS")) ())
  ("I133" "ALU_CELLS_A" "INV_X1" (("A" "dmn4") ("Y" "dm4") ("VDD" "VDD") ("VSS" "VSS")) ())
  ("I134" "ALU_CELLS_D" "CAS_X1" (("X" "p7_4") ("D" "dm4") ("T" "VSS") ("CI" "rc3") ("S" "ru4") ("CO" "rc4") ("VDD" "VDD") ("VSS" "VSS")) ())
  ("I135" "ALU_CELLS_A" "NAND2_X1" (("A" "dd5") ("B" "p7_8") ("Y" "dmn5") ("VDD" "VDD") ("VSS" "VSS")) ())
  ("I136" "ALU_CELLS_A" "INV_X1" (("A" "dmn5") ("Y" "dm5") ("VDD" "VDD") ("VSS" "VSS")) ())
  ("I137" "ALU_CELLS_D" "CAS_X1" (("X" "p7_5") ("D" "dm5") ("T" "VSS") ("CI" "rc4") ("S" "ru5") ("CO" "rc5") ("VDD" "VDD") ("VSS" "VSS")) ())
  ("I138" "ALU_CELLS_A" "NAND2_X1" (("A" "dd6") ("B" "p7_8") ("Y" "dmn6") ("VDD" "VDD") ("VSS" "VSS")) ())
  ("I139" "ALU_CELLS_A" "INV_X1" (("A" "dmn6") ("Y" "dm6") ("VDD" "VDD") ("VSS" "VSS")) ())
  ("I140" "ALU_CELLS_D" "CAS_X1" (("X" "p7_6") ("D" "dm6") ("T" "VSS") ("CI" "rc5") ("S" "ru6") ("CO" "rc6") ("VDD" "VDD") ("VSS" "VSS")) ())
  ("I141" "ALU_CELLS_A" "NAND2_X1" (("A" "dd7") ("B" "p7_8") ("Y" "dmn7") ("VDD" "VDD") ("VSS" "VSS")) ())
  ("I142" "ALU_CELLS_A" "INV_X1" (("A" "dmn7") ("Y" "dm7") ("VDD" "VDD") ("VSS" "VSS")) ())
  ("I143" "ALU_CELLS_D" "CAS_X1" (("X" "p7_7") ("D" "dm7") ("T" "VSS") ("CI" "rc6") ("S" "ru7") ("CO" "rc7") ("VDD" "VDD") ("VSS" "VSS")) ())
  ("I144" "ALU_STUB_B" "XOR2_X1" (("A" "A_7") ("B" "B_7") ("Y" "sq") ("VDD" "VDD") ("VSS" "VSS")) ())
  ("I145" "ALU_CELLS_A" "NAND2_X1" (("A" "sq") ("B" "Q_0") ("Y" "nqkn1") ("VDD" "VDD") ("VSS" "VSS")) ())
  ("I146" "ALU_STUB_B" "XNOR2_X1" (("A" "qu1") ("B" "nqkn1") ("Y" "Q_1") ("VDD" "VDD") ("VSS" "VSS")) ())
  ("I147" "ALU_CELLS_A" "INV_X1" (("A" "nqkn1") ("Y" "nqk1") ("VDD" "VDD") ("VSS" "VSS")) ())
  ("I148" "ALU_CELLS_A" "AOI21_X1" (("A1" "sq") ("A2" "qu1") ("B" "nqk1") ("Y" "nqkn2") ("VDD" "VDD") ("VSS" "VSS")) ())
  ("I149" "ALU_STUB_B" "XNOR2_X1" (("A" "qu2") ("B" "nqkn2") ("Y" "Q_2") ("VDD" "VDD") ("VSS" "VSS")) ())
  ("I150" "ALU_CELLS_A" "INV_X1" (("A" "nqkn2") ("Y" "nqk2") ("VDD" "VDD") ("VSS" "VSS")) ())
  ("I151" "ALU_CELLS_A" "AOI21_X1" (("A1" "sq") ("A2" "qu2") ("B" "nqk2") ("Y" "nqkn3") ("VDD" "VDD") ("VSS" "VSS")) ())
  ("I152" "ALU_STUB_B" "XNOR2_X1" (("A" "qu3") ("B" "nqkn3") ("Y" "Q_3") ("VDD" "VDD") ("VSS" "VSS")) ())
  ("I153" "ALU_CELLS_A" "INV_X1" (("A" "nqkn3") ("Y" "nqk3") ("VDD" "VDD") ("VSS" "VSS")) ())
  ("I154" "ALU_CELLS_A" "AOI21_X1" (("A1" "sq") ("A2" "qu3") ("B" "nqk3") ("Y" "nqkn4") ("VDD" "VDD") ("VSS" "VSS")) ())
  ("I155" "ALU_STUB_B" "XNOR2_X1" (("A" "qu4") ("B" "nqkn4") ("Y" "Q_4") ("VDD" "VDD") ("VSS" "VSS")) ())
  ("I156" "ALU_CELLS_A" "INV_X1" (("A" "nqkn4") ("Y" "nqk4") ("VDD" "VDD") ("VSS" "VSS")) ())
  ("I157" "ALU_CELLS_A" "AOI21_X1" (("A1" "sq") ("A2" "qu4") ("B" "nqk4") ("Y" "nqkn5") ("VDD" "VDD") ("VSS" "VSS")) ())
  ("I158" "ALU_STUB_B" "XNOR2_X1" (("A" "qu5") ("B" "nqkn5") ("Y" "Q_5") ("VDD" "VDD") ("VSS" "VSS")) ())
  ("I159" "ALU_CELLS_A" "INV_X1" (("A" "nqkn5") ("Y" "nqk5") ("VDD" "VDD") ("VSS" "VSS")) ())
  ("I160" "ALU_CELLS_A" "AOI21_X1" (("A1" "sq") ("A2" "qu5") ("B" "nqk5") ("Y" "nqkn6") ("VDD" "VDD") ("VSS" "VSS")) ())
  ("I161" "ALU_STUB_B" "XNOR2_X1" (("A" "qu6") ("B" "nqkn6") ("Y" "Q_6") ("VDD" "VDD") ("VSS" "VSS")) ())
  ("I162" "ALU_CELLS_A" "INV_X1" (("A" "nqkn6") ("Y" "nqk6") ("VDD" "VDD") ("VSS" "VSS")) ())
  ("I163" "ALU_CELLS_A" "AOI21_X1" (("A1" "sq") ("A2" "qu6") ("B" "nqk6") ("Y" "nqkn7") ("VDD" "VDD") ("VSS" "VSS")) ())
  ("I164" "ALU_STUB_B" "XNOR2_X1" (("A" "qu7") ("B" "nqkn7") ("Y" "Q_7") ("VDD" "VDD") ("VSS" "VSS")) ())
  ("I165" "ALU_CELLS_A" "NAND2_X1" (("A" "A_7") ("B" "R_0") ("Y" "nrkn1") ("VDD" "VDD") ("VSS" "VSS")) ())
  ("I166" "ALU_STUB_B" "XNOR2_X1" (("A" "ru1") ("B" "nrkn1") ("Y" "R_1") ("VDD" "VDD") ("VSS" "VSS")) ())
  ("I167" "ALU_CELLS_A" "INV_X1" (("A" "nrkn1") ("Y" "nrk1") ("VDD" "VDD") ("VSS" "VSS")) ())
  ("I168" "ALU_CELLS_A" "AOI21_X1" (("A1" "A_7") ("A2" "ru1") ("B" "nrk1") ("Y" "nrkn2") ("VDD" "VDD") ("VSS" "VSS")) ())
  ("I169" "ALU_STUB_B" "XNOR2_X1" (("A" "ru2") ("B" "nrkn2") ("Y" "R_2") ("VDD" "VDD") ("VSS" "VSS")) ())
  ("I170" "ALU_CELLS_A" "INV_X1" (("A" "nrkn2") ("Y" "nrk2") ("VDD" "VDD") ("VSS" "VSS")) ())
  ("I171" "ALU_CELLS_A" "AOI21_X1" (("A1" "A_7") ("A2" "ru2") ("B" "nrk2") ("Y" "nrkn3") ("VDD" "VDD") ("VSS" "VSS")) ())
  ("I172" "ALU_STUB_B" "XNOR2_X1" (("A" "ru3") ("B" "nrkn3") ("Y" "R_3") ("VDD" "VDD") ("VSS" "VSS")) ())
  ("I173" "ALU_CELLS_A" "INV_X1" (("A" "nrkn3") ("Y" "nrk3") ("VDD" "VDD") ("VSS" "VSS")) ())
  ("I174" "ALU_CELLS_A" "AOI21_X1" (("A1" "A_7") ("A2" "ru3") ("B" "nrk3") ("Y" "nrkn4") ("VDD" "VDD") ("VSS" "VSS")) ())
  ("I175" "ALU_STUB_B" "XNOR2_X1" (("A" "ru4") ("B" "nrkn4") ("Y" "R_4") ("VDD" "VDD") ("VSS" "VSS")) ())
  ("I176" "ALU_CELLS_A" "INV_X1" (("A" "nrkn4") ("Y" "nrk4") ("VDD" "VDD") ("VSS" "VSS")) ())
  ("I177" "ALU_CELLS_A" "AOI21_X1" (("A1" "A_7") ("A2" "ru4") ("B" "nrk4") ("Y" "nrkn5") ("VDD" "VDD") ("VSS" "VSS")) ())
  ("I178" "ALU_STUB_B" "XNOR2_X1" (("A" "ru5") ("B" "nrkn5") ("Y" "R_5") ("VDD" "VDD") ("VSS" "VSS")) ())
  ("I179" "ALU_CELLS_A" "INV_X1" (("A" "nrkn5") ("Y" "nrk5") ("VDD" "VDD") ("VSS" "VSS")) ())
  ("I180" "ALU_CELLS_A" "AOI21_X1" (("A1" "A_7") ("A2" "ru5") ("B" "nrk5") ("Y" "nrkn6") ("VDD" "VDD") ("VSS" "VSS")) ())
  ("I181" "ALU_STUB_B" "XNOR2_X1" (("A" "ru6") ("B" "nrkn6") ("Y" "R_6") ("VDD" "VDD") ("VSS" "VSS")) ())
  ("I182" "ALU_CELLS_A" "INV_X1" (("A" "nrkn6") ("Y" "nrk6") ("VDD" "VDD") ("VSS" "VSS")) ())
  ("I183" "ALU_CELLS_A" "AOI21_X1" (("A1" "A_7") ("A2" "ru6") ("B" "nrk6") ("Y" "nrkn7") ("VDD" "VDD") ("VSS" "VSS")) ())
  ("I184" "ALU_STUB_B" "XNOR2_X1" (("A" "ru7") ("B" "nrkn7") ("Y" "R_7") ("VDD" "VDD") ("VSS" "VSS")) ())
  ("I185" "ALU_CELLS_A" "NOR2_X1" (("A" "B_0") ("B" "B_1") ("Y" "z1_0") ("VDD" "VDD") ("VSS" "VSS")) ())
  ("I186" "ALU_CELLS_A" "NOR2_X1" (("A" "B_2") ("B" "B_3") ("Y" "z1_1") ("VDD" "VDD") ("VSS" "VSS")) ())
  ("I187" "ALU_CELLS_A" "NOR2_X1" (("A" "B_4") ("B" "B_5") ("Y" "z1_2") ("VDD" "VDD") ("VSS" "VSS")) ())
  ("I188" "ALU_CELLS_A" "NOR2_X1" (("A" "B_6") ("B" "B_7") ("Y" "z1_3") ("VDD" "VDD") ("VSS" "VSS")) ())
  ("I189" "ALU_CELLS_A" "NAND2_X1" (("A" "z1_0") ("B" "z1_1") ("Y" "z2_0") ("VDD" "VDD") ("VSS" "VSS")) ())
  ("I190" "ALU_CELLS_A" "NAND2_X1" (("A" "z1_2") ("B" "z1_3") ("Y" "z2_1") ("VDD" "VDD") ("VSS" "VSS")) ())
  ("I191" "ALU_CELLS_A" "NOR2_X1" (("A" "z2_0") ("B" "z2_1") ("Y" "DZ") ("VDD" "VDD") ("VSS" "VSS")) ())
  ("I192" "ALU_CELLS_A" "INV_X1" (("A" "sq") ("Y" "sqn") ("VDD" "VDD") ("VSS" "VSS")) ())
  ("I193" "ALU_CELLS_A" "NAND2_X1" (("A" "Q_7") ("B" "sqn") ("Y" "vn") ("VDD" "VDD") ("VSS" "VSS")) ())
  ("I194" "ALU_CELLS_A" "NOR2_X1" (("A" "vn") ("B" "DZ") ("Y" "V") ("VDD" "VDD") ("VSS" "VSS")) ()))) t)
  sbErrors++ printf("SB_ERROR DIV8: %L\n" errset.errset))
unless(errset(sbCell("ALU_TOP" "ALU_TOP" '(("A_0" "input") ("A_1" "input") ("A_2" "input") ("A_3" "input") ("A_4" "input") ("A_5" "input") ("A_6" "input") ("A_7" "input") ("B_0" "input") ("B_1" "input") ("B_2" "input") ("B_3" "input") ("B_4" "input") ("B_5" "input") ("B_6" "input") ("B_7" "input") ("OP_0" "input") ("OP_1" "input") ("OP_2" "input") ("OP_3" "input") ("Y_0" "output") ("Y_1" "output") ("Y_2" "output") ("Y_3" "output") ("Y_4" "output") ("Y_5" "output") ("Y_6" "output") ("Y_7" "output") ("Y_8" "output") ("Y_9" "output") ("Y_10" "output") ("Y_11" "output") ("Y_12" "output") ("Y_13" "output") ("Y_14" "output") ("Y_15" "output") ("Z" "output") ("C" "output") ("V" "output") ("DZ" "output") ("VDD" "inputOutput") ("VSS" "inputOutput"))
 '(
  ("I0" "ALU_MUL" "MUL8" (("A_0" "A_0") ("A_1" "A_1") ("A_2" "A_2") ("A_3" "A_3") ("A_4" "A_4") ("A_5" "A_5") ("A_6" "A_6") ("A_7" "A_7") ("B_0" "B_0") ("B_1" "B_1") ("B_2" "B_2") ("B_3" "B_3") ("B_4" "B_4") ("B_5" "B_5") ("B_6" "B_6") ("B_7" "B_7") ("P_0" "MULP_0") ("P_1" "MULP_1") ("P_2" "MULP_2") ("P_3" "MULP_3") ("P_4" "MULP_4") ("P_5" "MULP_5") ("P_6" "MULP_6") ("P_7" "MULP_7") ("P_8" "MULP_8") ("P_9" "MULP_9") ("P_10" "MULP_10") ("P_11" "MULP_11") ("P_12" "MULP_12") ("P_13" "MULP_13") ("P_14" "MULP_14") ("P_15" "MULP_15") ("VDD" "VDD") ("VSS" "VSS")) ())
  ("I1" "ALU_DIV" "DIV8" (("A_0" "A_0") ("A_1" "A_1") ("A_2" "A_2") ("A_3" "A_3") ("A_4" "A_4") ("A_5" "A_5") ("A_6" "A_6") ("A_7" "A_7") ("B_0" "B_0") ("B_1" "B_1") ("B_2" "B_2") ("B_3" "B_3") ("B_4" "B_4") ("B_5" "B_5") ("B_6" "B_6") ("B_7" "B_7") ("Q_0" "DIVQ_0") ("Q_1" "DIVQ_1") ("Q_2" "DIVQ_2") ("Q_3" "DIVQ_3") ("Q_4" "DIVQ_4") ("Q_5" "DIVQ_5") ("Q_6" "DIVQ_6") ("Q_7" "DIVQ_7") ("R_0" "DIVR_0") ("R_1" "DIVR_1") ("R_2" "DIVR_2") ("R_3" "DIVR_3") ("R_4" "DIVR_4") ("R_5" "DIVR_5") ("R_6" "DIVR_6") ("R_7" "DIVR_7") ("V" "DIVV") ("DZ" "DIVDZ") ("VDD" "VDD") ("VSS" "VSS")) ())
  ("I2" "ALU_CORE" "ALU_CORE" (("A_0" "A_0") ("A_1" "A_1") ("A_2" "A_2") ("A_3" "A_3") ("A_4" "A_4") ("A_5" "A_5") ("A_6" "A_6") ("A_7" "A_7") ("B_0" "B_0") ("B_1" "B_1") ("B_2" "B_2") ("B_3" "B_3") ("B_4" "B_4") ("B_5" "B_5") ("B_6" "B_6") ("B_7" "B_7") ("OP_0" "OP_0") ("OP_1" "OP_1") ("OP_2" "OP_2") ("OP_3" "OP_3") ("MULP_0" "MULP_0") ("MULP_1" "MULP_1") ("MULP_2" "MULP_2") ("MULP_3" "MULP_3") ("MULP_4" "MULP_4") ("MULP_5" "MULP_5") ("MULP_6" "MULP_6") ("MULP_7" "MULP_7") ("MULP_8" "MULP_8") ("MULP_9" "MULP_9") ("MULP_10" "MULP_10") ("MULP_11" "MULP_11") ("MULP_12" "MULP_12") ("MULP_13" "MULP_13") ("MULP_14" "MULP_14") ("MULP_15" "MULP_15") ("DIVQ_0" "DIVQ_0") ("DIVQ_1" "DIVQ_1") ("DIVQ_2" "DIVQ_2") ("DIVQ_3" "DIVQ_3") ("DIVQ_4" "DIVQ_4") ("DIVQ_5" "DIVQ_5") ("DIVQ_6" "DIVQ_6") ("DIVQ_7" "DIVQ_7") ("DIVR_0" "DIVR_0") ("DIVR_1" "DIVR_1") ("DIVR_2" "DIVR_2") ("DIVR_3" "DIVR_3") ("DIVR_4" "DIVR_4") ("DIVR_5" "DIVR_5") ("DIVR_6" "DIVR_6") ("DIVR_7" "DIVR_7") ("DIVV" "DIVV") ("DIVDZ" "DIVDZ") ("Y_0" "Y_0") ("Y_1" "Y_1") ("Y_2" "Y_2") ("Y_3" "Y_3") ("Y_4" "Y_4") ("Y_5" "Y_5") ("Y_6" "Y_6") ("Y_7" "Y_7") ("Y_8" "Y_8") ("Y_9" "Y_9") ("Y_10" "Y_10") ("Y_11" "Y_11") ("Y_12" "Y_12") ("Y_13" "Y_13") ("Y_14" "Y_14") ("Y_15" "Y_15") ("Z" "Z") ("C" "C") ("V" "V") ("DZ" "DZ") ("VDD" "VDD") ("VSS" "VSS")) ()))) t)
  sbErrors++ printf("SB_ERROR ALU_TOP: %L\n" errset.errset))
sbEnd()) t)
  printf("SB_ERROR uncaught: %L\n" errset.errset)
  exit(2))
exit(3)   ; unconditional: -nograph never exits on stdin EOF
