;; generated by tools/scs2skill.py from ALU_CELLS_A=cells/A ALU_STUB_B=cells/_stub_B ALU_CELLS_B=cells/B ALU_CELLS_C=cells/C ALU_CELLS_D=cells/D ALU_ADD=blocks/ALU_ADD/KSA8.scs ALU_ADD=blocks/ALU_ADD/ADDSUB8.scs ALU_CORE=blocks/ALU_CORE/LOGIC8.scs ALU_CORE=blocks/ALU_CORE/DEC_OP.scs ALU_CORE=blocks/ALU_CORE/OUTMUX.scs ALU_CORE=blocks/ALU_CORE/FLAGS.scs ALU_CORE=blocks/ALU_CORE/ALU_CORE.scs ALU_MUL=blocks/ALU_MUL/MUL8.scs ALU_DIV=blocks/ALU_DIV/DIV8F.scs ALU_DIV=blocks/ALU_DIV/DIV8K.scs ALU_TOP=blocks/ALU_TOP/ALU_TOPK.scs -- do not edit
;; run in the VM:  cd ~/ALU_PROJ && virtuoso -nograph -restore <this file> < /dev/null
;; run with < /dev/null; any SKILL error -> message + exit, never a hanging CIW prompt
unless(errset(progn(
sbDir = or(getShellEnvVar("SB_DIR") "/mnt/hgfs/Share/VLSI_work/skill")
load(strcat(sbDir "/sch_build.il"))
sbBegin()
sbLib("ALU_DIV" "gpdk090")
sbLib("ALU_TOP" "gpdk090")
unless(errset(sbCell("ALU_DIV" "DIV8F" '(("A_0" "input") ("A_1" "input") ("A_2" "input") ("A_3" "input") ("A_4" "input") ("A_5" "input") ("A_6" "input") ("A_7" "input") ("B_0" "input") ("B_1" "input") ("B_2" "input") ("B_3" "input") ("B_4" "input") ("B_5" "input") ("B_6" "input") ("B_7" "input") ("Q_0" "output") ("Q_1" "output") ("Q_2" "output") ("Q_3" "output") ("Q_4" "output") ("Q_5" "output") ("Q_6" "output") ("Q_7" "output") ("R_0" "output") ("R_1" "output") ("R_2" "output") ("R_3" "output") ("R_4" "output") ("R_5" "output") ("R_6" "output") ("R_7" "output") ("V" "output") ("DZ" "output") ("VDD" "inputOutput") ("VSS" "inputOutput"))
 '(
  ("I0" "ALU_CELLS_A" "NAND2_X1" (("A" "A_7") ("B" "A_0") ("Y" "nakn1") ("VDD" "VDD") ("VSS" "VSS")) ())
  ("I1" "ALU_STUB_B" "XNOR2_X1" (("A" "A_1") ("B" "nakn1") ("Y" "aa1") ("VDD" "VDD") ("VSS" "VSS")) ())
  ("I2" "ALU_CELLS_A" "INV_X1" (("A" "nakn1") ("Y" "nak1") ("VDD" "VDD") ("VSS" "VSS")) ())
  ("I3" "ALU_CELLS_A" "AOI21_X1" (("A1" "A_7") ("A2" "A_1") ("B" "nak1") ("Y" "nakn2") ("VDD" "VDD") ("VSS" "VSS")) ())
  ("I4" "ALU_STUB_B" "XNOR2_X1" (("A" "A_2") ("B" "nakn2") ("Y" "aa2") ("VDD" "VDD") ("VSS" "VSS")) ())
  ("I5" "ALU_CELLS_A" "INV_X1" (("A" "nakn2") ("Y" "nak2") ("VDD" "VDD") ("VSS" "VSS")) ())
  ("I6" "ALU_CELLS_A" "AOI21_X1" (("A1" "A_7") ("A2" "A_2") ("B" "nak2") ("Y" "nakn3") ("VDD" "VDD") ("VSS" "VSS")) ())
  ("I7" "ALU_STUB_B" "XNOR2_X1" (("A" "A_3") ("B" "nakn3") ("Y" "aa3") ("VDD" "VDD") ("VSS" "VSS")) ())
  ("I8" "ALU_CELLS_A" "INV_X1" (("A" "nakn3") ("Y" "nak3") ("VDD" "VDD") ("VSS" "VSS")) ())
  ("I9" "ALU_CELLS_A" "AOI21_X1" (("A1" "A_7") ("A2" "A_3") ("B" "nak3") ("Y" "nakn4") ("VDD" "VDD") ("VSS" "VSS")) ())
  ("I10" "ALU_STUB_B" "XNOR2_X1" (("A" "A_4") ("B" "nakn4") ("Y" "aa4") ("VDD" "VDD") ("VSS" "VSS")) ())
  ("I11" "ALU_CELLS_A" "INV_X1" (("A" "nakn4") ("Y" "nak4") ("VDD" "VDD") ("VSS" "VSS")) ())
  ("I12" "ALU_CELLS_A" "AOI21_X1" (("A1" "A_7") ("A2" "A_4") ("B" "nak4") ("Y" "nakn5") ("VDD" "VDD") ("VSS" "VSS")) ())
  ("I13" "ALU_STUB_B" "XNOR2_X1" (("A" "A_5") ("B" "nakn5") ("Y" "aa5") ("VDD" "VDD") ("VSS" "VSS")) ())
  ("I14" "ALU_CELLS_A" "INV_X1" (("A" "nakn5") ("Y" "nak5") ("VDD" "VDD") ("VSS" "VSS")) ())
  ("I15" "ALU_CELLS_A" "AOI21_X1" (("A1" "A_7") ("A2" "A_5") ("B" "nak5") ("Y" "nakn6") ("VDD" "VDD") ("VSS" "VSS")) ())
  ("I16" "ALU_STUB_B" "XNOR2_X1" (("A" "A_6") ("B" "nakn6") ("Y" "aa6") ("VDD" "VDD") ("VSS" "VSS")) ())
  ("I17" "ALU_CELLS_A" "INV_X1" (("A" "nakn6") ("Y" "nak6") ("VDD" "VDD") ("VSS" "VSS")) ())
  ("I18" "ALU_CELLS_A" "AOI21_X1" (("A1" "A_7") ("A2" "A_6") ("B" "nak6") ("Y" "nakn7") ("VDD" "VDD") ("VSS" "VSS")) ())
  ("I19" "ALU_STUB_B" "XNOR2_X1" (("A" "A_7") ("B" "nakn7") ("Y" "aa7") ("VDD" "VDD") ("VSS" "VSS")) ())
  ("I20" "ALU_CELLS_A" "NAND2_X1" (("A" "B_7") ("B" "B_0") ("Y" "nbkn1") ("VDD" "VDD") ("VSS" "VSS")) ())
  ("I21" "ALU_STUB_B" "XNOR2_X1" (("A" "B_1") ("B" "nbkn1") ("Y" "dd1") ("VDD" "VDD") ("VSS" "VSS")) ())
  ("I22" "ALU_CELLS_A" "INV_X1" (("A" "nbkn1") ("Y" "nbk1") ("VDD" "VDD") ("VSS" "VSS")) ())
  ("I23" "ALU_CELLS_A" "AOI21_X1" (("A1" "B_7") ("A2" "B_1") ("B" "nbk1") ("Y" "nbkn2") ("VDD" "VDD") ("VSS" "VSS")) ())
  ("I24" "ALU_STUB_B" "XNOR2_X1" (("A" "B_2") ("B" "nbkn2") ("Y" "dd2") ("VDD" "VDD") ("VSS" "VSS")) ())
  ("I25" "ALU_CELLS_A" "INV_X1" (("A" "nbkn2") ("Y" "nbk2") ("VDD" "VDD") ("VSS" "VSS")) ())
  ("I26" "ALU_CELLS_A" "AOI21_X1" (("A1" "B_7") ("A2" "B_2") ("B" "nbk2") ("Y" "nbkn3") ("VDD" "VDD") ("VSS" "VSS")) ())
  ("I27" "ALU_STUB_B" "XNOR2_X1" (("A" "B_3") ("B" "nbkn3") ("Y" "dd3") ("VDD" "VDD") ("VSS" "VSS")) ())
  ("I28" "ALU_CELLS_A" "INV_X1" (("A" "nbkn3") ("Y" "nbk3") ("VDD" "VDD") ("VSS" "VSS")) ())
  ("I29" "ALU_CELLS_A" "AOI21_X1" (("A1" "B_7") ("A2" "B_3") ("B" "nbk3") ("Y" "nbkn4") ("VDD" "VDD") ("VSS" "VSS")) ())
  ("I30" "ALU_STUB_B" "XNOR2_X1" (("A" "B_4") ("B" "nbkn4") ("Y" "dd4") ("VDD" "VDD") ("VSS" "VSS")) ())
  ("I31" "ALU_CELLS_A" "INV_X1" (("A" "nbkn4") ("Y" "nbk4") ("VDD" "VDD") ("VSS" "VSS")) ())
  ("I32" "ALU_CELLS_A" "AOI21_X1" (("A1" "B_7") ("A2" "B_4") ("B" "nbk4") ("Y" "nbkn5") ("VDD" "VDD") ("VSS" "VSS")) ())
  ("I33" "ALU_STUB_B" "XNOR2_X1" (("A" "B_5") ("B" "nbkn5") ("Y" "dd5") ("VDD" "VDD") ("VSS" "VSS")) ())
  ("I34" "ALU_CELLS_A" "INV_X1" (("A" "nbkn5") ("Y" "nbk5") ("VDD" "VDD") ("VSS" "VSS")) ())
  ("I35" "ALU_CELLS_A" "AOI21_X1" (("A1" "B_7") ("A2" "B_5") ("B" "nbk5") ("Y" "nbkn6") ("VDD" "VDD") ("VSS" "VSS")) ())
  ("I36" "ALU_STUB_B" "XNOR2_X1" (("A" "B_6") ("B" "nbkn6") ("Y" "dd6") ("VDD" "VDD") ("VSS" "VSS")) ())
  ("I37" "ALU_CELLS_A" "INV_X1" (("A" "nbkn6") ("Y" "nbk6") ("VDD" "VDD") ("VSS" "VSS")) ())
  ("I38" "ALU_CELLS_A" "AOI21_X1" (("A1" "B_7") ("A2" "B_6") ("B" "nbk6") ("Y" "nbkn7") ("VDD" "VDD") ("VSS" "VSS")) ())
  ("I39" "ALU_STUB_B" "XNOR2_X1" (("A" "B_7") ("B" "nbkn7") ("Y" "dd7") ("VDD" "VDD") ("VSS" "VSS")) ())
  ("I40" "ALU_STUB_B" "XOR2_X1" (("A" "B_0") ("B" "VDD") ("Y" "b0_0") ("VDD" "VDD") ("VSS" "VSS")) ())
  ("I41" "ALU_CELLS_C" "FA_X1" (("A" "aa7") ("B" "b0_0") ("CI" "VDD") ("S" "p0_0") ("CO" "c0_0") ("VDD" "VDD") ("VSS" "VSS")) ())
  ("I42" "ALU_STUB_B" "XOR2_X1" (("A" "dd1") ("B" "VDD") ("Y" "b0_1") ("VDD" "VDD") ("VSS" "VSS")) ())
  ("I43" "ALU_CELLS_C" "FA_X1" (("A" "VSS") ("B" "b0_1") ("CI" "c0_0") ("S" "p0_1") ("CO" "c0_1") ("VDD" "VDD") ("VSS" "VSS")) ())
  ("I44" "ALU_STUB_B" "XOR2_X1" (("A" "dd2") ("B" "VDD") ("Y" "b0_2") ("VDD" "VDD") ("VSS" "VSS")) ())
  ("I45" "ALU_CELLS_C" "FA_X1" (("A" "VSS") ("B" "b0_2") ("CI" "c0_1") ("S" "p0_2") ("CO" "c0_2") ("VDD" "VDD") ("VSS" "VSS")) ())
  ("I46" "ALU_STUB_B" "XOR2_X1" (("A" "dd3") ("B" "VDD") ("Y" "b0_3") ("VDD" "VDD") ("VSS" "VSS")) ())
  ("I47" "ALU_CELLS_C" "FA_X1" (("A" "VSS") ("B" "b0_3") ("CI" "c0_2") ("S" "p0_3") ("CO" "c0_3") ("VDD" "VDD") ("VSS" "VSS")) ())
  ("I48" "ALU_STUB_B" "XOR2_X1" (("A" "dd4") ("B" "VDD") ("Y" "b0_4") ("VDD" "VDD") ("VSS" "VSS")) ())
  ("I49" "ALU_CELLS_C" "FA_X1" (("A" "VSS") ("B" "b0_4") ("CI" "c0_3") ("S" "p0_4") ("CO" "c0_4") ("VDD" "VDD") ("VSS" "VSS")) ())
  ("I50" "ALU_STUB_B" "XOR2_X1" (("A" "dd5") ("B" "VDD") ("Y" "b0_5") ("VDD" "VDD") ("VSS" "VSS")) ())
  ("I51" "ALU_CELLS_C" "FA_X1" (("A" "VSS") ("B" "b0_5") ("CI" "c0_4") ("S" "p0_5") ("CO" "c0_5") ("VDD" "VDD") ("VSS" "VSS")) ())
  ("I52" "ALU_STUB_B" "XOR2_X1" (("A" "dd6") ("B" "VDD") ("Y" "b0_6") ("VDD" "VDD") ("VSS" "VSS")) ())
  ("I53" "ALU_CELLS_C" "FA_X1" (("A" "VSS") ("B" "b0_6") ("CI" "c0_5") ("S" "p0_6") ("CO" "c0_6") ("VDD" "VDD") ("VSS" "VSS")) ())
  ("I54" "ALU_STUB_B" "XOR2_X1" (("A" "dd7") ("B" "VDD") ("Y" "b0_7") ("VDD" "VDD") ("VSS" "VSS")) ())
  ("I55" "ALU_CELLS_C" "FA_X1" (("A" "VSS") ("B" "b0_7") ("CI" "c0_6") ("S" "p0_7") ("CO" "c0_7") ("VDD" "VDD") ("VSS" "VSS")) ())
  ("I56" "ALU_CELLS_C" "FA_X1" (("A" "VSS") ("B" "VDD") ("CI" "c0_7") ("S" "p0_8") ("CO" "c0_8") ("VDD" "VDD") ("VSS" "VSS")) ())
  ("I57" "ALU_CELLS_C" "INV_X4" (("A" "p0_8") ("Y" "qu7") ("VDD" "VDD") ("VSS" "VSS")) ())
  ("I58" "ALU_STUB_B" "XOR2_X1" (("A" "B_0") ("B" "qu7") ("Y" "b1_0") ("VDD" "VDD") ("VSS" "VSS")) ())
  ("I59" "ALU_CELLS_C" "FA_X1" (("A" "aa6") ("B" "b1_0") ("CI" "qu7") ("S" "p1_0") ("CO" "c1_0") ("VDD" "VDD") ("VSS" "VSS")) ())
  ("I60" "ALU_STUB_B" "XOR2_X1" (("A" "dd1") ("B" "qu7") ("Y" "b1_1") ("VDD" "VDD") ("VSS" "VSS")) ())
  ("I61" "ALU_CELLS_C" "FA_X1" (("A" "p0_0") ("B" "b1_1") ("CI" "c1_0") ("S" "p1_1") ("CO" "c1_1") ("VDD" "VDD") ("VSS" "VSS")) ())
  ("I62" "ALU_STUB_B" "XOR2_X1" (("A" "dd2") ("B" "qu7") ("Y" "b1_2") ("VDD" "VDD") ("VSS" "VSS")) ())
  ("I63" "ALU_CELLS_C" "FA_X1" (("A" "p0_1") ("B" "b1_2") ("CI" "c1_1") ("S" "p1_2") ("CO" "c1_2") ("VDD" "VDD") ("VSS" "VSS")) ())
  ("I64" "ALU_STUB_B" "XOR2_X1" (("A" "dd3") ("B" "qu7") ("Y" "b1_3") ("VDD" "VDD") ("VSS" "VSS")) ())
  ("I65" "ALU_CELLS_C" "FA_X1" (("A" "p0_2") ("B" "b1_3") ("CI" "c1_2") ("S" "p1_3") ("CO" "c1_3") ("VDD" "VDD") ("VSS" "VSS")) ())
  ("I66" "ALU_STUB_B" "XOR2_X1" (("A" "dd4") ("B" "qu7") ("Y" "b1_4") ("VDD" "VDD") ("VSS" "VSS")) ())
  ("I67" "ALU_CELLS_C" "FA_X1" (("A" "p0_3") ("B" "b1_4") ("CI" "c1_3") ("S" "p1_4") ("CO" "c1_4") ("VDD" "VDD") ("VSS" "VSS")) ())
  ("I68" "ALU_STUB_B" "XOR2_X1" (("A" "dd5") ("B" "qu7") ("Y" "b1_5") ("VDD" "VDD") ("VSS" "VSS")) ())
  ("I69" "ALU_CELLS_C" "FA_X1" (("A" "p0_4") ("B" "b1_5") ("CI" "c1_4") ("S" "p1_5") ("CO" "c1_5") ("VDD" "VDD") ("VSS" "VSS")) ())
  ("I70" "ALU_STUB_B" "XOR2_X1" (("A" "dd6") ("B" "qu7") ("Y" "b1_6") ("VDD" "VDD") ("VSS" "VSS")) ())
  ("I71" "ALU_CELLS_C" "FA_X1" (("A" "p0_5") ("B" "b1_6") ("CI" "c1_5") ("S" "p1_6") ("CO" "c1_6") ("VDD" "VDD") ("VSS" "VSS")) ())
  ("I72" "ALU_STUB_B" "XOR2_X1" (("A" "dd7") ("B" "qu7") ("Y" "b1_7") ("VDD" "VDD") ("VSS" "VSS")) ())
  ("I73" "ALU_CELLS_C" "FA_X1" (("A" "p0_6") ("B" "b1_7") ("CI" "c1_6") ("S" "p1_7") ("CO" "c1_7") ("VDD" "VDD") ("VSS" "VSS")) ())
  ("I74" "ALU_CELLS_C" "FA_X1" (("A" "p0_7") ("B" "qu7") ("CI" "c1_7") ("S" "p1_8") ("CO" "c1_8") ("VDD" "VDD") ("VSS" "VSS")) ())
  ("I75" "ALU_CELLS_C" "INV_X4" (("A" "p1_8") ("Y" "qu6") ("VDD" "VDD") ("VSS" "VSS")) ())
  ("I76" "ALU_STUB_B" "XOR2_X1" (("A" "B_0") ("B" "qu6") ("Y" "b2_0") ("VDD" "VDD") ("VSS" "VSS")) ())
  ("I77" "ALU_CELLS_C" "FA_X1" (("A" "aa5") ("B" "b2_0") ("CI" "qu6") ("S" "p2_0") ("CO" "c2_0") ("VDD" "VDD") ("VSS" "VSS")) ())
  ("I78" "ALU_STUB_B" "XOR2_X1" (("A" "dd1") ("B" "qu6") ("Y" "b2_1") ("VDD" "VDD") ("VSS" "VSS")) ())
  ("I79" "ALU_CELLS_C" "FA_X1" (("A" "p1_0") ("B" "b2_1") ("CI" "c2_0") ("S" "p2_1") ("CO" "c2_1") ("VDD" "VDD") ("VSS" "VSS")) ())
  ("I80" "ALU_STUB_B" "XOR2_X1" (("A" "dd2") ("B" "qu6") ("Y" "b2_2") ("VDD" "VDD") ("VSS" "VSS")) ())
  ("I81" "ALU_CELLS_C" "FA_X1" (("A" "p1_1") ("B" "b2_2") ("CI" "c2_1") ("S" "p2_2") ("CO" "c2_2") ("VDD" "VDD") ("VSS" "VSS")) ())
  ("I82" "ALU_STUB_B" "XOR2_X1" (("A" "dd3") ("B" "qu6") ("Y" "b2_3") ("VDD" "VDD") ("VSS" "VSS")) ())
  ("I83" "ALU_CELLS_C" "FA_X1" (("A" "p1_2") ("B" "b2_3") ("CI" "c2_2") ("S" "p2_3") ("CO" "c2_3") ("VDD" "VDD") ("VSS" "VSS")) ())
  ("I84" "ALU_STUB_B" "XOR2_X1" (("A" "dd4") ("B" "qu6") ("Y" "b2_4") ("VDD" "VDD") ("VSS" "VSS")) ())
  ("I85" "ALU_CELLS_C" "FA_X1" (("A" "p1_3") ("B" "b2_4") ("CI" "c2_3") ("S" "p2_4") ("CO" "c2_4") ("VDD" "VDD") ("VSS" "VSS")) ())
  ("I86" "ALU_STUB_B" "XOR2_X1" (("A" "dd5") ("B" "qu6") ("Y" "b2_5") ("VDD" "VDD") ("VSS" "VSS")) ())
  ("I87" "ALU_CELLS_C" "FA_X1" (("A" "p1_4") ("B" "b2_5") ("CI" "c2_4") ("S" "p2_5") ("CO" "c2_5") ("VDD" "VDD") ("VSS" "VSS")) ())
  ("I88" "ALU_STUB_B" "XOR2_X1" (("A" "dd6") ("B" "qu6") ("Y" "b2_6") ("VDD" "VDD") ("VSS" "VSS")) ())
  ("I89" "ALU_CELLS_C" "FA_X1" (("A" "p1_5") ("B" "b2_6") ("CI" "c2_5") ("S" "p2_6") ("CO" "c2_6") ("VDD" "VDD") ("VSS" "VSS")) ())
  ("I90" "ALU_STUB_B" "XOR2_X1" (("A" "dd7") ("B" "qu6") ("Y" "b2_7") ("VDD" "VDD") ("VSS" "VSS")) ())
  ("I91" "ALU_CELLS_C" "FA_X1" (("A" "p1_6") ("B" "b2_7") ("CI" "c2_6") ("S" "p2_7") ("CO" "c2_7") ("VDD" "VDD") ("VSS" "VSS")) ())
  ("I92" "ALU_CELLS_C" "FA_X1" (("A" "p1_7") ("B" "qu6") ("CI" "c2_7") ("S" "p2_8") ("CO" "c2_8") ("VDD" "VDD") ("VSS" "VSS")) ())
  ("I93" "ALU_CELLS_C" "INV_X4" (("A" "p2_8") ("Y" "qu5") ("VDD" "VDD") ("VSS" "VSS")) ())
  ("I94" "ALU_STUB_B" "XOR2_X1" (("A" "B_0") ("B" "qu5") ("Y" "b3_0") ("VDD" "VDD") ("VSS" "VSS")) ())
  ("I95" "ALU_CELLS_C" "FA_X1" (("A" "aa4") ("B" "b3_0") ("CI" "qu5") ("S" "p3_0") ("CO" "c3_0") ("VDD" "VDD") ("VSS" "VSS")) ())
  ("I96" "ALU_STUB_B" "XOR2_X1" (("A" "dd1") ("B" "qu5") ("Y" "b3_1") ("VDD" "VDD") ("VSS" "VSS")) ())
  ("I97" "ALU_CELLS_C" "FA_X1" (("A" "p2_0") ("B" "b3_1") ("CI" "c3_0") ("S" "p3_1") ("CO" "c3_1") ("VDD" "VDD") ("VSS" "VSS")) ())
  ("I98" "ALU_STUB_B" "XOR2_X1" (("A" "dd2") ("B" "qu5") ("Y" "b3_2") ("VDD" "VDD") ("VSS" "VSS")) ())
  ("I99" "ALU_CELLS_C" "FA_X1" (("A" "p2_1") ("B" "b3_2") ("CI" "c3_1") ("S" "p3_2") ("CO" "c3_2") ("VDD" "VDD") ("VSS" "VSS")) ())
  ("I100" "ALU_STUB_B" "XOR2_X1" (("A" "dd3") ("B" "qu5") ("Y" "b3_3") ("VDD" "VDD") ("VSS" "VSS")) ())
  ("I101" "ALU_CELLS_C" "FA_X1" (("A" "p2_2") ("B" "b3_3") ("CI" "c3_2") ("S" "p3_3") ("CO" "c3_3") ("VDD" "VDD") ("VSS" "VSS")) ())
  ("I102" "ALU_STUB_B" "XOR2_X1" (("A" "dd4") ("B" "qu5") ("Y" "b3_4") ("VDD" "VDD") ("VSS" "VSS")) ())
  ("I103" "ALU_CELLS_C" "FA_X1" (("A" "p2_3") ("B" "b3_4") ("CI" "c3_3") ("S" "p3_4") ("CO" "c3_4") ("VDD" "VDD") ("VSS" "VSS")) ())
  ("I104" "ALU_STUB_B" "XOR2_X1" (("A" "dd5") ("B" "qu5") ("Y" "b3_5") ("VDD" "VDD") ("VSS" "VSS")) ())
  ("I105" "ALU_CELLS_C" "FA_X1" (("A" "p2_4") ("B" "b3_5") ("CI" "c3_4") ("S" "p3_5") ("CO" "c3_5") ("VDD" "VDD") ("VSS" "VSS")) ())
  ("I106" "ALU_STUB_B" "XOR2_X1" (("A" "dd6") ("B" "qu5") ("Y" "b3_6") ("VDD" "VDD") ("VSS" "VSS")) ())
  ("I107" "ALU_CELLS_C" "FA_X1" (("A" "p2_5") ("B" "b3_6") ("CI" "c3_5") ("S" "p3_6") ("CO" "c3_6") ("VDD" "VDD") ("VSS" "VSS")) ())
  ("I108" "ALU_STUB_B" "XOR2_X1" (("A" "dd7") ("B" "qu5") ("Y" "b3_7") ("VDD" "VDD") ("VSS" "VSS")) ())
  ("I109" "ALU_CELLS_C" "FA_X1" (("A" "p2_6") ("B" "b3_7") ("CI" "c3_6") ("S" "p3_7") ("CO" "c3_7") ("VDD" "VDD") ("VSS" "VSS")) ())
  ("I110" "ALU_CELLS_C" "FA_X1" (("A" "p2_7") ("B" "qu5") ("CI" "c3_7") ("S" "p3_8") ("CO" "c3_8") ("VDD" "VDD") ("VSS" "VSS")) ())
  ("I111" "ALU_CELLS_C" "INV_X4" (("A" "p3_8") ("Y" "qu4") ("VDD" "VDD") ("VSS" "VSS")) ())
  ("I112" "ALU_STUB_B" "XOR2_X1" (("A" "B_0") ("B" "qu4") ("Y" "b4_0") ("VDD" "VDD") ("VSS" "VSS")) ())
  ("I113" "ALU_CELLS_C" "FA_X1" (("A" "aa3") ("B" "b4_0") ("CI" "qu4") ("S" "p4_0") ("CO" "c4_0") ("VDD" "VDD") ("VSS" "VSS")) ())
  ("I114" "ALU_STUB_B" "XOR2_X1" (("A" "dd1") ("B" "qu4") ("Y" "b4_1") ("VDD" "VDD") ("VSS" "VSS")) ())
  ("I115" "ALU_CELLS_C" "FA_X1" (("A" "p3_0") ("B" "b4_1") ("CI" "c4_0") ("S" "p4_1") ("CO" "c4_1") ("VDD" "VDD") ("VSS" "VSS")) ())
  ("I116" "ALU_STUB_B" "XOR2_X1" (("A" "dd2") ("B" "qu4") ("Y" "b4_2") ("VDD" "VDD") ("VSS" "VSS")) ())
  ("I117" "ALU_CELLS_C" "FA_X1" (("A" "p3_1") ("B" "b4_2") ("CI" "c4_1") ("S" "p4_2") ("CO" "c4_2") ("VDD" "VDD") ("VSS" "VSS")) ())
  ("I118" "ALU_STUB_B" "XOR2_X1" (("A" "dd3") ("B" "qu4") ("Y" "b4_3") ("VDD" "VDD") ("VSS" "VSS")) ())
  ("I119" "ALU_CELLS_C" "FA_X1" (("A" "p3_2") ("B" "b4_3") ("CI" "c4_2") ("S" "p4_3") ("CO" "c4_3") ("VDD" "VDD") ("VSS" "VSS")) ())
  ("I120" "ALU_STUB_B" "XOR2_X1" (("A" "dd4") ("B" "qu4") ("Y" "b4_4") ("VDD" "VDD") ("VSS" "VSS")) ())
  ("I121" "ALU_CELLS_C" "FA_X1" (("A" "p3_3") ("B" "b4_4") ("CI" "c4_3") ("S" "p4_4") ("CO" "c4_4") ("VDD" "VDD") ("VSS" "VSS")) ())
  ("I122" "ALU_STUB_B" "XOR2_X1" (("A" "dd5") ("B" "qu4") ("Y" "b4_5") ("VDD" "VDD") ("VSS" "VSS")) ())
  ("I123" "ALU_CELLS_C" "FA_X1" (("A" "p3_4") ("B" "b4_5") ("CI" "c4_4") ("S" "p4_5") ("CO" "c4_5") ("VDD" "VDD") ("VSS" "VSS")) ())
  ("I124" "ALU_STUB_B" "XOR2_X1" (("A" "dd6") ("B" "qu4") ("Y" "b4_6") ("VDD" "VDD") ("VSS" "VSS")) ())
  ("I125" "ALU_CELLS_C" "FA_X1" (("A" "p3_5") ("B" "b4_6") ("CI" "c4_5") ("S" "p4_6") ("CO" "c4_6") ("VDD" "VDD") ("VSS" "VSS")) ())
  ("I126" "ALU_STUB_B" "XOR2_X1" (("A" "dd7") ("B" "qu4") ("Y" "b4_7") ("VDD" "VDD") ("VSS" "VSS")) ())
  ("I127" "ALU_CELLS_C" "FA_X1" (("A" "p3_6") ("B" "b4_7") ("CI" "c4_6") ("S" "p4_7") ("CO" "c4_7") ("VDD" "VDD") ("VSS" "VSS")) ())
  ("I128" "ALU_CELLS_C" "FA_X1" (("A" "p3_7") ("B" "qu4") ("CI" "c4_7") ("S" "p4_8") ("CO" "c4_8") ("VDD" "VDD") ("VSS" "VSS")) ())
  ("I129" "ALU_CELLS_C" "INV_X4" (("A" "p4_8") ("Y" "qu3") ("VDD" "VDD") ("VSS" "VSS")) ())
  ("I130" "ALU_STUB_B" "XOR2_X1" (("A" "B_0") ("B" "qu3") ("Y" "b5_0") ("VDD" "VDD") ("VSS" "VSS")) ())
  ("I131" "ALU_CELLS_C" "FA_X1" (("A" "aa2") ("B" "b5_0") ("CI" "qu3") ("S" "p5_0") ("CO" "c5_0") ("VDD" "VDD") ("VSS" "VSS")) ())
  ("I132" "ALU_STUB_B" "XOR2_X1" (("A" "dd1") ("B" "qu3") ("Y" "b5_1") ("VDD" "VDD") ("VSS" "VSS")) ())
  ("I133" "ALU_CELLS_C" "FA_X1" (("A" "p4_0") ("B" "b5_1") ("CI" "c5_0") ("S" "p5_1") ("CO" "c5_1") ("VDD" "VDD") ("VSS" "VSS")) ())
  ("I134" "ALU_STUB_B" "XOR2_X1" (("A" "dd2") ("B" "qu3") ("Y" "b5_2") ("VDD" "VDD") ("VSS" "VSS")) ())
  ("I135" "ALU_CELLS_C" "FA_X1" (("A" "p4_1") ("B" "b5_2") ("CI" "c5_1") ("S" "p5_2") ("CO" "c5_2") ("VDD" "VDD") ("VSS" "VSS")) ())
  ("I136" "ALU_STUB_B" "XOR2_X1" (("A" "dd3") ("B" "qu3") ("Y" "b5_3") ("VDD" "VDD") ("VSS" "VSS")) ())
  ("I137" "ALU_CELLS_C" "FA_X1" (("A" "p4_2") ("B" "b5_3") ("CI" "c5_2") ("S" "p5_3") ("CO" "c5_3") ("VDD" "VDD") ("VSS" "VSS")) ())
  ("I138" "ALU_STUB_B" "XOR2_X1" (("A" "dd4") ("B" "qu3") ("Y" "b5_4") ("VDD" "VDD") ("VSS" "VSS")) ())
  ("I139" "ALU_CELLS_C" "FA_X1" (("A" "p4_3") ("B" "b5_4") ("CI" "c5_3") ("S" "p5_4") ("CO" "c5_4") ("VDD" "VDD") ("VSS" "VSS")) ())
  ("I140" "ALU_STUB_B" "XOR2_X1" (("A" "dd5") ("B" "qu3") ("Y" "b5_5") ("VDD" "VDD") ("VSS" "VSS")) ())
  ("I141" "ALU_CELLS_C" "FA_X1" (("A" "p4_4") ("B" "b5_5") ("CI" "c5_4") ("S" "p5_5") ("CO" "c5_5") ("VDD" "VDD") ("VSS" "VSS")) ())
  ("I142" "ALU_STUB_B" "XOR2_X1" (("A" "dd6") ("B" "qu3") ("Y" "b5_6") ("VDD" "VDD") ("VSS" "VSS")) ())
  ("I143" "ALU_CELLS_C" "FA_X1" (("A" "p4_5") ("B" "b5_6") ("CI" "c5_5") ("S" "p5_6") ("CO" "c5_6") ("VDD" "VDD") ("VSS" "VSS")) ())
  ("I144" "ALU_STUB_B" "XOR2_X1" (("A" "dd7") ("B" "qu3") ("Y" "b5_7") ("VDD" "VDD") ("VSS" "VSS")) ())
  ("I145" "ALU_CELLS_C" "FA_X1" (("A" "p4_6") ("B" "b5_7") ("CI" "c5_6") ("S" "p5_7") ("CO" "c5_7") ("VDD" "VDD") ("VSS" "VSS")) ())
  ("I146" "ALU_CELLS_C" "FA_X1" (("A" "p4_7") ("B" "qu3") ("CI" "c5_7") ("S" "p5_8") ("CO" "c5_8") ("VDD" "VDD") ("VSS" "VSS")) ())
  ("I147" "ALU_CELLS_C" "INV_X4" (("A" "p5_8") ("Y" "qu2") ("VDD" "VDD") ("VSS" "VSS")) ())
  ("I148" "ALU_STUB_B" "XOR2_X1" (("A" "B_0") ("B" "qu2") ("Y" "b6_0") ("VDD" "VDD") ("VSS" "VSS")) ())
  ("I149" "ALU_CELLS_C" "FA_X1" (("A" "aa1") ("B" "b6_0") ("CI" "qu2") ("S" "p6_0") ("CO" "c6_0") ("VDD" "VDD") ("VSS" "VSS")) ())
  ("I150" "ALU_STUB_B" "XOR2_X1" (("A" "dd1") ("B" "qu2") ("Y" "b6_1") ("VDD" "VDD") ("VSS" "VSS")) ())
  ("I151" "ALU_CELLS_C" "FA_X1" (("A" "p5_0") ("B" "b6_1") ("CI" "c6_0") ("S" "p6_1") ("CO" "c6_1") ("VDD" "VDD") ("VSS" "VSS")) ())
  ("I152" "ALU_STUB_B" "XOR2_X1" (("A" "dd2") ("B" "qu2") ("Y" "b6_2") ("VDD" "VDD") ("VSS" "VSS")) ())
  ("I153" "ALU_CELLS_C" "FA_X1" (("A" "p5_1") ("B" "b6_2") ("CI" "c6_1") ("S" "p6_2") ("CO" "c6_2") ("VDD" "VDD") ("VSS" "VSS")) ())
  ("I154" "ALU_STUB_B" "XOR2_X1" (("A" "dd3") ("B" "qu2") ("Y" "b6_3") ("VDD" "VDD") ("VSS" "VSS")) ())
  ("I155" "ALU_CELLS_C" "FA_X1" (("A" "p5_2") ("B" "b6_3") ("CI" "c6_2") ("S" "p6_3") ("CO" "c6_3") ("VDD" "VDD") ("VSS" "VSS")) ())
  ("I156" "ALU_STUB_B" "XOR2_X1" (("A" "dd4") ("B" "qu2") ("Y" "b6_4") ("VDD" "VDD") ("VSS" "VSS")) ())
  ("I157" "ALU_CELLS_C" "FA_X1" (("A" "p5_3") ("B" "b6_4") ("CI" "c6_3") ("S" "p6_4") ("CO" "c6_4") ("VDD" "VDD") ("VSS" "VSS")) ())
  ("I158" "ALU_STUB_B" "XOR2_X1" (("A" "dd5") ("B" "qu2") ("Y" "b6_5") ("VDD" "VDD") ("VSS" "VSS")) ())
  ("I159" "ALU_CELLS_C" "FA_X1" (("A" "p5_4") ("B" "b6_5") ("CI" "c6_4") ("S" "p6_5") ("CO" "c6_5") ("VDD" "VDD") ("VSS" "VSS")) ())
  ("I160" "ALU_STUB_B" "XOR2_X1" (("A" "dd6") ("B" "qu2") ("Y" "b6_6") ("VDD" "VDD") ("VSS" "VSS")) ())
  ("I161" "ALU_CELLS_C" "FA_X1" (("A" "p5_5") ("B" "b6_6") ("CI" "c6_5") ("S" "p6_6") ("CO" "c6_6") ("VDD" "VDD") ("VSS" "VSS")) ())
  ("I162" "ALU_STUB_B" "XOR2_X1" (("A" "dd7") ("B" "qu2") ("Y" "b6_7") ("VDD" "VDD") ("VSS" "VSS")) ())
  ("I163" "ALU_CELLS_C" "FA_X1" (("A" "p5_6") ("B" "b6_7") ("CI" "c6_6") ("S" "p6_7") ("CO" "c6_7") ("VDD" "VDD") ("VSS" "VSS")) ())
  ("I164" "ALU_CELLS_C" "FA_X1" (("A" "p5_7") ("B" "qu2") ("CI" "c6_7") ("S" "p6_8") ("CO" "c6_8") ("VDD" "VDD") ("VSS" "VSS")) ())
  ("I165" "ALU_CELLS_C" "INV_X4" (("A" "p6_8") ("Y" "qu1") ("VDD" "VDD") ("VSS" "VSS")) ())
  ("I166" "ALU_STUB_B" "XOR2_X1" (("A" "B_0") ("B" "qu1") ("Y" "b7_0") ("VDD" "VDD") ("VSS" "VSS")) ())
  ("I167" "ALU_CELLS_C" "FA_X1" (("A" "A_0") ("B" "b7_0") ("CI" "qu1") ("S" "p7_0") ("CO" "c7_0") ("VDD" "VDD") ("VSS" "VSS")) ())
  ("I168" "ALU_STUB_B" "XOR2_X1" (("A" "dd1") ("B" "qu1") ("Y" "b7_1") ("VDD" "VDD") ("VSS" "VSS")) ())
  ("I169" "ALU_CELLS_C" "FA_X1" (("A" "p6_0") ("B" "b7_1") ("CI" "c7_0") ("S" "p7_1") ("CO" "c7_1") ("VDD" "VDD") ("VSS" "VSS")) ())
  ("I170" "ALU_STUB_B" "XOR2_X1" (("A" "dd2") ("B" "qu1") ("Y" "b7_2") ("VDD" "VDD") ("VSS" "VSS")) ())
  ("I171" "ALU_CELLS_C" "FA_X1" (("A" "p6_1") ("B" "b7_2") ("CI" "c7_1") ("S" "p7_2") ("CO" "c7_2") ("VDD" "VDD") ("VSS" "VSS")) ())
  ("I172" "ALU_STUB_B" "XOR2_X1" (("A" "dd3") ("B" "qu1") ("Y" "b7_3") ("VDD" "VDD") ("VSS" "VSS")) ())
  ("I173" "ALU_CELLS_C" "FA_X1" (("A" "p6_2") ("B" "b7_3") ("CI" "c7_2") ("S" "p7_3") ("CO" "c7_3") ("VDD" "VDD") ("VSS" "VSS")) ())
  ("I174" "ALU_STUB_B" "XOR2_X1" (("A" "dd4") ("B" "qu1") ("Y" "b7_4") ("VDD" "VDD") ("VSS" "VSS")) ())
  ("I175" "ALU_CELLS_C" "FA_X1" (("A" "p6_3") ("B" "b7_4") ("CI" "c7_3") ("S" "p7_4") ("CO" "c7_4") ("VDD" "VDD") ("VSS" "VSS")) ())
  ("I176" "ALU_STUB_B" "XOR2_X1" (("A" "dd5") ("B" "qu1") ("Y" "b7_5") ("VDD" "VDD") ("VSS" "VSS")) ())
  ("I177" "ALU_CELLS_C" "FA_X1" (("A" "p6_4") ("B" "b7_5") ("CI" "c7_4") ("S" "p7_5") ("CO" "c7_5") ("VDD" "VDD") ("VSS" "VSS")) ())
  ("I178" "ALU_STUB_B" "XOR2_X1" (("A" "dd6") ("B" "qu1") ("Y" "b7_6") ("VDD" "VDD") ("VSS" "VSS")) ())
  ("I179" "ALU_CELLS_C" "FA_X1" (("A" "p6_5") ("B" "b7_6") ("CI" "c7_5") ("S" "p7_6") ("CO" "c7_6") ("VDD" "VDD") ("VSS" "VSS")) ())
  ("I180" "ALU_STUB_B" "XOR2_X1" (("A" "dd7") ("B" "qu1") ("Y" "b7_7") ("VDD" "VDD") ("VSS" "VSS")) ())
  ("I181" "ALU_CELLS_C" "FA_X1" (("A" "p6_6") ("B" "b7_7") ("CI" "c7_6") ("S" "p7_7") ("CO" "c7_7") ("VDD" "VDD") ("VSS" "VSS")) ())
  ("I182" "ALU_CELLS_C" "FA_X1" (("A" "p6_7") ("B" "qu1") ("CI" "c7_7") ("S" "p7_8") ("CO" "c7_8") ("VDD" "VDD") ("VSS" "VSS")) ())
  ("I183" "ALU_CELLS_A" "INV_X1" (("A" "p7_8") ("Y" "Q_0") ("VDD" "VDD") ("VSS" "VSS")) ())
  ("I184" "ALU_CELLS_A" "NAND2_X1" (("A" "B_0") ("B" "p7_8") ("Y" "dmn0") ("VDD" "VDD") ("VSS" "VSS")) ())
  ("I185" "ALU_CELLS_A" "INV_X1" (("A" "dmn0") ("Y" "dm0") ("VDD" "VDD") ("VSS" "VSS")) ())
  ("I186" "ALU_CELLS_C" "FA_X1" (("A" "p7_0") ("B" "dm0") ("CI" "VSS") ("S" "R_0") ("CO" "rc0") ("VDD" "VDD") ("VSS" "VSS")) ())
  ("I187" "ALU_CELLS_A" "NAND2_X1" (("A" "dd1") ("B" "p7_8") ("Y" "dmn1") ("VDD" "VDD") ("VSS" "VSS")) ())
  ("I188" "ALU_CELLS_A" "INV_X1" (("A" "dmn1") ("Y" "dm1") ("VDD" "VDD") ("VSS" "VSS")) ())
  ("I189" "ALU_CELLS_C" "FA_X1" (("A" "p7_1") ("B" "dm1") ("CI" "rc0") ("S" "ru1") ("CO" "rc1") ("VDD" "VDD") ("VSS" "VSS")) ())
  ("I190" "ALU_CELLS_A" "NAND2_X1" (("A" "dd2") ("B" "p7_8") ("Y" "dmn2") ("VDD" "VDD") ("VSS" "VSS")) ())
  ("I191" "ALU_CELLS_A" "INV_X1" (("A" "dmn2") ("Y" "dm2") ("VDD" "VDD") ("VSS" "VSS")) ())
  ("I192" "ALU_CELLS_C" "FA_X1" (("A" "p7_2") ("B" "dm2") ("CI" "rc1") ("S" "ru2") ("CO" "rc2") ("VDD" "VDD") ("VSS" "VSS")) ())
  ("I193" "ALU_CELLS_A" "NAND2_X1" (("A" "dd3") ("B" "p7_8") ("Y" "dmn3") ("VDD" "VDD") ("VSS" "VSS")) ())
  ("I194" "ALU_CELLS_A" "INV_X1" (("A" "dmn3") ("Y" "dm3") ("VDD" "VDD") ("VSS" "VSS")) ())
  ("I195" "ALU_CELLS_C" "FA_X1" (("A" "p7_3") ("B" "dm3") ("CI" "rc2") ("S" "ru3") ("CO" "rc3") ("VDD" "VDD") ("VSS" "VSS")) ())
  ("I196" "ALU_CELLS_A" "NAND2_X1" (("A" "dd4") ("B" "p7_8") ("Y" "dmn4") ("VDD" "VDD") ("VSS" "VSS")) ())
  ("I197" "ALU_CELLS_A" "INV_X1" (("A" "dmn4") ("Y" "dm4") ("VDD" "VDD") ("VSS" "VSS")) ())
  ("I198" "ALU_CELLS_C" "FA_X1" (("A" "p7_4") ("B" "dm4") ("CI" "rc3") ("S" "ru4") ("CO" "rc4") ("VDD" "VDD") ("VSS" "VSS")) ())
  ("I199" "ALU_CELLS_A" "NAND2_X1" (("A" "dd5") ("B" "p7_8") ("Y" "dmn5") ("VDD" "VDD") ("VSS" "VSS")) ())
  ("I200" "ALU_CELLS_A" "INV_X1" (("A" "dmn5") ("Y" "dm5") ("VDD" "VDD") ("VSS" "VSS")) ())
  ("I201" "ALU_CELLS_C" "FA_X1" (("A" "p7_5") ("B" "dm5") ("CI" "rc4") ("S" "ru5") ("CO" "rc5") ("VDD" "VDD") ("VSS" "VSS")) ())
  ("I202" "ALU_CELLS_A" "NAND2_X1" (("A" "dd6") ("B" "p7_8") ("Y" "dmn6") ("VDD" "VDD") ("VSS" "VSS")) ())
  ("I203" "ALU_CELLS_A" "INV_X1" (("A" "dmn6") ("Y" "dm6") ("VDD" "VDD") ("VSS" "VSS")) ())
  ("I204" "ALU_CELLS_C" "FA_X1" (("A" "p7_6") ("B" "dm6") ("CI" "rc5") ("S" "ru6") ("CO" "rc6") ("VDD" "VDD") ("VSS" "VSS")) ())
  ("I205" "ALU_CELLS_A" "NAND2_X1" (("A" "dd7") ("B" "p7_8") ("Y" "dmn7") ("VDD" "VDD") ("VSS" "VSS")) ())
  ("I206" "ALU_CELLS_A" "INV_X1" (("A" "dmn7") ("Y" "dm7") ("VDD" "VDD") ("VSS" "VSS")) ())
  ("I207" "ALU_CELLS_C" "FA_X1" (("A" "p7_7") ("B" "dm7") ("CI" "rc6") ("S" "ru7") ("CO" "rc7") ("VDD" "VDD") ("VSS" "VSS")) ())
  ("I208" "ALU_STUB_B" "XOR2_X1" (("A" "A_7") ("B" "B_7") ("Y" "sq") ("VDD" "VDD") ("VSS" "VSS")) ())
  ("I209" "ALU_CELLS_A" "NAND2_X1" (("A" "sq") ("B" "Q_0") ("Y" "nqkn1") ("VDD" "VDD") ("VSS" "VSS")) ())
  ("I210" "ALU_STUB_B" "XNOR2_X1" (("A" "qu1") ("B" "nqkn1") ("Y" "Q_1") ("VDD" "VDD") ("VSS" "VSS")) ())
  ("I211" "ALU_CELLS_A" "INV_X1" (("A" "nqkn1") ("Y" "nqk1") ("VDD" "VDD") ("VSS" "VSS")) ())
  ("I212" "ALU_CELLS_A" "AOI21_X1" (("A1" "sq") ("A2" "qu1") ("B" "nqk1") ("Y" "nqkn2") ("VDD" "VDD") ("VSS" "VSS")) ())
  ("I213" "ALU_STUB_B" "XNOR2_X1" (("A" "qu2") ("B" "nqkn2") ("Y" "Q_2") ("VDD" "VDD") ("VSS" "VSS")) ())
  ("I214" "ALU_CELLS_A" "INV_X1" (("A" "nqkn2") ("Y" "nqk2") ("VDD" "VDD") ("VSS" "VSS")) ())
  ("I215" "ALU_CELLS_A" "AOI21_X1" (("A1" "sq") ("A2" "qu2") ("B" "nqk2") ("Y" "nqkn3") ("VDD" "VDD") ("VSS" "VSS")) ())
  ("I216" "ALU_STUB_B" "XNOR2_X1" (("A" "qu3") ("B" "nqkn3") ("Y" "Q_3") ("VDD" "VDD") ("VSS" "VSS")) ())
  ("I217" "ALU_CELLS_A" "INV_X1" (("A" "nqkn3") ("Y" "nqk3") ("VDD" "VDD") ("VSS" "VSS")) ())
  ("I218" "ALU_CELLS_A" "AOI21_X1" (("A1" "sq") ("A2" "qu3") ("B" "nqk3") ("Y" "nqkn4") ("VDD" "VDD") ("VSS" "VSS")) ())
  ("I219" "ALU_STUB_B" "XNOR2_X1" (("A" "qu4") ("B" "nqkn4") ("Y" "Q_4") ("VDD" "VDD") ("VSS" "VSS")) ())
  ("I220" "ALU_CELLS_A" "INV_X1" (("A" "nqkn4") ("Y" "nqk4") ("VDD" "VDD") ("VSS" "VSS")) ())
  ("I221" "ALU_CELLS_A" "AOI21_X1" (("A1" "sq") ("A2" "qu4") ("B" "nqk4") ("Y" "nqkn5") ("VDD" "VDD") ("VSS" "VSS")) ())
  ("I222" "ALU_STUB_B" "XNOR2_X1" (("A" "qu5") ("B" "nqkn5") ("Y" "Q_5") ("VDD" "VDD") ("VSS" "VSS")) ())
  ("I223" "ALU_CELLS_A" "INV_X1" (("A" "nqkn5") ("Y" "nqk5") ("VDD" "VDD") ("VSS" "VSS")) ())
  ("I224" "ALU_CELLS_A" "AOI21_X1" (("A1" "sq") ("A2" "qu5") ("B" "nqk5") ("Y" "nqkn6") ("VDD" "VDD") ("VSS" "VSS")) ())
  ("I225" "ALU_STUB_B" "XNOR2_X1" (("A" "qu6") ("B" "nqkn6") ("Y" "Q_6") ("VDD" "VDD") ("VSS" "VSS")) ())
  ("I226" "ALU_CELLS_A" "INV_X1" (("A" "nqkn6") ("Y" "nqk6") ("VDD" "VDD") ("VSS" "VSS")) ())
  ("I227" "ALU_CELLS_A" "AOI21_X1" (("A1" "sq") ("A2" "qu6") ("B" "nqk6") ("Y" "nqkn7") ("VDD" "VDD") ("VSS" "VSS")) ())
  ("I228" "ALU_STUB_B" "XNOR2_X1" (("A" "qu7") ("B" "nqkn7") ("Y" "Q_7") ("VDD" "VDD") ("VSS" "VSS")) ())
  ("I229" "ALU_CELLS_A" "NAND2_X1" (("A" "A_7") ("B" "R_0") ("Y" "nrkn1") ("VDD" "VDD") ("VSS" "VSS")) ())
  ("I230" "ALU_STUB_B" "XNOR2_X1" (("A" "ru1") ("B" "nrkn1") ("Y" "R_1") ("VDD" "VDD") ("VSS" "VSS")) ())
  ("I231" "ALU_CELLS_A" "INV_X1" (("A" "nrkn1") ("Y" "nrk1") ("VDD" "VDD") ("VSS" "VSS")) ())
  ("I232" "ALU_CELLS_A" "AOI21_X1" (("A1" "A_7") ("A2" "ru1") ("B" "nrk1") ("Y" "nrkn2") ("VDD" "VDD") ("VSS" "VSS")) ())
  ("I233" "ALU_STUB_B" "XNOR2_X1" (("A" "ru2") ("B" "nrkn2") ("Y" "R_2") ("VDD" "VDD") ("VSS" "VSS")) ())
  ("I234" "ALU_CELLS_A" "INV_X1" (("A" "nrkn2") ("Y" "nrk2") ("VDD" "VDD") ("VSS" "VSS")) ())
  ("I235" "ALU_CELLS_A" "AOI21_X1" (("A1" "A_7") ("A2" "ru2") ("B" "nrk2") ("Y" "nrkn3") ("VDD" "VDD") ("VSS" "VSS")) ())
  ("I236" "ALU_STUB_B" "XNOR2_X1" (("A" "ru3") ("B" "nrkn3") ("Y" "R_3") ("VDD" "VDD") ("VSS" "VSS")) ())
  ("I237" "ALU_CELLS_A" "INV_X1" (("A" "nrkn3") ("Y" "nrk3") ("VDD" "VDD") ("VSS" "VSS")) ())
  ("I238" "ALU_CELLS_A" "AOI21_X1" (("A1" "A_7") ("A2" "ru3") ("B" "nrk3") ("Y" "nrkn4") ("VDD" "VDD") ("VSS" "VSS")) ())
  ("I239" "ALU_STUB_B" "XNOR2_X1" (("A" "ru4") ("B" "nrkn4") ("Y" "R_4") ("VDD" "VDD") ("VSS" "VSS")) ())
  ("I240" "ALU_CELLS_A" "INV_X1" (("A" "nrkn4") ("Y" "nrk4") ("VDD" "VDD") ("VSS" "VSS")) ())
  ("I241" "ALU_CELLS_A" "AOI21_X1" (("A1" "A_7") ("A2" "ru4") ("B" "nrk4") ("Y" "nrkn5") ("VDD" "VDD") ("VSS" "VSS")) ())
  ("I242" "ALU_STUB_B" "XNOR2_X1" (("A" "ru5") ("B" "nrkn5") ("Y" "R_5") ("VDD" "VDD") ("VSS" "VSS")) ())
  ("I243" "ALU_CELLS_A" "INV_X1" (("A" "nrkn5") ("Y" "nrk5") ("VDD" "VDD") ("VSS" "VSS")) ())
  ("I244" "ALU_CELLS_A" "AOI21_X1" (("A1" "A_7") ("A2" "ru5") ("B" "nrk5") ("Y" "nrkn6") ("VDD" "VDD") ("VSS" "VSS")) ())
  ("I245" "ALU_STUB_B" "XNOR2_X1" (("A" "ru6") ("B" "nrkn6") ("Y" "R_6") ("VDD" "VDD") ("VSS" "VSS")) ())
  ("I246" "ALU_CELLS_A" "INV_X1" (("A" "nrkn6") ("Y" "nrk6") ("VDD" "VDD") ("VSS" "VSS")) ())
  ("I247" "ALU_CELLS_A" "AOI21_X1" (("A1" "A_7") ("A2" "ru6") ("B" "nrk6") ("Y" "nrkn7") ("VDD" "VDD") ("VSS" "VSS")) ())
  ("I248" "ALU_STUB_B" "XNOR2_X1" (("A" "ru7") ("B" "nrkn7") ("Y" "R_7") ("VDD" "VDD") ("VSS" "VSS")) ())
  ("I249" "ALU_CELLS_A" "NOR2_X1" (("A" "B_0") ("B" "B_1") ("Y" "z1_0") ("VDD" "VDD") ("VSS" "VSS")) ())
  ("I250" "ALU_CELLS_A" "NOR2_X1" (("A" "B_2") ("B" "B_3") ("Y" "z1_1") ("VDD" "VDD") ("VSS" "VSS")) ())
  ("I251" "ALU_CELLS_A" "NOR2_X1" (("A" "B_4") ("B" "B_5") ("Y" "z1_2") ("VDD" "VDD") ("VSS" "VSS")) ())
  ("I252" "ALU_CELLS_A" "NOR2_X1" (("A" "B_6") ("B" "B_7") ("Y" "z1_3") ("VDD" "VDD") ("VSS" "VSS")) ())
  ("I253" "ALU_CELLS_A" "NAND2_X1" (("A" "z1_0") ("B" "z1_1") ("Y" "z2_0") ("VDD" "VDD") ("VSS" "VSS")) ())
  ("I254" "ALU_CELLS_A" "NAND2_X1" (("A" "z1_2") ("B" "z1_3") ("Y" "z2_1") ("VDD" "VDD") ("VSS" "VSS")) ())
  ("I255" "ALU_CELLS_A" "NOR2_X1" (("A" "z2_0") ("B" "z2_1") ("Y" "DZ") ("VDD" "VDD") ("VSS" "VSS")) ())
  ("I256" "ALU_CELLS_A" "INV_X1" (("A" "sq") ("Y" "sqn") ("VDD" "VDD") ("VSS" "VSS")) ())
  ("I257" "ALU_CELLS_A" "NAND2_X1" (("A" "Q_7") ("B" "sqn") ("Y" "vn") ("VDD" "VDD") ("VSS" "VSS")) ())
  ("I258" "ALU_CELLS_A" "NOR2_X1" (("A" "vn") ("B" "DZ") ("Y" "V") ("VDD" "VDD") ("VSS" "VSS")) ()))) t)
  sbErrors++ printf("SB_ERROR DIV8F: %L\n" errset.errset))
unless(errset(sbCell("ALU_DIV" "DIV8K" '(("A_0" "input") ("A_1" "input") ("A_2" "input") ("A_3" "input") ("A_4" "input") ("A_5" "input") ("A_6" "input") ("A_7" "input") ("B_0" "input") ("B_1" "input") ("B_2" "input") ("B_3" "input") ("B_4" "input") ("B_5" "input") ("B_6" "input") ("B_7" "input") ("Q_0" "output") ("Q_1" "output") ("Q_2" "output") ("Q_3" "output") ("Q_4" "output") ("Q_5" "output") ("Q_6" "output") ("Q_7" "output") ("R_0" "output") ("R_1" "output") ("R_2" "output") ("R_3" "output") ("R_4" "output") ("R_5" "output") ("R_6" "output") ("R_7" "output") ("V" "output") ("DZ" "output") ("VDD" "inputOutput") ("VSS" "inputOutput"))
 '(
  ("I0" "ALU_CELLS_A" "NAND2_X1" (("A" "A_7") ("B" "A_0") ("Y" "nakn1") ("VDD" "VDD") ("VSS" "VSS")) ())
  ("I1" "ALU_STUB_B" "XNOR2_X1" (("A" "A_1") ("B" "nakn1") ("Y" "aa1") ("VDD" "VDD") ("VSS" "VSS")) ())
  ("I2" "ALU_CELLS_A" "INV_X1" (("A" "nakn1") ("Y" "nak1") ("VDD" "VDD") ("VSS" "VSS")) ())
  ("I3" "ALU_CELLS_A" "AOI21_X1" (("A1" "A_7") ("A2" "A_1") ("B" "nak1") ("Y" "nakn2") ("VDD" "VDD") ("VSS" "VSS")) ())
  ("I4" "ALU_STUB_B" "XNOR2_X1" (("A" "A_2") ("B" "nakn2") ("Y" "aa2") ("VDD" "VDD") ("VSS" "VSS")) ())
  ("I5" "ALU_CELLS_A" "INV_X1" (("A" "nakn2") ("Y" "nak2") ("VDD" "VDD") ("VSS" "VSS")) ())
  ("I6" "ALU_CELLS_A" "AOI21_X1" (("A1" "A_7") ("A2" "A_2") ("B" "nak2") ("Y" "nakn3") ("VDD" "VDD") ("VSS" "VSS")) ())
  ("I7" "ALU_STUB_B" "XNOR2_X1" (("A" "A_3") ("B" "nakn3") ("Y" "aa3") ("VDD" "VDD") ("VSS" "VSS")) ())
  ("I8" "ALU_CELLS_A" "INV_X1" (("A" "nakn3") ("Y" "nak3") ("VDD" "VDD") ("VSS" "VSS")) ())
  ("I9" "ALU_CELLS_A" "AOI21_X1" (("A1" "A_7") ("A2" "A_3") ("B" "nak3") ("Y" "nakn4") ("VDD" "VDD") ("VSS" "VSS")) ())
  ("I10" "ALU_STUB_B" "XNOR2_X1" (("A" "A_4") ("B" "nakn4") ("Y" "aa4") ("VDD" "VDD") ("VSS" "VSS")) ())
  ("I11" "ALU_CELLS_A" "INV_X1" (("A" "nakn4") ("Y" "nak4") ("VDD" "VDD") ("VSS" "VSS")) ())
  ("I12" "ALU_CELLS_A" "AOI21_X1" (("A1" "A_7") ("A2" "A_4") ("B" "nak4") ("Y" "nakn5") ("VDD" "VDD") ("VSS" "VSS")) ())
  ("I13" "ALU_STUB_B" "XNOR2_X1" (("A" "A_5") ("B" "nakn5") ("Y" "aa5") ("VDD" "VDD") ("VSS" "VSS")) ())
  ("I14" "ALU_CELLS_A" "INV_X1" (("A" "nakn5") ("Y" "nak5") ("VDD" "VDD") ("VSS" "VSS")) ())
  ("I15" "ALU_CELLS_A" "AOI21_X1" (("A1" "A_7") ("A2" "A_5") ("B" "nak5") ("Y" "nakn6") ("VDD" "VDD") ("VSS" "VSS")) ())
  ("I16" "ALU_STUB_B" "XNOR2_X1" (("A" "A_6") ("B" "nakn6") ("Y" "aa6") ("VDD" "VDD") ("VSS" "VSS")) ())
  ("I17" "ALU_CELLS_A" "INV_X1" (("A" "nakn6") ("Y" "nak6") ("VDD" "VDD") ("VSS" "VSS")) ())
  ("I18" "ALU_CELLS_A" "AOI21_X1" (("A1" "A_7") ("A2" "A_6") ("B" "nak6") ("Y" "nakn7") ("VDD" "VDD") ("VSS" "VSS")) ())
  ("I19" "ALU_STUB_B" "XNOR2_X1" (("A" "A_7") ("B" "nakn7") ("Y" "aa7") ("VDD" "VDD") ("VSS" "VSS")) ())
  ("I20" "ALU_CELLS_A" "NAND2_X1" (("A" "B_7") ("B" "B_0") ("Y" "nbkn1") ("VDD" "VDD") ("VSS" "VSS")) ())
  ("I21" "ALU_STUB_B" "XNOR2_X1" (("A" "B_1") ("B" "nbkn1") ("Y" "dd1") ("VDD" "VDD") ("VSS" "VSS")) ())
  ("I22" "ALU_CELLS_A" "INV_X1" (("A" "nbkn1") ("Y" "nbk1") ("VDD" "VDD") ("VSS" "VSS")) ())
  ("I23" "ALU_CELLS_A" "AOI21_X1" (("A1" "B_7") ("A2" "B_1") ("B" "nbk1") ("Y" "nbkn2") ("VDD" "VDD") ("VSS" "VSS")) ())
  ("I24" "ALU_STUB_B" "XNOR2_X1" (("A" "B_2") ("B" "nbkn2") ("Y" "dd2") ("VDD" "VDD") ("VSS" "VSS")) ())
  ("I25" "ALU_CELLS_A" "INV_X1" (("A" "nbkn2") ("Y" "nbk2") ("VDD" "VDD") ("VSS" "VSS")) ())
  ("I26" "ALU_CELLS_A" "AOI21_X1" (("A1" "B_7") ("A2" "B_2") ("B" "nbk2") ("Y" "nbkn3") ("VDD" "VDD") ("VSS" "VSS")) ())
  ("I27" "ALU_STUB_B" "XNOR2_X1" (("A" "B_3") ("B" "nbkn3") ("Y" "dd3") ("VDD" "VDD") ("VSS" "VSS")) ())
  ("I28" "ALU_CELLS_A" "INV_X1" (("A" "nbkn3") ("Y" "nbk3") ("VDD" "VDD") ("VSS" "VSS")) ())
  ("I29" "ALU_CELLS_A" "AOI21_X1" (("A1" "B_7") ("A2" "B_3") ("B" "nbk3") ("Y" "nbkn4") ("VDD" "VDD") ("VSS" "VSS")) ())
  ("I30" "ALU_STUB_B" "XNOR2_X1" (("A" "B_4") ("B" "nbkn4") ("Y" "dd4") ("VDD" "VDD") ("VSS" "VSS")) ())
  ("I31" "ALU_CELLS_A" "INV_X1" (("A" "nbkn4") ("Y" "nbk4") ("VDD" "VDD") ("VSS" "VSS")) ())
  ("I32" "ALU_CELLS_A" "AOI21_X1" (("A1" "B_7") ("A2" "B_4") ("B" "nbk4") ("Y" "nbkn5") ("VDD" "VDD") ("VSS" "VSS")) ())
  ("I33" "ALU_STUB_B" "XNOR2_X1" (("A" "B_5") ("B" "nbkn5") ("Y" "dd5") ("VDD" "VDD") ("VSS" "VSS")) ())
  ("I34" "ALU_CELLS_A" "INV_X1" (("A" "nbkn5") ("Y" "nbk5") ("VDD" "VDD") ("VSS" "VSS")) ())
  ("I35" "ALU_CELLS_A" "AOI21_X1" (("A1" "B_7") ("A2" "B_5") ("B" "nbk5") ("Y" "nbkn6") ("VDD" "VDD") ("VSS" "VSS")) ())
  ("I36" "ALU_STUB_B" "XNOR2_X1" (("A" "B_6") ("B" "nbkn6") ("Y" "dd6") ("VDD" "VDD") ("VSS" "VSS")) ())
  ("I37" "ALU_CELLS_A" "INV_X1" (("A" "nbkn6") ("Y" "nbk6") ("VDD" "VDD") ("VSS" "VSS")) ())
  ("I38" "ALU_CELLS_A" "AOI21_X1" (("A1" "B_7") ("A2" "B_6") ("B" "nbk6") ("Y" "nbkn7") ("VDD" "VDD") ("VSS" "VSS")) ())
  ("I39" "ALU_STUB_B" "XNOR2_X1" (("A" "B_7") ("B" "nbkn7") ("Y" "dd7") ("VDD" "VDD") ("VSS" "VSS")) ())
  ("I40" "ALU_STUB_B" "XOR2_X1" (("A" "B_0") ("B" "VDD") ("Y" "b0_0") ("VDD" "VDD") ("VSS" "VSS")) ())
  ("I41" "ALU_STUB_B" "XOR2_X1" (("A" "dd1") ("B" "VDD") ("Y" "b0_1") ("VDD" "VDD") ("VSS" "VSS")) ())
  ("I42" "ALU_STUB_B" "XOR2_X1" (("A" "dd2") ("B" "VDD") ("Y" "b0_2") ("VDD" "VDD") ("VSS" "VSS")) ())
  ("I43" "ALU_STUB_B" "XOR2_X1" (("A" "dd3") ("B" "VDD") ("Y" "b0_3") ("VDD" "VDD") ("VSS" "VSS")) ())
  ("I44" "ALU_STUB_B" "XOR2_X1" (("A" "dd4") ("B" "VDD") ("Y" "b0_4") ("VDD" "VDD") ("VSS" "VSS")) ())
  ("I45" "ALU_STUB_B" "XOR2_X1" (("A" "dd5") ("B" "VDD") ("Y" "b0_5") ("VDD" "VDD") ("VSS" "VSS")) ())
  ("I46" "ALU_STUB_B" "XOR2_X1" (("A" "dd6") ("B" "VDD") ("Y" "b0_6") ("VDD" "VDD") ("VSS" "VSS")) ())
  ("I47" "ALU_STUB_B" "XOR2_X1" (("A" "dd7") ("B" "VDD") ("Y" "b0_7") ("VDD" "VDD") ("VSS" "VSS")) ())
  ("I48" "ALU_ADD" "KSA8" (("A_0" "aa7") ("A_1" "VSS") ("A_2" "VSS") ("A_3" "VSS") ("A_4" "VSS") ("A_5" "VSS") ("A_6" "VSS") ("A_7" "VSS") ("B_0" "b0_0") ("B_1" "b0_1") ("B_2" "b0_2") ("B_3" "b0_3") ("B_4" "b0_4") ("B_5" "b0_5") ("B_6" "b0_6") ("B_7" "b0_7") ("CIN" "VDD") ("S_0" "p0_0") ("S_1" "p0_1") ("S_2" "p0_2") ("S_3" "p0_3") ("S_4" "p0_4") ("S_5" "p0_5") ("S_6" "p0_6") ("S_7" "p0_7") ("C7" "c0_7") ("C8" "c0_8") ("VDD" "VDD") ("VSS" "VSS")) ())
  ("I49" "ALU_STUB_B" "XOR2_X1" (("A" "VSS") ("B" "VDD") ("Y" "h0") ("VDD" "VDD") ("VSS" "VSS")) ())
  ("I50" "ALU_STUB_B" "XOR2_X1" (("A" "h0") ("B" "c0_8") ("Y" "p0_8") ("VDD" "VDD") ("VSS" "VSS")) ())
  ("I51" "ALU_CELLS_C" "INV_X4" (("A" "p0_8") ("Y" "qu7") ("VDD" "VDD") ("VSS" "VSS")) ())
  ("I52" "ALU_STUB_B" "XOR2_X1" (("A" "B_0") ("B" "qu7") ("Y" "b1_0") ("VDD" "VDD") ("VSS" "VSS")) ())
  ("I53" "ALU_STUB_B" "XOR2_X1" (("A" "dd1") ("B" "qu7") ("Y" "b1_1") ("VDD" "VDD") ("VSS" "VSS")) ())
  ("I54" "ALU_STUB_B" "XOR2_X1" (("A" "dd2") ("B" "qu7") ("Y" "b1_2") ("VDD" "VDD") ("VSS" "VSS")) ())
  ("I55" "ALU_STUB_B" "XOR2_X1" (("A" "dd3") ("B" "qu7") ("Y" "b1_3") ("VDD" "VDD") ("VSS" "VSS")) ())
  ("I56" "ALU_STUB_B" "XOR2_X1" (("A" "dd4") ("B" "qu7") ("Y" "b1_4") ("VDD" "VDD") ("VSS" "VSS")) ())
  ("I57" "ALU_STUB_B" "XOR2_X1" (("A" "dd5") ("B" "qu7") ("Y" "b1_5") ("VDD" "VDD") ("VSS" "VSS")) ())
  ("I58" "ALU_STUB_B" "XOR2_X1" (("A" "dd6") ("B" "qu7") ("Y" "b1_6") ("VDD" "VDD") ("VSS" "VSS")) ())
  ("I59" "ALU_STUB_B" "XOR2_X1" (("A" "dd7") ("B" "qu7") ("Y" "b1_7") ("VDD" "VDD") ("VSS" "VSS")) ())
  ("I60" "ALU_ADD" "KSA8" (("A_0" "aa6") ("A_1" "p0_0") ("A_2" "p0_1") ("A_3" "p0_2") ("A_4" "p0_3") ("A_5" "p0_4") ("A_6" "p0_5") ("A_7" "p0_6") ("B_0" "b1_0") ("B_1" "b1_1") ("B_2" "b1_2") ("B_3" "b1_3") ("B_4" "b1_4") ("B_5" "b1_5") ("B_6" "b1_6") ("B_7" "b1_7") ("CIN" "qu7") ("S_0" "p1_0") ("S_1" "p1_1") ("S_2" "p1_2") ("S_3" "p1_3") ("S_4" "p1_4") ("S_5" "p1_5") ("S_6" "p1_6") ("S_7" "p1_7") ("C7" "c1_7") ("C8" "c1_8") ("VDD" "VDD") ("VSS" "VSS")) ())
  ("I61" "ALU_STUB_B" "XOR2_X1" (("A" "p0_7") ("B" "qu7") ("Y" "h1") ("VDD" "VDD") ("VSS" "VSS")) ())
  ("I62" "ALU_STUB_B" "XOR2_X1" (("A" "h1") ("B" "c1_8") ("Y" "p1_8") ("VDD" "VDD") ("VSS" "VSS")) ())
  ("I63" "ALU_CELLS_C" "INV_X4" (("A" "p1_8") ("Y" "qu6") ("VDD" "VDD") ("VSS" "VSS")) ())
  ("I64" "ALU_STUB_B" "XOR2_X1" (("A" "B_0") ("B" "qu6") ("Y" "b2_0") ("VDD" "VDD") ("VSS" "VSS")) ())
  ("I65" "ALU_STUB_B" "XOR2_X1" (("A" "dd1") ("B" "qu6") ("Y" "b2_1") ("VDD" "VDD") ("VSS" "VSS")) ())
  ("I66" "ALU_STUB_B" "XOR2_X1" (("A" "dd2") ("B" "qu6") ("Y" "b2_2") ("VDD" "VDD") ("VSS" "VSS")) ())
  ("I67" "ALU_STUB_B" "XOR2_X1" (("A" "dd3") ("B" "qu6") ("Y" "b2_3") ("VDD" "VDD") ("VSS" "VSS")) ())
  ("I68" "ALU_STUB_B" "XOR2_X1" (("A" "dd4") ("B" "qu6") ("Y" "b2_4") ("VDD" "VDD") ("VSS" "VSS")) ())
  ("I69" "ALU_STUB_B" "XOR2_X1" (("A" "dd5") ("B" "qu6") ("Y" "b2_5") ("VDD" "VDD") ("VSS" "VSS")) ())
  ("I70" "ALU_STUB_B" "XOR2_X1" (("A" "dd6") ("B" "qu6") ("Y" "b2_6") ("VDD" "VDD") ("VSS" "VSS")) ())
  ("I71" "ALU_STUB_B" "XOR2_X1" (("A" "dd7") ("B" "qu6") ("Y" "b2_7") ("VDD" "VDD") ("VSS" "VSS")) ())
  ("I72" "ALU_ADD" "KSA8" (("A_0" "aa5") ("A_1" "p1_0") ("A_2" "p1_1") ("A_3" "p1_2") ("A_4" "p1_3") ("A_5" "p1_4") ("A_6" "p1_5") ("A_7" "p1_6") ("B_0" "b2_0") ("B_1" "b2_1") ("B_2" "b2_2") ("B_3" "b2_3") ("B_4" "b2_4") ("B_5" "b2_5") ("B_6" "b2_6") ("B_7" "b2_7") ("CIN" "qu6") ("S_0" "p2_0") ("S_1" "p2_1") ("S_2" "p2_2") ("S_3" "p2_3") ("S_4" "p2_4") ("S_5" "p2_5") ("S_6" "p2_6") ("S_7" "p2_7") ("C7" "c2_7") ("C8" "c2_8") ("VDD" "VDD") ("VSS" "VSS")) ())
  ("I73" "ALU_STUB_B" "XOR2_X1" (("A" "p1_7") ("B" "qu6") ("Y" "h2") ("VDD" "VDD") ("VSS" "VSS")) ())
  ("I74" "ALU_STUB_B" "XOR2_X1" (("A" "h2") ("B" "c2_8") ("Y" "p2_8") ("VDD" "VDD") ("VSS" "VSS")) ())
  ("I75" "ALU_CELLS_C" "INV_X4" (("A" "p2_8") ("Y" "qu5") ("VDD" "VDD") ("VSS" "VSS")) ())
  ("I76" "ALU_STUB_B" "XOR2_X1" (("A" "B_0") ("B" "qu5") ("Y" "b3_0") ("VDD" "VDD") ("VSS" "VSS")) ())
  ("I77" "ALU_STUB_B" "XOR2_X1" (("A" "dd1") ("B" "qu5") ("Y" "b3_1") ("VDD" "VDD") ("VSS" "VSS")) ())
  ("I78" "ALU_STUB_B" "XOR2_X1" (("A" "dd2") ("B" "qu5") ("Y" "b3_2") ("VDD" "VDD") ("VSS" "VSS")) ())
  ("I79" "ALU_STUB_B" "XOR2_X1" (("A" "dd3") ("B" "qu5") ("Y" "b3_3") ("VDD" "VDD") ("VSS" "VSS")) ())
  ("I80" "ALU_STUB_B" "XOR2_X1" (("A" "dd4") ("B" "qu5") ("Y" "b3_4") ("VDD" "VDD") ("VSS" "VSS")) ())
  ("I81" "ALU_STUB_B" "XOR2_X1" (("A" "dd5") ("B" "qu5") ("Y" "b3_5") ("VDD" "VDD") ("VSS" "VSS")) ())
  ("I82" "ALU_STUB_B" "XOR2_X1" (("A" "dd6") ("B" "qu5") ("Y" "b3_6") ("VDD" "VDD") ("VSS" "VSS")) ())
  ("I83" "ALU_STUB_B" "XOR2_X1" (("A" "dd7") ("B" "qu5") ("Y" "b3_7") ("VDD" "VDD") ("VSS" "VSS")) ())
  ("I84" "ALU_ADD" "KSA8" (("A_0" "aa4") ("A_1" "p2_0") ("A_2" "p2_1") ("A_3" "p2_2") ("A_4" "p2_3") ("A_5" "p2_4") ("A_6" "p2_5") ("A_7" "p2_6") ("B_0" "b3_0") ("B_1" "b3_1") ("B_2" "b3_2") ("B_3" "b3_3") ("B_4" "b3_4") ("B_5" "b3_5") ("B_6" "b3_6") ("B_7" "b3_7") ("CIN" "qu5") ("S_0" "p3_0") ("S_1" "p3_1") ("S_2" "p3_2") ("S_3" "p3_3") ("S_4" "p3_4") ("S_5" "p3_5") ("S_6" "p3_6") ("S_7" "p3_7") ("C7" "c3_7") ("C8" "c3_8") ("VDD" "VDD") ("VSS" "VSS")) ())
  ("I85" "ALU_STUB_B" "XOR2_X1" (("A" "p2_7") ("B" "qu5") ("Y" "h3") ("VDD" "VDD") ("VSS" "VSS")) ())
  ("I86" "ALU_STUB_B" "XOR2_X1" (("A" "h3") ("B" "c3_8") ("Y" "p3_8") ("VDD" "VDD") ("VSS" "VSS")) ())
  ("I87" "ALU_CELLS_C" "INV_X4" (("A" "p3_8") ("Y" "qu4") ("VDD" "VDD") ("VSS" "VSS")) ())
  ("I88" "ALU_STUB_B" "XOR2_X1" (("A" "B_0") ("B" "qu4") ("Y" "b4_0") ("VDD" "VDD") ("VSS" "VSS")) ())
  ("I89" "ALU_STUB_B" "XOR2_X1" (("A" "dd1") ("B" "qu4") ("Y" "b4_1") ("VDD" "VDD") ("VSS" "VSS")) ())
  ("I90" "ALU_STUB_B" "XOR2_X1" (("A" "dd2") ("B" "qu4") ("Y" "b4_2") ("VDD" "VDD") ("VSS" "VSS")) ())
  ("I91" "ALU_STUB_B" "XOR2_X1" (("A" "dd3") ("B" "qu4") ("Y" "b4_3") ("VDD" "VDD") ("VSS" "VSS")) ())
  ("I92" "ALU_STUB_B" "XOR2_X1" (("A" "dd4") ("B" "qu4") ("Y" "b4_4") ("VDD" "VDD") ("VSS" "VSS")) ())
  ("I93" "ALU_STUB_B" "XOR2_X1" (("A" "dd5") ("B" "qu4") ("Y" "b4_5") ("VDD" "VDD") ("VSS" "VSS")) ())
  ("I94" "ALU_STUB_B" "XOR2_X1" (("A" "dd6") ("B" "qu4") ("Y" "b4_6") ("VDD" "VDD") ("VSS" "VSS")) ())
  ("I95" "ALU_STUB_B" "XOR2_X1" (("A" "dd7") ("B" "qu4") ("Y" "b4_7") ("VDD" "VDD") ("VSS" "VSS")) ())
  ("I96" "ALU_ADD" "KSA8" (("A_0" "aa3") ("A_1" "p3_0") ("A_2" "p3_1") ("A_3" "p3_2") ("A_4" "p3_3") ("A_5" "p3_4") ("A_6" "p3_5") ("A_7" "p3_6") ("B_0" "b4_0") ("B_1" "b4_1") ("B_2" "b4_2") ("B_3" "b4_3") ("B_4" "b4_4") ("B_5" "b4_5") ("B_6" "b4_6") ("B_7" "b4_7") ("CIN" "qu4") ("S_0" "p4_0") ("S_1" "p4_1") ("S_2" "p4_2") ("S_3" "p4_3") ("S_4" "p4_4") ("S_5" "p4_5") ("S_6" "p4_6") ("S_7" "p4_7") ("C7" "c4_7") ("C8" "c4_8") ("VDD" "VDD") ("VSS" "VSS")) ())
  ("I97" "ALU_STUB_B" "XOR2_X1" (("A" "p3_7") ("B" "qu4") ("Y" "h4") ("VDD" "VDD") ("VSS" "VSS")) ())
  ("I98" "ALU_STUB_B" "XOR2_X1" (("A" "h4") ("B" "c4_8") ("Y" "p4_8") ("VDD" "VDD") ("VSS" "VSS")) ())
  ("I99" "ALU_CELLS_C" "INV_X4" (("A" "p4_8") ("Y" "qu3") ("VDD" "VDD") ("VSS" "VSS")) ())
  ("I100" "ALU_STUB_B" "XOR2_X1" (("A" "B_0") ("B" "qu3") ("Y" "b5_0") ("VDD" "VDD") ("VSS" "VSS")) ())
  ("I101" "ALU_STUB_B" "XOR2_X1" (("A" "dd1") ("B" "qu3") ("Y" "b5_1") ("VDD" "VDD") ("VSS" "VSS")) ())
  ("I102" "ALU_STUB_B" "XOR2_X1" (("A" "dd2") ("B" "qu3") ("Y" "b5_2") ("VDD" "VDD") ("VSS" "VSS")) ())
  ("I103" "ALU_STUB_B" "XOR2_X1" (("A" "dd3") ("B" "qu3") ("Y" "b5_3") ("VDD" "VDD") ("VSS" "VSS")) ())
  ("I104" "ALU_STUB_B" "XOR2_X1" (("A" "dd4") ("B" "qu3") ("Y" "b5_4") ("VDD" "VDD") ("VSS" "VSS")) ())
  ("I105" "ALU_STUB_B" "XOR2_X1" (("A" "dd5") ("B" "qu3") ("Y" "b5_5") ("VDD" "VDD") ("VSS" "VSS")) ())
  ("I106" "ALU_STUB_B" "XOR2_X1" (("A" "dd6") ("B" "qu3") ("Y" "b5_6") ("VDD" "VDD") ("VSS" "VSS")) ())
  ("I107" "ALU_STUB_B" "XOR2_X1" (("A" "dd7") ("B" "qu3") ("Y" "b5_7") ("VDD" "VDD") ("VSS" "VSS")) ())
  ("I108" "ALU_ADD" "KSA8" (("A_0" "aa2") ("A_1" "p4_0") ("A_2" "p4_1") ("A_3" "p4_2") ("A_4" "p4_3") ("A_5" "p4_4") ("A_6" "p4_5") ("A_7" "p4_6") ("B_0" "b5_0") ("B_1" "b5_1") ("B_2" "b5_2") ("B_3" "b5_3") ("B_4" "b5_4") ("B_5" "b5_5") ("B_6" "b5_6") ("B_7" "b5_7") ("CIN" "qu3") ("S_0" "p5_0") ("S_1" "p5_1") ("S_2" "p5_2") ("S_3" "p5_3") ("S_4" "p5_4") ("S_5" "p5_5") ("S_6" "p5_6") ("S_7" "p5_7") ("C7" "c5_7") ("C8" "c5_8") ("VDD" "VDD") ("VSS" "VSS")) ())
  ("I109" "ALU_STUB_B" "XOR2_X1" (("A" "p4_7") ("B" "qu3") ("Y" "h5") ("VDD" "VDD") ("VSS" "VSS")) ())
  ("I110" "ALU_STUB_B" "XOR2_X1" (("A" "h5") ("B" "c5_8") ("Y" "p5_8") ("VDD" "VDD") ("VSS" "VSS")) ())
  ("I111" "ALU_CELLS_C" "INV_X4" (("A" "p5_8") ("Y" "qu2") ("VDD" "VDD") ("VSS" "VSS")) ())
  ("I112" "ALU_STUB_B" "XOR2_X1" (("A" "B_0") ("B" "qu2") ("Y" "b6_0") ("VDD" "VDD") ("VSS" "VSS")) ())
  ("I113" "ALU_STUB_B" "XOR2_X1" (("A" "dd1") ("B" "qu2") ("Y" "b6_1") ("VDD" "VDD") ("VSS" "VSS")) ())
  ("I114" "ALU_STUB_B" "XOR2_X1" (("A" "dd2") ("B" "qu2") ("Y" "b6_2") ("VDD" "VDD") ("VSS" "VSS")) ())
  ("I115" "ALU_STUB_B" "XOR2_X1" (("A" "dd3") ("B" "qu2") ("Y" "b6_3") ("VDD" "VDD") ("VSS" "VSS")) ())
  ("I116" "ALU_STUB_B" "XOR2_X1" (("A" "dd4") ("B" "qu2") ("Y" "b6_4") ("VDD" "VDD") ("VSS" "VSS")) ())
  ("I117" "ALU_STUB_B" "XOR2_X1" (("A" "dd5") ("B" "qu2") ("Y" "b6_5") ("VDD" "VDD") ("VSS" "VSS")) ())
  ("I118" "ALU_STUB_B" "XOR2_X1" (("A" "dd6") ("B" "qu2") ("Y" "b6_6") ("VDD" "VDD") ("VSS" "VSS")) ())
  ("I119" "ALU_STUB_B" "XOR2_X1" (("A" "dd7") ("B" "qu2") ("Y" "b6_7") ("VDD" "VDD") ("VSS" "VSS")) ())
  ("I120" "ALU_ADD" "KSA8" (("A_0" "aa1") ("A_1" "p5_0") ("A_2" "p5_1") ("A_3" "p5_2") ("A_4" "p5_3") ("A_5" "p5_4") ("A_6" "p5_5") ("A_7" "p5_6") ("B_0" "b6_0") ("B_1" "b6_1") ("B_2" "b6_2") ("B_3" "b6_3") ("B_4" "b6_4") ("B_5" "b6_5") ("B_6" "b6_6") ("B_7" "b6_7") ("CIN" "qu2") ("S_0" "p6_0") ("S_1" "p6_1") ("S_2" "p6_2") ("S_3" "p6_3") ("S_4" "p6_4") ("S_5" "p6_5") ("S_6" "p6_6") ("S_7" "p6_7") ("C7" "c6_7") ("C8" "c6_8") ("VDD" "VDD") ("VSS" "VSS")) ())
  ("I121" "ALU_STUB_B" "XOR2_X1" (("A" "p5_7") ("B" "qu2") ("Y" "h6") ("VDD" "VDD") ("VSS" "VSS")) ())
  ("I122" "ALU_STUB_B" "XOR2_X1" (("A" "h6") ("B" "c6_8") ("Y" "p6_8") ("VDD" "VDD") ("VSS" "VSS")) ())
  ("I123" "ALU_CELLS_C" "INV_X4" (("A" "p6_8") ("Y" "qu1") ("VDD" "VDD") ("VSS" "VSS")) ())
  ("I124" "ALU_STUB_B" "XOR2_X1" (("A" "B_0") ("B" "qu1") ("Y" "b7_0") ("VDD" "VDD") ("VSS" "VSS")) ())
  ("I125" "ALU_STUB_B" "XOR2_X1" (("A" "dd1") ("B" "qu1") ("Y" "b7_1") ("VDD" "VDD") ("VSS" "VSS")) ())
  ("I126" "ALU_STUB_B" "XOR2_X1" (("A" "dd2") ("B" "qu1") ("Y" "b7_2") ("VDD" "VDD") ("VSS" "VSS")) ())
  ("I127" "ALU_STUB_B" "XOR2_X1" (("A" "dd3") ("B" "qu1") ("Y" "b7_3") ("VDD" "VDD") ("VSS" "VSS")) ())
  ("I128" "ALU_STUB_B" "XOR2_X1" (("A" "dd4") ("B" "qu1") ("Y" "b7_4") ("VDD" "VDD") ("VSS" "VSS")) ())
  ("I129" "ALU_STUB_B" "XOR2_X1" (("A" "dd5") ("B" "qu1") ("Y" "b7_5") ("VDD" "VDD") ("VSS" "VSS")) ())
  ("I130" "ALU_STUB_B" "XOR2_X1" (("A" "dd6") ("B" "qu1") ("Y" "b7_6") ("VDD" "VDD") ("VSS" "VSS")) ())
  ("I131" "ALU_STUB_B" "XOR2_X1" (("A" "dd7") ("B" "qu1") ("Y" "b7_7") ("VDD" "VDD") ("VSS" "VSS")) ())
  ("I132" "ALU_ADD" "KSA8" (("A_0" "A_0") ("A_1" "p6_0") ("A_2" "p6_1") ("A_3" "p6_2") ("A_4" "p6_3") ("A_5" "p6_4") ("A_6" "p6_5") ("A_7" "p6_6") ("B_0" "b7_0") ("B_1" "b7_1") ("B_2" "b7_2") ("B_3" "b7_3") ("B_4" "b7_4") ("B_5" "b7_5") ("B_6" "b7_6") ("B_7" "b7_7") ("CIN" "qu1") ("S_0" "p7_0") ("S_1" "p7_1") ("S_2" "p7_2") ("S_3" "p7_3") ("S_4" "p7_4") ("S_5" "p7_5") ("S_6" "p7_6") ("S_7" "p7_7") ("C7" "c7_7") ("C8" "c7_8") ("VDD" "VDD") ("VSS" "VSS")) ())
  ("I133" "ALU_STUB_B" "XOR2_X1" (("A" "p6_7") ("B" "qu1") ("Y" "h7") ("VDD" "VDD") ("VSS" "VSS")) ())
  ("I134" "ALU_STUB_B" "XOR2_X1" (("A" "h7") ("B" "c7_8") ("Y" "p7_8") ("VDD" "VDD") ("VSS" "VSS")) ())
  ("I135" "ALU_CELLS_A" "INV_X1" (("A" "p7_8") ("Y" "Q_0") ("VDD" "VDD") ("VSS" "VSS")) ())
  ("I136" "ALU_CELLS_A" "NAND2_X1" (("A" "B_0") ("B" "p7_8") ("Y" "dmn0") ("VDD" "VDD") ("VSS" "VSS")) ())
  ("I137" "ALU_CELLS_A" "INV_X1" (("A" "dmn0") ("Y" "dm0") ("VDD" "VDD") ("VSS" "VSS")) ())
  ("I138" "ALU_CELLS_A" "NAND2_X1" (("A" "dd1") ("B" "p7_8") ("Y" "dmn1") ("VDD" "VDD") ("VSS" "VSS")) ())
  ("I139" "ALU_CELLS_A" "INV_X1" (("A" "dmn1") ("Y" "dm1") ("VDD" "VDD") ("VSS" "VSS")) ())
  ("I140" "ALU_CELLS_A" "NAND2_X1" (("A" "dd2") ("B" "p7_8") ("Y" "dmn2") ("VDD" "VDD") ("VSS" "VSS")) ())
  ("I141" "ALU_CELLS_A" "INV_X1" (("A" "dmn2") ("Y" "dm2") ("VDD" "VDD") ("VSS" "VSS")) ())
  ("I142" "ALU_CELLS_A" "NAND2_X1" (("A" "dd3") ("B" "p7_8") ("Y" "dmn3") ("VDD" "VDD") ("VSS" "VSS")) ())
  ("I143" "ALU_CELLS_A" "INV_X1" (("A" "dmn3") ("Y" "dm3") ("VDD" "VDD") ("VSS" "VSS")) ())
  ("I144" "ALU_CELLS_A" "NAND2_X1" (("A" "dd4") ("B" "p7_8") ("Y" "dmn4") ("VDD" "VDD") ("VSS" "VSS")) ())
  ("I145" "ALU_CELLS_A" "INV_X1" (("A" "dmn4") ("Y" "dm4") ("VDD" "VDD") ("VSS" "VSS")) ())
  ("I146" "ALU_CELLS_A" "NAND2_X1" (("A" "dd5") ("B" "p7_8") ("Y" "dmn5") ("VDD" "VDD") ("VSS" "VSS")) ())
  ("I147" "ALU_CELLS_A" "INV_X1" (("A" "dmn5") ("Y" "dm5") ("VDD" "VDD") ("VSS" "VSS")) ())
  ("I148" "ALU_CELLS_A" "NAND2_X1" (("A" "dd6") ("B" "p7_8") ("Y" "dmn6") ("VDD" "VDD") ("VSS" "VSS")) ())
  ("I149" "ALU_CELLS_A" "INV_X1" (("A" "dmn6") ("Y" "dm6") ("VDD" "VDD") ("VSS" "VSS")) ())
  ("I150" "ALU_CELLS_A" "NAND2_X1" (("A" "dd7") ("B" "p7_8") ("Y" "dmn7") ("VDD" "VDD") ("VSS" "VSS")) ())
  ("I151" "ALU_CELLS_A" "INV_X1" (("A" "dmn7") ("Y" "dm7") ("VDD" "VDD") ("VSS" "VSS")) ())
  ("I152" "ALU_ADD" "KSA8" (("A_0" "p7_0") ("A_1" "p7_1") ("A_2" "p7_2") ("A_3" "p7_3") ("A_4" "p7_4") ("A_5" "p7_5") ("A_6" "p7_6") ("A_7" "p7_7") ("B_0" "dm0") ("B_1" "dm1") ("B_2" "dm2") ("B_3" "dm3") ("B_4" "dm4") ("B_5" "dm5") ("B_6" "dm6") ("B_7" "dm7") ("CIN" "VSS") ("S_0" "R_0") ("S_1" "ru1") ("S_2" "ru2") ("S_3" "ru3") ("S_4" "ru4") ("S_5" "ru5") ("S_6" "ru6") ("S_7" "ru7") ("C7" "rc6") ("C8" "rc7") ("VDD" "VDD") ("VSS" "VSS")) ())
  ("I153" "ALU_STUB_B" "XOR2_X1" (("A" "A_7") ("B" "B_7") ("Y" "sq") ("VDD" "VDD") ("VSS" "VSS")) ())
  ("I154" "ALU_CELLS_A" "NAND2_X1" (("A" "sq") ("B" "Q_0") ("Y" "nqkn1") ("VDD" "VDD") ("VSS" "VSS")) ())
  ("I155" "ALU_STUB_B" "XNOR2_X1" (("A" "qu1") ("B" "nqkn1") ("Y" "Q_1") ("VDD" "VDD") ("VSS" "VSS")) ())
  ("I156" "ALU_CELLS_A" "INV_X1" (("A" "nqkn1") ("Y" "nqk1") ("VDD" "VDD") ("VSS" "VSS")) ())
  ("I157" "ALU_CELLS_A" "AOI21_X1" (("A1" "sq") ("A2" "qu1") ("B" "nqk1") ("Y" "nqkn2") ("VDD" "VDD") ("VSS" "VSS")) ())
  ("I158" "ALU_STUB_B" "XNOR2_X1" (("A" "qu2") ("B" "nqkn2") ("Y" "Q_2") ("VDD" "VDD") ("VSS" "VSS")) ())
  ("I159" "ALU_CELLS_A" "INV_X1" (("A" "nqkn2") ("Y" "nqk2") ("VDD" "VDD") ("VSS" "VSS")) ())
  ("I160" "ALU_CELLS_A" "AOI21_X1" (("A1" "sq") ("A2" "qu2") ("B" "nqk2") ("Y" "nqkn3") ("VDD" "VDD") ("VSS" "VSS")) ())
  ("I161" "ALU_STUB_B" "XNOR2_X1" (("A" "qu3") ("B" "nqkn3") ("Y" "Q_3") ("VDD" "VDD") ("VSS" "VSS")) ())
  ("I162" "ALU_CELLS_A" "INV_X1" (("A" "nqkn3") ("Y" "nqk3") ("VDD" "VDD") ("VSS" "VSS")) ())
  ("I163" "ALU_CELLS_A" "AOI21_X1" (("A1" "sq") ("A2" "qu3") ("B" "nqk3") ("Y" "nqkn4") ("VDD" "VDD") ("VSS" "VSS")) ())
  ("I164" "ALU_STUB_B" "XNOR2_X1" (("A" "qu4") ("B" "nqkn4") ("Y" "Q_4") ("VDD" "VDD") ("VSS" "VSS")) ())
  ("I165" "ALU_CELLS_A" "INV_X1" (("A" "nqkn4") ("Y" "nqk4") ("VDD" "VDD") ("VSS" "VSS")) ())
  ("I166" "ALU_CELLS_A" "AOI21_X1" (("A1" "sq") ("A2" "qu4") ("B" "nqk4") ("Y" "nqkn5") ("VDD" "VDD") ("VSS" "VSS")) ())
  ("I167" "ALU_STUB_B" "XNOR2_X1" (("A" "qu5") ("B" "nqkn5") ("Y" "Q_5") ("VDD" "VDD") ("VSS" "VSS")) ())
  ("I168" "ALU_CELLS_A" "INV_X1" (("A" "nqkn5") ("Y" "nqk5") ("VDD" "VDD") ("VSS" "VSS")) ())
  ("I169" "ALU_CELLS_A" "AOI21_X1" (("A1" "sq") ("A2" "qu5") ("B" "nqk5") ("Y" "nqkn6") ("VDD" "VDD") ("VSS" "VSS")) ())
  ("I170" "ALU_STUB_B" "XNOR2_X1" (("A" "qu6") ("B" "nqkn6") ("Y" "Q_6") ("VDD" "VDD") ("VSS" "VSS")) ())
  ("I171" "ALU_CELLS_A" "INV_X1" (("A" "nqkn6") ("Y" "nqk6") ("VDD" "VDD") ("VSS" "VSS")) ())
  ("I172" "ALU_CELLS_A" "AOI21_X1" (("A1" "sq") ("A2" "qu6") ("B" "nqk6") ("Y" "nqkn7") ("VDD" "VDD") ("VSS" "VSS")) ())
  ("I173" "ALU_STUB_B" "XNOR2_X1" (("A" "qu7") ("B" "nqkn7") ("Y" "Q_7") ("VDD" "VDD") ("VSS" "VSS")) ())
  ("I174" "ALU_CELLS_A" "NAND2_X1" (("A" "A_7") ("B" "R_0") ("Y" "nrkn1") ("VDD" "VDD") ("VSS" "VSS")) ())
  ("I175" "ALU_STUB_B" "XNOR2_X1" (("A" "ru1") ("B" "nrkn1") ("Y" "R_1") ("VDD" "VDD") ("VSS" "VSS")) ())
  ("I176" "ALU_CELLS_A" "INV_X1" (("A" "nrkn1") ("Y" "nrk1") ("VDD" "VDD") ("VSS" "VSS")) ())
  ("I177" "ALU_CELLS_A" "AOI21_X1" (("A1" "A_7") ("A2" "ru1") ("B" "nrk1") ("Y" "nrkn2") ("VDD" "VDD") ("VSS" "VSS")) ())
  ("I178" "ALU_STUB_B" "XNOR2_X1" (("A" "ru2") ("B" "nrkn2") ("Y" "R_2") ("VDD" "VDD") ("VSS" "VSS")) ())
  ("I179" "ALU_CELLS_A" "INV_X1" (("A" "nrkn2") ("Y" "nrk2") ("VDD" "VDD") ("VSS" "VSS")) ())
  ("I180" "ALU_CELLS_A" "AOI21_X1" (("A1" "A_7") ("A2" "ru2") ("B" "nrk2") ("Y" "nrkn3") ("VDD" "VDD") ("VSS" "VSS")) ())
  ("I181" "ALU_STUB_B" "XNOR2_X1" (("A" "ru3") ("B" "nrkn3") ("Y" "R_3") ("VDD" "VDD") ("VSS" "VSS")) ())
  ("I182" "ALU_CELLS_A" "INV_X1" (("A" "nrkn3") ("Y" "nrk3") ("VDD" "VDD") ("VSS" "VSS")) ())
  ("I183" "ALU_CELLS_A" "AOI21_X1" (("A1" "A_7") ("A2" "ru3") ("B" "nrk3") ("Y" "nrkn4") ("VDD" "VDD") ("VSS" "VSS")) ())
  ("I184" "ALU_STUB_B" "XNOR2_X1" (("A" "ru4") ("B" "nrkn4") ("Y" "R_4") ("VDD" "VDD") ("VSS" "VSS")) ())
  ("I185" "ALU_CELLS_A" "INV_X1" (("A" "nrkn4") ("Y" "nrk4") ("VDD" "VDD") ("VSS" "VSS")) ())
  ("I186" "ALU_CELLS_A" "AOI21_X1" (("A1" "A_7") ("A2" "ru4") ("B" "nrk4") ("Y" "nrkn5") ("VDD" "VDD") ("VSS" "VSS")) ())
  ("I187" "ALU_STUB_B" "XNOR2_X1" (("A" "ru5") ("B" "nrkn5") ("Y" "R_5") ("VDD" "VDD") ("VSS" "VSS")) ())
  ("I188" "ALU_CELLS_A" "INV_X1" (("A" "nrkn5") ("Y" "nrk5") ("VDD" "VDD") ("VSS" "VSS")) ())
  ("I189" "ALU_CELLS_A" "AOI21_X1" (("A1" "A_7") ("A2" "ru5") ("B" "nrk5") ("Y" "nrkn6") ("VDD" "VDD") ("VSS" "VSS")) ())
  ("I190" "ALU_STUB_B" "XNOR2_X1" (("A" "ru6") ("B" "nrkn6") ("Y" "R_6") ("VDD" "VDD") ("VSS" "VSS")) ())
  ("I191" "ALU_CELLS_A" "INV_X1" (("A" "nrkn6") ("Y" "nrk6") ("VDD" "VDD") ("VSS" "VSS")) ())
  ("I192" "ALU_CELLS_A" "AOI21_X1" (("A1" "A_7") ("A2" "ru6") ("B" "nrk6") ("Y" "nrkn7") ("VDD" "VDD") ("VSS" "VSS")) ())
  ("I193" "ALU_STUB_B" "XNOR2_X1" (("A" "ru7") ("B" "nrkn7") ("Y" "R_7") ("VDD" "VDD") ("VSS" "VSS")) ())
  ("I194" "ALU_CELLS_A" "NOR2_X1" (("A" "B_0") ("B" "B_1") ("Y" "z1_0") ("VDD" "VDD") ("VSS" "VSS")) ())
  ("I195" "ALU_CELLS_A" "NOR2_X1" (("A" "B_2") ("B" "B_3") ("Y" "z1_1") ("VDD" "VDD") ("VSS" "VSS")) ())
  ("I196" "ALU_CELLS_A" "NOR2_X1" (("A" "B_4") ("B" "B_5") ("Y" "z1_2") ("VDD" "VDD") ("VSS" "VSS")) ())
  ("I197" "ALU_CELLS_A" "NOR2_X1" (("A" "B_6") ("B" "B_7") ("Y" "z1_3") ("VDD" "VDD") ("VSS" "VSS")) ())
  ("I198" "ALU_CELLS_A" "NAND2_X1" (("A" "z1_0") ("B" "z1_1") ("Y" "z2_0") ("VDD" "VDD") ("VSS" "VSS")) ())
  ("I199" "ALU_CELLS_A" "NAND2_X1" (("A" "z1_2") ("B" "z1_3") ("Y" "z2_1") ("VDD" "VDD") ("VSS" "VSS")) ())
  ("I200" "ALU_CELLS_A" "NOR2_X1" (("A" "z2_0") ("B" "z2_1") ("Y" "DZ") ("VDD" "VDD") ("VSS" "VSS")) ())
  ("I201" "ALU_CELLS_A" "INV_X1" (("A" "sq") ("Y" "sqn") ("VDD" "VDD") ("VSS" "VSS")) ())
  ("I202" "ALU_CELLS_A" "NAND2_X1" (("A" "Q_7") ("B" "sqn") ("Y" "vn") ("VDD" "VDD") ("VSS" "VSS")) ())
  ("I203" "ALU_CELLS_A" "NOR2_X1" (("A" "vn") ("B" "DZ") ("Y" "V") ("VDD" "VDD") ("VSS" "VSS")) ()))) t)
  sbErrors++ printf("SB_ERROR DIV8K: %L\n" errset.errset))
unless(errset(sbCell("ALU_TOP" "ALU_TOPK" '(("A_0" "input") ("A_1" "input") ("A_2" "input") ("A_3" "input") ("A_4" "input") ("A_5" "input") ("A_6" "input") ("A_7" "input") ("B_0" "input") ("B_1" "input") ("B_2" "input") ("B_3" "input") ("B_4" "input") ("B_5" "input") ("B_6" "input") ("B_7" "input") ("OP_0" "input") ("OP_1" "input") ("OP_2" "input") ("OP_3" "input") ("Y_0" "output") ("Y_1" "output") ("Y_2" "output") ("Y_3" "output") ("Y_4" "output") ("Y_5" "output") ("Y_6" "output") ("Y_7" "output") ("Y_8" "output") ("Y_9" "output") ("Y_10" "output") ("Y_11" "output") ("Y_12" "output") ("Y_13" "output") ("Y_14" "output") ("Y_15" "output") ("Z" "output") ("C" "output") ("V" "output") ("DZ" "output") ("VDD" "inputOutput") ("VSS" "inputOutput"))
 '(
  ("I0" "ALU_MUL" "MUL8" (("A_0" "A_0") ("A_1" "A_1") ("A_2" "A_2") ("A_3" "A_3") ("A_4" "A_4") ("A_5" "A_5") ("A_6" "A_6") ("A_7" "A_7") ("B_0" "B_0") ("B_1" "B_1") ("B_2" "B_2") ("B_3" "B_3") ("B_4" "B_4") ("B_5" "B_5") ("B_6" "B_6") ("B_7" "B_7") ("P_0" "MULP_0") ("P_1" "MULP_1") ("P_2" "MULP_2") ("P_3" "MULP_3") ("P_4" "MULP_4") ("P_5" "MULP_5") ("P_6" "MULP_6") ("P_7" "MULP_7") ("P_8" "MULP_8") ("P_9" "MULP_9") ("P_10" "MULP_10") ("P_11" "MULP_11") ("P_12" "MULP_12") ("P_13" "MULP_13") ("P_14" "MULP_14") ("P_15" "MULP_15") ("VDD" "VDD") ("VSS" "VSS")) ())
  ("I1" "ALU_DIV" "DIV8K" (("A_0" "A_0") ("A_1" "A_1") ("A_2" "A_2") ("A_3" "A_3") ("A_4" "A_4") ("A_5" "A_5") ("A_6" "A_6") ("A_7" "A_7") ("B_0" "B_0") ("B_1" "B_1") ("B_2" "B_2") ("B_3" "B_3") ("B_4" "B_4") ("B_5" "B_5") ("B_6" "B_6") ("B_7" "B_7") ("Q_0" "DIVQ_0") ("Q_1" "DIVQ_1") ("Q_2" "DIVQ_2") ("Q_3" "DIVQ_3") ("Q_4" "DIVQ_4") ("Q_5" "DIVQ_5") ("Q_6" "DIVQ_6") ("Q_7" "DIVQ_7") ("R_0" "DIVR_0") ("R_1" "DIVR_1") ("R_2" "DIVR_2") ("R_3" "DIVR_3") ("R_4" "DIVR_4") ("R_5" "DIVR_5") ("R_6" "DIVR_6") ("R_7" "DIVR_7") ("V" "DIVV") ("DZ" "DIVDZ") ("VDD" "VDD") ("VSS" "VSS")) ())
  ("I2" "ALU_CORE" "ALU_CORE" (("A_0" "A_0") ("A_1" "A_1") ("A_2" "A_2") ("A_3" "A_3") ("A_4" "A_4") ("A_5" "A_5") ("A_6" "A_6") ("A_7" "A_7") ("B_0" "B_0") ("B_1" "B_1") ("B_2" "B_2") ("B_3" "B_3") ("B_4" "B_4") ("B_5" "B_5") ("B_6" "B_6") ("B_7" "B_7") ("OP_0" "OP_0") ("OP_1" "OP_1") ("OP_2" "OP_2") ("OP_3" "OP_3") ("MULP_0" "MULP_0") ("MULP_1" "MULP_1") ("MULP_2" "MULP_2") ("MULP_3" "MULP_3") ("MULP_4" "MULP_4") ("MULP_5" "MULP_5") ("MULP_6" "MULP_6") ("MULP_7" "MULP_7") ("MULP_8" "MULP_8") ("MULP_9" "MULP_9") ("MULP_10" "MULP_10") ("MULP_11" "MULP_11") ("MULP_12" "MULP_12") ("MULP_13" "MULP_13") ("MULP_14" "MULP_14") ("MULP_15" "MULP_15") ("DIVQ_0" "DIVQ_0") ("DIVQ_1" "DIVQ_1") ("DIVQ_2" "DIVQ_2") ("DIVQ_3" "DIVQ_3") ("DIVQ_4" "DIVQ_4") ("DIVQ_5" "DIVQ_5") ("DIVQ_6" "DIVQ_6") ("DIVQ_7" "DIVQ_7") ("DIVR_0" "DIVR_0") ("DIVR_1" "DIVR_1") ("DIVR_2" "DIVR_2") ("DIVR_3" "DIVR_3") ("DIVR_4" "DIVR_4") ("DIVR_5" "DIVR_5") ("DIVR_6" "DIVR_6") ("DIVR_7" "DIVR_7") ("DIVV" "DIVV") ("DIVDZ" "DIVDZ") ("Y_0" "Y_0") ("Y_1" "Y_1") ("Y_2" "Y_2") ("Y_3" "Y_3") ("Y_4" "Y_4") ("Y_5" "Y_5") ("Y_6" "Y_6") ("Y_7" "Y_7") ("Y_8" "Y_8") ("Y_9" "Y_9") ("Y_10" "Y_10") ("Y_11" "Y_11") ("Y_12" "Y_12") ("Y_13" "Y_13") ("Y_14" "Y_14") ("Y_15" "Y_15") ("Z" "Z") ("C" "C") ("V" "V") ("DZ" "DZ") ("VDD" "VDD") ("VSS" "VSS")) ()))) t)
  sbErrors++ printf("SB_ERROR ALU_TOPK: %L\n" errset.errset))
sbEnd()) t)
  printf("SB_ERROR uncaught: %L\n" errset.errset)
  exit(2))
exit(3)   ; unconditional: -nograph never exits on stdin EOF
