;; generated by tools/scs2skill.py from ALU_CELLS_A=cells/A ALU_STUB_B=cells/_stub_B -- do not edit
;; run in the VM:  cd ~/ALU_PROJ && virtuoso -nograph -restore <this file> < /dev/null
;; run with < /dev/null; any SKILL error -> message + exit, never a hanging CIW prompt
unless(errset(progn(
sbDir = or(getShellEnvVar("SB_DIR") "/mnt/hgfs/Share/VLSI_work/skill")
load(strcat(sbDir "/sch_build.il"))
sbBegin()
sbLib("ALU_CELLS_A" "gpdk090")
sbLib("ALU_STUB_B" "gpdk090")
unless(errset(sbCell("ALU_CELLS_A" "AOI21_X1" '(("A1" "input") ("A2" "input") ("B" "input") ("Y" "output") ("VDD" "inputOutput") ("VSS" "inputOutput"))
 '(
  ("MN0" "gpdk090" "nmos1v" (("D" "Y") ("G" "A1") ("S" "n1") ("B" "VSS")) (("fingers" "1") ("w" "240n") ("fw" "240n") ("l" "100n")))
  ("MN1" "gpdk090" "nmos1v" (("D" "n1") ("G" "A2") ("S" "VSS") ("B" "VSS")) (("fingers" "1") ("w" "240n") ("fw" "240n") ("l" "100n")))
  ("MN2" "gpdk090" "nmos1v" (("D" "Y") ("G" "B") ("S" "VSS") ("B" "VSS")) (("fingers" "1") ("w" "120n") ("fw" "120n") ("l" "100n")))
  ("MP0" "gpdk090" "pmos1v" (("D" "p1") ("G" "A1") ("S" "VDD") ("B" "VDD")) (("fingers" "1") ("w" "480n") ("fw" "480n") ("l" "100n")))
  ("MP1" "gpdk090" "pmos1v" (("D" "p1") ("G" "A2") ("S" "VDD") ("B" "VDD")) (("fingers" "1") ("w" "480n") ("fw" "480n") ("l" "100n")))
  ("MP2" "gpdk090" "pmos1v" (("D" "Y") ("G" "B") ("S" "p1") ("B" "VDD")) (("fingers" "1") ("w" "480n") ("fw" "480n") ("l" "100n"))))) t)
  sbErrors++ printf("SB_ERROR AOI21_X1: %L\n" errset.errset))
unless(errset(sbCell("ALU_CELLS_A" "OAI21_X1" '(("A1" "input") ("A2" "input") ("B" "input") ("Y" "output") ("VDD" "inputOutput") ("VSS" "inputOutput"))
 '(
  ("MN0" "gpdk090" "nmos1v" (("D" "Y") ("G" "A1") ("S" "n1") ("B" "VSS")) (("fingers" "1") ("w" "240n") ("fw" "240n") ("l" "100n")))
  ("MN1" "gpdk090" "nmos1v" (("D" "Y") ("G" "A2") ("S" "n1") ("B" "VSS")) (("fingers" "1") ("w" "240n") ("fw" "240n") ("l" "100n")))
  ("MN2" "gpdk090" "nmos1v" (("D" "n1") ("G" "B") ("S" "VSS") ("B" "VSS")) (("fingers" "1") ("w" "240n") ("fw" "240n") ("l" "100n")))
  ("MP0" "gpdk090" "pmos1v" (("D" "p1") ("G" "A1") ("S" "VDD") ("B" "VDD")) (("fingers" "1") ("w" "480n") ("fw" "480n") ("l" "100n")))
  ("MP1" "gpdk090" "pmos1v" (("D" "Y") ("G" "A2") ("S" "p1") ("B" "VDD")) (("fingers" "1") ("w" "480n") ("fw" "480n") ("l" "100n")))
  ("MP2" "gpdk090" "pmos1v" (("D" "Y") ("G" "B") ("S" "VDD") ("B" "VDD")) (("fingers" "1") ("w" "240n") ("fw" "240n") ("l" "100n"))))) t)
  sbErrors++ printf("SB_ERROR OAI21_X1: %L\n" errset.errset))
unless(errset(sbCell("ALU_CELLS_A" "NOR2_X1" '(("A" "input") ("B" "input") ("Y" "output") ("VDD" "inputOutput") ("VSS" "inputOutput"))
 '(
  ("MN0" "gpdk090" "nmos1v" (("D" "Y") ("G" "A") ("S" "VSS") ("B" "VSS")) (("fingers" "1") ("w" "120n") ("fw" "120n") ("l" "100n")))
  ("MN1" "gpdk090" "nmos1v" (("D" "Y") ("G" "B") ("S" "VSS") ("B" "VSS")) (("fingers" "1") ("w" "120n") ("fw" "120n") ("l" "100n")))
  ("MP0" "gpdk090" "pmos1v" (("D" "p1") ("G" "A") ("S" "VDD") ("B" "VDD")) (("fingers" "1") ("w" "480n") ("fw" "480n") ("l" "100n")))
  ("MP1" "gpdk090" "pmos1v" (("D" "Y") ("G" "B") ("S" "p1") ("B" "VDD")) (("fingers" "1") ("w" "480n") ("fw" "480n") ("l" "100n"))))) t)
  sbErrors++ printf("SB_ERROR NOR2_X1: %L\n" errset.errset))
unless(errset(sbCell("ALU_CELLS_A" "BLK_N" '(("GIN" "input") ("PIN" "input") ("GKN" "input") ("PKN" "input") ("GO" "output") ("PO" "output") ("VDD" "inputOutput") ("VSS" "inputOutput"))
 '(
  ("XG" "ALU_CELLS_A" "OAI21_X1" (("A1" "PIN") ("A2" "GKN") ("B" "GIN") ("Y" "GO") ("VDD" "VDD") ("VSS" "VSS")) ())
  ("XP" "ALU_CELLS_A" "NOR2_X1" (("A" "PIN") ("B" "PKN") ("Y" "PO") ("VDD" "VDD") ("VSS" "VSS")) ()))) t)
  sbErrors++ printf("SB_ERROR BLK_N: %L\n" errset.errset))
unless(errset(sbCell("ALU_CELLS_A" "NAND2_X1" '(("A" "input") ("B" "input") ("Y" "output") ("VDD" "inputOutput") ("VSS" "inputOutput"))
 '(
  ("MN0" "gpdk090" "nmos1v" (("D" "Y") ("G" "A") ("S" "n1") ("B" "VSS")) (("fingers" "1") ("w" "240n") ("fw" "240n") ("l" "100n")))
  ("MN1" "gpdk090" "nmos1v" (("D" "n1") ("G" "B") ("S" "VSS") ("B" "VSS")) (("fingers" "1") ("w" "240n") ("fw" "240n") ("l" "100n")))
  ("MP0" "gpdk090" "pmos1v" (("D" "Y") ("G" "A") ("S" "VDD") ("B" "VDD")) (("fingers" "1") ("w" "240n") ("fw" "240n") ("l" "100n")))
  ("MP1" "gpdk090" "pmos1v" (("D" "Y") ("G" "B") ("S" "VDD") ("B" "VDD")) (("fingers" "1") ("w" "240n") ("fw" "240n") ("l" "100n"))))) t)
  sbErrors++ printf("SB_ERROR NAND2_X1: %L\n" errset.errset))
unless(errset(sbCell("ALU_CELLS_A" "BLK_P" '(("GI" "input") ("PI" "input") ("GK" "input") ("PK" "input") ("GON" "output") ("PON" "output") ("VDD" "inputOutput") ("VSS" "inputOutput"))
 '(
  ("XG" "ALU_CELLS_A" "AOI21_X1" (("A1" "PI") ("A2" "GK") ("B" "GI") ("Y" "GON") ("VDD" "VDD") ("VSS" "VSS")) ())
  ("XP" "ALU_CELLS_A" "NAND2_X1" (("A" "PI") ("B" "PK") ("Y" "PON") ("VDD" "VDD") ("VSS" "VSS")) ()))) t)
  sbErrors++ printf("SB_ERROR BLK_P: %L\n" errset.errset))
unless(errset(sbCell("ALU_CELLS_A" "GRY_N" '(("GIN" "input") ("PIN" "input") ("GKN" "input") ("GO" "output") ("VDD" "inputOutput") ("VSS" "inputOutput"))
 '(
  ("XG" "ALU_CELLS_A" "OAI21_X1" (("A1" "PIN") ("A2" "GKN") ("B" "GIN") ("Y" "GO") ("VDD" "VDD") ("VSS" "VSS")) ()))) t)
  sbErrors++ printf("SB_ERROR GRY_N: %L\n" errset.errset))
unless(errset(sbCell("ALU_CELLS_A" "GRY_P" '(("GI" "input") ("PI" "input") ("GK" "input") ("GON" "output") ("VDD" "inputOutput") ("VSS" "inputOutput"))
 '(
  ("XG" "ALU_CELLS_A" "AOI21_X1" (("A1" "PI") ("A2" "GK") ("B" "GI") ("Y" "GON") ("VDD" "VDD") ("VSS" "VSS")) ()))) t)
  sbErrors++ printf("SB_ERROR GRY_P: %L\n" errset.errset))
unless(errset(sbCell("ALU_CELLS_A" "INV_X1" '(("A" "input") ("Y" "output") ("VDD" "inputOutput") ("VSS" "inputOutput"))
 '(
  ("MN0" "gpdk090" "nmos1v" (("D" "Y") ("G" "A") ("S" "VSS") ("B" "VSS")) (("fingers" "1") ("w" "120n") ("fw" "120n") ("l" "100n")))
  ("MP0" "gpdk090" "pmos1v" (("D" "Y") ("G" "A") ("S" "VDD") ("B" "VDD")) (("fingers" "1") ("w" "240n") ("fw" "240n") ("l" "100n"))))) t)
  sbErrors++ printf("SB_ERROR INV_X1: %L\n" errset.errset))
unless(errset(sbCell("ALU_STUB_B" "XNOR2_X1" '(("A" "input") ("B" "input") ("Y" "output") ("VDD" "inputOutput") ("VSS" "inputOutput"))
 '(
  ("MN0" "gpdk090" "nmos1v" (("D" "An") ("G" "A") ("S" "VSS") ("B" "VSS")) (("fingers" "1") ("w" "120n") ("fw" "120n") ("l" "100n")))
  ("MP0" "gpdk090" "pmos1v" (("D" "An") ("G" "A") ("S" "VDD") ("B" "VDD")) (("fingers" "1") ("w" "240n") ("fw" "240n") ("l" "100n")))
  ("MN1" "gpdk090" "nmos1v" (("D" "Bn") ("G" "B") ("S" "VSS") ("B" "VSS")) (("fingers" "1") ("w" "120n") ("fw" "120n") ("l" "100n")))
  ("MP1" "gpdk090" "pmos1v" (("D" "Bn") ("G" "B") ("S" "VDD") ("B" "VDD")) (("fingers" "1") ("w" "240n") ("fw" "240n") ("l" "100n")))
  ("MN2" "gpdk090" "nmos1v" (("D" "Y") ("G" "A") ("S" "n1") ("B" "VSS")) (("fingers" "1") ("w" "240n") ("fw" "240n") ("l" "100n")))
  ("MN3" "gpdk090" "nmos1v" (("D" "n1") ("G" "Bn") ("S" "VSS") ("B" "VSS")) (("fingers" "1") ("w" "240n") ("fw" "240n") ("l" "100n")))
  ("MN4" "gpdk090" "nmos1v" (("D" "Y") ("G" "An") ("S" "n2") ("B" "VSS")) (("fingers" "1") ("w" "240n") ("fw" "240n") ("l" "100n")))
  ("MN5" "gpdk090" "nmos1v" (("D" "n2") ("G" "B") ("S" "VSS") ("B" "VSS")) (("fingers" "1") ("w" "240n") ("fw" "240n") ("l" "100n")))
  ("MP2" "gpdk090" "pmos1v" (("D" "p1") ("G" "A") ("S" "VDD") ("B" "VDD")) (("fingers" "1") ("w" "480n") ("fw" "480n") ("l" "100n")))
  ("MP3" "gpdk090" "pmos1v" (("D" "p1") ("G" "Bn") ("S" "VDD") ("B" "VDD")) (("fingers" "1") ("w" "480n") ("fw" "480n") ("l" "100n")))
  ("MP4" "gpdk090" "pmos1v" (("D" "Y") ("G" "An") ("S" "p1") ("B" "VDD")) (("fingers" "1") ("w" "480n") ("fw" "480n") ("l" "100n")))
  ("MP5" "gpdk090" "pmos1v" (("D" "Y") ("G" "B") ("S" "p1") ("B" "VDD")) (("fingers" "1") ("w" "480n") ("fw" "480n") ("l" "100n"))))) t)
  sbErrors++ printf("SB_ERROR XNOR2_X1: %L\n" errset.errset))
unless(errset(sbCell("ALU_STUB_B" "XOR2_X1" '(("A" "input") ("B" "input") ("Y" "output") ("VDD" "inputOutput") ("VSS" "inputOutput"))
 '(
  ("MN0" "gpdk090" "nmos1v" (("D" "An") ("G" "A") ("S" "VSS") ("B" "VSS")) (("fingers" "1") ("w" "120n") ("fw" "120n") ("l" "100n")))
  ("MP0" "gpdk090" "pmos1v" (("D" "An") ("G" "A") ("S" "VDD") ("B" "VDD")) (("fingers" "1") ("w" "240n") ("fw" "240n") ("l" "100n")))
  ("MN1" "gpdk090" "nmos1v" (("D" "Bn") ("G" "B") ("S" "VSS") ("B" "VSS")) (("fingers" "1") ("w" "120n") ("fw" "120n") ("l" "100n")))
  ("MP1" "gpdk090" "pmos1v" (("D" "Bn") ("G" "B") ("S" "VDD") ("B" "VDD")) (("fingers" "1") ("w" "240n") ("fw" "240n") ("l" "100n")))
  ("MN2" "gpdk090" "nmos1v" (("D" "Y") ("G" "A") ("S" "n1") ("B" "VSS")) (("fingers" "1") ("w" "240n") ("fw" "240n") ("l" "100n")))
  ("MN3" "gpdk090" "nmos1v" (("D" "n1") ("G" "B") ("S" "VSS") ("B" "VSS")) (("fingers" "1") ("w" "240n") ("fw" "240n") ("l" "100n")))
  ("MN4" "gpdk090" "nmos1v" (("D" "Y") ("G" "An") ("S" "n2") ("B" "VSS")) (("fingers" "1") ("w" "240n") ("fw" "240n") ("l" "100n")))
  ("MN5" "gpdk090" "nmos1v" (("D" "n2") ("G" "Bn") ("S" "VSS") ("B" "VSS")) (("fingers" "1") ("w" "240n") ("fw" "240n") ("l" "100n")))
  ("MP2" "gpdk090" "pmos1v" (("D" "p1") ("G" "A") ("S" "VDD") ("B" "VDD")) (("fingers" "1") ("w" "480n") ("fw" "480n") ("l" "100n")))
  ("MP3" "gpdk090" "pmos1v" (("D" "p1") ("G" "B") ("S" "VDD") ("B" "VDD")) (("fingers" "1") ("w" "480n") ("fw" "480n") ("l" "100n")))
  ("MP4" "gpdk090" "pmos1v" (("D" "Y") ("G" "An") ("S" "p1") ("B" "VDD")) (("fingers" "1") ("w" "480n") ("fw" "480n") ("l" "100n")))
  ("MP5" "gpdk090" "pmos1v" (("D" "Y") ("G" "Bn") ("S" "p1") ("B" "VDD")) (("fingers" "1") ("w" "480n") ("fw" "480n") ("l" "100n"))))) t)
  sbErrors++ printf("SB_ERROR XOR2_X1: %L\n" errset.errset))
sbEnd()) t)
  printf("SB_ERROR uncaught: %L\n" errset.errset)
  exit(2))
exit(3)   ; unconditional: -nograph never exits on stdin EOF
