;; generated by tools/scs2skill.py from ALU_CELLS_A=cells/A ALU_STUB_B=cells/_stub_B ALU_ADD=blocks/ALU_ADD/KSA8.scs ALU_ADD=blocks/ALU_ADD/ADDSUB8.scs ALU_CORE=blocks/ALU_CORE/LOGIC8.scs ALU_CORE=blocks/ALU_CORE/DEC_OP.scs ALU_CORE=blocks/ALU_CORE/OUTMUX.scs ALU_CORE=blocks/ALU_CORE/FLAGS.scs ALU_CORE=blocks/ALU_CORE/ALU_CORE.scs -- do not edit
;; run in the VM:  cd ~/ALU_PROJ && virtuoso -nograph -restore <this file> < /dev/null
;; run with < /dev/null; any SKILL error -> message + exit, never a hanging CIW prompt
unless(errset(progn(
sbDir = or(getShellEnvVar("SB_DIR") "/mnt/hgfs/Share/VLSI_work/skill")
load(strcat(sbDir "/sch_build.il"))
sbBegin()
sbLib("ALU_ADD" "gpdk090")
sbLib("ALU_CORE" "gpdk090")
unless(errset(sbCell("ALU_ADD" "KSA8" '(("A_0" "input") ("A_1" "input") ("A_2" "input") ("A_3" "input") ("A_4" "input") ("A_5" "input") ("A_6" "input") ("A_7" "input") ("B_0" "input") ("B_1" "input") ("B_2" "input") ("B_3" "input") ("B_4" "input") ("B_5" "input") ("B_6" "input") ("B_7" "input") ("CIN" "input") ("S_0" "output") ("S_1" "output") ("S_2" "output") ("S_3" "output") ("S_4" "output") ("S_5" "output") ("S_6" "output") ("S_7" "output") ("C7" "output") ("C8" "output") ("VDD" "inputOutput") ("VSS" "inputOutput"))
 '(
  ("I0" "ALU_CELLS_A" "NAND2_X1" (("A" "A_0") ("B" "B_0") ("Y" "gn0") ("VDD" "VDD") ("VSS" "VSS")) ())
  ("I1" "ALU_CELLS_A" "NAND2_X1" (("A" "A_1") ("B" "B_1") ("Y" "gn1") ("VDD" "VDD") ("VSS" "VSS")) ())
  ("I2" "ALU_CELLS_A" "NAND2_X1" (("A" "A_2") ("B" "B_2") ("Y" "gn2") ("VDD" "VDD") ("VSS" "VSS")) ())
  ("I3" "ALU_CELLS_A" "NAND2_X1" (("A" "A_3") ("B" "B_3") ("Y" "gn3") ("VDD" "VDD") ("VSS" "VSS")) ())
  ("I4" "ALU_CELLS_A" "NAND2_X1" (("A" "A_4") ("B" "B_4") ("Y" "gn4") ("VDD" "VDD") ("VSS" "VSS")) ())
  ("I5" "ALU_CELLS_A" "NAND2_X1" (("A" "A_5") ("B" "B_5") ("Y" "gn5") ("VDD" "VDD") ("VSS" "VSS")) ())
  ("I6" "ALU_CELLS_A" "NAND2_X1" (("A" "A_6") ("B" "B_6") ("Y" "gn6") ("VDD" "VDD") ("VSS" "VSS")) ())
  ("I7" "ALU_CELLS_A" "NAND2_X1" (("A" "A_7") ("B" "B_7") ("Y" "gn7") ("VDD" "VDD") ("VSS" "VSS")) ())
  ("I8" "ALU_STUB_B" "XNOR2_X1" (("A" "A_0") ("B" "B_0") ("Y" "pn0") ("VDD" "VDD") ("VSS" "VSS")) ())
  ("I9" "ALU_STUB_B" "XNOR2_X1" (("A" "A_1") ("B" "B_1") ("Y" "pn1") ("VDD" "VDD") ("VSS" "VSS")) ())
  ("I10" "ALU_STUB_B" "XNOR2_X1" (("A" "A_2") ("B" "B_2") ("Y" "pn2") ("VDD" "VDD") ("VSS" "VSS")) ())
  ("I11" "ALU_STUB_B" "XNOR2_X1" (("A" "A_3") ("B" "B_3") ("Y" "pn3") ("VDD" "VDD") ("VSS" "VSS")) ())
  ("I12" "ALU_STUB_B" "XNOR2_X1" (("A" "A_4") ("B" "B_4") ("Y" "pn4") ("VDD" "VDD") ("VSS" "VSS")) ())
  ("I13" "ALU_STUB_B" "XNOR2_X1" (("A" "A_5") ("B" "B_5") ("Y" "pn5") ("VDD" "VDD") ("VSS" "VSS")) ())
  ("I14" "ALU_STUB_B" "XNOR2_X1" (("A" "A_6") ("B" "B_6") ("Y" "pn6") ("VDD" "VDD") ("VSS" "VSS")) ())
  ("I15" "ALU_STUB_B" "XNOR2_X1" (("A" "A_7") ("B" "B_7") ("Y" "pn7") ("VDD" "VDD") ("VSS" "VSS")) ())
  ("I16" "ALU_CELLS_A" "INV_X1" (("A" "CIN") ("Y" "cinn") ("VDD" "VDD") ("VSS" "VSS")) ())
  ("I17" "ALU_CELLS_A" "GRY_N" (("GIN" "gn0") ("PIN" "pn0") ("GKN" "cinn") ("GO" "G0_0") ("VDD" "VDD") ("VSS" "VSS")) ())
  ("I18" "ALU_CELLS_A" "INV_X1" (("A" "G0_0") ("Y" "G0_0n") ("VDD" "VDD") ("VSS" "VSS")) ())
  ("I19" "ALU_CELLS_A" "GRY_N" (("GIN" "gn1") ("PIN" "pn1") ("GKN" "G0_0n") ("GO" "G1_0") ("VDD" "VDD") ("VSS" "VSS")) ())
  ("I20" "ALU_CELLS_A" "BLK_N" (("GIN" "gn2") ("PIN" "pn2") ("GKN" "gn1") ("PKN" "pn1") ("GO" "G2_1") ("PO" "P2_1") ("VDD" "VDD") ("VSS" "VSS")) ())
  ("I21" "ALU_CELLS_A" "BLK_N" (("GIN" "gn3") ("PIN" "pn3") ("GKN" "gn2") ("PKN" "pn2") ("GO" "G3_2") ("PO" "P3_2") ("VDD" "VDD") ("VSS" "VSS")) ())
  ("I22" "ALU_CELLS_A" "BLK_N" (("GIN" "gn4") ("PIN" "pn4") ("GKN" "gn3") ("PKN" "pn3") ("GO" "G4_3") ("PO" "P4_3") ("VDD" "VDD") ("VSS" "VSS")) ())
  ("I23" "ALU_CELLS_A" "BLK_N" (("GIN" "gn5") ("PIN" "pn5") ("GKN" "gn4") ("PKN" "pn4") ("GO" "G5_4") ("PO" "P5_4") ("VDD" "VDD") ("VSS" "VSS")) ())
  ("I24" "ALU_CELLS_A" "BLK_N" (("GIN" "gn6") ("PIN" "pn6") ("GKN" "gn5") ("PKN" "pn5") ("GO" "G6_5") ("PO" "P6_5") ("VDD" "VDD") ("VSS" "VSS")) ())
  ("I25" "ALU_CELLS_A" "BLK_N" (("GIN" "gn7") ("PIN" "pn7") ("GKN" "gn6") ("PKN" "pn6") ("GO" "G7_6") ("PO" "P7_6") ("VDD" "VDD") ("VSS" "VSS")) ())
  ("I26" "ALU_CELLS_A" "GRY_P" (("GI" "G2_1") ("PI" "P2_1") ("GK" "G0_0") ("GON" "G2_0n") ("VDD" "VDD") ("VSS" "VSS")) ())
  ("I27" "ALU_CELLS_A" "GRY_P" (("GI" "G3_2") ("PI" "P3_2") ("GK" "G1_0") ("GON" "G3_0n") ("VDD" "VDD") ("VSS" "VSS")) ())
  ("I28" "ALU_CELLS_A" "BLK_P" (("GI" "G4_3") ("PI" "P4_3") ("GK" "G2_1") ("PK" "P2_1") ("GON" "G4_1n") ("PON" "P4_1n") ("VDD" "VDD") ("VSS" "VSS")) ())
  ("I29" "ALU_CELLS_A" "BLK_P" (("GI" "G5_4") ("PI" "P5_4") ("GK" "G3_2") ("PK" "P3_2") ("GON" "G5_2n") ("PON" "P5_2n") ("VDD" "VDD") ("VSS" "VSS")) ())
  ("I30" "ALU_CELLS_A" "BLK_P" (("GI" "G6_5") ("PI" "P6_5") ("GK" "G4_3") ("PK" "P4_3") ("GON" "G6_3n") ("PON" "P6_3n") ("VDD" "VDD") ("VSS" "VSS")) ())
  ("I31" "ALU_CELLS_A" "BLK_P" (("GI" "G7_6") ("PI" "P7_6") ("GK" "G5_4") ("PK" "P5_4") ("GON" "G7_4n") ("PON" "P7_4n") ("VDD" "VDD") ("VSS" "VSS")) ())
  ("I32" "ALU_CELLS_A" "GRY_N" (("GIN" "G4_1n") ("PIN" "P4_1n") ("GKN" "G0_0n") ("GO" "G4_0") ("VDD" "VDD") ("VSS" "VSS")) ())
  ("I33" "ALU_CELLS_A" "INV_X1" (("A" "G1_0") ("Y" "G1_0n") ("VDD" "VDD") ("VSS" "VSS")) ())
  ("I34" "ALU_CELLS_A" "GRY_N" (("GIN" "G5_2n") ("PIN" "P5_2n") ("GKN" "G1_0n") ("GO" "G5_0") ("VDD" "VDD") ("VSS" "VSS")) ())
  ("I35" "ALU_CELLS_A" "GRY_N" (("GIN" "G6_3n") ("PIN" "P6_3n") ("GKN" "G2_0n") ("GO" "C7") ("VDD" "VDD") ("VSS" "VSS")) ())
  ("I36" "ALU_CELLS_A" "GRY_N" (("GIN" "G7_4n") ("PIN" "P7_4n") ("GKN" "G3_0n") ("GO" "C8") ("VDD" "VDD") ("VSS" "VSS")) ())
  ("I37" "ALU_STUB_B" "XNOR2_X1" (("A" "pn0") ("B" "CIN") ("Y" "S_0") ("VDD" "VDD") ("VSS" "VSS")) ())
  ("I38" "ALU_STUB_B" "XNOR2_X1" (("A" "pn1") ("B" "G0_0") ("Y" "S_1") ("VDD" "VDD") ("VSS" "VSS")) ())
  ("I39" "ALU_STUB_B" "XNOR2_X1" (("A" "pn2") ("B" "G1_0") ("Y" "S_2") ("VDD" "VDD") ("VSS" "VSS")) ())
  ("I40" "ALU_STUB_B" "XOR2_X1" (("A" "pn3") ("B" "G2_0n") ("Y" "S_3") ("VDD" "VDD") ("VSS" "VSS")) ())
  ("I41" "ALU_STUB_B" "XOR2_X1" (("A" "pn4") ("B" "G3_0n") ("Y" "S_4") ("VDD" "VDD") ("VSS" "VSS")) ())
  ("I42" "ALU_STUB_B" "XNOR2_X1" (("A" "pn5") ("B" "G4_0") ("Y" "S_5") ("VDD" "VDD") ("VSS" "VSS")) ())
  ("I43" "ALU_STUB_B" "XNOR2_X1" (("A" "pn6") ("B" "G5_0") ("Y" "S_6") ("VDD" "VDD") ("VSS" "VSS")) ())
  ("I44" "ALU_STUB_B" "XNOR2_X1" (("A" "pn7") ("B" "C7") ("Y" "S_7") ("VDD" "VDD") ("VSS" "VSS")) ()))) t)
  sbErrors++ printf("SB_ERROR KSA8: %L\n" errset.errset))
unless(errset(sbCell("ALU_ADD" "ADDSUB8" '(("A_0" "input") ("A_1" "input") ("A_2" "input") ("A_3" "input") ("A_4" "input") ("A_5" "input") ("A_6" "input") ("A_7" "input") ("B_0" "input") ("B_1" "input") ("B_2" "input") ("B_3" "input") ("B_4" "input") ("B_5" "input") ("B_6" "input") ("B_7" "input") ("SUB" "input") ("S_0" "output") ("S_1" "output") ("S_2" "output") ("S_3" "output") ("S_4" "output") ("S_5" "output") ("S_6" "output") ("S_7" "output") ("C7" "output") ("C8" "output") ("VDD" "inputOutput") ("VSS" "inputOutput"))
 '(
  ("I0" "ALU_STUB_B" "XOR2_X1" (("A" "B_0") ("B" "SUB") ("Y" "bx0") ("VDD" "VDD") ("VSS" "VSS")) ())
  ("I1" "ALU_STUB_B" "XOR2_X1" (("A" "B_1") ("B" "SUB") ("Y" "bx1") ("VDD" "VDD") ("VSS" "VSS")) ())
  ("I2" "ALU_STUB_B" "XOR2_X1" (("A" "B_2") ("B" "SUB") ("Y" "bx2") ("VDD" "VDD") ("VSS" "VSS")) ())
  ("I3" "ALU_STUB_B" "XOR2_X1" (("A" "B_3") ("B" "SUB") ("Y" "bx3") ("VDD" "VDD") ("VSS" "VSS")) ())
  ("I4" "ALU_STUB_B" "XOR2_X1" (("A" "B_4") ("B" "SUB") ("Y" "bx4") ("VDD" "VDD") ("VSS" "VSS")) ())
  ("I5" "ALU_STUB_B" "XOR2_X1" (("A" "B_5") ("B" "SUB") ("Y" "bx5") ("VDD" "VDD") ("VSS" "VSS")) ())
  ("I6" "ALU_STUB_B" "XOR2_X1" (("A" "B_6") ("B" "SUB") ("Y" "bx6") ("VDD" "VDD") ("VSS" "VSS")) ())
  ("I7" "ALU_STUB_B" "XOR2_X1" (("A" "B_7") ("B" "SUB") ("Y" "bx7") ("VDD" "VDD") ("VSS" "VSS")) ())
  ("I8" "ALU_ADD" "KSA8" (("A_0" "A_0") ("A_1" "A_1") ("A_2" "A_2") ("A_3" "A_3") ("A_4" "A_4") ("A_5" "A_5") ("A_6" "A_6") ("A_7" "A_7") ("B_0" "bx0") ("B_1" "bx1") ("B_2" "bx2") ("B_3" "bx3") ("B_4" "bx4") ("B_5" "bx5") ("B_6" "bx6") ("B_7" "bx7") ("CIN" "SUB") ("S_0" "S_0") ("S_1" "S_1") ("S_2" "S_2") ("S_3" "S_3") ("S_4" "S_4") ("S_5" "S_5") ("S_6" "S_6") ("S_7" "S_7") ("C7" "C7") ("C8" "C8") ("VDD" "VDD") ("VSS" "VSS")) ()))) t)
  sbErrors++ printf("SB_ERROR ADDSUB8: %L\n" errset.errset))
unless(errset(sbCell("ALU_CORE" "LOGIC8" '(("A_0" "input") ("A_1" "input") ("A_2" "input") ("A_3" "input") ("A_4" "input") ("A_5" "input") ("A_6" "input") ("A_7" "input") ("B_0" "input") ("B_1" "input") ("B_2" "input") ("B_3" "input") ("B_4" "input") ("B_5" "input") ("B_6" "input") ("B_7" "input") ("AND_0" "output") ("AND_1" "output") ("AND_2" "output") ("AND_3" "output") ("AND_4" "output") ("AND_5" "output") ("AND_6" "output") ("AND_7" "output") ("OR_0" "output") ("OR_1" "output") ("OR_2" "output") ("OR_3" "output") ("OR_4" "output") ("OR_5" "output") ("OR_6" "output") ("OR_7" "output") ("XOR_0" "output") ("XOR_1" "output") ("XOR_2" "output") ("XOR_3" "output") ("XOR_4" "output") ("XOR_5" "output") ("XOR_6" "output") ("XOR_7" "output") ("NOT_0" "output") ("NOT_1" "output") ("NOT_2" "output") ("NOT_3" "output") ("NOT_4" "output") ("NOT_5" "output") ("NOT_6" "output") ("NOT_7" "output") ("VDD" "inputOutput") ("VSS" "inputOutput"))
 '(
  ("I0" "ALU_CELLS_A" "NAND2_X1" (("A" "A_0") ("B" "B_0") ("Y" "nand0") ("VDD" "VDD") ("VSS" "VSS")) ())
  ("I1" "ALU_CELLS_A" "INV_X1" (("A" "nand0") ("Y" "AND_0") ("VDD" "VDD") ("VSS" "VSS")) ())
  ("I2" "ALU_CELLS_A" "NOR2_X1" (("A" "A_0") ("B" "B_0") ("Y" "nor0") ("VDD" "VDD") ("VSS" "VSS")) ())
  ("I3" "ALU_CELLS_A" "INV_X1" (("A" "nor0") ("Y" "OR_0") ("VDD" "VDD") ("VSS" "VSS")) ())
  ("I4" "ALU_STUB_B" "XOR2_X1" (("A" "A_0") ("B" "B_0") ("Y" "XOR_0") ("VDD" "VDD") ("VSS" "VSS")) ())
  ("I5" "ALU_CELLS_A" "INV_X1" (("A" "A_0") ("Y" "NOT_0") ("VDD" "VDD") ("VSS" "VSS")) ())
  ("I6" "ALU_CELLS_A" "NAND2_X1" (("A" "A_1") ("B" "B_1") ("Y" "nand1") ("VDD" "VDD") ("VSS" "VSS")) ())
  ("I7" "ALU_CELLS_A" "INV_X1" (("A" "nand1") ("Y" "AND_1") ("VDD" "VDD") ("VSS" "VSS")) ())
  ("I8" "ALU_CELLS_A" "NOR2_X1" (("A" "A_1") ("B" "B_1") ("Y" "nor1") ("VDD" "VDD") ("VSS" "VSS")) ())
  ("I9" "ALU_CELLS_A" "INV_X1" (("A" "nor1") ("Y" "OR_1") ("VDD" "VDD") ("VSS" "VSS")) ())
  ("I10" "ALU_STUB_B" "XOR2_X1" (("A" "A_1") ("B" "B_1") ("Y" "XOR_1") ("VDD" "VDD") ("VSS" "VSS")) ())
  ("I11" "ALU_CELLS_A" "INV_X1" (("A" "A_1") ("Y" "NOT_1") ("VDD" "VDD") ("VSS" "VSS")) ())
  ("I12" "ALU_CELLS_A" "NAND2_X1" (("A" "A_2") ("B" "B_2") ("Y" "nand2") ("VDD" "VDD") ("VSS" "VSS")) ())
  ("I13" "ALU_CELLS_A" "INV_X1" (("A" "nand2") ("Y" "AND_2") ("VDD" "VDD") ("VSS" "VSS")) ())
  ("I14" "ALU_CELLS_A" "NOR2_X1" (("A" "A_2") ("B" "B_2") ("Y" "nor2") ("VDD" "VDD") ("VSS" "VSS")) ())
  ("I15" "ALU_CELLS_A" "INV_X1" (("A" "nor2") ("Y" "OR_2") ("VDD" "VDD") ("VSS" "VSS")) ())
  ("I16" "ALU_STUB_B" "XOR2_X1" (("A" "A_2") ("B" "B_2") ("Y" "XOR_2") ("VDD" "VDD") ("VSS" "VSS")) ())
  ("I17" "ALU_CELLS_A" "INV_X1" (("A" "A_2") ("Y" "NOT_2") ("VDD" "VDD") ("VSS" "VSS")) ())
  ("I18" "ALU_CELLS_A" "NAND2_X1" (("A" "A_3") ("B" "B_3") ("Y" "nand3") ("VDD" "VDD") ("VSS" "VSS")) ())
  ("I19" "ALU_CELLS_A" "INV_X1" (("A" "nand3") ("Y" "AND_3") ("VDD" "VDD") ("VSS" "VSS")) ())
  ("I20" "ALU_CELLS_A" "NOR2_X1" (("A" "A_3") ("B" "B_3") ("Y" "nor3") ("VDD" "VDD") ("VSS" "VSS")) ())
  ("I21" "ALU_CELLS_A" "INV_X1" (("A" "nor3") ("Y" "OR_3") ("VDD" "VDD") ("VSS" "VSS")) ())
  ("I22" "ALU_STUB_B" "XOR2_X1" (("A" "A_3") ("B" "B_3") ("Y" "XOR_3") ("VDD" "VDD") ("VSS" "VSS")) ())
  ("I23" "ALU_CELLS_A" "INV_X1" (("A" "A_3") ("Y" "NOT_3") ("VDD" "VDD") ("VSS" "VSS")) ())
  ("I24" "ALU_CELLS_A" "NAND2_X1" (("A" "A_4") ("B" "B_4") ("Y" "nand4") ("VDD" "VDD") ("VSS" "VSS")) ())
  ("I25" "ALU_CELLS_A" "INV_X1" (("A" "nand4") ("Y" "AND_4") ("VDD" "VDD") ("VSS" "VSS")) ())
  ("I26" "ALU_CELLS_A" "NOR2_X1" (("A" "A_4") ("B" "B_4") ("Y" "nor4") ("VDD" "VDD") ("VSS" "VSS")) ())
  ("I27" "ALU_CELLS_A" "INV_X1" (("A" "nor4") ("Y" "OR_4") ("VDD" "VDD") ("VSS" "VSS")) ())
  ("I28" "ALU_STUB_B" "XOR2_X1" (("A" "A_4") ("B" "B_4") ("Y" "XOR_4") ("VDD" "VDD") ("VSS" "VSS")) ())
  ("I29" "ALU_CELLS_A" "INV_X1" (("A" "A_4") ("Y" "NOT_4") ("VDD" "VDD") ("VSS" "VSS")) ())
  ("I30" "ALU_CELLS_A" "NAND2_X1" (("A" "A_5") ("B" "B_5") ("Y" "nand5") ("VDD" "VDD") ("VSS" "VSS")) ())
  ("I31" "ALU_CELLS_A" "INV_X1" (("A" "nand5") ("Y" "AND_5") ("VDD" "VDD") ("VSS" "VSS")) ())
  ("I32" "ALU_CELLS_A" "NOR2_X1" (("A" "A_5") ("B" "B_5") ("Y" "nor5") ("VDD" "VDD") ("VSS" "VSS")) ())
  ("I33" "ALU_CELLS_A" "INV_X1" (("A" "nor5") ("Y" "OR_5") ("VDD" "VDD") ("VSS" "VSS")) ())
  ("I34" "ALU_STUB_B" "XOR2_X1" (("A" "A_5") ("B" "B_5") ("Y" "XOR_5") ("VDD" "VDD") ("VSS" "VSS")) ())
  ("I35" "ALU_CELLS_A" "INV_X1" (("A" "A_5") ("Y" "NOT_5") ("VDD" "VDD") ("VSS" "VSS")) ())
  ("I36" "ALU_CELLS_A" "NAND2_X1" (("A" "A_6") ("B" "B_6") ("Y" "nand6") ("VDD" "VDD") ("VSS" "VSS")) ())
  ("I37" "ALU_CELLS_A" "INV_X1" (("A" "nand6") ("Y" "AND_6") ("VDD" "VDD") ("VSS" "VSS")) ())
  ("I38" "ALU_CELLS_A" "NOR2_X1" (("A" "A_6") ("B" "B_6") ("Y" "nor6") ("VDD" "VDD") ("VSS" "VSS")) ())
  ("I39" "ALU_CELLS_A" "INV_X1" (("A" "nor6") ("Y" "OR_6") ("VDD" "VDD") ("VSS" "VSS")) ())
  ("I40" "ALU_STUB_B" "XOR2_X1" (("A" "A_6") ("B" "B_6") ("Y" "XOR_6") ("VDD" "VDD") ("VSS" "VSS")) ())
  ("I41" "ALU_CELLS_A" "INV_X1" (("A" "A_6") ("Y" "NOT_6") ("VDD" "VDD") ("VSS" "VSS")) ())
  ("I42" "ALU_CELLS_A" "NAND2_X1" (("A" "A_7") ("B" "B_7") ("Y" "nand7") ("VDD" "VDD") ("VSS" "VSS")) ())
  ("I43" "ALU_CELLS_A" "INV_X1" (("A" "nand7") ("Y" "AND_7") ("VDD" "VDD") ("VSS" "VSS")) ())
  ("I44" "ALU_CELLS_A" "NOR2_X1" (("A" "A_7") ("B" "B_7") ("Y" "nor7") ("VDD" "VDD") ("VSS" "VSS")) ())
  ("I45" "ALU_CELLS_A" "INV_X1" (("A" "nor7") ("Y" "OR_7") ("VDD" "VDD") ("VSS" "VSS")) ())
  ("I46" "ALU_STUB_B" "XOR2_X1" (("A" "A_7") ("B" "B_7") ("Y" "XOR_7") ("VDD" "VDD") ("VSS" "VSS")) ())
  ("I47" "ALU_CELLS_A" "INV_X1" (("A" "A_7") ("Y" "NOT_7") ("VDD" "VDD") ("VSS" "VSS")) ()))) t)
  sbErrors++ printf("SB_ERROR LOGIC8: %L\n" errset.errset))
unless(errset(sbCell("ALU_CORE" "DEC_OP" '(("OP_0" "input") ("OP_1" "input") ("OP_2" "input") ("OP_3" "input") ("SEL_AS" "output") ("SEL_AND" "output") ("SEL_OR" "output") ("SEL_XOR" "output") ("SEL_NOT" "output") ("SEL_MUL" "output") ("SEL_DIV" "output") ("VDD" "inputOutput") ("VSS" "inputOutput"))
 '(
  ("I0" "ALU_CELLS_A" "INV_X1" (("A" "OP_0") ("Y" "opn0") ("VDD" "VDD") ("VSS" "VSS")) ())
  ("I1" "ALU_CELLS_A" "INV_X1" (("A" "OP_1") ("Y" "opn1") ("VDD" "VDD") ("VSS" "VSS")) ())
  ("I2" "ALU_CELLS_A" "INV_X1" (("A" "OP_2") ("Y" "opn2") ("VDD" "VDD") ("VSS" "VSS")) ())
  ("I3" "ALU_CELLS_A" "INV_X1" (("A" "OP_3") ("Y" "opn3") ("VDD" "VDD") ("VSS" "VSS")) ())
  ("I4" "ALU_CELLS_A" "NAND2_X1" (("A" "opn3") ("B" "opn2") ("Y" "h00") ("VDD" "VDD") ("VSS" "VSS")) ())
  ("I5" "ALU_CELLS_A" "NAND2_X1" (("A" "opn3") ("B" "OP_2") ("Y" "h01") ("VDD" "VDD") ("VSS" "VSS")) ())
  ("I6" "ALU_CELLS_A" "NAND2_X1" (("A" "OP_3") ("B" "opn2") ("Y" "h10") ("VDD" "VDD") ("VSS" "VSS")) ())
  ("I7" "ALU_CELLS_A" "NAND2_X1" (("A" "opn1") ("B" "opn0") ("Y" "l00") ("VDD" "VDD") ("VSS" "VSS")) ())
  ("I8" "ALU_CELLS_A" "NAND2_X1" (("A" "opn1") ("B" "OP_0") ("Y" "l01") ("VDD" "VDD") ("VSS" "VSS")) ())
  ("I9" "ALU_CELLS_A" "NAND2_X1" (("A" "OP_1") ("B" "opn0") ("Y" "l10") ("VDD" "VDD") ("VSS" "VSS")) ())
  ("I10" "ALU_CELLS_A" "NAND2_X1" (("A" "OP_1") ("B" "OP_0") ("Y" "l11") ("VDD" "VDD") ("VSS" "VSS")) ())
  ("I11" "ALU_CELLS_A" "NOR2_X1" (("A" "h00") ("B" "OP_1") ("Y" "SEL_AS") ("VDD" "VDD") ("VSS" "VSS")) ())
  ("I12" "ALU_CELLS_A" "NOR2_X1" (("A" "h00") ("B" "l10") ("Y" "SEL_AND") ("VDD" "VDD") ("VSS" "VSS")) ())
  ("I13" "ALU_CELLS_A" "NOR2_X1" (("A" "h00") ("B" "l11") ("Y" "SEL_OR") ("VDD" "VDD") ("VSS" "VSS")) ())
  ("I14" "ALU_CELLS_A" "NOR2_X1" (("A" "h01") ("B" "l00") ("Y" "SEL_XOR") ("VDD" "VDD") ("VSS" "VSS")) ())
  ("I15" "ALU_CELLS_A" "NOR2_X1" (("A" "h01") ("B" "l01") ("Y" "SEL_NOT") ("VDD" "VDD") ("VSS" "VSS")) ())
  ("I16" "ALU_CELLS_A" "NOR2_X1" (("A" "h10") ("B" "l01") ("Y" "SEL_MUL") ("VDD" "VDD") ("VSS" "VSS")) ())
  ("I17" "ALU_CELLS_A" "NOR2_X1" (("A" "h10") ("B" "l11") ("Y" "SEL_DIV") ("VDD" "VDD") ("VSS" "VSS")) ()))) t)
  sbErrors++ printf("SB_ERROR DEC_OP: %L\n" errset.errset))
unless(errset(sbCell("ALU_CORE" "OUTMUX" '(("S_0" "input") ("S_1" "input") ("S_2" "input") ("S_3" "input") ("S_4" "input") ("S_5" "input") ("S_6" "input") ("S_7" "input") ("AND_0" "input") ("AND_1" "input") ("AND_2" "input") ("AND_3" "input") ("AND_4" "input") ("AND_5" "input") ("AND_6" "input") ("AND_7" "input") ("OR_0" "input") ("OR_1" "input") ("OR_2" "input") ("OR_3" "input") ("OR_4" "input") ("OR_5" "input") ("OR_6" "input") ("OR_7" "input") ("XOR_0" "input") ("XOR_1" "input") ("XOR_2" "input") ("XOR_3" "input") ("XOR_4" "input") ("XOR_5" "input") ("XOR_6" "input") ("XOR_7" "input") ("NOT_0" "input") ("NOT_1" "input") ("NOT_2" "input") ("NOT_3" "input") ("NOT_4" "input") ("NOT_5" "input") ("NOT_6" "input") ("NOT_7" "input") ("MULP_0" "input") ("MULP_1" "input") ("MULP_2" "input") ("MULP_3" "input") ("MULP_4" "input") ("MULP_5" "input") ("MULP_6" "input") ("MULP_7" "input") ("MULP_8" "input") ("MULP_9" "input") ("MULP_10" "input") ("MULP_11" "input") ("MULP_12" "input") ("MULP_13" "input") ("MULP_14" "input") ("MULP_15" "input") ("DIVQ_0" "input") ("DIVQ_1" "input") ("DIVQ_2" "input") ("DIVQ_3" "input") ("DIVQ_4" "input") ("DIVQ_5" "input") ("DIVQ_6" "input") ("DIVQ_7" "input") ("DIVR_0" "input") ("DIVR_1" "input") ("DIVR_2" "input") ("DIVR_3" "input") ("DIVR_4" "input") ("DIVR_5" "input") ("DIVR_6" "input") ("DIVR_7" "input") ("SEL_AS" "input") ("SEL_AND" "input") ("SEL_OR" "input") ("SEL_XOR" "input") ("SEL_NOT" "input") ("SEL_MUL" "input") ("SEL_DIV" "input") ("Y_0" "output") ("Y_1" "output") ("Y_2" "output") ("Y_3" "output") ("Y_4" "output") ("Y_5" "output") ("Y_6" "output") ("Y_7" "output") ("Y_8" "output") ("Y_9" "output") ("Y_10" "output") ("Y_11" "output") ("Y_12" "output") ("Y_13" "output") ("Y_14" "output") ("Y_15" "output") ("VDD" "inputOutput") ("VSS" "inputOutput"))
 '(
  ("I0" "ALU_CELLS_A" "NAND2_X1" (("A" "SEL_AND") ("B" "AND_0") ("Y" "n0_0") ("VDD" "VDD") ("VSS" "VSS")) ())
  ("I1" "ALU_CELLS_A" "NAND2_X1" (("A" "SEL_OR") ("B" "OR_0") ("Y" "n0_1") ("VDD" "VDD") ("VSS" "VSS")) ())
  ("I2" "ALU_CELLS_A" "NAND2_X1" (("A" "SEL_XOR") ("B" "XOR_0") ("Y" "n0_2") ("VDD" "VDD") ("VSS" "VSS")) ())
  ("I3" "ALU_CELLS_A" "NAND2_X1" (("A" "SEL_NOT") ("B" "NOT_0") ("Y" "n0_3") ("VDD" "VDD") ("VSS" "VSS")) ())
  ("I4" "ALU_CELLS_A" "NAND2_X1" (("A" "SEL_MUL") ("B" "MULP_0") ("Y" "n0_4") ("VDD" "VDD") ("VSS" "VSS")) ())
  ("I5" "ALU_CELLS_A" "NAND2_X1" (("A" "SEL_DIV") ("B" "DIVQ_0") ("Y" "n0_5") ("VDD" "VDD") ("VSS" "VSS")) ())
  ("I6" "ALU_CELLS_A" "NAND2_X1" (("A" "n0_0") ("B" "n0_1") ("Y" "o0_0") ("VDD" "VDD") ("VSS" "VSS")) ())
  ("I7" "ALU_CELLS_A" "NAND2_X1" (("A" "n0_2") ("B" "n0_3") ("Y" "o0_1") ("VDD" "VDD") ("VSS" "VSS")) ())
  ("I8" "ALU_CELLS_A" "NAND2_X1" (("A" "n0_4") ("B" "n0_5") ("Y" "o0_2") ("VDD" "VDD") ("VSS" "VSS")) ())
  ("I9" "ALU_CELLS_A" "NOR2_X1" (("A" "o0_0") ("B" "o0_1") ("Y" "q0_1") ("VDD" "VDD") ("VSS" "VSS")) ())
  ("I10" "ALU_CELLS_A" "AOI21_X1" (("A1" "SEL_AS") ("A2" "S_0") ("B" "o0_2") ("Y" "q0_2") ("VDD" "VDD") ("VSS" "VSS")) ())
  ("I11" "ALU_CELLS_A" "NAND2_X1" (("A" "q0_1") ("B" "q0_2") ("Y" "Y_0") ("VDD" "VDD") ("VSS" "VSS")) ())
  ("I12" "ALU_CELLS_A" "NAND2_X1" (("A" "SEL_AND") ("B" "AND_1") ("Y" "n1_0") ("VDD" "VDD") ("VSS" "VSS")) ())
  ("I13" "ALU_CELLS_A" "NAND2_X1" (("A" "SEL_OR") ("B" "OR_1") ("Y" "n1_1") ("VDD" "VDD") ("VSS" "VSS")) ())
  ("I14" "ALU_CELLS_A" "NAND2_X1" (("A" "SEL_XOR") ("B" "XOR_1") ("Y" "n1_2") ("VDD" "VDD") ("VSS" "VSS")) ())
  ("I15" "ALU_CELLS_A" "NAND2_X1" (("A" "SEL_NOT") ("B" "NOT_1") ("Y" "n1_3") ("VDD" "VDD") ("VSS" "VSS")) ())
  ("I16" "ALU_CELLS_A" "NAND2_X1" (("A" "SEL_MUL") ("B" "MULP_1") ("Y" "n1_4") ("VDD" "VDD") ("VSS" "VSS")) ())
  ("I17" "ALU_CELLS_A" "NAND2_X1" (("A" "SEL_DIV") ("B" "DIVQ_1") ("Y" "n1_5") ("VDD" "VDD") ("VSS" "VSS")) ())
  ("I18" "ALU_CELLS_A" "NAND2_X1" (("A" "n1_0") ("B" "n1_1") ("Y" "o1_0") ("VDD" "VDD") ("VSS" "VSS")) ())
  ("I19" "ALU_CELLS_A" "NAND2_X1" (("A" "n1_2") ("B" "n1_3") ("Y" "o1_1") ("VDD" "VDD") ("VSS" "VSS")) ())
  ("I20" "ALU_CELLS_A" "NAND2_X1" (("A" "n1_4") ("B" "n1_5") ("Y" "o1_2") ("VDD" "VDD") ("VSS" "VSS")) ())
  ("I21" "ALU_CELLS_A" "NOR2_X1" (("A" "o1_0") ("B" "o1_1") ("Y" "q1_1") ("VDD" "VDD") ("VSS" "VSS")) ())
  ("I22" "ALU_CELLS_A" "AOI21_X1" (("A1" "SEL_AS") ("A2" "S_1") ("B" "o1_2") ("Y" "q1_2") ("VDD" "VDD") ("VSS" "VSS")) ())
  ("I23" "ALU_CELLS_A" "NAND2_X1" (("A" "q1_1") ("B" "q1_2") ("Y" "Y_1") ("VDD" "VDD") ("VSS" "VSS")) ())
  ("I24" "ALU_CELLS_A" "NAND2_X1" (("A" "SEL_AND") ("B" "AND_2") ("Y" "n2_0") ("VDD" "VDD") ("VSS" "VSS")) ())
  ("I25" "ALU_CELLS_A" "NAND2_X1" (("A" "SEL_OR") ("B" "OR_2") ("Y" "n2_1") ("VDD" "VDD") ("VSS" "VSS")) ())
  ("I26" "ALU_CELLS_A" "NAND2_X1" (("A" "SEL_XOR") ("B" "XOR_2") ("Y" "n2_2") ("VDD" "VDD") ("VSS" "VSS")) ())
  ("I27" "ALU_CELLS_A" "NAND2_X1" (("A" "SEL_NOT") ("B" "NOT_2") ("Y" "n2_3") ("VDD" "VDD") ("VSS" "VSS")) ())
  ("I28" "ALU_CELLS_A" "NAND2_X1" (("A" "SEL_MUL") ("B" "MULP_2") ("Y" "n2_4") ("VDD" "VDD") ("VSS" "VSS")) ())
  ("I29" "ALU_CELLS_A" "NAND2_X1" (("A" "SEL_DIV") ("B" "DIVQ_2") ("Y" "n2_5") ("VDD" "VDD") ("VSS" "VSS")) ())
  ("I30" "ALU_CELLS_A" "NAND2_X1" (("A" "n2_0") ("B" "n2_1") ("Y" "o2_0") ("VDD" "VDD") ("VSS" "VSS")) ())
  ("I31" "ALU_CELLS_A" "NAND2_X1" (("A" "n2_2") ("B" "n2_3") ("Y" "o2_1") ("VDD" "VDD") ("VSS" "VSS")) ())
  ("I32" "ALU_CELLS_A" "NAND2_X1" (("A" "n2_4") ("B" "n2_5") ("Y" "o2_2") ("VDD" "VDD") ("VSS" "VSS")) ())
  ("I33" "ALU_CELLS_A" "NOR2_X1" (("A" "o2_0") ("B" "o2_1") ("Y" "q2_1") ("VDD" "VDD") ("VSS" "VSS")) ())
  ("I34" "ALU_CELLS_A" "AOI21_X1" (("A1" "SEL_AS") ("A2" "S_2") ("B" "o2_2") ("Y" "q2_2") ("VDD" "VDD") ("VSS" "VSS")) ())
  ("I35" "ALU_CELLS_A" "NAND2_X1" (("A" "q2_1") ("B" "q2_2") ("Y" "Y_2") ("VDD" "VDD") ("VSS" "VSS")) ())
  ("I36" "ALU_CELLS_A" "NAND2_X1" (("A" "SEL_AND") ("B" "AND_3") ("Y" "n3_0") ("VDD" "VDD") ("VSS" "VSS")) ())
  ("I37" "ALU_CELLS_A" "NAND2_X1" (("A" "SEL_OR") ("B" "OR_3") ("Y" "n3_1") ("VDD" "VDD") ("VSS" "VSS")) ())
  ("I38" "ALU_CELLS_A" "NAND2_X1" (("A" "SEL_XOR") ("B" "XOR_3") ("Y" "n3_2") ("VDD" "VDD") ("VSS" "VSS")) ())
  ("I39" "ALU_CELLS_A" "NAND2_X1" (("A" "SEL_NOT") ("B" "NOT_3") ("Y" "n3_3") ("VDD" "VDD") ("VSS" "VSS")) ())
  ("I40" "ALU_CELLS_A" "NAND2_X1" (("A" "SEL_MUL") ("B" "MULP_3") ("Y" "n3_4") ("VDD" "VDD") ("VSS" "VSS")) ())
  ("I41" "ALU_CELLS_A" "NAND2_X1" (("A" "SEL_DIV") ("B" "DIVQ_3") ("Y" "n3_5") ("VDD" "VDD") ("VSS" "VSS")) ())
  ("I42" "ALU_CELLS_A" "NAND2_X1" (("A" "n3_0") ("B" "n3_1") ("Y" "o3_0") ("VDD" "VDD") ("VSS" "VSS")) ())
  ("I43" "ALU_CELLS_A" "NAND2_X1" (("A" "n3_2") ("B" "n3_3") ("Y" "o3_1") ("VDD" "VDD") ("VSS" "VSS")) ())
  ("I44" "ALU_CELLS_A" "NAND2_X1" (("A" "n3_4") ("B" "n3_5") ("Y" "o3_2") ("VDD" "VDD") ("VSS" "VSS")) ())
  ("I45" "ALU_CELLS_A" "NOR2_X1" (("A" "o3_0") ("B" "o3_1") ("Y" "q3_1") ("VDD" "VDD") ("VSS" "VSS")) ())
  ("I46" "ALU_CELLS_A" "AOI21_X1" (("A1" "SEL_AS") ("A2" "S_3") ("B" "o3_2") ("Y" "q3_2") ("VDD" "VDD") ("VSS" "VSS")) ())
  ("I47" "ALU_CELLS_A" "NAND2_X1" (("A" "q3_1") ("B" "q3_2") ("Y" "Y_3") ("VDD" "VDD") ("VSS" "VSS")) ())
  ("I48" "ALU_CELLS_A" "NAND2_X1" (("A" "SEL_AND") ("B" "AND_4") ("Y" "n4_0") ("VDD" "VDD") ("VSS" "VSS")) ())
  ("I49" "ALU_CELLS_A" "NAND2_X1" (("A" "SEL_OR") ("B" "OR_4") ("Y" "n4_1") ("VDD" "VDD") ("VSS" "VSS")) ())
  ("I50" "ALU_CELLS_A" "NAND2_X1" (("A" "SEL_XOR") ("B" "XOR_4") ("Y" "n4_2") ("VDD" "VDD") ("VSS" "VSS")) ())
  ("I51" "ALU_CELLS_A" "NAND2_X1" (("A" "SEL_NOT") ("B" "NOT_4") ("Y" "n4_3") ("VDD" "VDD") ("VSS" "VSS")) ())
  ("I52" "ALU_CELLS_A" "NAND2_X1" (("A" "SEL_MUL") ("B" "MULP_4") ("Y" "n4_4") ("VDD" "VDD") ("VSS" "VSS")) ())
  ("I53" "ALU_CELLS_A" "NAND2_X1" (("A" "SEL_DIV") ("B" "DIVQ_4") ("Y" "n4_5") ("VDD" "VDD") ("VSS" "VSS")) ())
  ("I54" "ALU_CELLS_A" "NAND2_X1" (("A" "n4_0") ("B" "n4_1") ("Y" "o4_0") ("VDD" "VDD") ("VSS" "VSS")) ())
  ("I55" "ALU_CELLS_A" "NAND2_X1" (("A" "n4_2") ("B" "n4_3") ("Y" "o4_1") ("VDD" "VDD") ("VSS" "VSS")) ())
  ("I56" "ALU_CELLS_A" "NAND2_X1" (("A" "n4_4") ("B" "n4_5") ("Y" "o4_2") ("VDD" "VDD") ("VSS" "VSS")) ())
  ("I57" "ALU_CELLS_A" "NOR2_X1" (("A" "o4_0") ("B" "o4_1") ("Y" "q4_1") ("VDD" "VDD") ("VSS" "VSS")) ())
  ("I58" "ALU_CELLS_A" "AOI21_X1" (("A1" "SEL_AS") ("A2" "S_4") ("B" "o4_2") ("Y" "q4_2") ("VDD" "VDD") ("VSS" "VSS")) ())
  ("I59" "ALU_CELLS_A" "NAND2_X1" (("A" "q4_1") ("B" "q4_2") ("Y" "Y_4") ("VDD" "VDD") ("VSS" "VSS")) ())
  ("I60" "ALU_CELLS_A" "NAND2_X1" (("A" "SEL_AND") ("B" "AND_5") ("Y" "n5_0") ("VDD" "VDD") ("VSS" "VSS")) ())
  ("I61" "ALU_CELLS_A" "NAND2_X1" (("A" "SEL_OR") ("B" "OR_5") ("Y" "n5_1") ("VDD" "VDD") ("VSS" "VSS")) ())
  ("I62" "ALU_CELLS_A" "NAND2_X1" (("A" "SEL_XOR") ("B" "XOR_5") ("Y" "n5_2") ("VDD" "VDD") ("VSS" "VSS")) ())
  ("I63" "ALU_CELLS_A" "NAND2_X1" (("A" "SEL_NOT") ("B" "NOT_5") ("Y" "n5_3") ("VDD" "VDD") ("VSS" "VSS")) ())
  ("I64" "ALU_CELLS_A" "NAND2_X1" (("A" "SEL_MUL") ("B" "MULP_5") ("Y" "n5_4") ("VDD" "VDD") ("VSS" "VSS")) ())
  ("I65" "ALU_CELLS_A" "NAND2_X1" (("A" "SEL_DIV") ("B" "DIVQ_5") ("Y" "n5_5") ("VDD" "VDD") ("VSS" "VSS")) ())
  ("I66" "ALU_CELLS_A" "NAND2_X1" (("A" "n5_0") ("B" "n5_1") ("Y" "o5_0") ("VDD" "VDD") ("VSS" "VSS")) ())
  ("I67" "ALU_CELLS_A" "NAND2_X1" (("A" "n5_2") ("B" "n5_3") ("Y" "o5_1") ("VDD" "VDD") ("VSS" "VSS")) ())
  ("I68" "ALU_CELLS_A" "NAND2_X1" (("A" "n5_4") ("B" "n5_5") ("Y" "o5_2") ("VDD" "VDD") ("VSS" "VSS")) ())
  ("I69" "ALU_CELLS_A" "NOR2_X1" (("A" "o5_0") ("B" "o5_1") ("Y" "q5_1") ("VDD" "VDD") ("VSS" "VSS")) ())
  ("I70" "ALU_CELLS_A" "AOI21_X1" (("A1" "SEL_AS") ("A2" "S_5") ("B" "o5_2") ("Y" "q5_2") ("VDD" "VDD") ("VSS" "VSS")) ())
  ("I71" "ALU_CELLS_A" "NAND2_X1" (("A" "q5_1") ("B" "q5_2") ("Y" "Y_5") ("VDD" "VDD") ("VSS" "VSS")) ())
  ("I72" "ALU_CELLS_A" "NAND2_X1" (("A" "SEL_AND") ("B" "AND_6") ("Y" "n6_0") ("VDD" "VDD") ("VSS" "VSS")) ())
  ("I73" "ALU_CELLS_A" "NAND2_X1" (("A" "SEL_OR") ("B" "OR_6") ("Y" "n6_1") ("VDD" "VDD") ("VSS" "VSS")) ())
  ("I74" "ALU_CELLS_A" "NAND2_X1" (("A" "SEL_XOR") ("B" "XOR_6") ("Y" "n6_2") ("VDD" "VDD") ("VSS" "VSS")) ())
  ("I75" "ALU_CELLS_A" "NAND2_X1" (("A" "SEL_NOT") ("B" "NOT_6") ("Y" "n6_3") ("VDD" "VDD") ("VSS" "VSS")) ())
  ("I76" "ALU_CELLS_A" "NAND2_X1" (("A" "SEL_MUL") ("B" "MULP_6") ("Y" "n6_4") ("VDD" "VDD") ("VSS" "VSS")) ())
  ("I77" "ALU_CELLS_A" "NAND2_X1" (("A" "SEL_DIV") ("B" "DIVQ_6") ("Y" "n6_5") ("VDD" "VDD") ("VSS" "VSS")) ())
  ("I78" "ALU_CELLS_A" "NAND2_X1" (("A" "n6_0") ("B" "n6_1") ("Y" "o6_0") ("VDD" "VDD") ("VSS" "VSS")) ())
  ("I79" "ALU_CELLS_A" "NAND2_X1" (("A" "n6_2") ("B" "n6_3") ("Y" "o6_1") ("VDD" "VDD") ("VSS" "VSS")) ())
  ("I80" "ALU_CELLS_A" "NAND2_X1" (("A" "n6_4") ("B" "n6_5") ("Y" "o6_2") ("VDD" "VDD") ("VSS" "VSS")) ())
  ("I81" "ALU_CELLS_A" "NOR2_X1" (("A" "o6_0") ("B" "o6_1") ("Y" "q6_1") ("VDD" "VDD") ("VSS" "VSS")) ())
  ("I82" "ALU_CELLS_A" "AOI21_X1" (("A1" "SEL_AS") ("A2" "S_6") ("B" "o6_2") ("Y" "q6_2") ("VDD" "VDD") ("VSS" "VSS")) ())
  ("I83" "ALU_CELLS_A" "NAND2_X1" (("A" "q6_1") ("B" "q6_2") ("Y" "Y_6") ("VDD" "VDD") ("VSS" "VSS")) ())
  ("I84" "ALU_CELLS_A" "NAND2_X1" (("A" "SEL_AND") ("B" "AND_7") ("Y" "n7_0") ("VDD" "VDD") ("VSS" "VSS")) ())
  ("I85" "ALU_CELLS_A" "NAND2_X1" (("A" "SEL_OR") ("B" "OR_7") ("Y" "n7_1") ("VDD" "VDD") ("VSS" "VSS")) ())
  ("I86" "ALU_CELLS_A" "NAND2_X1" (("A" "SEL_XOR") ("B" "XOR_7") ("Y" "n7_2") ("VDD" "VDD") ("VSS" "VSS")) ())
  ("I87" "ALU_CELLS_A" "NAND2_X1" (("A" "SEL_NOT") ("B" "NOT_7") ("Y" "n7_3") ("VDD" "VDD") ("VSS" "VSS")) ())
  ("I88" "ALU_CELLS_A" "NAND2_X1" (("A" "SEL_MUL") ("B" "MULP_7") ("Y" "n7_4") ("VDD" "VDD") ("VSS" "VSS")) ())
  ("I89" "ALU_CELLS_A" "NAND2_X1" (("A" "SEL_DIV") ("B" "DIVQ_7") ("Y" "n7_5") ("VDD" "VDD") ("VSS" "VSS")) ())
  ("I90" "ALU_CELLS_A" "NAND2_X1" (("A" "n7_0") ("B" "n7_1") ("Y" "o7_0") ("VDD" "VDD") ("VSS" "VSS")) ())
  ("I91" "ALU_CELLS_A" "NAND2_X1" (("A" "n7_2") ("B" "n7_3") ("Y" "o7_1") ("VDD" "VDD") ("VSS" "VSS")) ())
  ("I92" "ALU_CELLS_A" "NAND2_X1" (("A" "n7_4") ("B" "n7_5") ("Y" "o7_2") ("VDD" "VDD") ("VSS" "VSS")) ())
  ("I93" "ALU_CELLS_A" "NOR2_X1" (("A" "o7_0") ("B" "o7_1") ("Y" "q7_1") ("VDD" "VDD") ("VSS" "VSS")) ())
  ("I94" "ALU_CELLS_A" "AOI21_X1" (("A1" "SEL_AS") ("A2" "S_7") ("B" "o7_2") ("Y" "q7_2") ("VDD" "VDD") ("VSS" "VSS")) ())
  ("I95" "ALU_CELLS_A" "NAND2_X1" (("A" "q7_1") ("B" "q7_2") ("Y" "Y_7") ("VDD" "VDD") ("VSS" "VSS")) ())
  ("I96" "ALU_CELLS_A" "NAND2_X1" (("A" "SEL_MUL") ("B" "MULP_8") ("Y" "hm8") ("VDD" "VDD") ("VSS" "VSS")) ())
  ("I97" "ALU_CELLS_A" "NAND2_X1" (("A" "SEL_DIV") ("B" "DIVR_0") ("Y" "hd8") ("VDD" "VDD") ("VSS" "VSS")) ())
  ("I98" "ALU_CELLS_A" "NAND2_X1" (("A" "hm8") ("B" "hd8") ("Y" "Y_8") ("VDD" "VDD") ("VSS" "VSS")) ())
  ("I99" "ALU_CELLS_A" "NAND2_X1" (("A" "SEL_MUL") ("B" "MULP_9") ("Y" "hm9") ("VDD" "VDD") ("VSS" "VSS")) ())
  ("I100" "ALU_CELLS_A" "NAND2_X1" (("A" "SEL_DIV") ("B" "DIVR_1") ("Y" "hd9") ("VDD" "VDD") ("VSS" "VSS")) ())
  ("I101" "ALU_CELLS_A" "NAND2_X1" (("A" "hm9") ("B" "hd9") ("Y" "Y_9") ("VDD" "VDD") ("VSS" "VSS")) ())
  ("I102" "ALU_CELLS_A" "NAND2_X1" (("A" "SEL_MUL") ("B" "MULP_10") ("Y" "hm10") ("VDD" "VDD") ("VSS" "VSS")) ())
  ("I103" "ALU_CELLS_A" "NAND2_X1" (("A" "SEL_DIV") ("B" "DIVR_2") ("Y" "hd10") ("VDD" "VDD") ("VSS" "VSS")) ())
  ("I104" "ALU_CELLS_A" "NAND2_X1" (("A" "hm10") ("B" "hd10") ("Y" "Y_10") ("VDD" "VDD") ("VSS" "VSS")) ())
  ("I105" "ALU_CELLS_A" "NAND2_X1" (("A" "SEL_MUL") ("B" "MULP_11") ("Y" "hm11") ("VDD" "VDD") ("VSS" "VSS")) ())
  ("I106" "ALU_CELLS_A" "NAND2_X1" (("A" "SEL_DIV") ("B" "DIVR_3") ("Y" "hd11") ("VDD" "VDD") ("VSS" "VSS")) ())
  ("I107" "ALU_CELLS_A" "NAND2_X1" (("A" "hm11") ("B" "hd11") ("Y" "Y_11") ("VDD" "VDD") ("VSS" "VSS")) ())
  ("I108" "ALU_CELLS_A" "NAND2_X1" (("A" "SEL_MUL") ("B" "MULP_12") ("Y" "hm12") ("VDD" "VDD") ("VSS" "VSS")) ())
  ("I109" "ALU_CELLS_A" "NAND2_X1" (("A" "SEL_DIV") ("B" "DIVR_4") ("Y" "hd12") ("VDD" "VDD") ("VSS" "VSS")) ())
  ("I110" "ALU_CELLS_A" "NAND2_X1" (("A" "hm12") ("B" "hd12") ("Y" "Y_12") ("VDD" "VDD") ("VSS" "VSS")) ())
  ("I111" "ALU_CELLS_A" "NAND2_X1" (("A" "SEL_MUL") ("B" "MULP_13") ("Y" "hm13") ("VDD" "VDD") ("VSS" "VSS")) ())
  ("I112" "ALU_CELLS_A" "NAND2_X1" (("A" "SEL_DIV") ("B" "DIVR_5") ("Y" "hd13") ("VDD" "VDD") ("VSS" "VSS")) ())
  ("I113" "ALU_CELLS_A" "NAND2_X1" (("A" "hm13") ("B" "hd13") ("Y" "Y_13") ("VDD" "VDD") ("VSS" "VSS")) ())
  ("I114" "ALU_CELLS_A" "NAND2_X1" (("A" "SEL_MUL") ("B" "MULP_14") ("Y" "hm14") ("VDD" "VDD") ("VSS" "VSS")) ())
  ("I115" "ALU_CELLS_A" "NAND2_X1" (("A" "SEL_DIV") ("B" "DIVR_6") ("Y" "hd14") ("VDD" "VDD") ("VSS" "VSS")) ())
  ("I116" "ALU_CELLS_A" "NAND2_X1" (("A" "hm14") ("B" "hd14") ("Y" "Y_14") ("VDD" "VDD") ("VSS" "VSS")) ())
  ("I117" "ALU_CELLS_A" "NAND2_X1" (("A" "SEL_MUL") ("B" "MULP_15") ("Y" "hm15") ("VDD" "VDD") ("VSS" "VSS")) ())
  ("I118" "ALU_CELLS_A" "NAND2_X1" (("A" "SEL_DIV") ("B" "DIVR_7") ("Y" "hd15") ("VDD" "VDD") ("VSS" "VSS")) ())
  ("I119" "ALU_CELLS_A" "NAND2_X1" (("A" "hm15") ("B" "hd15") ("Y" "Y_15") ("VDD" "VDD") ("VSS" "VSS")) ()))) t)
  sbErrors++ printf("SB_ERROR OUTMUX: %L\n" errset.errset))
unless(errset(sbCell("ALU_CORE" "FLAGS" '(("Y_0" "input") ("Y_1" "input") ("Y_2" "input") ("Y_3" "input") ("Y_4" "input") ("Y_5" "input") ("Y_6" "input") ("Y_7" "input") ("Y_8" "input") ("Y_9" "input") ("Y_10" "input") ("Y_11" "input") ("Y_12" "input") ("Y_13" "input") ("Y_14" "input") ("Y_15" "input") ("C7" "input") ("C8" "input") ("DIVV" "input") ("DIVDZ" "input") ("SEL_AS" "input") ("SEL_DIV" "input") ("Z" "output") ("C" "output") ("V" "output") ("DZ" "output") ("VDD" "inputOutput") ("VSS" "inputOutput"))
 '(
  ("I0" "ALU_CELLS_A" "NOR2_X1" (("A" "Y_0") ("B" "Y_1") ("Y" "za0") ("VDD" "VDD") ("VSS" "VSS")) ())
  ("I1" "ALU_CELLS_A" "NOR2_X1" (("A" "Y_2") ("B" "Y_3") ("Y" "za1") ("VDD" "VDD") ("VSS" "VSS")) ())
  ("I2" "ALU_CELLS_A" "NOR2_X1" (("A" "Y_4") ("B" "Y_5") ("Y" "za2") ("VDD" "VDD") ("VSS" "VSS")) ())
  ("I3" "ALU_CELLS_A" "NOR2_X1" (("A" "Y_6") ("B" "Y_7") ("Y" "za3") ("VDD" "VDD") ("VSS" "VSS")) ())
  ("I4" "ALU_CELLS_A" "NOR2_X1" (("A" "Y_8") ("B" "Y_9") ("Y" "za4") ("VDD" "VDD") ("VSS" "VSS")) ())
  ("I5" "ALU_CELLS_A" "NOR2_X1" (("A" "Y_10") ("B" "Y_11") ("Y" "za5") ("VDD" "VDD") ("VSS" "VSS")) ())
  ("I6" "ALU_CELLS_A" "NOR2_X1" (("A" "Y_12") ("B" "Y_13") ("Y" "za6") ("VDD" "VDD") ("VSS" "VSS")) ())
  ("I7" "ALU_CELLS_A" "NOR2_X1" (("A" "Y_14") ("B" "Y_15") ("Y" "za7") ("VDD" "VDD") ("VSS" "VSS")) ())
  ("I8" "ALU_CELLS_A" "NAND2_X1" (("A" "za0") ("B" "za1") ("Y" "zb0") ("VDD" "VDD") ("VSS" "VSS")) ())
  ("I9" "ALU_CELLS_A" "NAND2_X1" (("A" "za2") ("B" "za3") ("Y" "zb1") ("VDD" "VDD") ("VSS" "VSS")) ())
  ("I10" "ALU_CELLS_A" "NAND2_X1" (("A" "za4") ("B" "za5") ("Y" "zb2") ("VDD" "VDD") ("VSS" "VSS")) ())
  ("I11" "ALU_CELLS_A" "NAND2_X1" (("A" "za6") ("B" "za7") ("Y" "zb3") ("VDD" "VDD") ("VSS" "VSS")) ())
  ("I12" "ALU_CELLS_A" "NOR2_X1" (("A" "zb0") ("B" "zb1") ("Y" "zc0") ("VDD" "VDD") ("VSS" "VSS")) ())
  ("I13" "ALU_CELLS_A" "NOR2_X1" (("A" "zb2") ("B" "zb3") ("Y" "zc1") ("VDD" "VDD") ("VSS" "VSS")) ())
  ("I14" "ALU_CELLS_A" "NAND2_X1" (("A" "zc0") ("B" "zc1") ("Y" "zd") ("VDD" "VDD") ("VSS" "VSS")) ())
  ("I15" "ALU_CELLS_A" "INV_X1" (("A" "zd") ("Y" "Z") ("VDD" "VDD") ("VSS" "VSS")) ())
  ("I16" "ALU_CELLS_A" "NAND2_X1" (("A" "C8") ("B" "SEL_AS") ("Y" "cn") ("VDD" "VDD") ("VSS" "VSS")) ())
  ("I17" "ALU_CELLS_A" "INV_X1" (("A" "cn") ("Y" "C") ("VDD" "VDD") ("VSS" "VSS")) ())
  ("I18" "ALU_STUB_B" "XOR2_X1" (("A" "C7") ("B" "C8") ("Y" "ovf") ("VDD" "VDD") ("VSS" "VSS")) ())
  ("I19" "ALU_CELLS_A" "NAND2_X1" (("A" "SEL_AS") ("B" "ovf") ("Y" "v1") ("VDD" "VDD") ("VSS" "VSS")) ())
  ("I20" "ALU_CELLS_A" "NAND2_X1" (("A" "SEL_DIV") ("B" "DIVV") ("Y" "v2") ("VDD" "VDD") ("VSS" "VSS")) ())
  ("I21" "ALU_CELLS_A" "NAND2_X1" (("A" "v1") ("B" "v2") ("Y" "V") ("VDD" "VDD") ("VSS" "VSS")) ())
  ("I22" "ALU_CELLS_A" "NAND2_X1" (("A" "SEL_DIV") ("B" "DIVDZ") ("Y" "dzn") ("VDD" "VDD") ("VSS" "VSS")) ())
  ("I23" "ALU_CELLS_A" "INV_X1" (("A" "dzn") ("Y" "DZ") ("VDD" "VDD") ("VSS" "VSS")) ()))) t)
  sbErrors++ printf("SB_ERROR FLAGS: %L\n" errset.errset))
unless(errset(sbCell("ALU_CORE" "ALU_CORE" '(("A_0" "input") ("A_1" "input") ("A_2" "input") ("A_3" "input") ("A_4" "input") ("A_5" "input") ("A_6" "input") ("A_7" "input") ("B_0" "input") ("B_1" "input") ("B_2" "input") ("B_3" "input") ("B_4" "input") ("B_5" "input") ("B_6" "input") ("B_7" "input") ("OP_0" "input") ("OP_1" "input") ("OP_2" "input") ("OP_3" "input") ("MULP_0" "input") ("MULP_1" "input") ("MULP_2" "input") ("MULP_3" "input") ("MULP_4" "input") ("MULP_5" "input") ("MULP_6" "input") ("MULP_7" "input") ("MULP_8" "input") ("MULP_9" "input") ("MULP_10" "input") ("MULP_11" "input") ("MULP_12" "input") ("MULP_13" "input") ("MULP_14" "input") ("MULP_15" "input") ("DIVQ_0" "input") ("DIVQ_1" "input") ("DIVQ_2" "input") ("DIVQ_3" "input") ("DIVQ_4" "input") ("DIVQ_5" "input") ("DIVQ_6" "input") ("DIVQ_7" "input") ("DIVR_0" "input") ("DIVR_1" "input") ("DIVR_2" "input") ("DIVR_3" "input") ("DIVR_4" "input") ("DIVR_5" "input") ("DIVR_6" "input") ("DIVR_7" "input") ("DIVV" "input") ("DIVDZ" "input") ("Y_0" "output") ("Y_1" "output") ("Y_2" "output") ("Y_3" "output") ("Y_4" "output") ("Y_5" "output") ("Y_6" "output") ("Y_7" "output") ("Y_8" "output") ("Y_9" "output") ("Y_10" "output") ("Y_11" "output") ("Y_12" "output") ("Y_13" "output") ("Y_14" "output") ("Y_15" "output") ("Z" "output") ("C" "output") ("V" "output") ("DZ" "output") ("VDD" "inputOutput") ("VSS" "inputOutput"))
 '(
  ("I0" "ALU_CORE" "DEC_OP" (("OP_0" "OP_0") ("OP_1" "OP_1") ("OP_2" "OP_2") ("OP_3" "OP_3") ("SEL_AS" "SEL_AS") ("SEL_AND" "SEL_AND") ("SEL_OR" "SEL_OR") ("SEL_XOR" "SEL_XOR") ("SEL_NOT" "SEL_NOT") ("SEL_MUL" "SEL_MUL") ("SEL_DIV" "SEL_DIV") ("VDD" "VDD") ("VSS" "VSS")) ())
  ("I1" "ALU_ADD" "ADDSUB8" (("A_0" "A_0") ("A_1" "A_1") ("A_2" "A_2") ("A_3" "A_3") ("A_4" "A_4") ("A_5" "A_5") ("A_6" "A_6") ("A_7" "A_7") ("B_0" "B_0") ("B_1" "B_1") ("B_2" "B_2") ("B_3" "B_3") ("B_4" "B_4") ("B_5" "B_5") ("B_6" "B_6") ("B_7" "B_7") ("SUB" "OP_0") ("S_0" "S_0") ("S_1" "S_1") ("S_2" "S_2") ("S_3" "S_3") ("S_4" "S_4") ("S_5" "S_5") ("S_6" "S_6") ("S_7" "S_7") ("C7" "C7") ("C8" "C8") ("VDD" "VDD") ("VSS" "VSS")) ())
  ("I2" "ALU_CORE" "LOGIC8" (("A_0" "A_0") ("A_1" "A_1") ("A_2" "A_2") ("A_3" "A_3") ("A_4" "A_4") ("A_5" "A_5") ("A_6" "A_6") ("A_7" "A_7") ("B_0" "B_0") ("B_1" "B_1") ("B_2" "B_2") ("B_3" "B_3") ("B_4" "B_4") ("B_5" "B_5") ("B_6" "B_6") ("B_7" "B_7") ("AND_0" "AND_0") ("AND_1" "AND_1") ("AND_2" "AND_2") ("AND_3" "AND_3") ("AND_4" "AND_4") ("AND_5" "AND_5") ("AND_6" "AND_6") ("AND_7" "AND_7") ("OR_0" "OR_0") ("OR_1" "OR_1") ("OR_2" "OR_2") ("OR_3" "OR_3") ("OR_4" "OR_4") ("OR_5" "OR_5") ("OR_6" "OR_6") ("OR_7" "OR_7") ("XOR_0" "XOR_0") ("XOR_1" "XOR_1") ("XOR_2" "XOR_2") ("XOR_3" "XOR_3") ("XOR_4" "XOR_4") ("XOR_5" "XOR_5") ("XOR_6" "XOR_6") ("XOR_7" "XOR_7") ("NOT_0" "NOT_0") ("NOT_1" "NOT_1") ("NOT_2" "NOT_2") ("NOT_3" "NOT_3") ("NOT_4" "NOT_4") ("NOT_5" "NOT_5") ("NOT_6" "NOT_6") ("NOT_7" "NOT_7") ("VDD" "VDD") ("VSS" "VSS")) ())
  ("I3" "ALU_CORE" "OUTMUX" (("S_0" "S_0") ("S_1" "S_1") ("S_2" "S_2") ("S_3" "S_3") ("S_4" "S_4") ("S_5" "S_5") ("S_6" "S_6") ("S_7" "S_7") ("AND_0" "AND_0") ("AND_1" "AND_1") ("AND_2" "AND_2") ("AND_3" "AND_3") ("AND_4" "AND_4") ("AND_5" "AND_5") ("AND_6" "AND_6") ("AND_7" "AND_7") ("OR_0" "OR_0") ("OR_1" "OR_1") ("OR_2" "OR_2") ("OR_3" "OR_3") ("OR_4" "OR_4") ("OR_5" "OR_5") ("OR_6" "OR_6") ("OR_7" "OR_7") ("XOR_0" "XOR_0") ("XOR_1" "XOR_1") ("XOR_2" "XOR_2") ("XOR_3" "XOR_3") ("XOR_4" "XOR_4") ("XOR_5" "XOR_5") ("XOR_6" "XOR_6") ("XOR_7" "XOR_7") ("NOT_0" "NOT_0") ("NOT_1" "NOT_1") ("NOT_2" "NOT_2") ("NOT_3" "NOT_3") ("NOT_4" "NOT_4") ("NOT_5" "NOT_5") ("NOT_6" "NOT_6") ("NOT_7" "NOT_7") ("MULP_0" "MULP_0") ("MULP_1" "MULP_1") ("MULP_2" "MULP_2") ("MULP_3" "MULP_3") ("MULP_4" "MULP_4") ("MULP_5" "MULP_5") ("MULP_6" "MULP_6") ("MULP_7" "MULP_7") ("MULP_8" "MULP_8") ("MULP_9" "MULP_9") ("MULP_10" "MULP_10") ("MULP_11" "MULP_11") ("MULP_12" "MULP_12") ("MULP_13" "MULP_13") ("MULP_14" "MULP_14") ("MULP_15" "MULP_15") ("DIVQ_0" "DIVQ_0") ("DIVQ_1" "DIVQ_1") ("DIVQ_2" "DIVQ_2") ("DIVQ_3" "DIVQ_3") ("DIVQ_4" "DIVQ_4") ("DIVQ_5" "DIVQ_5") ("DIVQ_6" "DIVQ_6") ("DIVQ_7" "DIVQ_7") ("DIVR_0" "DIVR_0") ("DIVR_1" "DIVR_1") ("DIVR_2" "DIVR_2") ("DIVR_3" "DIVR_3") ("DIVR_4" "DIVR_4") ("DIVR_5" "DIVR_5") ("DIVR_6" "DIVR_6") ("DIVR_7" "DIVR_7") ("SEL_AS" "SEL_AS") ("SEL_AND" "SEL_AND") ("SEL_OR" "SEL_OR") ("SEL_XOR" "SEL_XOR") ("SEL_NOT" "SEL_NOT") ("SEL_MUL" "SEL_MUL") ("SEL_DIV" "SEL_DIV") ("Y_0" "Y_0") ("Y_1" "Y_1") ("Y_2" "Y_2") ("Y_3" "Y_3") ("Y_4" "Y_4") ("Y_5" "Y_5") ("Y_6" "Y_6") ("Y_7" "Y_7") ("Y_8" "Y_8") ("Y_9" "Y_9") ("Y_10" "Y_10") ("Y_11" "Y_11") ("Y_12" "Y_12") ("Y_13" "Y_13") ("Y_14" "Y_14") ("Y_15" "Y_15") ("VDD" "VDD") ("VSS" "VSS")) ())
  ("I4" "ALU_CORE" "FLAGS" (("Y_0" "Y_0") ("Y_1" "Y_1") ("Y_2" "Y_2") ("Y_3" "Y_3") ("Y_4" "Y_4") ("Y_5" "Y_5") ("Y_6" "Y_6") ("Y_7" "Y_7") ("Y_8" "Y_8") ("Y_9" "Y_9") ("Y_10" "Y_10") ("Y_11" "Y_11") ("Y_12" "Y_12") ("Y_13" "Y_13") ("Y_14" "Y_14") ("Y_15" "Y_15") ("C7" "C7") ("C8" "C8") ("DIVV" "DIVV") ("DIVDZ" "DIVDZ") ("SEL_AS" "SEL_AS") ("SEL_DIV" "SEL_DIV") ("Z" "Z") ("C" "C") ("V" "V") ("DZ" "DZ") ("VDD" "VDD") ("VSS" "VSS")) ()))) t)
  sbErrors++ printf("SB_ERROR ALU_CORE: %L\n" errset.errset))
sbEnd()) t)
  printf("SB_ERROR uncaught: %L\n" errset.errset)
  exit(2))
exit(3)   ; unconditional: -nograph never exits on stdin EOF
