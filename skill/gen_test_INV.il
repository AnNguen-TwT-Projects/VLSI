;; generated by tools/scs2skill.py from ALU_CELLS_A=cells/A/INV_X1/INV_X1.scs -- do not edit
;; run in the VM:  cd ~/ALU_PROJ && virtuoso -nograph -restore <this file> < /dev/null
;; run with < /dev/null; any SKILL error -> message + exit, never a hanging CIW prompt
unless(errset(progn(
sbDir = or(getShellEnvVar("SB_DIR") "/mnt/hgfs/Share/VLSI_work/skill")
load(strcat(sbDir "/sch_build.il"))
sbBegin()
sbLib("ALU_CELLS_A" "gpdk090")
unless(errset(sbCell("ALU_CELLS_A" "INV_X1" '(("A" "input") ("Y" "output") ("VDD" "inputOutput") ("VSS" "inputOutput"))
 '(
  ("MN0" "gpdk090" "nmos1v" (("D" "Y") ("G" "A") ("S" "VSS") ("B" "VSS")) (("fingers" "1") ("w" "120n") ("fw" "120n") ("l" "100n")))
  ("MP0" "gpdk090" "pmos1v" (("D" "Y") ("G" "A") ("S" "VDD") ("B" "VDD")) (("fingers" "1") ("w" "240n") ("fw" "240n") ("l" "100n"))))) t)
  sbErrors++ printf("SB_ERROR INV_X1: %L\n" errset.errset))
sbEnd()) t)
  printf("SB_ERROR uncaught: %L\n" errset.errset)
  exit(2))
exit(3)   ; unconditional: -nograph never exits on stdin EOF
