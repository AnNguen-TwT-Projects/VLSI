// KSA32: sinh tu dong boi alu32/gen_alun.py - khong sua tay
simulator lang=spectre
subckt KSA32 A_0 A_1 A_2 A_3 A_4 A_5 A_6 A_7 A_8 A_9 A_10 A_11 A_12 A_13 A_14 A_15 A_16 \
    A_17 A_18 A_19 A_20 A_21 A_22 A_23 A_24 A_25 A_26 A_27 A_28 A_29 A_30 A_31 B_0 B_1 B_2 \
    B_3 B_4 B_5 B_6 B_7 B_8 B_9 B_10 B_11 B_12 B_13 B_14 B_15 B_16 B_17 B_18 B_19 B_20 \
    B_21 B_22 B_23 B_24 B_25 B_26 B_27 B_28 B_29 B_30 B_31 CIN S_0 S_1 S_2 S_3 S_4 S_5 S_6 \
    S_7 S_8 S_9 S_10 S_11 S_12 S_13 S_14 S_15 S_16 S_17 S_18 S_19 S_20 S_21 S_22 S_23 S_24 \
    S_25 S_26 S_27 S_28 S_29 S_30 S_31 CM CO VDD VSS
I0 (A_0 B_0 gn0 VDD VSS) NAND2_X1
I1 (A_1 B_1 gn1 VDD VSS) NAND2_X1
I2 (A_2 B_2 gn2 VDD VSS) NAND2_X1
I3 (A_3 B_3 gn3 VDD VSS) NAND2_X1
I4 (A_4 B_4 gn4 VDD VSS) NAND2_X1
I5 (A_5 B_5 gn5 VDD VSS) NAND2_X1
I6 (A_6 B_6 gn6 VDD VSS) NAND2_X1
I7 (A_7 B_7 gn7 VDD VSS) NAND2_X1
I8 (A_8 B_8 gn8 VDD VSS) NAND2_X1
I9 (A_9 B_9 gn9 VDD VSS) NAND2_X1
I10 (A_10 B_10 gn10 VDD VSS) NAND2_X1
I11 (A_11 B_11 gn11 VDD VSS) NAND2_X1
I12 (A_12 B_12 gn12 VDD VSS) NAND2_X1
I13 (A_13 B_13 gn13 VDD VSS) NAND2_X1
I14 (A_14 B_14 gn14 VDD VSS) NAND2_X1
I15 (A_15 B_15 gn15 VDD VSS) NAND2_X1
I16 (A_16 B_16 gn16 VDD VSS) NAND2_X1
I17 (A_17 B_17 gn17 VDD VSS) NAND2_X1
I18 (A_18 B_18 gn18 VDD VSS) NAND2_X1
I19 (A_19 B_19 gn19 VDD VSS) NAND2_X1
I20 (A_20 B_20 gn20 VDD VSS) NAND2_X1
I21 (A_21 B_21 gn21 VDD VSS) NAND2_X1
I22 (A_22 B_22 gn22 VDD VSS) NAND2_X1
I23 (A_23 B_23 gn23 VDD VSS) NAND2_X1
I24 (A_24 B_24 gn24 VDD VSS) NAND2_X1
I25 (A_25 B_25 gn25 VDD VSS) NAND2_X1
I26 (A_26 B_26 gn26 VDD VSS) NAND2_X1
I27 (A_27 B_27 gn27 VDD VSS) NAND2_X1
I28 (A_28 B_28 gn28 VDD VSS) NAND2_X1
I29 (A_29 B_29 gn29 VDD VSS) NAND2_X1
I30 (A_30 B_30 gn30 VDD VSS) NAND2_X1
I31 (A_31 B_31 gn31 VDD VSS) NAND2_X1
I32 (A_0 B_0 pn0 VDD VSS) XNOR2_X1
I33 (A_1 B_1 pn1 VDD VSS) XNOR2_X1
I34 (A_2 B_2 pn2 VDD VSS) XNOR2_X1
I35 (A_3 B_3 pn3 VDD VSS) XNOR2_X1
I36 (A_4 B_4 pn4 VDD VSS) XNOR2_X1
I37 (A_5 B_5 pn5 VDD VSS) XNOR2_X1
I38 (A_6 B_6 pn6 VDD VSS) XNOR2_X1
I39 (A_7 B_7 pn7 VDD VSS) XNOR2_X1
I40 (A_8 B_8 pn8 VDD VSS) XNOR2_X1
I41 (A_9 B_9 pn9 VDD VSS) XNOR2_X1
I42 (A_10 B_10 pn10 VDD VSS) XNOR2_X1
I43 (A_11 B_11 pn11 VDD VSS) XNOR2_X1
I44 (A_12 B_12 pn12 VDD VSS) XNOR2_X1
I45 (A_13 B_13 pn13 VDD VSS) XNOR2_X1
I46 (A_14 B_14 pn14 VDD VSS) XNOR2_X1
I47 (A_15 B_15 pn15 VDD VSS) XNOR2_X1
I48 (A_16 B_16 pn16 VDD VSS) XNOR2_X1
I49 (A_17 B_17 pn17 VDD VSS) XNOR2_X1
I50 (A_18 B_18 pn18 VDD VSS) XNOR2_X1
I51 (A_19 B_19 pn19 VDD VSS) XNOR2_X1
I52 (A_20 B_20 pn20 VDD VSS) XNOR2_X1
I53 (A_21 B_21 pn21 VDD VSS) XNOR2_X1
I54 (A_22 B_22 pn22 VDD VSS) XNOR2_X1
I55 (A_23 B_23 pn23 VDD VSS) XNOR2_X1
I56 (A_24 B_24 pn24 VDD VSS) XNOR2_X1
I57 (A_25 B_25 pn25 VDD VSS) XNOR2_X1
I58 (A_26 B_26 pn26 VDD VSS) XNOR2_X1
I59 (A_27 B_27 pn27 VDD VSS) XNOR2_X1
I60 (A_28 B_28 pn28 VDD VSS) XNOR2_X1
I61 (A_29 B_29 pn29 VDD VSS) XNOR2_X1
I62 (A_30 B_30 pn30 VDD VSS) XNOR2_X1
I63 (A_31 B_31 pn31 VDD VSS) XNOR2_X1
I64 (CIN cinn VDD VSS) INV_X1
I65 (gn0 pn0 cinn G0_0 VDD VSS) GRY_N
I66 (G0_0 G0_0n VDD VSS) INV_X1
I67 (gn1 pn1 G0_0n G1_0 VDD VSS) GRY_N
I68 (gn2 pn2 gn1 pn1 G2_1 P2_1 VDD VSS) BLK_N
I69 (gn3 pn3 gn2 pn2 G3_2 P3_2 VDD VSS) BLK_N
I70 (gn4 pn4 gn3 pn3 G4_3 P4_3 VDD VSS) BLK_N
I71 (gn5 pn5 gn4 pn4 G5_4 P5_4 VDD VSS) BLK_N
I72 (gn6 pn6 gn5 pn5 G6_5 P6_5 VDD VSS) BLK_N
I73 (gn7 pn7 gn6 pn6 G7_6 P7_6 VDD VSS) BLK_N
I74 (gn8 pn8 gn7 pn7 G8_7 P8_7 VDD VSS) BLK_N
I75 (gn9 pn9 gn8 pn8 G9_8 P9_8 VDD VSS) BLK_N
I76 (gn10 pn10 gn9 pn9 G10_9 P10_9 VDD VSS) BLK_N
I77 (gn11 pn11 gn10 pn10 G11_10 P11_10 VDD VSS) BLK_N
I78 (gn12 pn12 gn11 pn11 G12_11 P12_11 VDD VSS) BLK_N
I79 (gn13 pn13 gn12 pn12 G13_12 P13_12 VDD VSS) BLK_N
I80 (gn14 pn14 gn13 pn13 G14_13 P14_13 VDD VSS) BLK_N
I81 (gn15 pn15 gn14 pn14 G15_14 P15_14 VDD VSS) BLK_N
I82 (gn16 pn16 gn15 pn15 G16_15 P16_15 VDD VSS) BLK_N
I83 (gn17 pn17 gn16 pn16 G17_16 P17_16 VDD VSS) BLK_N
I84 (gn18 pn18 gn17 pn17 G18_17 P18_17 VDD VSS) BLK_N
I85 (gn19 pn19 gn18 pn18 G19_18 P19_18 VDD VSS) BLK_N
I86 (gn20 pn20 gn19 pn19 G20_19 P20_19 VDD VSS) BLK_N
I87 (gn21 pn21 gn20 pn20 G21_20 P21_20 VDD VSS) BLK_N
I88 (gn22 pn22 gn21 pn21 G22_21 P22_21 VDD VSS) BLK_N
I89 (gn23 pn23 gn22 pn22 G23_22 P23_22 VDD VSS) BLK_N
I90 (gn24 pn24 gn23 pn23 G24_23 P24_23 VDD VSS) BLK_N
I91 (gn25 pn25 gn24 pn24 G25_24 P25_24 VDD VSS) BLK_N
I92 (gn26 pn26 gn25 pn25 G26_25 P26_25 VDD VSS) BLK_N
I93 (gn27 pn27 gn26 pn26 G27_26 P27_26 VDD VSS) BLK_N
I94 (gn28 pn28 gn27 pn27 G28_27 P28_27 VDD VSS) BLK_N
I95 (gn29 pn29 gn28 pn28 G29_28 P29_28 VDD VSS) BLK_N
I96 (gn30 pn30 gn29 pn29 G30_29 P30_29 VDD VSS) BLK_N
I97 (gn31 pn31 gn30 pn30 G31_30 P31_30 VDD VSS) BLK_N
I98 (G2_1 P2_1 G0_0 G2_0n VDD VSS) GRY_P
I99 (G3_2 P3_2 G1_0 G3_0n VDD VSS) GRY_P
I100 (G4_3 P4_3 G2_1 P2_1 G4_1n P4_1n VDD VSS) BLK_P
I101 (G5_4 P5_4 G3_2 P3_2 G5_2n P5_2n VDD VSS) BLK_P
I102 (G6_5 P6_5 G4_3 P4_3 G6_3n P6_3n VDD VSS) BLK_P
I103 (G7_6 P7_6 G5_4 P5_4 G7_4n P7_4n VDD VSS) BLK_P
I104 (G8_7 P8_7 G6_5 P6_5 G8_5n P8_5n VDD VSS) BLK_P
I105 (G9_8 P9_8 G7_6 P7_6 G9_6n P9_6n VDD VSS) BLK_P
I106 (G10_9 P10_9 G8_7 P8_7 G10_7n P10_7n VDD VSS) BLK_P
I107 (G11_10 P11_10 G9_8 P9_8 G11_8n P11_8n VDD VSS) BLK_P
I108 (G12_11 P12_11 G10_9 P10_9 G12_9n P12_9n VDD VSS) BLK_P
I109 (G13_12 P13_12 G11_10 P11_10 G13_10n P13_10n VDD VSS) BLK_P
I110 (G14_13 P14_13 G12_11 P12_11 G14_11n P14_11n VDD VSS) BLK_P
I111 (G15_14 P15_14 G13_12 P13_12 G15_12n P15_12n VDD VSS) BLK_P
I112 (G16_15 P16_15 G14_13 P14_13 G16_13n P16_13n VDD VSS) BLK_P
I113 (G17_16 P17_16 G15_14 P15_14 G17_14n P17_14n VDD VSS) BLK_P
I114 (G18_17 P18_17 G16_15 P16_15 G18_15n P18_15n VDD VSS) BLK_P
I115 (G19_18 P19_18 G17_16 P17_16 G19_16n P19_16n VDD VSS) BLK_P
I116 (G20_19 P20_19 G18_17 P18_17 G20_17n P20_17n VDD VSS) BLK_P
I117 (G21_20 P21_20 G19_18 P19_18 G21_18n P21_18n VDD VSS) BLK_P
I118 (G22_21 P22_21 G20_19 P20_19 G22_19n P22_19n VDD VSS) BLK_P
I119 (G23_22 P23_22 G21_20 P21_20 G23_20n P23_20n VDD VSS) BLK_P
I120 (G24_23 P24_23 G22_21 P22_21 G24_21n P24_21n VDD VSS) BLK_P
I121 (G25_24 P25_24 G23_22 P23_22 G25_22n P25_22n VDD VSS) BLK_P
I122 (G26_25 P26_25 G24_23 P24_23 G26_23n P26_23n VDD VSS) BLK_P
I123 (G27_26 P27_26 G25_24 P25_24 G27_24n P27_24n VDD VSS) BLK_P
I124 (G28_27 P28_27 G26_25 P26_25 G28_25n P28_25n VDD VSS) BLK_P
I125 (G29_28 P29_28 G27_26 P27_26 G29_26n P29_26n VDD VSS) BLK_P
I126 (G30_29 P30_29 G28_27 P28_27 G30_27n P30_27n VDD VSS) BLK_P
I127 (G31_30 P31_30 G29_28 P29_28 G31_28n P31_28n VDD VSS) BLK_P
I128 (G4_1n P4_1n G0_0n G4_0 VDD VSS) GRY_N
I129 (G1_0 G1_0n VDD VSS) INV_X1
I130 (G5_2n P5_2n G1_0n G5_0 VDD VSS) GRY_N
I131 (G6_3n P6_3n G2_0n G6_0 VDD VSS) GRY_N
I132 (G7_4n P7_4n G3_0n G7_0 VDD VSS) GRY_N
I133 (G8_5n P8_5n G4_1n P4_1n G8_1 P8_1 VDD VSS) BLK_N
I134 (G9_6n P9_6n G5_2n P5_2n G9_2 P9_2 VDD VSS) BLK_N
I135 (G10_7n P10_7n G6_3n P6_3n G10_3 P10_3 VDD VSS) BLK_N
I136 (G11_8n P11_8n G7_4n P7_4n G11_4 P11_4 VDD VSS) BLK_N
I137 (G12_9n P12_9n G8_5n P8_5n G12_5 P12_5 VDD VSS) BLK_N
I138 (G13_10n P13_10n G9_6n P9_6n G13_6 P13_6 VDD VSS) BLK_N
I139 (G14_11n P14_11n G10_7n P10_7n G14_7 P14_7 VDD VSS) BLK_N
I140 (G15_12n P15_12n G11_8n P11_8n G15_8 P15_8 VDD VSS) BLK_N
I141 (G16_13n P16_13n G12_9n P12_9n G16_9 P16_9 VDD VSS) BLK_N
I142 (G17_14n P17_14n G13_10n P13_10n G17_10 P17_10 VDD VSS) BLK_N
I143 (G18_15n P18_15n G14_11n P14_11n G18_11 P18_11 VDD VSS) BLK_N
I144 (G19_16n P19_16n G15_12n P15_12n G19_12 P19_12 VDD VSS) BLK_N
I145 (G20_17n P20_17n G16_13n P16_13n G20_13 P20_13 VDD VSS) BLK_N
I146 (G21_18n P21_18n G17_14n P17_14n G21_14 P21_14 VDD VSS) BLK_N
I147 (G22_19n P22_19n G18_15n P18_15n G22_15 P22_15 VDD VSS) BLK_N
I148 (G23_20n P23_20n G19_16n P19_16n G23_16 P23_16 VDD VSS) BLK_N
I149 (G24_21n P24_21n G20_17n P20_17n G24_17 P24_17 VDD VSS) BLK_N
I150 (G25_22n P25_22n G21_18n P21_18n G25_18 P25_18 VDD VSS) BLK_N
I151 (G26_23n P26_23n G22_19n P22_19n G26_19 P26_19 VDD VSS) BLK_N
I152 (G27_24n P27_24n G23_20n P23_20n G27_20 P27_20 VDD VSS) BLK_N
I153 (G28_25n P28_25n G24_21n P24_21n G28_21 P28_21 VDD VSS) BLK_N
I154 (G29_26n P29_26n G25_22n P25_22n G29_22 P29_22 VDD VSS) BLK_N
I155 (G30_27n P30_27n G26_23n P26_23n G30_23 P30_23 VDD VSS) BLK_N
I156 (G31_28n P31_28n G27_24n P27_24n G31_24 P31_24 VDD VSS) BLK_N
I157 (G8_1 P8_1 G0_0 G8_0n VDD VSS) GRY_P
I158 (G9_2 P9_2 G1_0 G9_0n VDD VSS) GRY_P
I159 (G2_0n G2_0np VDD VSS) INV_X1
I160 (G10_3 P10_3 G2_0np G10_0n VDD VSS) GRY_P
I161 (G3_0n G3_0np VDD VSS) INV_X1
I162 (G11_4 P11_4 G3_0np G11_0n VDD VSS) GRY_P
I163 (G12_5 P12_5 G4_0 G12_0n VDD VSS) GRY_P
I164 (G13_6 P13_6 G5_0 G13_0n VDD VSS) GRY_P
I165 (G14_7 P14_7 G6_0 G14_0n VDD VSS) GRY_P
I166 (G15_8 P15_8 G7_0 G15_0n VDD VSS) GRY_P
I167 (G16_9 P16_9 G8_1 P8_1 G16_1n P16_1n VDD VSS) BLK_P
I168 (G17_10 P17_10 G9_2 P9_2 G17_2n P17_2n VDD VSS) BLK_P
I169 (G18_11 P18_11 G10_3 P10_3 G18_3n P18_3n VDD VSS) BLK_P
I170 (G19_12 P19_12 G11_4 P11_4 G19_4n P19_4n VDD VSS) BLK_P
I171 (G20_13 P20_13 G12_5 P12_5 G20_5n P20_5n VDD VSS) BLK_P
I172 (G21_14 P21_14 G13_6 P13_6 G21_6n P21_6n VDD VSS) BLK_P
I173 (G22_15 P22_15 G14_7 P14_7 G22_7n P22_7n VDD VSS) BLK_P
I174 (G23_16 P23_16 G15_8 P15_8 G23_8n P23_8n VDD VSS) BLK_P
I175 (G24_17 P24_17 G16_9 P16_9 G24_9n P24_9n VDD VSS) BLK_P
I176 (G25_18 P25_18 G17_10 P17_10 G25_10n P25_10n VDD VSS) BLK_P
I177 (G26_19 P26_19 G18_11 P18_11 G26_11n P26_11n VDD VSS) BLK_P
I178 (G27_20 P27_20 G19_12 P19_12 G27_12n P27_12n VDD VSS) BLK_P
I179 (G28_21 P28_21 G20_13 P20_13 G28_13n P28_13n VDD VSS) BLK_P
I180 (G29_22 P29_22 G21_14 P21_14 G29_14n P29_14n VDD VSS) BLK_P
I181 (G30_23 P30_23 G22_15 P22_15 G30_15n P30_15n VDD VSS) BLK_P
I182 (G31_24 P31_24 G23_16 P23_16 G31_16n P31_16n VDD VSS) BLK_P
I183 (G16_1n P16_1n G0_0n G16_0 VDD VSS) GRY_N
I184 (G17_2n P17_2n G1_0n G17_0 VDD VSS) GRY_N
I185 (G18_3n P18_3n G2_0n G18_0 VDD VSS) GRY_N
I186 (G19_4n P19_4n G3_0n G19_0 VDD VSS) GRY_N
I187 (G4_0 G4_0n VDD VSS) INV_X1
I188 (G20_5n P20_5n G4_0n G20_0 VDD VSS) GRY_N
I189 (G5_0 G5_0n VDD VSS) INV_X1
I190 (G21_6n P21_6n G5_0n G21_0 VDD VSS) GRY_N
I191 (G6_0 G6_0n VDD VSS) INV_X1
I192 (G22_7n P22_7n G6_0n G22_0 VDD VSS) GRY_N
I193 (G7_0 G7_0n VDD VSS) INV_X1
I194 (G23_8n P23_8n G7_0n G23_0 VDD VSS) GRY_N
I195 (G24_9n P24_9n G8_0n G24_0 VDD VSS) GRY_N
I196 (G25_10n P25_10n G9_0n G25_0 VDD VSS) GRY_N
I197 (G26_11n P26_11n G10_0n G26_0 VDD VSS) GRY_N
I198 (G27_12n P27_12n G11_0n G27_0 VDD VSS) GRY_N
I199 (G28_13n P28_13n G12_0n G28_0 VDD VSS) GRY_N
I200 (G29_14n P29_14n G13_0n G29_0 VDD VSS) GRY_N
I201 (G30_15n P30_15n G14_0n CM VDD VSS) GRY_N
I202 (G31_16n P31_16n G15_0n CO VDD VSS) GRY_N
I203 (pn0 CIN S_0 VDD VSS) XNOR2_X1
I204 (pn1 G0_0 S_1 VDD VSS) XNOR2_X1
I205 (pn2 G1_0 S_2 VDD VSS) XNOR2_X1
I206 (pn3 G2_0n S_3 VDD VSS) XOR2_X1
I207 (pn4 G3_0n S_4 VDD VSS) XOR2_X1
I208 (pn5 G4_0 S_5 VDD VSS) XNOR2_X1
I209 (pn6 G5_0 S_6 VDD VSS) XNOR2_X1
I210 (pn7 G6_0 S_7 VDD VSS) XNOR2_X1
I211 (pn8 G7_0 S_8 VDD VSS) XNOR2_X1
I212 (pn9 G8_0n S_9 VDD VSS) XOR2_X1
I213 (pn10 G9_0n S_10 VDD VSS) XOR2_X1
I214 (pn11 G10_0n S_11 VDD VSS) XOR2_X1
I215 (pn12 G11_0n S_12 VDD VSS) XOR2_X1
I216 (pn13 G12_0n S_13 VDD VSS) XOR2_X1
I217 (pn14 G13_0n S_14 VDD VSS) XOR2_X1
I218 (pn15 G14_0n S_15 VDD VSS) XOR2_X1
I219 (pn16 G15_0n S_16 VDD VSS) XOR2_X1
I220 (pn17 G16_0 S_17 VDD VSS) XNOR2_X1
I221 (pn18 G17_0 S_18 VDD VSS) XNOR2_X1
I222 (pn19 G18_0 S_19 VDD VSS) XNOR2_X1
I223 (pn20 G19_0 S_20 VDD VSS) XNOR2_X1
I224 (pn21 G20_0 S_21 VDD VSS) XNOR2_X1
I225 (pn22 G21_0 S_22 VDD VSS) XNOR2_X1
I226 (pn23 G22_0 S_23 VDD VSS) XNOR2_X1
I227 (pn24 G23_0 S_24 VDD VSS) XNOR2_X1
I228 (pn25 G24_0 S_25 VDD VSS) XNOR2_X1
I229 (pn26 G25_0 S_26 VDD VSS) XNOR2_X1
I230 (pn27 G26_0 S_27 VDD VSS) XNOR2_X1
I231 (pn28 G27_0 S_28 VDD VSS) XNOR2_X1
I232 (pn29 G28_0 S_29 VDD VSS) XNOR2_X1
I233 (pn30 G29_0 S_30 VDD VSS) XNOR2_X1
I234 (pn31 CM S_31 VDD VSS) XNOR2_X1
ends KSA32
