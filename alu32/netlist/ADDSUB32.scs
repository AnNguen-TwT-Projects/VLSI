// ADDSUB32: sinh tu dong boi alu32/gen_alun.py - khong sua tay
simulator lang=spectre
subckt ADDSUB32 A_0 A_1 A_2 A_3 A_4 A_5 A_6 A_7 A_8 A_9 A_10 A_11 A_12 A_13 A_14 A_15 A_16 \
    A_17 A_18 A_19 A_20 A_21 A_22 A_23 A_24 A_25 A_26 A_27 A_28 A_29 A_30 A_31 B_0 B_1 B_2 \
    B_3 B_4 B_5 B_6 B_7 B_8 B_9 B_10 B_11 B_12 B_13 B_14 B_15 B_16 B_17 B_18 B_19 B_20 \
    B_21 B_22 B_23 B_24 B_25 B_26 B_27 B_28 B_29 B_30 B_31 SUB S_0 S_1 S_2 S_3 S_4 S_5 S_6 \
    S_7 S_8 S_9 S_10 S_11 S_12 S_13 S_14 S_15 S_16 S_17 S_18 S_19 S_20 S_21 S_22 S_23 S_24 \
    S_25 S_26 S_27 S_28 S_29 S_30 S_31 CM CO VDD VSS
I0 (SUB SUB_b0 VDD VSS) INV_X1
I1 (SUB_b0 SUB_b1_0 VDD VSS) INV_X4
I2 (SUB_b1_0 SUB_b2_0 VDD VSS) INV_X4
I3 (SUB_b1_0 SUB_b2_1 VDD VSS) INV_X4
I4 (SUB_b2_0 SUB_b3_0 VDD VSS) INV_X4
I5 (SUB_b2_0 SUB_b3_1 VDD VSS) INV_X4
I6 (SUB_b2_0 SUB_b3_2 VDD VSS) INV_X4
I7 (SUB_b2_1 SUB_b3_3 VDD VSS) INV_X4
I8 (SUB_b2_1 SUB_b3_4 VDD VSS) INV_X4
I9 (SUB_b2_1 SUB_b3_5 VDD VSS) INV_X4
I10 (B_0 SUB_b3_0 bx0 VDD VSS) XOR2_X1
I11 (B_1 SUB_b3_0 bx1 VDD VSS) XOR2_X1
I12 (B_2 SUB_b3_0 bx2 VDD VSS) XOR2_X1
I13 (B_3 SUB_b3_0 bx3 VDD VSS) XOR2_X1
I14 (B_4 SUB_b3_0 bx4 VDD VSS) XOR2_X1
I15 (B_5 SUB_b3_0 bx5 VDD VSS) XOR2_X1
I16 (B_6 SUB_b3_1 bx6 VDD VSS) XOR2_X1
I17 (B_7 SUB_b3_1 bx7 VDD VSS) XOR2_X1
I18 (B_8 SUB_b3_1 bx8 VDD VSS) XOR2_X1
I19 (B_9 SUB_b3_1 bx9 VDD VSS) XOR2_X1
I20 (B_10 SUB_b3_1 bx10 VDD VSS) XOR2_X1
I21 (B_11 SUB_b3_2 bx11 VDD VSS) XOR2_X1
I22 (B_12 SUB_b3_2 bx12 VDD VSS) XOR2_X1
I23 (B_13 SUB_b3_2 bx13 VDD VSS) XOR2_X1
I24 (B_14 SUB_b3_2 bx14 VDD VSS) XOR2_X1
I25 (B_15 SUB_b3_2 bx15 VDD VSS) XOR2_X1
I26 (B_16 SUB_b3_2 bx16 VDD VSS) XOR2_X1
I27 (B_17 SUB_b3_3 bx17 VDD VSS) XOR2_X1
I28 (B_18 SUB_b3_3 bx18 VDD VSS) XOR2_X1
I29 (B_19 SUB_b3_3 bx19 VDD VSS) XOR2_X1
I30 (B_20 SUB_b3_3 bx20 VDD VSS) XOR2_X1
I31 (B_21 SUB_b3_3 bx21 VDD VSS) XOR2_X1
I32 (B_22 SUB_b3_4 bx22 VDD VSS) XOR2_X1
I33 (B_23 SUB_b3_4 bx23 VDD VSS) XOR2_X1
I34 (B_24 SUB_b3_4 bx24 VDD VSS) XOR2_X1
I35 (B_25 SUB_b3_4 bx25 VDD VSS) XOR2_X1
I36 (B_26 SUB_b3_4 bx26 VDD VSS) XOR2_X1
I37 (B_27 SUB_b3_4 bx27 VDD VSS) XOR2_X1
I38 (B_28 SUB_b3_5 bx28 VDD VSS) XOR2_X1
I39 (B_29 SUB_b3_5 bx29 VDD VSS) XOR2_X1
I40 (B_30 SUB_b3_5 bx30 VDD VSS) XOR2_X1
I41 (B_31 SUB_b3_5 bx31 VDD VSS) XOR2_X1
I42 (A_0 A_1 A_2 A_3 A_4 A_5 A_6 A_7 A_8 A_9 A_10 A_11 A_12 A_13 A_14 A_15 A_16 A_17 A_18 \
    A_19 A_20 A_21 A_22 A_23 A_24 A_25 A_26 A_27 A_28 A_29 A_30 A_31 bx0 bx1 bx2 bx3 bx4 \
    bx5 bx6 bx7 bx8 bx9 bx10 bx11 bx12 bx13 bx14 bx15 bx16 bx17 bx18 bx19 bx20 bx21 bx22 \
    bx23 bx24 bx25 bx26 bx27 bx28 bx29 bx30 bx31 SUB_b3_5 S_0 S_1 S_2 S_3 S_4 S_5 S_6 S_7 \
    S_8 S_9 S_10 S_11 S_12 S_13 S_14 S_15 S_16 S_17 S_18 S_19 S_20 S_21 S_22 S_23 S_24 \
    S_25 S_26 S_27 S_28 S_29 S_30 S_31 CM CO VDD VSS) KSA32
ends ADDSUB32
