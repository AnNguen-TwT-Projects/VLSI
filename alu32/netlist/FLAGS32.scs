// FLAGS32: sinh tu dong boi alu32/gen_alun.py - khong sua tay
simulator lang=spectre
subckt FLAGS32 Y_0 Y_1 Y_2 Y_3 Y_4 Y_5 Y_6 Y_7 Y_8 Y_9 Y_10 Y_11 Y_12 Y_13 Y_14 Y_15 Y_16 \
    Y_17 Y_18 Y_19 Y_20 Y_21 Y_22 Y_23 Y_24 Y_25 Y_26 Y_27 Y_28 Y_29 Y_30 Y_31 Y_32 Y_33 \
    Y_34 Y_35 Y_36 Y_37 Y_38 Y_39 Y_40 Y_41 Y_42 Y_43 Y_44 Y_45 Y_46 Y_47 Y_48 Y_49 Y_50 \
    Y_51 Y_52 Y_53 Y_54 Y_55 Y_56 Y_57 Y_58 Y_59 Y_60 Y_61 Y_62 Y_63 CM CO DIVV DIVDZ \
    SEL_AS SEL_DIV Z C V DZ VDD VSS
I0 (Y_0 Y_1 z0_0 VDD VSS) NOR2_X1
I1 (Y_2 Y_3 z0_1 VDD VSS) NOR2_X1
I2 (Y_4 Y_5 z0_2 VDD VSS) NOR2_X1
I3 (Y_6 Y_7 z0_3 VDD VSS) NOR2_X1
I4 (Y_8 Y_9 z0_4 VDD VSS) NOR2_X1
I5 (Y_10 Y_11 z0_5 VDD VSS) NOR2_X1
I6 (Y_12 Y_13 z0_6 VDD VSS) NOR2_X1
I7 (Y_14 Y_15 z0_7 VDD VSS) NOR2_X1
I8 (Y_16 Y_17 z0_8 VDD VSS) NOR2_X1
I9 (Y_18 Y_19 z0_9 VDD VSS) NOR2_X1
I10 (Y_20 Y_21 z0_10 VDD VSS) NOR2_X1
I11 (Y_22 Y_23 z0_11 VDD VSS) NOR2_X1
I12 (Y_24 Y_25 z0_12 VDD VSS) NOR2_X1
I13 (Y_26 Y_27 z0_13 VDD VSS) NOR2_X1
I14 (Y_28 Y_29 z0_14 VDD VSS) NOR2_X1
I15 (Y_30 Y_31 z0_15 VDD VSS) NOR2_X1
I16 (Y_32 Y_33 z0_16 VDD VSS) NOR2_X1
I17 (Y_34 Y_35 z0_17 VDD VSS) NOR2_X1
I18 (Y_36 Y_37 z0_18 VDD VSS) NOR2_X1
I19 (Y_38 Y_39 z0_19 VDD VSS) NOR2_X1
I20 (Y_40 Y_41 z0_20 VDD VSS) NOR2_X1
I21 (Y_42 Y_43 z0_21 VDD VSS) NOR2_X1
I22 (Y_44 Y_45 z0_22 VDD VSS) NOR2_X1
I23 (Y_46 Y_47 z0_23 VDD VSS) NOR2_X1
I24 (Y_48 Y_49 z0_24 VDD VSS) NOR2_X1
I25 (Y_50 Y_51 z0_25 VDD VSS) NOR2_X1
I26 (Y_52 Y_53 z0_26 VDD VSS) NOR2_X1
I27 (Y_54 Y_55 z0_27 VDD VSS) NOR2_X1
I28 (Y_56 Y_57 z0_28 VDD VSS) NOR2_X1
I29 (Y_58 Y_59 z0_29 VDD VSS) NOR2_X1
I30 (Y_60 Y_61 z0_30 VDD VSS) NOR2_X1
I31 (Y_62 Y_63 z0_31 VDD VSS) NOR2_X1
I32 (z0_0 z0_1 z1_0 VDD VSS) NAND2_X1
I33 (z0_2 z0_3 z1_1 VDD VSS) NAND2_X1
I34 (z0_4 z0_5 z1_2 VDD VSS) NAND2_X1
I35 (z0_6 z0_7 z1_3 VDD VSS) NAND2_X1
I36 (z0_8 z0_9 z1_4 VDD VSS) NAND2_X1
I37 (z0_10 z0_11 z1_5 VDD VSS) NAND2_X1
I38 (z0_12 z0_13 z1_6 VDD VSS) NAND2_X1
I39 (z0_14 z0_15 z1_7 VDD VSS) NAND2_X1
I40 (z0_16 z0_17 z1_8 VDD VSS) NAND2_X1
I41 (z0_18 z0_19 z1_9 VDD VSS) NAND2_X1
I42 (z0_20 z0_21 z1_10 VDD VSS) NAND2_X1
I43 (z0_22 z0_23 z1_11 VDD VSS) NAND2_X1
I44 (z0_24 z0_25 z1_12 VDD VSS) NAND2_X1
I45 (z0_26 z0_27 z1_13 VDD VSS) NAND2_X1
I46 (z0_28 z0_29 z1_14 VDD VSS) NAND2_X1
I47 (z0_30 z0_31 z1_15 VDD VSS) NAND2_X1
I48 (z1_0 z1_1 z2_0 VDD VSS) NOR2_X1
I49 (z1_2 z1_3 z2_1 VDD VSS) NOR2_X1
I50 (z1_4 z1_5 z2_2 VDD VSS) NOR2_X1
I51 (z1_6 z1_7 z2_3 VDD VSS) NOR2_X1
I52 (z1_8 z1_9 z2_4 VDD VSS) NOR2_X1
I53 (z1_10 z1_11 z2_5 VDD VSS) NOR2_X1
I54 (z1_12 z1_13 z2_6 VDD VSS) NOR2_X1
I55 (z1_14 z1_15 z2_7 VDD VSS) NOR2_X1
I56 (z2_0 z2_1 z3_0 VDD VSS) NAND2_X1
I57 (z2_2 z2_3 z3_1 VDD VSS) NAND2_X1
I58 (z2_4 z2_5 z3_2 VDD VSS) NAND2_X1
I59 (z2_6 z2_7 z3_3 VDD VSS) NAND2_X1
I60 (z3_0 z3_1 z4_0 VDD VSS) NOR2_X1
I61 (z3_2 z3_3 z4_1 VDD VSS) NOR2_X1
I62 (z4_0 z4_1 z5_0 VDD VSS) NAND2_X1
I63 (z5_0 Z VDD VSS) INV_X1
I64 (CO SEL_AS cn VDD VSS) NAND2_X1
I65 (cn C VDD VSS) INV_X1
I66 (CM CO ovf VDD VSS) XOR2_X1
I67 (SEL_AS ovf v1 VDD VSS) NAND2_X1
I68 (SEL_DIV DIVV v2 VDD VSS) NAND2_X1
I69 (v1 v2 V VDD VSS) NAND2_X1
I70 (SEL_DIV DIVDZ dzn VDD VSS) NAND2_X1
I71 (dzn DZ VDD VSS) INV_X1
ends FLAGS32
