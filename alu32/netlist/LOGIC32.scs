// LOGIC32: sinh tu dong boi alu32/gen_alun.py - khong sua tay
simulator lang=spectre
subckt LOGIC32 A_0 A_1 A_2 A_3 A_4 A_5 A_6 A_7 A_8 A_9 A_10 A_11 A_12 A_13 A_14 A_15 A_16 \
    A_17 A_18 A_19 A_20 A_21 A_22 A_23 A_24 A_25 A_26 A_27 A_28 A_29 A_30 A_31 B_0 B_1 B_2 \
    B_3 B_4 B_5 B_6 B_7 B_8 B_9 B_10 B_11 B_12 B_13 B_14 B_15 B_16 B_17 B_18 B_19 B_20 \
    B_21 B_22 B_23 B_24 B_25 B_26 B_27 B_28 B_29 B_30 B_31 AND_0 AND_1 AND_2 AND_3 AND_4 \
    AND_5 AND_6 AND_7 AND_8 AND_9 AND_10 AND_11 AND_12 AND_13 AND_14 AND_15 AND_16 AND_17 \
    AND_18 AND_19 AND_20 AND_21 AND_22 AND_23 AND_24 AND_25 AND_26 AND_27 AND_28 AND_29 \
    AND_30 AND_31 OR_0 OR_1 OR_2 OR_3 OR_4 OR_5 OR_6 OR_7 OR_8 OR_9 OR_10 OR_11 OR_12 \
    OR_13 OR_14 OR_15 OR_16 OR_17 OR_18 OR_19 OR_20 OR_21 OR_22 OR_23 OR_24 OR_25 OR_26 \
    OR_27 OR_28 OR_29 OR_30 OR_31 XOR_0 XOR_1 XOR_2 XOR_3 XOR_4 XOR_5 XOR_6 XOR_7 XOR_8 \
    XOR_9 XOR_10 XOR_11 XOR_12 XOR_13 XOR_14 XOR_15 XOR_16 XOR_17 XOR_18 XOR_19 XOR_20 \
    XOR_21 XOR_22 XOR_23 XOR_24 XOR_25 XOR_26 XOR_27 XOR_28 XOR_29 XOR_30 XOR_31 NOT_0 \
    NOT_1 NOT_2 NOT_3 NOT_4 NOT_5 NOT_6 NOT_7 NOT_8 NOT_9 NOT_10 NOT_11 NOT_12 NOT_13 \
    NOT_14 NOT_15 NOT_16 NOT_17 NOT_18 NOT_19 NOT_20 NOT_21 NOT_22 NOT_23 NOT_24 NOT_25 \
    NOT_26 NOT_27 NOT_28 NOT_29 NOT_30 NOT_31 VDD VSS
I0 (A_0 B_0 nand0 VDD VSS) NAND2_X1
I1 (nand0 AND_0 VDD VSS) INV_X1
I2 (A_0 B_0 nor0 VDD VSS) NOR2_X1
I3 (nor0 OR_0 VDD VSS) INV_X1
I4 (A_0 B_0 XOR_0 VDD VSS) XOR2_X1
I5 (A_0 NOT_0 VDD VSS) INV_X1
I6 (A_1 B_1 nand1 VDD VSS) NAND2_X1
I7 (nand1 AND_1 VDD VSS) INV_X1
I8 (A_1 B_1 nor1 VDD VSS) NOR2_X1
I9 (nor1 OR_1 VDD VSS) INV_X1
I10 (A_1 B_1 XOR_1 VDD VSS) XOR2_X1
I11 (A_1 NOT_1 VDD VSS) INV_X1
I12 (A_2 B_2 nand2 VDD VSS) NAND2_X1
I13 (nand2 AND_2 VDD VSS) INV_X1
I14 (A_2 B_2 nor2 VDD VSS) NOR2_X1
I15 (nor2 OR_2 VDD VSS) INV_X1
I16 (A_2 B_2 XOR_2 VDD VSS) XOR2_X1
I17 (A_2 NOT_2 VDD VSS) INV_X1
I18 (A_3 B_3 nand3 VDD VSS) NAND2_X1
I19 (nand3 AND_3 VDD VSS) INV_X1
I20 (A_3 B_3 nor3 VDD VSS) NOR2_X1
I21 (nor3 OR_3 VDD VSS) INV_X1
I22 (A_3 B_3 XOR_3 VDD VSS) XOR2_X1
I23 (A_3 NOT_3 VDD VSS) INV_X1
I24 (A_4 B_4 nand4 VDD VSS) NAND2_X1
I25 (nand4 AND_4 VDD VSS) INV_X1
I26 (A_4 B_4 nor4 VDD VSS) NOR2_X1
I27 (nor4 OR_4 VDD VSS) INV_X1
I28 (A_4 B_4 XOR_4 VDD VSS) XOR2_X1
I29 (A_4 NOT_4 VDD VSS) INV_X1
I30 (A_5 B_5 nand5 VDD VSS) NAND2_X1
I31 (nand5 AND_5 VDD VSS) INV_X1
I32 (A_5 B_5 nor5 VDD VSS) NOR2_X1
I33 (nor5 OR_5 VDD VSS) INV_X1
I34 (A_5 B_5 XOR_5 VDD VSS) XOR2_X1
I35 (A_5 NOT_5 VDD VSS) INV_X1
I36 (A_6 B_6 nand6 VDD VSS) NAND2_X1
I37 (nand6 AND_6 VDD VSS) INV_X1
I38 (A_6 B_6 nor6 VDD VSS) NOR2_X1
I39 (nor6 OR_6 VDD VSS) INV_X1
I40 (A_6 B_6 XOR_6 VDD VSS) XOR2_X1
I41 (A_6 NOT_6 VDD VSS) INV_X1
I42 (A_7 B_7 nand7 VDD VSS) NAND2_X1
I43 (nand7 AND_7 VDD VSS) INV_X1
I44 (A_7 B_7 nor7 VDD VSS) NOR2_X1
I45 (nor7 OR_7 VDD VSS) INV_X1
I46 (A_7 B_7 XOR_7 VDD VSS) XOR2_X1
I47 (A_7 NOT_7 VDD VSS) INV_X1
I48 (A_8 B_8 nand8 VDD VSS) NAND2_X1
I49 (nand8 AND_8 VDD VSS) INV_X1
I50 (A_8 B_8 nor8 VDD VSS) NOR2_X1
I51 (nor8 OR_8 VDD VSS) INV_X1
I52 (A_8 B_8 XOR_8 VDD VSS) XOR2_X1
I53 (A_8 NOT_8 VDD VSS) INV_X1
I54 (A_9 B_9 nand9 VDD VSS) NAND2_X1
I55 (nand9 AND_9 VDD VSS) INV_X1
I56 (A_9 B_9 nor9 VDD VSS) NOR2_X1
I57 (nor9 OR_9 VDD VSS) INV_X1
I58 (A_9 B_9 XOR_9 VDD VSS) XOR2_X1
I59 (A_9 NOT_9 VDD VSS) INV_X1
I60 (A_10 B_10 nand10 VDD VSS) NAND2_X1
I61 (nand10 AND_10 VDD VSS) INV_X1
I62 (A_10 B_10 nor10 VDD VSS) NOR2_X1
I63 (nor10 OR_10 VDD VSS) INV_X1
I64 (A_10 B_10 XOR_10 VDD VSS) XOR2_X1
I65 (A_10 NOT_10 VDD VSS) INV_X1
I66 (A_11 B_11 nand11 VDD VSS) NAND2_X1
I67 (nand11 AND_11 VDD VSS) INV_X1
I68 (A_11 B_11 nor11 VDD VSS) NOR2_X1
I69 (nor11 OR_11 VDD VSS) INV_X1
I70 (A_11 B_11 XOR_11 VDD VSS) XOR2_X1
I71 (A_11 NOT_11 VDD VSS) INV_X1
I72 (A_12 B_12 nand12 VDD VSS) NAND2_X1
I73 (nand12 AND_12 VDD VSS) INV_X1
I74 (A_12 B_12 nor12 VDD VSS) NOR2_X1
I75 (nor12 OR_12 VDD VSS) INV_X1
I76 (A_12 B_12 XOR_12 VDD VSS) XOR2_X1
I77 (A_12 NOT_12 VDD VSS) INV_X1
I78 (A_13 B_13 nand13 VDD VSS) NAND2_X1
I79 (nand13 AND_13 VDD VSS) INV_X1
I80 (A_13 B_13 nor13 VDD VSS) NOR2_X1
I81 (nor13 OR_13 VDD VSS) INV_X1
I82 (A_13 B_13 XOR_13 VDD VSS) XOR2_X1
I83 (A_13 NOT_13 VDD VSS) INV_X1
I84 (A_14 B_14 nand14 VDD VSS) NAND2_X1
I85 (nand14 AND_14 VDD VSS) INV_X1
I86 (A_14 B_14 nor14 VDD VSS) NOR2_X1
I87 (nor14 OR_14 VDD VSS) INV_X1
I88 (A_14 B_14 XOR_14 VDD VSS) XOR2_X1
I89 (A_14 NOT_14 VDD VSS) INV_X1
I90 (A_15 B_15 nand15 VDD VSS) NAND2_X1
I91 (nand15 AND_15 VDD VSS) INV_X1
I92 (A_15 B_15 nor15 VDD VSS) NOR2_X1
I93 (nor15 OR_15 VDD VSS) INV_X1
I94 (A_15 B_15 XOR_15 VDD VSS) XOR2_X1
I95 (A_15 NOT_15 VDD VSS) INV_X1
I96 (A_16 B_16 nand16 VDD VSS) NAND2_X1
I97 (nand16 AND_16 VDD VSS) INV_X1
I98 (A_16 B_16 nor16 VDD VSS) NOR2_X1
I99 (nor16 OR_16 VDD VSS) INV_X1
I100 (A_16 B_16 XOR_16 VDD VSS) XOR2_X1
I101 (A_16 NOT_16 VDD VSS) INV_X1
I102 (A_17 B_17 nand17 VDD VSS) NAND2_X1
I103 (nand17 AND_17 VDD VSS) INV_X1
I104 (A_17 B_17 nor17 VDD VSS) NOR2_X1
I105 (nor17 OR_17 VDD VSS) INV_X1
I106 (A_17 B_17 XOR_17 VDD VSS) XOR2_X1
I107 (A_17 NOT_17 VDD VSS) INV_X1
I108 (A_18 B_18 nand18 VDD VSS) NAND2_X1
I109 (nand18 AND_18 VDD VSS) INV_X1
I110 (A_18 B_18 nor18 VDD VSS) NOR2_X1
I111 (nor18 OR_18 VDD VSS) INV_X1
I112 (A_18 B_18 XOR_18 VDD VSS) XOR2_X1
I113 (A_18 NOT_18 VDD VSS) INV_X1
I114 (A_19 B_19 nand19 VDD VSS) NAND2_X1
I115 (nand19 AND_19 VDD VSS) INV_X1
I116 (A_19 B_19 nor19 VDD VSS) NOR2_X1
I117 (nor19 OR_19 VDD VSS) INV_X1
I118 (A_19 B_19 XOR_19 VDD VSS) XOR2_X1
I119 (A_19 NOT_19 VDD VSS) INV_X1
I120 (A_20 B_20 nand20 VDD VSS) NAND2_X1
I121 (nand20 AND_20 VDD VSS) INV_X1
I122 (A_20 B_20 nor20 VDD VSS) NOR2_X1
I123 (nor20 OR_20 VDD VSS) INV_X1
I124 (A_20 B_20 XOR_20 VDD VSS) XOR2_X1
I125 (A_20 NOT_20 VDD VSS) INV_X1
I126 (A_21 B_21 nand21 VDD VSS) NAND2_X1
I127 (nand21 AND_21 VDD VSS) INV_X1
I128 (A_21 B_21 nor21 VDD VSS) NOR2_X1
I129 (nor21 OR_21 VDD VSS) INV_X1
I130 (A_21 B_21 XOR_21 VDD VSS) XOR2_X1
I131 (A_21 NOT_21 VDD VSS) INV_X1
I132 (A_22 B_22 nand22 VDD VSS) NAND2_X1
I133 (nand22 AND_22 VDD VSS) INV_X1
I134 (A_22 B_22 nor22 VDD VSS) NOR2_X1
I135 (nor22 OR_22 VDD VSS) INV_X1
I136 (A_22 B_22 XOR_22 VDD VSS) XOR2_X1
I137 (A_22 NOT_22 VDD VSS) INV_X1
I138 (A_23 B_23 nand23 VDD VSS) NAND2_X1
I139 (nand23 AND_23 VDD VSS) INV_X1
I140 (A_23 B_23 nor23 VDD VSS) NOR2_X1
I141 (nor23 OR_23 VDD VSS) INV_X1
I142 (A_23 B_23 XOR_23 VDD VSS) XOR2_X1
I143 (A_23 NOT_23 VDD VSS) INV_X1
I144 (A_24 B_24 nand24 VDD VSS) NAND2_X1
I145 (nand24 AND_24 VDD VSS) INV_X1
I146 (A_24 B_24 nor24 VDD VSS) NOR2_X1
I147 (nor24 OR_24 VDD VSS) INV_X1
I148 (A_24 B_24 XOR_24 VDD VSS) XOR2_X1
I149 (A_24 NOT_24 VDD VSS) INV_X1
I150 (A_25 B_25 nand25 VDD VSS) NAND2_X1
I151 (nand25 AND_25 VDD VSS) INV_X1
I152 (A_25 B_25 nor25 VDD VSS) NOR2_X1
I153 (nor25 OR_25 VDD VSS) INV_X1
I154 (A_25 B_25 XOR_25 VDD VSS) XOR2_X1
I155 (A_25 NOT_25 VDD VSS) INV_X1
I156 (A_26 B_26 nand26 VDD VSS) NAND2_X1
I157 (nand26 AND_26 VDD VSS) INV_X1
I158 (A_26 B_26 nor26 VDD VSS) NOR2_X1
I159 (nor26 OR_26 VDD VSS) INV_X1
I160 (A_26 B_26 XOR_26 VDD VSS) XOR2_X1
I161 (A_26 NOT_26 VDD VSS) INV_X1
I162 (A_27 B_27 nand27 VDD VSS) NAND2_X1
I163 (nand27 AND_27 VDD VSS) INV_X1
I164 (A_27 B_27 nor27 VDD VSS) NOR2_X1
I165 (nor27 OR_27 VDD VSS) INV_X1
I166 (A_27 B_27 XOR_27 VDD VSS) XOR2_X1
I167 (A_27 NOT_27 VDD VSS) INV_X1
I168 (A_28 B_28 nand28 VDD VSS) NAND2_X1
I169 (nand28 AND_28 VDD VSS) INV_X1
I170 (A_28 B_28 nor28 VDD VSS) NOR2_X1
I171 (nor28 OR_28 VDD VSS) INV_X1
I172 (A_28 B_28 XOR_28 VDD VSS) XOR2_X1
I173 (A_28 NOT_28 VDD VSS) INV_X1
I174 (A_29 B_29 nand29 VDD VSS) NAND2_X1
I175 (nand29 AND_29 VDD VSS) INV_X1
I176 (A_29 B_29 nor29 VDD VSS) NOR2_X1
I177 (nor29 OR_29 VDD VSS) INV_X1
I178 (A_29 B_29 XOR_29 VDD VSS) XOR2_X1
I179 (A_29 NOT_29 VDD VSS) INV_X1
I180 (A_30 B_30 nand30 VDD VSS) NAND2_X1
I181 (nand30 AND_30 VDD VSS) INV_X1
I182 (A_30 B_30 nor30 VDD VSS) NOR2_X1
I183 (nor30 OR_30 VDD VSS) INV_X1
I184 (A_30 B_30 XOR_30 VDD VSS) XOR2_X1
I185 (A_30 NOT_30 VDD VSS) INV_X1
I186 (A_31 B_31 nand31 VDD VSS) NAND2_X1
I187 (nand31 AND_31 VDD VSS) INV_X1
I188 (A_31 B_31 nor31 VDD VSS) NOR2_X1
I189 (nor31 OR_31 VDD VSS) INV_X1
I190 (A_31 B_31 XOR_31 VDD VSS) XOR2_X1
I191 (A_31 NOT_31 VDD VSS) INV_X1
ends LOGIC32
